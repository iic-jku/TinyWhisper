** sch_path: /foss/designs/TinyWhisper/ihp130/macros/iqmod/xschem/iqmod_spdt_switch.sch
.subckt iqmod_spdt_switch VDD di_spdt_ctrl VSS v_c v_b v_a
*.PININFO v_a:B v_b:B v_c:B VDD:B VSS:B di_spdt_ctrl:I
x1 nwell psub VDD di_spdt_ctrl spdt_ctrl_n VSS iqmod_spdt_switch_inv
x2 nwell psub VDD spdt_ctrl_n spdt_ctrl_buf VSS iqmod_spdt_switch_inv
x3 nwell psub VDD spdt_ctrl_buf VSS v_c v_a spdt_ctrl_n iqmod_spdt_switch_tg
x4 nwell psub VDD spdt_ctrl_n VSS v_c v_b spdt_ctrl_buf iqmod_spdt_switch_tg
.ends

* expanding   symbol:  iqmod_spdt_switch_inv.sym # of pins=6
** sym_path: xschem/iqmod_spdt_switch_inv.sym
** sch_path: /foss/designs/TinyWhisper/ihp130/macros/iqmod/xschem/iqmod_spdt_switch_inv.sch
.subckt iqmod_spdt_switch_inv nwell psub VDD vin vout VSS
*.PININFO vin:I VDD:B VSS:B vout:B nwell:B psub:B
MM1 vout vin VSS psub sg13_lv_nmos w=2.0u l=0.13u ng=2
MM2 vout vin VDD nwell sg13_lv_pmos w=12.0u l=0.13u ng=2
MMdummy1 VSS VSS VSS psub sg13_lv_nmos w=2.0u l=0.13u ng=2
MMdummy2 VDD VDD VDD nwell sg13_lv_pmos w=12.0u l=0.13u ng=2
RR1 VDD nwell ntap1 A=7.068e-12 P=4.712e-05
RR2 VSS psub ptap1 A=4.284e-12 P=2.856e-05
.ends

* expanding   symbol:  iqmod_spdt_switch_tg.sym # of pins=8
** sym_path: xschem/iqmod_spdt_switch_tg.sym
** sch_path: /foss/designs/TinyWhisper/ihp130/macros/iqmod/xschem/iqmod_spdt_switch_tg.sch
.subckt iqmod_spdt_switch_tg nwell psub VDD di_tg_ctrl VSS v_b v_a di_tg_ctrl_n
*.PININFO v_a:B v_b:B VDD:B VSS:B di_tg_ctrl:I di_tg_ctrl_n:I nwell:B psub:B
MM2 v_a di_tg_ctrl_n v_b nwell sg13_lv_pmos w=36.0u l=0.13u ng=6
MM1 v_a di_tg_ctrl v_b psub sg13_lv_nmos w=6.0u l=0.13u ng=6
RR1 VDD nwell ntap1 A=7.68e-12 P=5.12e-05
RR2 VSS psub ptap1 A=4.896e-12 P=3.264e-05
.ends
