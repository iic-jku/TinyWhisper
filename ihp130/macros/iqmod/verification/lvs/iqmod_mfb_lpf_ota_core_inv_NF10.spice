** sch_path: /foss/designs/TinyWhisper/ihp130/macros/iqmod/xschem/iqmod_mfb_lpf_ota_core_inv_NF10.sch
.subckt iqmod_mfb_lpf_ota_core_inv_NF10 nwell psub VDD vin vout VSS
*.PININFO vin:I VDD:B VSS:B vout:B nwell:B psub:B
MM1 vout vin VSS psub sg13_lv_nmos w=10.0u l=1.0u ng=10
MM2 vout vin VDD nwell sg13_lv_pmos w=60.0u l=1.0u ng=10
MMdummy1 VSS VSS VSS psub sg13_lv_nmos w=2.0u l=1.0u ng=2
MMdummy2 VDD VDD VDD nwell sg13_lv_pmos w=12.0u l=1.0u ng=2
RR1 VDD nwell ntap1 A=1.578e-11 P=0.0001052
RR2 VSS psub ptap1 A=1.2996e-11 P=8.664e-05
.ends
