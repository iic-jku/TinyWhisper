** sch_path: /foss/designs/TinyWhisper/ihp130/macros/iqmod/xschem/iqmod_mfb_lpf_ota_core_spdt_switch_tg.sch
.subckt iqmod_mfb_lpf_ota_core_spdt_switch_tg nwell psub VDD di_tg_ctrl VSS v_b v_a di_tg_ctrl_n
*.PININFO v_a:B v_b:B VDD:B VSS:B di_tg_ctrl:I di_tg_ctrl_n:I nwell:B psub:B
MM2 v_a di_tg_ctrl_n v_b nwell sg13_lv_pmos w=36.0u l=0.13u ng=6
MM1 v_a di_tg_ctrl v_b psub sg13_lv_nmos w=6.0u l=0.13u ng=6
RR1 VDD nwell ntap1 A=7.68e-12 P=5.12e-05
RR2 VSS psub ptap1 A=4.896e-12 P=3.264e-05
.ends
