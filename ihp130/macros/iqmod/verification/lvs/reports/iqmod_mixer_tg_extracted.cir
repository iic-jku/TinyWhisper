* Extracted by KLayout with SG13G2 LVS runset on : 28/03/2026 19:06

.SUBCKT iqmod_mixer_tg VSS v_a di_tg_ctrl v_b di_tg_ctrl_n VDD
M$1 v_b di_tg_ctrl v_a \$1 sg13_lv_nmos L=0.13u W=108u AS=20.97p AD=20.52p
+ PS=124.98u PD=121.68u rfmode=0
M$37 v_b di_tg_ctrl_n v_b \$1 sg13_lv_nmos L=0.13u W=54u AS=10.26p AD=10.71p
+ PS=60.84u PD=64.14u rfmode=0
R$55 VSS \$1 ptap1 A=20.784p P=138.56u
M$56 v_b di_tg_ctrl_n v_a \$I241 sg13_lv_pmos L=0.13u W=324u AS=62.91p
+ AD=61.56p PS=346.98u PD=337.68u rfmode=0
M$92 v_b di_tg_ctrl v_b \$I241 sg13_lv_pmos L=0.13u W=162u AS=30.78p AD=32.13p
+ PS=168.84u PD=178.14u rfmode=0
R$110 VDD \$I241 ntap1 A=24.168p P=161.12u
.ENDS iqmod_mixer_tg
