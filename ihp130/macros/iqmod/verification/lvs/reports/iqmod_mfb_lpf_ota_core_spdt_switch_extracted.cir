* Extracted by KLayout with SG13G2 LVS runset on : 27/03/2026 23:40

.SUBCKT iqmod_mfb_lpf_ota_core_spdt_switch VSS
+ di_tg_ctrl|di_tg_ctrl_n|do_spdt_ctrl_n|vin|vout di_tg_ctrl|di_tg_ctrl_n|vout
+ v_a v_a|v_b v_b|v_c di_spdt_ctrl|vin VDD
M$1 VSS VSS VSS \$1 sg13_lv_nmos L=0.13u W=4u AS=1.06p AD=1.06p PS=8.12u
+ PD=8.12u rfmode=0
M$2 VSS di_spdt_ctrl|vin di_tg_ctrl|di_tg_ctrl_n|do_spdt_ctrl_n|vin|vout \$1
+ sg13_lv_nmos L=0.13u W=2u AS=0.38p AD=0.38p PS=2.76u PD=2.76u rfmode=0
M$6 VSS di_tg_ctrl|di_tg_ctrl_n|do_spdt_ctrl_n|vin|vout
+ di_tg_ctrl|di_tg_ctrl_n|vout \$1 sg13_lv_nmos L=0.13u W=2u AS=0.38p AD=0.38p
+ PS=2.76u PD=2.76u rfmode=0
M$9 v_a di_tg_ctrl|di_tg_ctrl_n|vout v_b|v_c \$1 sg13_lv_nmos L=0.13u W=6u
+ AS=1.29p AD=1.29p PS=9.58u PD=9.58u rfmode=0
M$15 v_a|v_b di_tg_ctrl|di_tg_ctrl_n|do_spdt_ctrl_n|vin|vout v_b|v_c \$1
+ sg13_lv_nmos L=0.13u W=6u AS=1.29p AD=1.29p PS=9.58u PD=9.58u rfmode=0
M$21 VDD VDD VDD \$17 sg13_lv_pmos L=0.13u W=24u AS=6.36p AD=6.36p PS=38.12u
+ PD=38.12u rfmode=0
M$22 VDD di_spdt_ctrl|vin di_tg_ctrl|di_tg_ctrl_n|do_spdt_ctrl_n|vin|vout \$17
+ sg13_lv_pmos L=0.13u W=12u AS=2.28p AD=2.28p PS=12.76u PD=12.76u rfmode=0
M$26 VDD di_tg_ctrl|di_tg_ctrl_n|do_spdt_ctrl_n|vin|vout
+ di_tg_ctrl|di_tg_ctrl_n|vout \$17 sg13_lv_pmos L=0.13u W=12u AS=2.28p
+ AD=2.28p PS=12.76u PD=12.76u rfmode=0
M$29 v_a di_tg_ctrl|di_tg_ctrl_n|do_spdt_ctrl_n|vin|vout v_b|v_c \$17
+ sg13_lv_pmos L=0.13u W=36u AS=7.74p AD=7.74p PS=44.58u PD=44.58u rfmode=0
M$35 v_a|v_b di_tg_ctrl|di_tg_ctrl_n|vout v_b|v_c \$17 sg13_lv_pmos L=0.13u
+ W=36u AS=7.74p AD=7.74p PS=44.58u PD=44.58u rfmode=0
R$41 VDD \$17 ntap1 A=22.278p P=146.72u
R$42 VSS \$1 ptap1 A=15.318p P=100.32u
.ENDS iqmod_mfb_lpf_ota_core_spdt_switch
