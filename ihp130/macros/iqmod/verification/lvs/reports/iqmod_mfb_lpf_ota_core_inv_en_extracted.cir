* Extracted by KLayout with SG13G2 LVS runset on : 23/03/2026 22:56

.SUBCKT iqmod_mfb_lpf_ota_core_inv_en VSS vout vin VDD
M$1 VSS VSS VSS \$1 sg13_lv_nmos L=0.13u W=2u AS=0.53p AD=0.53p PS=4.06u
+ PD=4.06u rfmode=0
M$2 VSS vin vout \$1 sg13_lv_nmos L=0.13u W=2u AS=0.38p AD=0.38p PS=2.76u
+ PD=2.76u rfmode=0
M$5 VDD VDD VDD \$7 sg13_lv_pmos L=0.13u W=12u AS=3.18p AD=3.18p PS=19.06u
+ PD=19.06u rfmode=0
M$6 VDD vin vout \$7 sg13_lv_pmos L=0.13u W=12u AS=2.28p AD=2.28p PS=12.76u
+ PD=12.76u rfmode=0
R$9 VDD \$7 ntap1 A=7.068p P=47.12u
R$10 VSS \$1 ptap1 A=4.284p P=28.56u
.ENDS iqmod_mfb_lpf_ota_core_inv_en
