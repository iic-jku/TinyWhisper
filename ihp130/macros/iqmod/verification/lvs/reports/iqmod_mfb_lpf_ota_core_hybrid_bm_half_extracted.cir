* Extracted by KLayout with SG13G2 LVS runset on : 28/03/2026 01:46

.SUBCKT iqmod_mfb_lpf_ota_core_hybrid_bm_half VSS
+ di_tg_ctrl|di_tg_ctrl_n|do_spdt_ctrl_n|vin|vout di_tg_ctrl|di_tg_ctrl_n|vout
+ v_a|vinp v_b|v_c|vin di_ota_en|di_spdt_ctrl|di_tg_ctrl|vin v_a|vin|vout
+ vin|vout|voutp v_a|vin|vout$1 v_b|vin|vout v_b|vin|vout$1 VDD|v_a|v_b
M$1 VSS VSS VSS \$1 sg13_lv_nmos L=0.13u W=4u AS=1.06p AD=1.06p PS=8.12u
+ PD=8.12u rfmode=0
M$2 VSS di_ota_en|di_spdt_ctrl|di_tg_ctrl|vin
+ di_tg_ctrl|di_tg_ctrl_n|do_spdt_ctrl_n|vin|vout \$1 sg13_lv_nmos L=0.13u W=2u
+ AS=0.38p AD=0.38p PS=2.76u PD=2.76u rfmode=0
M$6 VSS di_tg_ctrl|di_tg_ctrl_n|do_spdt_ctrl_n|vin|vout
+ di_tg_ctrl|di_tg_ctrl_n|vout \$1 sg13_lv_nmos L=0.13u W=2u AS=0.38p AD=0.38p
+ PS=2.76u PD=2.76u rfmode=0
M$9 v_a|vinp di_tg_ctrl|di_tg_ctrl_n|vout v_b|v_c|vin \$1 sg13_lv_nmos L=0.13u
+ W=6u AS=1.29p AD=1.29p PS=9.58u PD=9.58u rfmode=0
M$15 VDD|v_a|v_b di_tg_ctrl|di_tg_ctrl_n|do_spdt_ctrl_n|vin|vout v_b|v_c|vin
+ \$1 sg13_lv_nmos L=0.13u W=6u AS=1.29p AD=1.29p PS=9.58u PD=9.58u rfmode=0
M$21 VSS VSS VSS \$1 sg13_lv_nmos L=1u W=14u AS=3.71p AD=3.71p PS=28.42u
+ PD=28.42u rfmode=0
M$22 VSS v_b|v_c|vin v_a|vin|vout \$1 sg13_lv_nmos L=1u W=10u AS=1.9p AD=1.9p
+ PS=13.8u PD=13.8u rfmode=0
M$33 v_a|vin|vout di_ota_en|di_spdt_ctrl|di_tg_ctrl|vin v_b|vin|vout \$1
+ sg13_lv_nmos L=0.13u W=6u AS=1.29p AD=1.29p PS=9.58u PD=9.58u rfmode=0
M$40 VSS v_a|vin|vout v_b|vin|vout \$1 sg13_lv_nmos L=1u W=6u AS=1.14p AD=1.14p
+ PS=8.28u PD=8.28u rfmode=0
M$48 VSS v_b|v_c|vin vin|vout|voutp \$1 sg13_lv_nmos L=1u W=20u AS=3.8p AD=3.8p
+ PS=27.6u PD=27.6u rfmode=0
M$70 VSS v_b|vin|vout vin|vout|voutp \$1 sg13_lv_nmos L=1u W=20u AS=3.8p
+ AD=3.8p PS=27.6u PD=27.6u rfmode=0
M$92 VSS v_b|vin|vout$1 v_b|vin|vout \$1 sg13_lv_nmos L=1u W=6u AS=1.14p
+ AD=1.14p PS=8.28u PD=8.28u rfmode=0
M$100 VSS v_a|vin|vout$1 v_b|vin|vout$1 \$1 sg13_lv_nmos L=1u W=6u AS=1.14p
+ AD=1.14p PS=8.28u PD=8.28u rfmode=0
M$107 v_a|vin|vout$1 di_ota_en|di_spdt_ctrl|di_tg_ctrl|vin v_b|vin|vout$1 \$1
+ sg13_lv_nmos L=0.13u W=6u AS=1.29p AD=1.29p PS=9.58u PD=9.58u rfmode=0
M$114 VSS vin|vout|voutp v_a|vin|vout$1 \$1 sg13_lv_nmos L=1u W=20u AS=3.8p
+ AD=3.8p PS=27.6u PD=27.6u rfmode=0
M$135 VDD|v_a|v_b VDD|v_a|v_b VDD|v_a|v_b \$39 sg13_lv_pmos L=0.13u W=24u
+ AS=6.36p AD=6.36p PS=38.12u PD=38.12u rfmode=0
M$136 VDD|v_a|v_b di_ota_en|di_spdt_ctrl|di_tg_ctrl|vin
+ di_tg_ctrl|di_tg_ctrl_n|do_spdt_ctrl_n|vin|vout \$39 sg13_lv_pmos L=0.13u
+ W=12u AS=2.28p AD=2.28p PS=12.76u PD=12.76u rfmode=0
M$140 VDD|v_a|v_b di_tg_ctrl|di_tg_ctrl_n|do_spdt_ctrl_n|vin|vout
+ di_tg_ctrl|di_tg_ctrl_n|vout \$39 sg13_lv_pmos L=0.13u W=12u AS=2.28p
+ AD=2.28p PS=12.76u PD=12.76u rfmode=0
M$143 v_a|vinp di_tg_ctrl|di_tg_ctrl_n|do_spdt_ctrl_n|vin|vout v_b|v_c|vin \$39
+ sg13_lv_pmos L=0.13u W=36u AS=7.74p AD=7.74p PS=44.58u PD=44.58u rfmode=0
M$149 VDD|v_a|v_b di_tg_ctrl|di_tg_ctrl_n|vout v_b|v_c|vin \$39 sg13_lv_pmos
+ L=0.13u W=36u AS=7.74p AD=7.74p PS=44.58u PD=44.58u rfmode=0
M$155 VDD|v_a|v_b VDD|v_a|v_b VDD|v_a|v_b \$39 sg13_lv_pmos L=1u W=84u
+ AS=22.26p AD=22.26p PS=133.42u PD=133.42u rfmode=0
M$156 VDD|v_a|v_b v_b|v_c|vin v_a|vin|vout \$39 sg13_lv_pmos L=1u W=60u
+ AS=11.4p AD=11.4p PS=63.8u PD=63.8u rfmode=0
M$167 v_a|vin|vout di_tg_ctrl|di_tg_ctrl_n|do_spdt_ctrl_n|vin|vout v_b|vin|vout
+ \$39 sg13_lv_pmos L=0.13u W=36u AS=7.74p AD=7.74p PS=44.58u PD=44.58u rfmode=0
M$174 VDD|v_a|v_b v_a|vin|vout v_b|vin|vout \$39 sg13_lv_pmos L=1u W=36u
+ AS=6.84p AD=6.84p PS=38.28u PD=38.28u rfmode=0
M$182 VDD|v_a|v_b v_b|v_c|vin vin|vout|voutp \$39 sg13_lv_pmos L=1u W=120u
+ AS=22.8p AD=22.8p PS=127.6u PD=127.6u rfmode=0
M$204 VDD|v_a|v_b v_b|vin|vout vin|vout|voutp \$39 sg13_lv_pmos L=1u W=120u
+ AS=22.8p AD=22.8p PS=127.6u PD=127.6u rfmode=0
M$226 VDD|v_a|v_b v_b|vin|vout$1 v_b|vin|vout \$39 sg13_lv_pmos L=1u W=36u
+ AS=6.84p AD=6.84p PS=38.28u PD=38.28u rfmode=0
M$234 VDD|v_a|v_b v_a|vin|vout$1 v_b|vin|vout$1 \$39 sg13_lv_pmos L=1u W=36u
+ AS=6.84p AD=6.84p PS=38.28u PD=38.28u rfmode=0
M$241 v_a|vin|vout$1 di_tg_ctrl|di_tg_ctrl_n|do_spdt_ctrl_n|vin|vout
+ v_b|vin|vout$1 \$39 sg13_lv_pmos L=0.13u W=36u AS=7.74p AD=7.74p PS=44.58u
+ PD=44.58u rfmode=0
M$248 VDD|v_a|v_b vin|vout|voutp v_a|vin|vout$1 \$39 sg13_lv_pmos L=1u W=120u
+ AS=22.8p AD=22.8p PS=127.6u PD=127.6u rfmode=0
R$269 VDD|v_a|v_b \$39 ntap1 A=143.754p P=951.76u
R$271 VSS \$1 ptap1 A=122.874p P=812.56u
.ENDS iqmod_mfb_lpf_ota_core_hybrid_bm_half
