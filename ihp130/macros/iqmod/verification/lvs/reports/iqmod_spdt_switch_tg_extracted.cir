* Extracted by KLayout with SG13G2 LVS runset on : 29/03/2026 01:59

.SUBCKT iqmod_spdt_switch_tg VDD VSS di_tg_ctrl_n v_a di_tg_ctrl v_b
M$1 v_a di_tg_ctrl v_b \$7 sg13_lv_nmos L=0.13u W=6u AS=1.29p AD=1.29p PS=9.58u
+ PD=9.58u rfmode=0
R$7 VSS \$7 ptap1 A=4.896p P=32.64u
M$8 v_a di_tg_ctrl_n v_b \$I32 sg13_lv_pmos L=0.13u W=36u AS=7.74p AD=7.74p
+ PS=44.58u PD=44.58u rfmode=0
R$14 VDD \$I32 ntap1 A=7.68p P=51.2u
.ENDS iqmod_spdt_switch_tg
