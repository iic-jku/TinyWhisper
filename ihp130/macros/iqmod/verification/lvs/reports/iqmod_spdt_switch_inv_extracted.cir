* Extracted by KLayout with SG13G2 LVS runset on : 29/03/2026 01:59

.SUBCKT iqmod_spdt_switch_inv VDD vin vout VSS
M$1 VDD VDD VDD \$I30 sg13_lv_pmos L=0.13u W=12u AS=3.18p AD=3.18p PS=19.06u
+ PD=19.06u rfmode=0
M$2 VDD vin vout \$I30 sg13_lv_pmos L=0.13u W=12u AS=2.28p AD=2.28p PS=12.76u
+ PD=12.76u rfmode=0
R$5 VDD \$I30 ntap1 A=7.068p P=47.12u
M$6 VSS VSS VSS \$4 sg13_lv_nmos L=0.13u W=2u AS=0.53p AD=0.53p PS=4.06u
+ PD=4.06u rfmode=0
M$7 VSS vin vout \$4 sg13_lv_nmos L=0.13u W=2u AS=0.38p AD=0.38p PS=2.76u
+ PD=2.76u rfmode=0
R$10 VSS \$4 ptap1 A=4.284p P=28.56u
.ENDS iqmod_spdt_switch_inv
