* Extracted by KLayout with SG13G2 LVS runset on : 28/03/2026 19:04

.SUBCKT iqmod_mixer_se2diff_inv_NF18 VSS vout VDD vin
M$1 VSS VSS VSS \$1 sg13_lv_nmos L=0.13u W=2u AS=0.53p AD=0.53p PS=4.06u
+ PD=4.06u rfmode=0
M$2 VSS vin vout \$1 sg13_lv_nmos L=0.13u W=18u AS=3.42p AD=3.42p PS=24.84u
+ PD=24.84u rfmode=0
R$21 VSS \$1 ptap1 A=9.18p P=61.2u
M$22 VDD VDD VDD \$I97 sg13_lv_pmos L=0.13u W=6u AS=1.59p AD=1.59p PS=10.06u
+ PD=10.06u rfmode=0
M$23 VDD vin vout \$I97 sg13_lv_pmos L=0.13u W=54u AS=10.26p AD=10.26p
+ PS=60.84u PD=60.84u rfmode=0
R$42 VDD \$I97 ntap1 A=10.164p P=67.76u
.ENDS iqmod_mixer_se2diff_inv_NF18
