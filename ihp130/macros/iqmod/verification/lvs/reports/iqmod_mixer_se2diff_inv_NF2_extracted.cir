* Extracted by KLayout with SG13G2 LVS runset on : 28/03/2026 19:03

.SUBCKT iqmod_mixer_se2diff_inv_NF2 vin vout VSS VDD
M$1 VDD VDD VDD \$I30 sg13_lv_pmos L=0.13u W=6u AS=1.59p AD=1.59p PS=10.06u
+ PD=10.06u rfmode=0
M$2 VDD vin vout \$I30 sg13_lv_pmos L=0.13u W=6u AS=1.14p AD=1.14p PS=6.76u
+ PD=6.76u rfmode=0
R$5 VDD \$I30 ntap1 A=5.268p P=35.12u
M$6 VSS VSS VSS \$3 sg13_lv_nmos L=0.13u W=2u AS=0.53p AD=0.53p PS=4.06u
+ PD=4.06u rfmode=0
M$7 VSS vin vout \$3 sg13_lv_nmos L=0.13u W=2u AS=0.38p AD=0.38p PS=2.76u
+ PD=2.76u rfmode=0
R$10 VSS \$3 ptap1 A=4.284p P=28.56u
.ENDS iqmod_mixer_se2diff_inv_NF2
