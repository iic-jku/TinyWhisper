* Extracted by KLayout with SG13G2 LVS runset on : 28/03/2026 19:04

.SUBCKT iqmod_mixer_se2diff_inv_NF54 VSS vout VDD vin
M$1 VSS VSS VSS \$1 sg13_lv_nmos L=0.13u W=2u AS=0.53p AD=0.53p PS=4.06u
+ PD=4.06u rfmode=0
M$2 VSS vin vout \$1 sg13_lv_nmos L=0.13u W=54u AS=10.26p AD=10.26p PS=74.52u
+ PD=74.52u rfmode=0
R$57 VSS \$1 ptap1 A=20.196p P=134.64u
M$58 VDD VDD VDD \$I241 sg13_lv_pmos L=0.13u W=6u AS=1.59p AD=1.59p PS=10.06u
+ PD=10.06u rfmode=0
M$59 VDD vin vout \$I241 sg13_lv_pmos L=0.13u W=162u AS=30.78p AD=30.78p
+ PS=182.52u PD=182.52u rfmode=0
R$114 VDD \$I241 ntap1 A=21.18p P=141.2u
.ENDS iqmod_mixer_se2diff_inv_NF54
