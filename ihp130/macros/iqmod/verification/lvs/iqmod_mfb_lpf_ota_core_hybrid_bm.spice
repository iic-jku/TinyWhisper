** sch_path: /foss/designs/TinyWhisper/ihp130/macros/iqmod/xschem/iqmod_mfb_lpf_ota_core_hybrid_bm.sch
.subckt iqmod_mfb_lpf_ota_core_hybrid_bm psub voutp voutn vinn vinp VDD VSS di_ota_en
*.PININFO vinp:I vinn:I VDD:B VSS:B voutp:O voutn:O di_ota_en:I psub:B
x6 nwell1 psub VDD node_CDG voutn VSS iqmod_mfb_lpf_ota_core_inv_NF20
x7 nwell2 psub VDD node_CDG voutp VSS iqmod_mfb_lpf_ota_core_inv_NF20
x11 nwell1 psub VDD voutn node_EF VSS iqmod_mfb_lpf_ota_core_inv_NF20
x12 nwell2 psub VDD voutp node_EF VSS iqmod_mfb_lpf_ota_core_inv_NF20
x9 nwell1 psub VDD node_vinp node_BC VSS iqmod_mfb_lpf_ota_core_inv_NF10
x10 nwell2 psub VDD node_vinn node_BC VSS iqmod_mfb_lpf_ota_core_inv_NF10
x5 nwell1 psub VDD node_EF node_FG VSS iqmod_mfb_lpf_ota_core_inv_NF6
x1 nwell1 psub VDD node_BC node_CDG VSS iqmod_mfb_lpf_ota_core_inv_NF6
x4 nwell2 psub VDD node_BC node_CDG VSS iqmod_mfb_lpf_ota_core_inv_NF6
x13 nwell2 psub VDD node_EF node_FG VSS iqmod_mfb_lpf_ota_core_inv_NF6
x8 nwell1 psub VDD node_FG node_CDG VSS iqmod_mfb_lpf_ota_core_inv_NF6
x14 nwell2 psub VDD node_FG node_CDG VSS iqmod_mfb_lpf_ota_core_inv_NF6
x2 nwell1 psub VDD node_vinp voutn VSS iqmod_mfb_lpf_ota_core_inv_NF20
x3 nwell2 psub VDD node_vinn voutp VSS iqmod_mfb_lpf_ota_core_inv_NF20
x16 ota_en_n_1 nwell1 psub VDD di_ota_en VSS node_vinp VDD vinp iqmod_mfb_lpf_ota_core_spdt_switch
x17 ota_en_n_2 nwell2 psub VDD di_ota_en VSS node_vinn VDD vinn iqmod_mfb_lpf_ota_core_spdt_switch
x15 nwell1 psub VDD di_ota_en VSS node_CDG node_BC ota_en_n_1 iqmod_mfb_lpf_ota_core_tg
x18 nwell1 psub VDD di_ota_en VSS node_FG node_EF ota_en_n_1 iqmod_mfb_lpf_ota_core_tg
x20 nwell2 psub VDD di_ota_en VSS node_CDG node_BC ota_en_n_2 iqmod_mfb_lpf_ota_core_tg
x23 nwell2 psub VDD di_ota_en VSS node_FG node_EF ota_en_n_2 iqmod_mfb_lpf_ota_core_tg
.ends

* expanding   symbol:  iqmod_mfb_lpf_ota_core_inv_NF20.sym # of pins=6
** sym_path: xschem/iqmod_mfb_lpf_ota_core_inv_NF20.sym
** sch_path: /foss/designs/TinyWhisper/ihp130/macros/iqmod/xschem/iqmod_mfb_lpf_ota_core_inv_NF20.sch
.subckt iqmod_mfb_lpf_ota_core_inv_NF20 nwell psub VDD vin vout VSS
*.PININFO vin:I VDD:B VSS:B vout:B nwell:B psub:B
MMdummy1 VSS VSS VSS psub sg13_lv_nmos w=2.0u l=1.0u ng=2
MMdummy2 VDD VDD VDD nwell sg13_lv_pmos w=12.0u l=1.0u ng=2
MM1 vout vin VSS psub sg13_lv_nmos w=20.0u l=1.0u ng=20
MM2 vout vin VDD nwell sg13_lv_pmos w=120.0u l=1.0u ng=20
RR1 VDD nwell ntap1 A=2.406e-11 P=0.0001604
RR2 VSS psub ptap1 A=2.1276e-11 P=0.00014184
.ends

* expanding   symbol:  iqmod_mfb_lpf_ota_core_inv_NF10.sym # of pins=6
** sym_path: xschem/iqmod_mfb_lpf_ota_core_inv_NF10.sym
** sch_path: /foss/designs/TinyWhisper/ihp130/macros/iqmod/xschem/iqmod_mfb_lpf_ota_core_inv_NF10.sch
.subckt iqmod_mfb_lpf_ota_core_inv_NF10 nwell psub VDD vin vout VSS
*.PININFO vin:I VDD:B VSS:B vout:B nwell:B psub:B
MM1 vout vin VSS psub sg13_lv_nmos w=10.0u l=1.0u ng=10
MM2 vout vin VDD nwell sg13_lv_pmos w=60.0u l=1.0u ng=10
MMdummy1 VSS VSS VSS psub sg13_lv_nmos w=2.0u l=1.0u ng=2
MMdummy2 VDD VDD VDD nwell sg13_lv_pmos w=12.0u l=1.0u ng=2
RR1 VDD nwell ntap1 A=1.578e-11 P=0.0001052
RR2 VSS psub ptap1 A=1.2996e-11 P=8.664e-05
.ends

* expanding   symbol:  iqmod_mfb_lpf_ota_core_inv_NF6.sym # of pins=6
** sym_path: xschem/iqmod_mfb_lpf_ota_core_inv_NF6.sym
** sch_path: /foss/designs/TinyWhisper/ihp130/macros/iqmod/xschem/iqmod_mfb_lpf_ota_core_inv_NF6.sch
.subckt iqmod_mfb_lpf_ota_core_inv_NF6 nwell psub VDD vin vout VSS
*.PININFO vin:I VDD:B VSS:B vout:B nwell:B psub:B
MMdummy1 VSS VSS VSS psub sg13_lv_nmos w=2.0u l=1.0u ng=2
MMdummy2 VDD VDD VDD nwell sg13_lv_pmos w=12.0u l=1.0u ng=2
MM1 vout vin VSS psub sg13_lv_nmos w=6.0u l=1.0u ng=6
MM2 vout vin VDD nwell sg13_lv_pmos w=36.0u l=1.0u ng=6
RR1 VDD nwell ntap1 A=1.2468e-11 P=8.312e-05
RR2 VSS psub ptap1 A=9.684e-12 P=6.456e-05
.ends

* expanding   symbol:  iqmod_mfb_lpf_ota_core_spdt_switch.sym # of pins=9
** sym_path: xschem/iqmod_mfb_lpf_ota_core_spdt_switch.sym
** sch_path: /foss/designs/TinyWhisper/ihp130/macros/iqmod/xschem/iqmod_mfb_lpf_ota_core_spdt_switch.sch
.subckt iqmod_mfb_lpf_ota_core_spdt_switch do_spdt_ctrl_n nwell psub VDD di_spdt_ctrl VSS v_c v_b v_a
*.PININFO v_a:B v_b:B v_c:B VDD:B VSS:B di_spdt_ctrl:I do_spdt_ctrl_n:O nwell:B psub:B
x1 nwell psub VDD di_spdt_ctrl do_spdt_ctrl_n VSS iqmod_mfb_lpf_ota_core_spdt_switch_inv
x2 nwell psub VDD do_spdt_ctrl_n spdt_ctrl_buf VSS iqmod_mfb_lpf_ota_core_spdt_switch_inv
x3 nwell psub VDD spdt_ctrl_buf VSS v_c v_a do_spdt_ctrl_n iqmod_mfb_lpf_ota_core_spdt_switch_tg
x4 nwell psub VDD do_spdt_ctrl_n VSS v_c v_b spdt_ctrl_buf iqmod_mfb_lpf_ota_core_spdt_switch_tg
.ends

* expanding   symbol:  iqmod_mfb_lpf_ota_core_tg.sym # of pins=8
** sym_path: xschem/iqmod_mfb_lpf_ota_core_tg.sym
** sch_path: /foss/designs/TinyWhisper/ihp130/macros/iqmod/xschem/iqmod_mfb_lpf_ota_core_tg.sch
.subckt iqmod_mfb_lpf_ota_core_tg nwell psub VDD di_tg_ctrl VSS v_b v_a di_tg_ctrl_n
*.PININFO v_a:B v_b:B VDD:B VSS:B di_tg_ctrl:I di_tg_ctrl_n:I nwell:B psub:B
MM2 v_a di_tg_ctrl_n v_b nwell sg13_lv_pmos w=36.0u l=0.13u ng=6
MM1 v_a di_tg_ctrl v_b psub sg13_lv_nmos w=6.0u l=0.13u ng=6
RR1 VDD nwell ntap1 A=7.68e-12 P=5.12e-05
RR2 VSS psub ptap1 A=4.896e-12 P=3.264e-05
.ends

* expanding   symbol:  iqmod_mfb_lpf_ota_core_spdt_switch_inv.sym # of pins=6
** sym_path: xschem/iqmod_mfb_lpf_ota_core_spdt_switch_inv.sym
** sch_path: /foss/designs/TinyWhisper/ihp130/macros/iqmod/xschem/iqmod_mfb_lpf_ota_core_spdt_switch_inv.sch
.subckt iqmod_mfb_lpf_ota_core_spdt_switch_inv nwell psub VDD vin vout VSS
*.PININFO vin:I VDD:B VSS:B vout:B nwell:B psub:B
MM1 vout vin VSS psub sg13_lv_nmos w=2.0u l=0.13u ng=2
MM2 vout vin VDD nwell sg13_lv_pmos w=12.0u l=0.13u ng=2
MMdummy1 VSS VSS VSS psub sg13_lv_nmos w=2.0u l=0.13u ng=2
MMdummy2 VDD VDD VDD nwell sg13_lv_pmos w=12.0u l=0.13u ng=2
RR1 VDD nwell ntap1 A=7.068e-12 P=4.712e-05
RR2 VSS psub ptap1 A=4.284e-12 P=2.856e-05
.ends

* expanding   symbol:  iqmod_mfb_lpf_ota_core_spdt_switch_tg.sym # of pins=8
** sym_path: xschem/iqmod_mfb_lpf_ota_core_spdt_switch_tg.sym
** sch_path: /foss/designs/TinyWhisper/ihp130/macros/iqmod/xschem/iqmod_mfb_lpf_ota_core_spdt_switch_tg.sch
.subckt iqmod_mfb_lpf_ota_core_spdt_switch_tg nwell psub VDD di_tg_ctrl VSS v_b v_a di_tg_ctrl_n
*.PININFO v_a:B v_b:B VDD:B VSS:B di_tg_ctrl:I di_tg_ctrl_n:I nwell:B psub:B
MM2 v_a di_tg_ctrl_n v_b nwell sg13_lv_pmos w=36.0u l=0.13u ng=6
MM1 v_a di_tg_ctrl v_b psub sg13_lv_nmos w=6.0u l=0.13u ng=6
RR1 VDD nwell ntap1 A=7.68e-12 P=5.12e-05
RR2 VSS psub ptap1 A=4.896e-12 P=3.264e-05
.ends
