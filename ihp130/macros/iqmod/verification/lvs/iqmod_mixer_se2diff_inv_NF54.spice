** sch_path: /foss/designs/TinyWhisper/ihp130/macros/iqmod/xschem/iqmod_mixer_se2diff_inv_NF54.sch
.subckt iqmod_mixer_se2diff_inv_NF54 nwell psub VDD vin vout VSS
*.PININFO vin:I VDD:B VSS:B vout:B nwell:B psub:B
MM1 vout vin VSS psub sg13_lv_nmos w=54.0u l=0.13u ng=54
MM2 vout vin VDD nwell sg13_lv_pmos w=162.0u l=0.13u ng=54
MMdummy1 VSS VSS VSS psub sg13_lv_nmos w=2.0u l=0.13u ng=2
MMdummy2 VDD VDD VDD nwell sg13_lv_pmos w=6.0u l=0.13u ng=2
RR1 VDD nwell ntap1 A=2.118e-11 P=0.0001412
RR2 VSS psub ptap1 A=2.0196e-11 P=0.00013464
.ends
