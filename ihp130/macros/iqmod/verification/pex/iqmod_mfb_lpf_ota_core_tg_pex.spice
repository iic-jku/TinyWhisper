* PEX produced on Fri Mar 27 05:47:21 PM CET 2026 using /foss/tools/sak/sak-pex.sh with m=2 and s=1
* NGSPICE file created from iqmod_mfb_lpf_ota_core_tg_pex.ext - technology: ihp-sg13g2

.subckt iqmod_mfb_lpf_ota_core_tg_pex VDD VSS v_a di_tg_ctrl di_tg_ctrl_n v_b
X0 v_a di_tg_ctrl_n v_b VDD sg13_lv_pmos ad=1.14p pd=6.38u as=1.14p ps=6.38u w=6u l=0.13u
X1 v_b di_tg_ctrl_n v_a VDD sg13_lv_pmos ad=1.14p pd=6.38u as=1.14p ps=6.38u w=6u l=0.13u
X2 v_a di_tg_ctrl_n v_b VDD sg13_lv_pmos ad=2.04p pd=12.68u as=1.14p ps=6.38u w=6u l=0.13u
X3 v_b di_tg_ctrl v_a VSS sg13_lv_nmos ad=0.19p pd=1.38u as=0.34p ps=2.68u w=1u l=0.13u
X4 v_a di_tg_ctrl v_b VSS sg13_lv_nmos ad=0.19p pd=1.38u as=0.19p ps=1.38u w=1u l=0.13u
X5 v_a di_tg_ctrl_n v_b VDD sg13_lv_pmos ad=1.14p pd=6.38u as=1.14p ps=6.38u w=6u l=0.13u
X6 v_b di_tg_ctrl v_a VSS sg13_lv_nmos ad=0.19p pd=1.38u as=0.19p ps=1.38u w=1u l=0.13u
X7 v_a di_tg_ctrl v_b VSS sg13_lv_nmos ad=0.19p pd=1.38u as=0.19p ps=1.38u w=1u l=0.13u
X8 v_b di_tg_ctrl v_a VSS sg13_lv_nmos ad=0.19p pd=1.38u as=0.19p ps=1.38u w=1u l=0.13u
X9 v_a di_tg_ctrl v_b VSS sg13_lv_nmos ad=0.34p pd=2.68u as=0.19p ps=1.38u w=1u l=0.13u
X10 v_b di_tg_ctrl_n v_a VDD sg13_lv_pmos ad=1.14p pd=6.38u as=2.04p ps=12.68u w=6u l=0.13u
X11 v_b di_tg_ctrl_n v_a VDD sg13_lv_pmos ad=1.14p pd=6.38u as=1.14p ps=6.38u w=6u l=0.13u
C0 di_tg_ctrl_n v_a 0.61724f
C1 v_b di_tg_ctrl_n 0.66709f
C2 di_tg_ctrl VDD 0.01086f
C3 VDD v_a 1.17719f
C4 di_tg_ctrl v_a 0.38701f
C5 v_b VDD 0.28563f
C6 v_b di_tg_ctrl 0.35979f
C7 v_b v_a 12.7114f
C8 di_tg_ctrl_n VDD 1.68862f
C9 di_tg_ctrl VSS 1.1384f
C10 v_b VSS 0.68647f
C11 v_a VSS 1.00456f
C12 di_tg_ctrl_n VSS 0.07591f
C13 VDD VSS 1.56645f
.ends
