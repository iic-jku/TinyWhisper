* PEX produced on Sat Mar 28 07:02:56 PM CET 2026 using /foss/tools/sak/sak-pex.sh with m=1 and s=1
* NGSPICE file created from iqmod_mixer_se2diff_tg_NF6_pex.ext - technology: ihp-sg13g2

.subckt iqmod_mixer_se2diff_tg_NF6_pex VDD VSS v_a di_tg_ctrl di_tg_ctrl_n v_b
X0 v_a di_tg_ctrl_n v_b VDD sg13_lv_pmos ad=0.57p pd=3.38u as=0.57p ps=3.38u w=3u l=0.13u
X1 v_b di_tg_ctrl_n v_a VDD sg13_lv_pmos ad=0.57p pd=3.38u as=0.57p ps=3.38u w=3u l=0.13u
X2 v_a di_tg_ctrl_n v_b VDD sg13_lv_pmos ad=1.02p pd=6.68u as=0.57p ps=3.38u w=3u l=0.13u
X3 v_b di_tg_ctrl v_a VSS sg13_lv_nmos ad=0.19p pd=1.38u as=0.34p ps=2.68u w=1u l=0.13u
X4 v_a di_tg_ctrl v_b VSS sg13_lv_nmos ad=0.19p pd=1.38u as=0.19p ps=1.38u w=1u l=0.13u
X5 v_a di_tg_ctrl_n v_b VDD sg13_lv_pmos ad=0.57p pd=3.38u as=0.57p ps=3.38u w=3u l=0.13u
X6 v_b di_tg_ctrl v_a VSS sg13_lv_nmos ad=0.19p pd=1.38u as=0.19p ps=1.38u w=1u l=0.13u
X7 v_a di_tg_ctrl v_b VSS sg13_lv_nmos ad=0.19p pd=1.38u as=0.19p ps=1.38u w=1u l=0.13u
X8 v_b di_tg_ctrl v_a VSS sg13_lv_nmos ad=0.19p pd=1.38u as=0.19p ps=1.38u w=1u l=0.13u
X9 v_a di_tg_ctrl v_b VSS sg13_lv_nmos ad=0.34p pd=2.68u as=0.19p ps=1.38u w=1u l=0.13u
X10 v_b di_tg_ctrl_n v_a VDD sg13_lv_pmos ad=0.57p pd=3.38u as=1.02p ps=6.68u w=3u l=0.13u
X11 v_b di_tg_ctrl_n v_a VDD sg13_lv_pmos ad=0.57p pd=3.38u as=0.57p ps=3.38u w=3u l=0.13u
C0 di_tg_ctrl VSS 1.15626f
C1 v_b VSS 3.61223f
C2 v_a VSS 3.65942f
C3 di_tg_ctrl_n VSS 1.29265f
C4 VDD VSS 3.03158f
.ends
