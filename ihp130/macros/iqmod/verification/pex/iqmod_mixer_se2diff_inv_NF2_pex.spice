* PEX produced on Sat Mar 28 07:03:30 PM CET 2026 using /foss/tools/sak/sak-pex.sh with m=1 and s=1
* NGSPICE file created from iqmod_mixer_se2diff_inv_NF2_pex.ext - technology: ihp-sg13g2

.subckt iqmod_mixer_se2diff_inv_NF2_pex vin VDD VSS vout
X0 vout vin VDD VDD sg13_lv_pmos ad=0.57p pd=3.38u as=0.57p ps=3.38u w=3u l=0.13u
X1 VDD vin vout VDD sg13_lv_pmos ad=0.57p pd=3.38u as=0.57p ps=3.38u w=3u l=0.13u
X2 VSS VSS VSS VSS sg13_lv_nmos ad=0.34p pd=2.68u as=14.2195p ps=30.56u w=1u l=0.13u
X3 vout vin VSS VSS sg13_lv_nmos ad=0.19p pd=1.38u as=0.19p ps=1.38u w=1u l=0.13u
X4 VDD VDD VDD VDD sg13_lv_pmos ad=0.57p pd=3.38u as=20.5725p ps=37.12u w=3u l=0.13u
X5 VSS vin vout VSS sg13_lv_nmos ad=0.19p pd=1.38u as=0.19p ps=1.38u w=1u l=0.13u
X6 VSS VSS VSS VSS sg13_lv_nmos ad=0.19p pd=1.38u as=0 ps=0 w=1u l=0.13u
X7 VDD VDD VDD VDD sg13_lv_pmos ad=1.02p pd=6.68u as=0 ps=0 w=3u l=0.13u
C0 vout VSS 1.21998f
C1 vin VSS 0.89165f
C2 VDD VSS 4.11053f
.ends
