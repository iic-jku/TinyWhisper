* PEX produced on Sun Mar 29 05:08:21 PM CEST 2026 using /foss/tools/sak/sak-pex.sh with m=2 and s=1
* NGSPICE file created from iqmod_top_half_pex.ext - technology: ihp-sg13g2

.subckt iqmod_top_half_pex di_spdt_ctrl_I voutn_I_RF voutp_I_RF VSS VDD di_lo_I di_lo_Ix
+ di_ds_I_n vinn_I vinp_I di_ds_I_p di_analog_en
X0 iqmod_mixer_0.iqmod_mixer_half_0.iqmod_mixer_se2diff$1_0.iqmod_mixer_se2diff_half_inv$2_0.iqmod_mixer_se2diff_inv_NF2$7_1.vout iqmod_mixer_0.iqmod_mixer_half_0.iqmod_mixer_se2diff$1_0.iqmod_mixer_se2diff_half_tg$2_0.iqmod_mixer_se2diff_tg_NF6$3_0.v_b VSS VSS sg13_lv_nmos ad=0.19p pd=1.38u as=0.19p ps=1.38u w=1u l=0.13u
X1 iqmod_mixer_0.iqmod_mixer_half_1.iqmod_mixer_se2diff$1_0.iqmod_mixer_se2diff_half_tg$2_0.iqmod_mixer_se2diff_tg_NF6$3_0.v_b VDD iqmod_mixer_0.iqmod_mixer_half_1.iqmod_mixer_se2diff$1_0.iqmod_mixer_se2diff_half_inv$2_0.iqmod_mixer_se2diff_inv_NF6$7_0.vin VSS sg13_lv_nmos ad=0.19p pd=1.38u as=0.19p ps=1.38u w=1u l=0.13u
X2 VSS iqmod_mixer_0.iqmod_mixer_half_0.iqmod_mixer_se2diff$1_0.iqmod_mixer_se2diff_half_inv$2_0.iqmod_mixer_se2diff_inv_NF6$7_1.vin iqmod_mixer_0.iqmod_mixer_half_0.iqmod_mixer_se2diff$1_0.iqmod_mixer_se2diff_half_inv$2_0.iqmod_mixer_se2diff_inv_NF18$7_0.vin VSS sg13_lv_nmos ad=0.19p pd=1.38u as=0.19p ps=1.38u w=1u l=0.13u
X3 VDD iqmod_mixer_0.iqmod_mixer_half_0.iqmod_mixer_se2diff$1_0.iqmod_mixer_se2diff_half_inv$2_0.iqmod_mixer_se2diff_inv_NF54$7_0.vin iqmod_mixer_0.iqmod_mixer_half_0.iqmod_mixer_tg$1_0.di_tg_ctrl VDD sg13_lv_pmos ad=0.57p pd=3.38u as=0.57p ps=3.38u w=3u l=0.13u
X4 iqmod_mixer_0.vinn_IF iqmod_mfb_lpf_0.iqmod_mfb_lpf_half_0.iqmod_mfb_lpf_ota_core_hybrid_bm_half$1_0.iqmod_mfb_lpf_ota_core_tg$2_0.v_b VSS VSS sg13_lv_nmos ad=0.19p pd=1.38u as=0.19p ps=1.38u w=1u l=1u
X5 VDD iqmod_mfb_lpf_0.iqmod_mfb_lpf_half_0.iqmod_mfb_lpf_ota_core_hybrid_bm_half$1_0.iqmod_mfb_lpf_ota_core_tg$2_0.di_tg_ctrl_n iqmod_mfb_lpf_0.iqmod_mfb_lpf_half_0.iqmod_mfb_lpf_ota_core_hybrid_bm_half$1_0.iqmod_mfb_lpf_ota_core_inv_NF20$2_1.vin VSS sg13_lv_nmos ad=0.19p pd=1.38u as=0.19p ps=1.38u w=1u l=0.13u
X6 VSS VSS VSS VSS sg13_lv_nmos ad=0.34p pd=2.68u as=3.5775n ps=5.32783m w=1u l=0.13u
X7 VSS VSS VSS rhigh l=59u w=0.5u
X8 VDD iqmod_mixer_0.iqmod_mixer_half_0.iqmod_mixer_se2diff$1_0.iqmod_mixer_se2diff_half_inv$2_0.iqmod_mixer_se2diff_inv_NF2$7_1.vout iqmod_mixer_0.iqmod_mixer_half_0.iqmod_mixer_se2diff$1_0.iqmod_mixer_se2diff_half_tg$2_0.iqmod_mixer_se2diff_inv_NF18$6_0.vin VDD sg13_lv_pmos ad=0.57p pd=3.38u as=0.57p ps=3.38u w=3u l=0.13u
X9 iqmod_mixer_0.iqmod_mixer_half_0.iqmod_mixer_tg$1_0.di_tg_ctrl_n iqmod_mixer_0.iqmod_mixer_half_0.iqmod_mixer_se2diff$1_0.iqmod_mixer_se2diff_half_tg$2_0.iqmod_mixer_se2diff_inv_NF54$6_0.vin VDD VDD sg13_lv_pmos ad=0.57p pd=3.38u as=0.57p ps=3.38u w=3u l=0.13u
X10 iqmod_mfb_lpf_0.iqmod_mfb_lpf_half_0.iqmod_mfb_lpf_ota_core_hybrid_bm_half$1_0.iqmod_mfb_lpf_ota_core_inv_NF20$2_0.vout di_analog_en iqmod_mfb_lpf_0.iqmod_mfb_lpf_half_0.iqmod_mfb_lpf_ota_core_hybrid_bm_half$1_0.iqmod_mfb_lpf_ota_core_inv_NF6$2_1.vout VSS sg13_lv_nmos ad=0.34p pd=2.68u as=0.19p ps=1.38u w=1u l=0.13u
X11 iqmod_mixer_0.iqmod_mixer_half_1.iqmod_mixer_tg$1_0.di_tg_ctrl iqmod_mixer_0.iqmod_mixer_half_1.iqmod_mixer_se2diff$1_0.iqmod_mixer_se2diff_half_inv$2_0.iqmod_mixer_se2diff_inv_NF54$7_0.vin VSS VSS sg13_lv_nmos ad=0.19p pd=1.38u as=0.19p ps=1.38u w=1u l=0.13u
X12 VDD VDD VDD VDD sg13_lv_pmos ad=1.02p pd=6.68u as=2.74865n ps=6.46494m w=3u l=0.13u
X13 iqmod_mixer_0.iqmod_mixer_half_0.iqmod_mixer_tg$1_0.di_tg_ctrl iqmod_mixer_0.iqmod_mixer_half_0.iqmod_mixer_se2diff$1_0.iqmod_mixer_se2diff_half_inv$2_0.iqmod_mixer_se2diff_inv_NF54$7_0.vin VDD VDD sg13_lv_pmos ad=0.57p pd=3.38u as=0.57p ps=3.38u w=3u l=0.13u
X14 iqmod_mixer_0.iqmod_mixer_half_0.iqmod_mixer_se2diff$1_0.iqmod_mixer_se2diff_half_tg$2_0.iqmod_mixer_se2diff_inv_NF18$6_0.vin iqmod_mixer_0.iqmod_mixer_half_0.iqmod_mixer_se2diff$1_0.iqmod_mixer_se2diff_half_inv$2_0.iqmod_mixer_se2diff_inv_NF2$7_1.vout VDD VDD sg13_lv_pmos ad=0.57p pd=3.38u as=0.57p ps=3.38u w=3u l=0.13u
X15 iqmod_mfb_lpf_0.iqmod_mfb_lpf_half_0.iqmod_mfb_lpf_ota_core_hybrid_bm_half$1_0.iqmod_mfb_lpf_ota_core_inv_NF6$2_1.vout di_analog_en iqmod_mfb_lpf_0.iqmod_mfb_lpf_half_0.iqmod_mfb_lpf_ota_core_hybrid_bm_half$1_0.iqmod_mfb_lpf_ota_core_inv_NF20$2_0.vout VSS sg13_lv_nmos ad=0.19p pd=1.38u as=0.19p ps=1.38u w=1u l=0.13u
X16 VDD iqmod_mfb_lpf_0.iqmod_mfb_lpf_half_1.iqmod_mfb_lpf_ota_core_hybrid_bm_half$1_0.iqmod_mfb_lpf_ota_core_inv_NF20$2_1.vin iqmod_mixer_0.vinp_IF VDD sg13_lv_pmos ad=1.14p pd=6.38u as=1.14p ps=6.38u w=6u l=1u
X17 VSS VSS VSS rhigh l=27u w=0.5u
X18 VSS iqmod_mixer_0.iqmod_mixer_half_1.iqmod_mixer_se2diff$1_0.iqmod_mixer_se2diff_half_tg$2_0.iqmod_mixer_se2diff_inv_NF54$6_0.vin iqmod_mixer_0.iqmod_mixer_half_1.iqmod_mixer_tg$1_0.di_tg_ctrl_n VSS sg13_lv_nmos ad=0.19p pd=1.38u as=0.19p ps=1.38u w=1u l=0.13u
X19 iqmod_mfb_lpf_0.iqmod_mfb_lpf_half_0.iqmod_mfb_lpf_ota_core_hybrid_bm_half$1_0.iqmod_mfb_lpf_ota_core_inv_NF6$2_1.vout iqmod_mfb_lpf_0.iqmod_mfb_lpf_half_0.iqmod_mfb_lpf_ota_core_hybrid_bm_half$1_0.iqmod_mfb_lpf_ota_core_inv_NF20$2_0.vout VDD VDD sg13_lv_pmos ad=1.14p pd=6.38u as=1.14p ps=6.38u w=6u l=1u
X20 iqmod_mixer_0.iqmod_mixer_half_1.iqmod_mixer_tg$1_0.di_tg_ctrl_n iqmod_mixer_0.iqmod_mixer_half_1.iqmod_mixer_se2diff$1_0.iqmod_mixer_se2diff_half_tg$2_0.iqmod_mixer_se2diff_inv_NF54$6_0.vin VDD VDD sg13_lv_pmos ad=0.57p pd=3.38u as=0.57p ps=3.38u w=3u l=0.13u
X21 iqmod_mfb_lpf_0.iqmod_mfb_lpf_half_0.iqmod_mfb_lpf_ota_core_hybrid_bm_half$1_0.iqmod_mfb_lpf_ota_core_inv_NF20$2_1.vin iqmod_mfb_lpf_0.iqmod_mfb_lpf_half_0.iqmod_mfb_lpf_ota_core_hybrid_bm_half$1_0.iqmod_mfb_lpf_ota_core_tg$2_0.di_tg_ctrl_n iqmod_spdt_switch_1.v_c VDD sg13_lv_pmos ad=1.14p pd=6.38u as=1.14p ps=6.38u w=6u l=0.13u
X22 VSS iqmod_mfb_lpf_0.iqmod_mfb_lpf_half_0.iqmod_mfb_lpf_ota_core_hybrid_bm_half$1_0.iqmod_mfb_lpf_ota_core_tg$2_0.v_b iqmod_mixer_0.vinn_IF VSS sg13_lv_nmos ad=0.19p pd=1.38u as=0.19p ps=1.38u w=1u l=1u
X23 VDD iqmod_mixer_0.vinn_IF iqmod_mfb_lpf_0.iqmod_mfb_lpf_half_0.iqmod_mfb_lpf_ota_core_hybrid_bm_half$1_0.iqmod_mfb_lpf_ota_core_inv_NF20$2_0.vout VDD sg13_lv_pmos ad=1.14p pd=6.38u as=1.14p ps=6.38u w=6u l=1u
X24 a_36853_10752# iqmod_mixer_0.vinn_IF VSS rhigh l=60u w=0.5u
X25 iqmod_spdt_switch_0.v_c iqmod_spdt_switch_0.spdt_switch_inv_0.vin vinn_I VDD sg13_lv_pmos ad=1.14p pd=6.38u as=2.04p ps=12.68u w=6u l=0.13u
X26 iqmod_spdt_switch_0.spdt_switch_inv_0.vout iqmod_spdt_switch_0.spdt_switch_inv_0.vin VDD VDD sg13_lv_pmos ad=1.14p pd=6.38u as=1.14p ps=6.38u w=6u l=0.13u
X27 voutp_I_RF iqmod_mixer_0.iqmod_mixer_half_1.iqmod_mixer_tg$1_0.di_tg_ctrl_n voutp_I_RF VSS sg13_lv_nmos ad=0.57p pd=3.38u as=93.24p ps=0.91908m w=3u l=0.13u
X28 iqmod_mfb_lpf_0.iqmod_mfb_lpf_half_0.iqmod_mfb_lpf_ota_core_hybrid_bm_half$1_0.iqmod_mfb_lpf_ota_core_inv_NF6$2_1.vout iqmod_mfb_lpf_0.iqmod_mfb_lpf_half_0.iqmod_mfb_lpf_ota_core_hybrid_bm_half$1_0.iqmod_mfb_lpf_ota_core_inv_NF20$2_0.vout VDD VDD sg13_lv_pmos ad=1.14p pd=6.38u as=1.14p ps=6.38u w=6u l=1u
X29 iqmod_mixer_0.vinp_IF iqmod_mixer_0.iqmod_mixer_half_1.iqmod_mixer_tg$1_0.di_tg_ctrl voutp_I_RF VSS sg13_lv_nmos ad=0.57p pd=3.38u as=0.57p ps=3.38u w=3u l=0.13u
X30 iqmod_mfb_lpf_0.iqmod_mfb_lpf_half_0.C2_half iqmod_mfb_lpf_0.iqmod_mfb_lpf_half_0.iqmod_mfb_lpf_R3$1_0.v_a cap_cmim l=8u w=8u
X31 iqmod_mixer_0.iqmod_mixer_half_0.iqmod_mixer_se2diff$1_0.iqmod_mixer_se2diff_half_inv$2_0.iqmod_mixer_se2diff_inv_NF6$7_0.vout iqmod_mixer_0.iqmod_mixer_half_0.iqmod_mixer_se2diff$1_0.iqmod_mixer_se2diff_half_inv$2_0.iqmod_mixer_se2diff_inv_NF6$7_0.vin VSS VSS sg13_lv_nmos ad=0.19p pd=1.38u as=0.19p ps=1.38u w=1u l=0.13u
X32 iqmod_spdt_switch_1.v_c iqmod_mfb_lpf_0.iqmod_mfb_lpf_half_0.iqmod_mfb_lpf_ota_core_hybrid_bm_half$1_0.iqmod_mfb_lpf_ota_core_tg$2_0.di_tg_ctrl_n iqmod_mfb_lpf_0.iqmod_mfb_lpf_half_0.iqmod_mfb_lpf_ota_core_hybrid_bm_half$1_0.iqmod_mfb_lpf_ota_core_inv_NF20$2_1.vin VDD sg13_lv_pmos ad=1.14p pd=6.38u as=1.14p ps=6.38u w=6u l=0.13u
X33 VDD iqmod_mfb_lpf_0.iqmod_mfb_lpf_half_0.iqmod_mfb_lpf_ota_core_hybrid_bm_half$1_0.iqmod_mfb_lpf_ota_core_inv_NF20$2_1.vin iqmod_mfb_lpf_0.iqmod_mfb_lpf_half_0.iqmod_mfb_lpf_ota_core_hybrid_bm_half$1_0.iqmod_mfb_lpf_ota_core_tg$2_0.v_a VDD sg13_lv_pmos ad=1.14p pd=6.38u as=1.14p ps=6.38u w=6u l=1u
X34 iqmod_mixer_0.iqmod_mixer_half_0.iqmod_mixer_tg$1_0.di_tg_ctrl_n iqmod_mixer_0.iqmod_mixer_half_0.iqmod_mixer_se2diff$1_0.iqmod_mixer_se2diff_half_tg$2_0.iqmod_mixer_se2diff_inv_NF54$6_0.vin VSS VSS sg13_lv_nmos ad=0.19p pd=1.38u as=0.19p ps=1.38u w=1u l=0.13u
X35 iqmod_mfb_lpf_0.iqmod_mfb_lpf_half_0.iqmod_mfb_lpf_ota_core_hybrid_bm_half$1_0.iqmod_mfb_lpf_ota_core_tg$2_0.v_a di_analog_en iqmod_mfb_lpf_0.iqmod_mfb_lpf_half_0.iqmod_mfb_lpf_ota_core_hybrid_bm_half$1_0.iqmod_mfb_lpf_ota_core_tg$2_0.v_b VSS sg13_lv_nmos ad=0.19p pd=1.38u as=0.19p ps=1.38u w=1u l=0.13u
X36 VDD iqmod_mixer_0.vinp_IF iqmod_mfb_lpf_0.iqmod_mfb_lpf_half_0.iqmod_mfb_lpf_ota_core_hybrid_bm_half$1_0.iqmod_mfb_lpf_ota_core_inv_NF20$2_0.vout VDD sg13_lv_pmos ad=1.14p pd=6.38u as=1.14p ps=6.38u w=6u l=1u
X37 voutp_I_RF iqmod_mixer_0.iqmod_mixer_half_1.iqmod_mixer_tg$1_0.di_tg_ctrl_n voutp_I_RF VSS sg13_lv_nmos ad=0.57p pd=3.38u as=0 ps=0 w=3u l=0.13u
X38 VDD iqmod_mixer_0.iqmod_mixer_half_1.iqmod_mixer_se2diff$1_0.iqmod_mixer_se2diff_half_inv$2_0.iqmod_mixer_se2diff_inv_NF54$7_0.vin iqmod_mixer_0.iqmod_mixer_half_1.iqmod_mixer_tg$1_0.di_tg_ctrl VDD sg13_lv_pmos ad=0.57p pd=3.38u as=0.57p ps=3.38u w=3u l=0.13u
X39 iqmod_mixer_0.vinp_IF iqmod_mfb_lpf_0.iqmod_mfb_lpf_half_1.iqmod_mfb_lpf_ota_core_hybrid_bm_half$1_0.iqmod_mfb_lpf_ota_core_inv_NF20$2_1.vin VDD VDD sg13_lv_pmos ad=1.14p pd=6.38u as=1.14p ps=6.38u w=6u l=1u
X40 VDD iqmod_mixer_0.iqmod_mixer_half_1.iqmod_mixer_se2diff$1_0.iqmod_mixer_se2diff_half_inv$2_0.iqmod_mixer_se2diff_inv_NF6$7_0.vin iqmod_mixer_0.iqmod_mixer_half_1.iqmod_mixer_se2diff$1_0.iqmod_mixer_se2diff_half_inv$2_0.iqmod_mixer_se2diff_inv_NF6$7_0.vout VDD sg13_lv_pmos ad=0.57p pd=3.38u as=0.57p ps=3.38u w=3u l=0.13u
X41 VSS iqmod_mixer_0.iqmod_mixer_half_0.iqmod_mixer_se2diff$1_0.iqmod_mixer_se2diff_half_inv$2_0.iqmod_mixer_se2diff_inv_NF6$7_0.vin iqmod_mixer_0.iqmod_mixer_half_0.iqmod_mixer_se2diff$1_0.iqmod_mixer_se2diff_half_inv$2_0.iqmod_mixer_se2diff_inv_NF6$7_0.vout VSS sg13_lv_nmos ad=0.19p pd=1.38u as=0.19p ps=1.38u w=1u l=0.13u
X42 iqmod_mixer_0.iqmod_mixer_half_1.iqmod_mixer_se2diff$1_0.iqmod_mixer_se2diff_half_inv$2_0.iqmod_mixer_se2diff_inv_NF6$7_0.vin di_lo_I VDD VDD sg13_lv_pmos ad=0.57p pd=3.38u as=0.57p ps=3.38u w=3u l=0.13u
X43 iqmod_mixer_0.iqmod_mixer_half_0.iqmod_mixer_se2diff$1_0.iqmod_mixer_se2diff_half_inv$2_0.iqmod_mixer_se2diff_inv_NF6$7_0.vin VSS iqmod_mixer_0.iqmod_mixer_half_0.iqmod_mixer_se2diff$1_0.iqmod_mixer_se2diff_half_tg$2_0.iqmod_mixer_se2diff_tg_NF6$3_0.v_b VDD sg13_lv_pmos ad=0.57p pd=3.38u as=0.57p ps=3.38u w=3u l=0.13u
X44 VSS iqmod_mixer_0.vinp_IF iqmod_mfb_lpf_0.iqmod_mfb_lpf_half_0.iqmod_mfb_lpf_ota_core_hybrid_bm_half$1_0.iqmod_mfb_lpf_ota_core_inv_NF20$2_0.vout VSS sg13_lv_nmos ad=0.19p pd=1.38u as=0.19p ps=1.38u w=1u l=1u
X45 VSS iqmod_mixer_0.iqmod_mixer_half_0.iqmod_mixer_se2diff$1_0.iqmod_mixer_se2diff_half_tg$2_0.iqmod_mixer_se2diff_inv_NF54$6_0.vin iqmod_mixer_0.iqmod_mixer_half_0.iqmod_mixer_tg$1_0.di_tg_ctrl_n VSS sg13_lv_nmos ad=0.19p pd=1.38u as=0.19p ps=1.38u w=1u l=0.13u
X46 iqmod_spdt_switch_1.spdt_switch_inv_0.vin di_spdt_ctrl_I VSS VSS sg13_lv_nmos ad=0.19p pd=1.38u as=0.19p ps=1.38u w=1u l=0.13u
X47 iqmod_mixer_0.iqmod_mixer_half_1.iqmod_mixer_tg$1_0.di_tg_ctrl_n iqmod_mixer_0.iqmod_mixer_half_1.iqmod_mixer_se2diff$1_0.iqmod_mixer_se2diff_half_tg$2_0.iqmod_mixer_se2diff_inv_NF54$6_0.vin VSS VSS sg13_lv_nmos ad=0.19p pd=1.38u as=0.19p ps=1.38u w=1u l=0.13u
X48 iqmod_mfb_lpf_0.iqmod_mfb_lpf_half_0.iqmod_mfb_lpf_ota_core_hybrid_bm_half$1_0.iqmod_mfb_lpf_ota_core_tg$2_0.v_b di_analog_en iqmod_mfb_lpf_0.iqmod_mfb_lpf_half_0.iqmod_mfb_lpf_ota_core_hybrid_bm_half$1_0.iqmod_mfb_lpf_ota_core_tg$2_0.v_a VSS sg13_lv_nmos ad=0.19p pd=1.38u as=0.34p ps=2.68u w=1u l=0.13u
X49 iqmod_mixer_0.iqmod_mixer_half_1.iqmod_mixer_tg$1_0.di_tg_ctrl iqmod_mixer_0.iqmod_mixer_half_1.iqmod_mixer_se2diff$1_0.iqmod_mixer_se2diff_half_inv$2_0.iqmod_mixer_se2diff_inv_NF54$7_0.vin VSS VSS sg13_lv_nmos ad=0.19p pd=1.38u as=0.19p ps=1.38u w=1u l=0.13u
X50 VSS iqmod_mfb_lpf_0.iqmod_mfb_lpf_half_1.iqmod_mfb_lpf_ota_core_hybrid_bm_half$1_0.iqmod_mfb_lpf_ota_core_inv_NF20$2_1.vin iqmod_mfb_lpf_0.iqmod_mfb_lpf_half_0.iqmod_mfb_lpf_ota_core_hybrid_bm_half$1_0.iqmod_mfb_lpf_ota_core_tg$2_0.v_a VSS sg13_lv_nmos ad=0.19p pd=1.38u as=0.19p ps=1.38u w=1u l=1u
X51 iqmod_mixer_0.iqmod_mixer_half_0.iqmod_mixer_se2diff$1_0.iqmod_mixer_se2diff_half_tg$2_0.iqmod_mixer_se2diff_tg_NF6$3_0.v_b VSS iqmod_mixer_0.iqmod_mixer_half_0.iqmod_mixer_se2diff$1_0.iqmod_mixer_se2diff_half_inv$2_0.iqmod_mixer_se2diff_inv_NF6$7_0.vin VDD sg13_lv_pmos ad=0.57p pd=3.38u as=1.02p ps=6.68u w=3u l=0.13u
X52 iqmod_mixer_0.iqmod_mixer_half_0.iqmod_mixer_tg$1_0.di_tg_ctrl iqmod_mixer_0.iqmod_mixer_half_0.iqmod_mixer_se2diff$1_0.iqmod_mixer_se2diff_half_inv$2_0.iqmod_mixer_se2diff_inv_NF54$7_0.vin VDD VDD sg13_lv_pmos ad=0.57p pd=3.38u as=0.57p ps=3.38u w=3u l=0.13u
X53 iqmod_mfb_lpf_0.iqmod_mfb_lpf_half_0.iqmod_mfb_lpf_ota_core_hybrid_bm_half$1_0.iqmod_mfb_lpf_ota_core_tg$2_0.v_b iqmod_mfb_lpf_0.iqmod_mfb_lpf_half_0.iqmod_mfb_lpf_ota_core_hybrid_bm_half$1_0.iqmod_mfb_lpf_ota_core_tg$2_0.v_a VSS VSS sg13_lv_nmos ad=0.19p pd=1.38u as=0.19p ps=1.38u w=1u l=1u
X54 VDD iqmod_mixer_0.iqmod_mixer_half_1.iqmod_mixer_se2diff$1_0.iqmod_mixer_se2diff_half_inv$2_0.iqmod_mixer_se2diff_inv_NF54$7_0.vin iqmod_mixer_0.iqmod_mixer_half_1.iqmod_mixer_tg$1_0.di_tg_ctrl VDD sg13_lv_pmos ad=0.57p pd=3.38u as=0.57p ps=3.38u w=3u l=0.13u
X55 iqmod_mixer_0.iqmod_mixer_half_0.iqmod_mixer_tg$1_0.di_tg_ctrl iqmod_mixer_0.iqmod_mixer_half_0.iqmod_mixer_se2diff$1_0.iqmod_mixer_se2diff_half_inv$2_0.iqmod_mixer_se2diff_inv_NF54$7_0.vin VSS VSS sg13_lv_nmos ad=0.19p pd=1.38u as=0.19p ps=1.38u w=1u l=0.13u
X56 VDD VDD VDD VDD sg13_lv_pmos ad=1.02p pd=6.68u as=0 ps=0 w=3u l=0.13u
X57 vinp_I iqmod_spdt_switch_1.spdt_switch_inv_0.vin iqmod_spdt_switch_1.v_c VDD sg13_lv_pmos ad=1.14p pd=6.38u as=1.14p ps=6.38u w=6u l=0.13u
X58 iqmod_spdt_switch_1.v_c iqmod_spdt_switch_1.spdt_switch_inv_0.vout di_ds_I_p VDD sg13_lv_pmos ad=1.14p pd=6.38u as=2.04p ps=12.68u w=6u l=0.13u
X59 VDD iqmod_mfb_lpf_0.iqmod_mfb_lpf_half_1.iqmod_mfb_lpf_ota_core_hybrid_bm_half$1_0.iqmod_mfb_lpf_ota_core_inv_NF20$2_1.vin iqmod_mixer_0.vinp_IF VDD sg13_lv_pmos ad=1.14p pd=6.38u as=1.14p ps=6.38u w=6u l=1u
X60 VSS VSS VSS VSS sg13_lv_nmos ad=0.34p pd=2.68u as=0 ps=0 w=1u l=1u
X61 VSS iqmod_mixer_0.iqmod_mixer_half_1.iqmod_mixer_se2diff$1_0.iqmod_mixer_se2diff_half_tg$2_0.iqmod_mixer_se2diff_inv_NF54$6_0.vin iqmod_mixer_0.iqmod_mixer_half_1.iqmod_mixer_tg$1_0.di_tg_ctrl_n VSS sg13_lv_nmos ad=0.19p pd=1.38u as=0.19p ps=1.38u w=1u l=0.13u
X62 iqmod_mfb_lpf_0.iqmod_mfb_lpf_half_0.iqmod_mfb_lpf_ota_core_hybrid_bm_half$1_0.iqmod_mfb_lpf_ota_core_inv_NF20$2_0.vout iqmod_mixer_0.vinp_IF VSS VSS sg13_lv_nmos ad=0.19p pd=1.38u as=0.19p ps=1.38u w=1u l=1u
X63 di_ds_I_n iqmod_spdt_switch_0.spdt_switch_inv_0.vin iqmod_spdt_switch_0.v_c VSS sg13_lv_nmos ad=0.34p pd=2.68u as=0.19p ps=1.38u w=1u l=0.13u
X64 iqmod_mixer_0.vinp_IF iqmod_mixer_0.iqmod_mixer_half_1.iqmod_mixer_tg$1_0.di_tg_ctrl_n voutp_I_RF VDD sg13_lv_pmos ad=1.71p pd=9.38u as=1.71p ps=9.38u w=9u l=0.13u
X65 VDD iqmod_mixer_0.iqmod_mixer_half_0.iqmod_mixer_se2diff$1_0.iqmod_mixer_se2diff_half_tg$2_0.iqmod_mixer_se2diff_inv_NF54$6_0.vin iqmod_mixer_0.iqmod_mixer_half_0.iqmod_mixer_tg$1_0.di_tg_ctrl_n VDD sg13_lv_pmos ad=0.57p pd=3.38u as=0.57p ps=3.38u w=3u l=0.13u
X66 iqmod_mixer_0.iqmod_mixer_half_1.iqmod_mixer_tg$1_0.di_tg_ctrl_n iqmod_mixer_0.iqmod_mixer_half_1.iqmod_mixer_se2diff$1_0.iqmod_mixer_se2diff_half_tg$2_0.iqmod_mixer_se2diff_inv_NF54$6_0.vin VSS VSS sg13_lv_nmos ad=0.19p pd=1.38u as=0.19p ps=1.38u w=1u l=0.13u
X67 VDD iqmod_mixer_0.iqmod_mixer_half_1.iqmod_mixer_se2diff$1_0.iqmod_mixer_se2diff_half_inv$2_0.iqmod_mixer_se2diff_inv_NF54$7_0.vin iqmod_mixer_0.iqmod_mixer_half_1.iqmod_mixer_tg$1_0.di_tg_ctrl VDD sg13_lv_pmos ad=0.57p pd=3.38u as=0.57p ps=3.38u w=3u l=0.13u
X68 VDD VDD VDD VDD sg13_lv_pmos ad=1.02p pd=6.68u as=0 ps=0 w=3u l=0.13u
X69 iqmod_mixer_0.iqmod_mixer_half_0.iqmod_mixer_tg$1_0.di_tg_ctrl_n iqmod_mixer_0.iqmod_mixer_half_0.iqmod_mixer_se2diff$1_0.iqmod_mixer_se2diff_half_tg$2_0.iqmod_mixer_se2diff_inv_NF54$6_0.vin VDD VDD sg13_lv_pmos ad=0.57p pd=3.38u as=0.57p ps=3.38u w=3u l=0.13u
X70 iqmod_mixer_0.iqmod_mixer_half_1.iqmod_mixer_se2diff$1_0.iqmod_mixer_se2diff_half_tg$2_0.iqmod_mixer_se2diff_inv_NF54$6_0.vin iqmod_mixer_0.iqmod_mixer_half_1.iqmod_mixer_se2diff$1_0.iqmod_mixer_se2diff_half_tg$2_0.iqmod_mixer_se2diff_inv_NF18$6_0.vin VDD VDD sg13_lv_pmos ad=0.57p pd=3.38u as=0.57p ps=3.38u w=3u l=0.13u
X71 VSS iqmod_mixer_0.vinp_IF iqmod_mfb_lpf_0.iqmod_mfb_lpf_half_0.iqmod_mfb_lpf_ota_core_hybrid_bm_half$1_0.iqmod_mfb_lpf_ota_core_inv_NF20$2_0.vout VSS sg13_lv_nmos ad=0.19p pd=1.38u as=0.19p ps=1.38u w=1u l=1u
X72 VSS iqmod_mixer_0.iqmod_mixer_half_0.iqmod_mixer_se2diff$1_0.iqmod_mixer_se2diff_half_inv$2_0.iqmod_mixer_se2diff_inv_NF54$7_0.vin iqmod_mixer_0.iqmod_mixer_half_0.iqmod_mixer_tg$1_0.di_tg_ctrl VSS sg13_lv_nmos ad=0.19p pd=1.38u as=0.19p ps=1.38u w=1u l=0.13u
X73 iqmod_mixer_0.vinn_IF iqmod_mfb_lpf_0.iqmod_mfb_lpf_half_0.iqmod_mfb_lpf_ota_core_hybrid_bm_half$1_0.iqmod_mfb_lpf_ota_core_inv_NF20$2_1.vin VSS VSS sg13_lv_nmos ad=0.19p pd=1.38u as=0.19p ps=1.38u w=1u l=1u
X74 iqmod_mfb_lpf_0.iqmod_mfb_lpf_half_0.C2_half iqmod_mfb_lpf_0.iqmod_mfb_lpf_half_0.iqmod_mfb_lpf_R3$1_0.v_a cap_cmim l=8u w=8u
X75 VSS iqmod_mfb_lpf_0.iqmod_mfb_lpf_half_1.iqmod_mfb_lpf_ota_core_hybrid_bm_half$1_0.iqmod_mfb_lpf_ota_core_tg$2_0.di_tg_ctrl_n iqmod_mfb_lpf_0.iqmod_mfb_lpf_half_1.iqmod_mfb_lpf_ota_core_hybrid_bm_half$1_0.iqmod_mfb_lpf_ota_core_spdt_switch$2_0.iqmod_mfb_lpf_ota_core_spdt_switch_inv$3_0.vout VSS sg13_lv_nmos ad=0.19p pd=1.38u as=0.19p ps=1.38u w=1u l=0.13u
X76 VDD iqmod_mixer_0.iqmod_mixer_half_1.iqmod_mixer_se2diff$1_0.iqmod_mixer_se2diff_half_tg$2_0.iqmod_mixer_se2diff_inv_NF18$6_0.vin iqmod_mixer_0.iqmod_mixer_half_1.iqmod_mixer_se2diff$1_0.iqmod_mixer_se2diff_half_tg$2_0.iqmod_mixer_se2diff_inv_NF54$6_0.vin VDD sg13_lv_pmos ad=0.57p pd=3.38u as=0.57p ps=3.38u w=3u l=0.13u
X77 VDD iqmod_mixer_0.iqmod_mixer_half_1.iqmod_mixer_se2diff$1_0.iqmod_mixer_se2diff_half_inv$2_0.iqmod_mixer_se2diff_inv_NF54$7_0.vin iqmod_mixer_0.iqmod_mixer_half_1.iqmod_mixer_tg$1_0.di_tg_ctrl VDD sg13_lv_pmos ad=0.57p pd=3.38u as=0.57p ps=3.38u w=3u l=0.13u
X78 iqmod_mixer_0.iqmod_mixer_half_0.iqmod_mixer_tg$1_0.di_tg_ctrl iqmod_mixer_0.iqmod_mixer_half_0.iqmod_mixer_se2diff$1_0.iqmod_mixer_se2diff_half_inv$2_0.iqmod_mixer_se2diff_inv_NF54$7_0.vin VSS VSS sg13_lv_nmos ad=0.19p pd=1.38u as=0.19p ps=1.38u w=1u l=0.13u
X79 iqmod_mfb_lpf_0.iqmod_mfb_lpf_half_0.iqmod_mfb_lpf_ota_core_hybrid_bm_half$1_0.iqmod_mfb_lpf_ota_core_inv_NF6$2_1.vout di_analog_en iqmod_mfb_lpf_0.iqmod_mfb_lpf_half_0.iqmod_mfb_lpf_ota_core_hybrid_bm_half$1_0.iqmod_mfb_lpf_ota_core_inv_NF20$2_0.vout VSS sg13_lv_nmos ad=0.19p pd=1.38u as=0.19p ps=1.38u w=1u l=0.13u
X80 iqmod_mixer_0.iqmod_mixer_half_0.iqmod_mixer_tg$1_0.di_tg_ctrl_n iqmod_mixer_0.iqmod_mixer_half_0.iqmod_mixer_se2diff$1_0.iqmod_mixer_se2diff_half_tg$2_0.iqmod_mixer_se2diff_inv_NF54$6_0.vin VDD VDD sg13_lv_pmos ad=0.57p pd=3.38u as=0.57p ps=3.38u w=3u l=0.13u
X81 VSS iqmod_mfb_lpf_0.iqmod_mfb_lpf_half_0.iqmod_mfb_lpf_ota_core_hybrid_bm_half$1_0.iqmod_mfb_lpf_ota_core_tg$2_0.v_b iqmod_mixer_0.vinp_IF VSS sg13_lv_nmos ad=0.19p pd=1.38u as=0.19p ps=1.38u w=1u l=1u
X82 VSS iqmod_mixer_0.iqmod_mixer_half_1.iqmod_mixer_se2diff$1_0.iqmod_mixer_se2diff_half_tg$2_0.iqmod_mixer_se2diff_inv_NF54$6_0.vin iqmod_mixer_0.iqmod_mixer_half_1.iqmod_mixer_tg$1_0.di_tg_ctrl_n VSS sg13_lv_nmos ad=0.19p pd=1.38u as=0.19p ps=1.38u w=1u l=0.13u
X83 iqmod_mfb_lpf_0.iqmod_mfb_lpf_half_0.iqmod_mfb_lpf_R1$1_0.v_b iqmod_mfb_lpf_0.iqmod_mfb_lpf_half_0.C1_half cap_cmim l=8u w=8u
X84 voutn_I_RF iqmod_mixer_0.iqmod_mixer_half_0.iqmod_mixer_tg$1_0.di_tg_ctrl_n iqmod_mixer_0.vinn_IF VDD sg13_lv_pmos ad=1.71p pd=9.38u as=1.71p ps=9.38u w=9u l=0.13u
X85 di_ds_I_n iqmod_spdt_switch_0.spdt_switch_inv_0.vin iqmod_spdt_switch_0.v_c VSS sg13_lv_nmos ad=0.19p pd=1.38u as=0.19p ps=1.38u w=1u l=0.13u
X86 VSS iqmod_mixer_0.iqmod_mixer_half_0.iqmod_mixer_se2diff$1_0.iqmod_mixer_se2diff_half_tg$2_0.iqmod_mixer_se2diff_inv_NF18$6_0.vin iqmod_mixer_0.iqmod_mixer_half_0.iqmod_mixer_se2diff$1_0.iqmod_mixer_se2diff_half_tg$2_0.iqmod_mixer_se2diff_inv_NF54$6_0.vin VSS sg13_lv_nmos ad=0.19p pd=1.38u as=0.19p ps=1.38u w=1u l=0.13u
X87 VSS iqmod_mfb_lpf_0.iqmod_mfb_lpf_half_0.iqmod_mfb_lpf_ota_core_hybrid_bm_half$1_0.iqmod_mfb_lpf_ota_core_inv_NF20$2_0.vout iqmod_mfb_lpf_0.iqmod_mfb_lpf_half_0.iqmod_mfb_lpf_ota_core_hybrid_bm_half$1_0.iqmod_mfb_lpf_ota_core_inv_NF6$2_1.vout VSS sg13_lv_nmos ad=0.19p pd=1.38u as=0.19p ps=1.38u w=1u l=1u
X88 iqmod_mixer_0.iqmod_mixer_half_1.iqmod_mixer_se2diff$1_0.iqmod_mixer_se2diff_half_inv$2_0.iqmod_mixer_se2diff_inv_NF54$7_0.vin iqmod_mixer_0.iqmod_mixer_half_1.iqmod_mixer_se2diff$1_0.iqmod_mixer_se2diff_half_inv$2_0.iqmod_mixer_se2diff_inv_NF18$7_0.vin VSS VSS sg13_lv_nmos ad=0.19p pd=1.38u as=0.19p ps=1.38u w=1u l=0.13u
X89 iqmod_mixer_0.vinn_IF iqmod_mixer_0.iqmod_mixer_half_0.iqmod_mixer_tg$1_0.di_tg_ctrl_n voutn_I_RF VDD sg13_lv_pmos ad=1.71p pd=9.38u as=1.71p ps=9.38u w=9u l=0.13u
X90 VDD VDD VDD VDD sg13_lv_pmos ad=2.04p pd=12.68u as=0 ps=0 w=6u l=1u
X91 VDD iqmod_mixer_0.iqmod_mixer_half_0.iqmod_mixer_se2diff$1_0.iqmod_mixer_se2diff_half_tg$2_0.iqmod_mixer_se2diff_inv_NF54$6_0.vin iqmod_mixer_0.iqmod_mixer_half_0.iqmod_mixer_tg$1_0.di_tg_ctrl_n VDD sg13_lv_pmos ad=0.57p pd=3.38u as=0.57p ps=3.38u w=3u l=0.13u
X92 VSS iqmod_mixer_0.iqmod_mixer_half_0.iqmod_mixer_se2diff$1_0.iqmod_mixer_se2diff_half_inv$2_0.iqmod_mixer_se2diff_inv_NF54$7_0.vin iqmod_mixer_0.iqmod_mixer_half_0.iqmod_mixer_tg$1_0.di_tg_ctrl VSS sg13_lv_nmos ad=0.19p pd=1.38u as=0.19p ps=1.38u w=1u l=0.13u
X93 voutn_I_RF iqmod_mixer_0.iqmod_mixer_half_0.iqmod_mixer_tg$1_0.di_tg_ctrl iqmod_mixer_0.vinn_IF VSS sg13_lv_nmos ad=0.57p pd=3.38u as=0.57p ps=3.38u w=3u l=0.13u
X94 VDD VDD VDD VDD sg13_lv_pmos ad=1.14p pd=6.38u as=0 ps=0 w=6u l=1u
X95 iqmod_mixer_0.iqmod_mixer_half_1.iqmod_mixer_tg$1_0.di_tg_ctrl_n iqmod_mixer_0.iqmod_mixer_half_1.iqmod_mixer_se2diff$1_0.iqmod_mixer_se2diff_half_tg$2_0.iqmod_mixer_se2diff_inv_NF54$6_0.vin VDD VDD sg13_lv_pmos ad=0.57p pd=3.38u as=0.57p ps=3.38u w=3u l=0.13u
X96 iqmod_mixer_0.iqmod_mixer_half_0.iqmod_mixer_se2diff$1_0.iqmod_mixer_se2diff_half_inv$2_0.iqmod_mixer_se2diff_inv_NF54$7_0.vin iqmod_mixer_0.iqmod_mixer_half_0.iqmod_mixer_se2diff$1_0.iqmod_mixer_se2diff_half_inv$2_0.iqmod_mixer_se2diff_inv_NF18$7_0.vin VDD VDD sg13_lv_pmos ad=0.57p pd=3.38u as=0.57p ps=3.38u w=3u l=0.13u
X97 voutp_I_RF iqmod_mixer_0.iqmod_mixer_half_1.iqmod_mixer_tg$1_0.di_tg_ctrl_n iqmod_mixer_0.vinp_IF VDD sg13_lv_pmos ad=1.71p pd=9.38u as=1.71p ps=9.38u w=9u l=0.13u
X98 VSS iqmod_mixer_0.iqmod_mixer_half_1.iqmod_mixer_se2diff$1_0.iqmod_mixer_se2diff_half_inv$2_0.iqmod_mixer_se2diff_inv_NF18$7_0.vin iqmod_mixer_0.iqmod_mixer_half_1.iqmod_mixer_se2diff$1_0.iqmod_mixer_se2diff_half_inv$2_0.iqmod_mixer_se2diff_inv_NF54$7_0.vin VSS sg13_lv_nmos ad=0.19p pd=1.38u as=0.19p ps=1.38u w=1u l=0.13u
X99 voutn_I_RF iqmod_mixer_0.iqmod_mixer_half_0.iqmod_mixer_tg$1_0.di_tg_ctrl_n iqmod_mixer_0.vinn_IF VDD sg13_lv_pmos ad=1.71p pd=9.38u as=1.71p ps=9.38u w=9u l=0.13u
X100 VDD iqmod_mixer_0.iqmod_mixer_half_1.iqmod_mixer_se2diff$1_0.iqmod_mixer_se2diff_half_inv$2_0.iqmod_mixer_se2diff_inv_NF2$7_1.vout iqmod_mixer_0.iqmod_mixer_half_1.iqmod_mixer_se2diff$1_0.iqmod_mixer_se2diff_half_inv$2_0.iqmod_mixer_se2diff_inv_NF6$7_1.vin VDD sg13_lv_pmos ad=0.57p pd=3.38u as=0.57p ps=3.38u w=3u l=0.13u
X101 iqmod_mixer_0.vinn_IF iqmod_mixer_0.iqmod_mixer_half_0.iqmod_mixer_tg$1_0.di_tg_ctrl voutn_I_RF VSS sg13_lv_nmos ad=0.57p pd=3.38u as=0.57p ps=3.38u w=3u l=0.13u
X102 voutp_I_RF iqmod_mixer_0.iqmod_mixer_half_1.iqmod_mixer_tg$1_0.di_tg_ctrl_n voutp_I_RF VSS sg13_lv_nmos ad=0.57p pd=3.38u as=0 ps=0 w=3u l=0.13u
X103 iqmod_mixer_0.iqmod_mixer_half_0.iqmod_mixer_tg$1_0.di_tg_ctrl_n iqmod_mixer_0.iqmod_mixer_half_0.iqmod_mixer_se2diff$1_0.iqmod_mixer_se2diff_half_tg$2_0.iqmod_mixer_se2diff_inv_NF54$6_0.vin VDD VDD sg13_lv_pmos ad=0.57p pd=3.38u as=0.57p ps=3.38u w=3u l=0.13u
X104 VDD iqmod_mixer_0.iqmod_mixer_half_1.iqmod_mixer_se2diff$1_0.iqmod_mixer_se2diff_half_tg$2_0.iqmod_mixer_se2diff_inv_NF54$6_0.vin iqmod_mixer_0.iqmod_mixer_half_1.iqmod_mixer_tg$1_0.di_tg_ctrl_n VDD sg13_lv_pmos ad=0.57p pd=3.38u as=0.57p ps=3.38u w=3u l=0.13u
X105 VSS iqmod_mfb_lpf_0.iqmod_mfb_lpf_half_0.iqmod_mfb_lpf_ota_core_hybrid_bm_half$1_0.iqmod_mfb_lpf_ota_core_inv_NF20$2_1.vin iqmod_mixer_0.vinn_IF VSS sg13_lv_nmos ad=0.19p pd=1.38u as=0.19p ps=1.38u w=1u l=1u
X106 iqmod_mfb_lpf_0.iqmod_mfb_lpf_half_0.iqmod_mfb_lpf_ota_core_hybrid_bm_half$1_0.iqmod_mfb_lpf_ota_core_inv_NF20$2_0.vout iqmod_mfb_lpf_0.iqmod_mfb_lpf_half_0.iqmod_mfb_lpf_ota_core_hybrid_bm_half$1_0.iqmod_mfb_lpf_ota_core_tg$2_0.di_tg_ctrl_n iqmod_mfb_lpf_0.iqmod_mfb_lpf_half_0.iqmod_mfb_lpf_ota_core_hybrid_bm_half$1_0.iqmod_mfb_lpf_ota_core_inv_NF6$2_1.vout VDD sg13_lv_pmos ad=1.14p pd=6.38u as=1.14p ps=6.38u w=6u l=0.13u
X107 VDD iqmod_mixer_0.iqmod_mixer_half_0.iqmod_mixer_se2diff$1_0.iqmod_mixer_se2diff_half_inv$2_0.iqmod_mixer_se2diff_inv_NF18$7_0.vin iqmod_mixer_0.iqmod_mixer_half_0.iqmod_mixer_se2diff$1_0.iqmod_mixer_se2diff_half_inv$2_0.iqmod_mixer_se2diff_inv_NF54$7_0.vin VDD sg13_lv_pmos ad=0.57p pd=3.38u as=0.57p ps=3.38u w=3u l=0.13u
X108 voutp_I_RF iqmod_mixer_0.iqmod_mixer_half_1.iqmod_mixer_tg$1_0.di_tg_ctrl iqmod_mixer_0.vinp_IF VSS sg13_lv_nmos ad=0.57p pd=3.38u as=0.57p ps=3.38u w=3u l=0.13u
X109 iqmod_mfb_lpf_0.iqmod_mfb_lpf_half_0.iqmod_mfb_lpf_ota_core_hybrid_bm_half$1_0.iqmod_mfb_lpf_ota_core_tg$2_0.v_b di_analog_en iqmod_mfb_lpf_0.iqmod_mfb_lpf_half_0.iqmod_mfb_lpf_ota_core_hybrid_bm_half$1_0.iqmod_mfb_lpf_ota_core_tg$2_0.v_a VSS sg13_lv_nmos ad=0.19p pd=1.38u as=0.19p ps=1.38u w=1u l=0.13u
X110 voutn_I_RF iqmod_mixer_0.iqmod_mixer_half_0.iqmod_mixer_tg$1_0.di_tg_ctrl iqmod_mixer_0.vinn_IF VSS sg13_lv_nmos ad=0.57p pd=3.38u as=0.57p ps=3.38u w=3u l=0.13u
X111 voutp_I_RF iqmod_mixer_0.iqmod_mixer_half_1.iqmod_mixer_tg$1_0.di_tg_ctrl_n voutp_I_RF VSS sg13_lv_nmos ad=0.57p pd=3.38u as=0 ps=0 w=3u l=0.13u
X112 a_17685_10452# a_23971_10752# VSS rhigh l=31u w=0.5u
X113 iqmod_mixer_0.iqmod_mixer_half_0.iqmod_mixer_tg$1_0.di_tg_ctrl iqmod_mixer_0.iqmod_mixer_half_0.iqmod_mixer_se2diff$1_0.iqmod_mixer_se2diff_half_inv$2_0.iqmod_mixer_se2diff_inv_NF54$7_0.vin VSS VSS sg13_lv_nmos ad=0.19p pd=1.38u as=0.19p ps=1.38u w=1u l=0.13u
X114 VSS iqmod_mfb_lpf_0.iqmod_mfb_lpf_half_0.iqmod_mfb_lpf_ota_core_hybrid_bm_half$1_0.iqmod_mfb_lpf_ota_core_tg$2_0.v_b iqmod_mixer_0.vinp_IF VSS sg13_lv_nmos ad=0.19p pd=1.38u as=0.19p ps=1.38u w=1u l=1u
X115 iqmod_mixer_0.iqmod_mixer_half_1.iqmod_mixer_tg$1_0.di_tg_ctrl iqmod_mixer_0.iqmod_mixer_half_1.iqmod_mixer_se2diff$1_0.iqmod_mixer_se2diff_half_inv$2_0.iqmod_mixer_se2diff_inv_NF54$7_0.vin VSS VSS sg13_lv_nmos ad=0.19p pd=1.38u as=0.19p ps=1.38u w=1u l=0.13u
X116 VSS iqmod_mixer_0.iqmod_mixer_half_1.iqmod_mixer_se2diff$1_0.iqmod_mixer_se2diff_half_inv$2_0.iqmod_mixer_se2diff_inv_NF6$7_1.vin iqmod_mixer_0.iqmod_mixer_half_1.iqmod_mixer_se2diff$1_0.iqmod_mixer_se2diff_half_inv$2_0.iqmod_mixer_se2diff_inv_NF2$7_1.vout VSS sg13_lv_nmos ad=0.19p pd=1.38u as=0.19p ps=1.38u w=1u l=0.13u
X117 iqmod_mixer_0.vinn_IF iqmod_mfb_lpf_0.iqmod_mfb_lpf_half_0.iqmod_mfb_lpf_ota_core_hybrid_bm_half$1_0.iqmod_mfb_lpf_ota_core_inv_NF20$2_1.vin VSS VSS sg13_lv_nmos ad=0.19p pd=1.38u as=0.19p ps=1.38u w=1u l=1u
X118 iqmod_mfb_lpf_0.iqmod_mfb_lpf_half_0.C1_half iqmod_mfb_lpf_0.iqmod_mfb_lpf_half_0.iqmod_mfb_lpf_R1$1_0.v_b cap_cmim l=8u w=8u
X119 VSS iqmod_mixer_0.iqmod_mixer_half_0.iqmod_mixer_se2diff$1_0.iqmod_mixer_se2diff_half_tg$2_0.iqmod_mixer_se2diff_inv_NF18$6_0.vin iqmod_mixer_0.iqmod_mixer_half_0.iqmod_mixer_se2diff$1_0.iqmod_mixer_se2diff_half_tg$2_0.iqmod_mixer_se2diff_inv_NF54$6_0.vin VSS sg13_lv_nmos ad=0.19p pd=1.38u as=0.19p ps=1.38u w=1u l=0.13u
X120 VSS VSS VSS VSS sg13_lv_nmos ad=0.19p pd=1.38u as=0 ps=0 w=1u l=0.13u
X121 iqmod_mixer_0.iqmod_mixer_half_0.iqmod_mixer_tg$1_0.di_tg_ctrl iqmod_mixer_0.iqmod_mixer_half_0.iqmod_mixer_se2diff$1_0.iqmod_mixer_se2diff_half_inv$2_0.iqmod_mixer_se2diff_inv_NF54$7_0.vin VDD VDD sg13_lv_pmos ad=0.57p pd=3.38u as=0.57p ps=3.38u w=3u l=0.13u
X122 iqmod_mixer_0.iqmod_mixer_half_1.iqmod_mixer_se2diff$1_0.iqmod_mixer_se2diff_half_tg$2_0.iqmod_mixer_se2diff_inv_NF54$6_0.vin iqmod_mixer_0.iqmod_mixer_half_1.iqmod_mixer_se2diff$1_0.iqmod_mixer_se2diff_half_tg$2_0.iqmod_mixer_se2diff_inv_NF18$6_0.vin VSS VSS sg13_lv_nmos ad=0.19p pd=1.38u as=0.19p ps=1.38u w=1u l=0.13u
X123 VSS iqmod_mixer_0.iqmod_mixer_half_1.iqmod_mixer_se2diff$1_0.iqmod_mixer_se2diff_half_inv$2_0.iqmod_mixer_se2diff_inv_NF54$7_0.vin iqmod_mixer_0.iqmod_mixer_half_1.iqmod_mixer_tg$1_0.di_tg_ctrl VSS sg13_lv_nmos ad=0.19p pd=1.38u as=0.19p ps=1.38u w=1u l=0.13u
X124 voutp_I_RF iqmod_mixer_0.iqmod_mixer_half_1.iqmod_mixer_tg$1_0.di_tg_ctrl iqmod_mixer_0.vinp_IF VSS sg13_lv_nmos ad=0.57p pd=3.38u as=0.57p ps=3.38u w=3u l=0.13u
X125 iqmod_mfb_lpf_0.iqmod_mfb_lpf_half_0.iqmod_mfb_lpf_ota_core_hybrid_bm_half$1_0.iqmod_mfb_lpf_ota_core_tg$2_0.v_a iqmod_mfb_lpf_0.iqmod_mfb_lpf_half_0.iqmod_mfb_lpf_ota_core_hybrid_bm_half$1_0.iqmod_mfb_lpf_ota_core_inv_NF20$2_1.vin VSS VSS sg13_lv_nmos ad=0.19p pd=1.38u as=0.19p ps=1.38u w=1u l=1u
X126 iqmod_mfb_lpf_0.iqmod_mfb_lpf_half_0.iqmod_mfb_lpf_ota_core_hybrid_bm_half$1_0.iqmod_mfb_lpf_ota_core_inv_NF6$2_1.vout iqmod_mfb_lpf_0.iqmod_mfb_lpf_half_0.iqmod_mfb_lpf_ota_core_hybrid_bm_half$1_0.iqmod_mfb_lpf_ota_core_inv_NF20$2_0.vout VDD VDD sg13_lv_pmos ad=1.14p pd=6.38u as=1.14p ps=6.38u w=6u l=1u
X127 VDD iqmod_mixer_0.iqmod_mixer_half_0.iqmod_mixer_se2diff$1_0.iqmod_mixer_se2diff_half_inv$2_0.iqmod_mixer_se2diff_inv_NF6$7_1.vin iqmod_mixer_0.iqmod_mixer_half_0.iqmod_mixer_se2diff$1_0.iqmod_mixer_se2diff_half_inv$2_0.iqmod_mixer_se2diff_inv_NF2$7_1.vout VDD sg13_lv_pmos ad=0.57p pd=3.38u as=0.57p ps=3.38u w=3u l=0.13u
X128 iqmod_mfb_lpf_0.iqmod_mfb_lpf_half_1.iqmod_mfb_lpf_ota_core_hybrid_bm_half$1_0.iqmod_mfb_lpf_ota_core_inv_NF20$2_1.vin iqmod_mfb_lpf_0.iqmod_mfb_lpf_half_1.iqmod_mfb_lpf_ota_core_hybrid_bm_half$1_0.iqmod_mfb_lpf_ota_core_tg$2_0.di_tg_ctrl_n iqmod_spdt_switch_0.v_c VDD sg13_lv_pmos ad=1.14p pd=6.38u as=1.14p ps=6.38u w=6u l=0.13u
X129 iqmod_spdt_switch_1.v_c iqmod_spdt_switch_1.spdt_switch_inv_0.vin di_ds_I_p VSS sg13_lv_nmos ad=0.19p pd=1.38u as=0.19p ps=1.38u w=1u l=0.13u
X130 VSS iqmod_mfb_lpf_0.iqmod_mfb_lpf_half_0.iqmod_mfb_lpf_ota_core_hybrid_bm_half$1_0.iqmod_mfb_lpf_ota_core_tg$2_0.v_a iqmod_mfb_lpf_0.iqmod_mfb_lpf_half_0.iqmod_mfb_lpf_ota_core_hybrid_bm_half$1_0.iqmod_mfb_lpf_ota_core_tg$2_0.v_b VSS sg13_lv_nmos ad=0.19p pd=1.38u as=0.19p ps=1.38u w=1u l=1u
X131 VDD iqmod_mixer_0.vinp_IF iqmod_mfb_lpf_0.iqmod_mfb_lpf_half_0.iqmod_mfb_lpf_ota_core_hybrid_bm_half$1_0.iqmod_mfb_lpf_ota_core_inv_NF20$2_0.vout VDD sg13_lv_pmos ad=1.14p pd=6.38u as=1.14p ps=6.38u w=6u l=1u
X132 iqmod_mixer_0.iqmod_mixer_half_0.iqmod_mixer_se2diff$1_0.iqmod_mixer_se2diff_half_tg$2_0.iqmod_mixer_se2diff_inv_NF54$6_0.vin iqmod_mixer_0.iqmod_mixer_half_0.iqmod_mixer_se2diff$1_0.iqmod_mixer_se2diff_half_tg$2_0.iqmod_mixer_se2diff_inv_NF18$6_0.vin VSS VSS sg13_lv_nmos ad=0.19p pd=1.38u as=0.19p ps=1.38u w=1u l=0.13u
X133 VDD iqmod_mixer_0.iqmod_mixer_half_0.iqmod_mixer_se2diff$1_0.iqmod_mixer_se2diff_half_inv$2_0.iqmod_mixer_se2diff_inv_NF54$7_0.vin iqmod_mixer_0.iqmod_mixer_half_0.iqmod_mixer_tg$1_0.di_tg_ctrl VDD sg13_lv_pmos ad=0.57p pd=3.38u as=0.57p ps=3.38u w=3u l=0.13u
X134 VDD di_lo_I iqmod_mixer_0.iqmod_mixer_half_1.iqmod_mixer_se2diff$1_0.iqmod_mixer_se2diff_half_inv$2_0.iqmod_mixer_se2diff_inv_NF6$7_0.vin VDD sg13_lv_pmos ad=0.57p pd=3.38u as=0.57p ps=3.38u w=3u l=0.13u
X135 iqmod_mfb_lpf_0.iqmod_mfb_lpf_half_0.iqmod_mfb_lpf_ota_core_hybrid_bm_half$1_0.iqmod_mfb_lpf_ota_core_inv_NF6$2_1.vout iqmod_mfb_lpf_0.iqmod_mfb_lpf_half_0.iqmod_mfb_lpf_ota_core_hybrid_bm_half$1_0.iqmod_mfb_lpf_ota_core_inv_NF20$2_0.vout VDD VDD sg13_lv_pmos ad=1.14p pd=6.38u as=1.14p ps=6.38u w=6u l=1u
X136 iqmod_mixer_0.vinp_IF iqmod_mfb_lpf_0.iqmod_mfb_lpf_half_0.iqmod_mfb_lpf_ota_core_hybrid_bm_half$1_0.iqmod_mfb_lpf_ota_core_tg$2_0.v_b VSS VSS sg13_lv_nmos ad=0.19p pd=1.38u as=0.19p ps=1.38u w=1u l=1u
X137 VSS VSS VSS VSS sg13_lv_nmos ad=0.34p pd=2.68u as=0 ps=0 w=1u l=0.13u
X138 VSS VSS VSS VSS sg13_lv_nmos ad=0.34p pd=2.68u as=0 ps=0 w=1u l=0.13u
X139 iqmod_mfb_lpf_0.iqmod_mfb_lpf_half_0.iqmod_mfb_lpf_ota_core_hybrid_bm_half$1_0.iqmod_mfb_lpf_ota_core_inv_NF20$2_0.vout iqmod_mixer_0.vinn_IF VDD VDD sg13_lv_pmos ad=1.14p pd=6.38u as=1.14p ps=6.38u w=6u l=1u
X140 VDD iqmod_mfb_lpf_0.iqmod_mfb_lpf_half_1.iqmod_mfb_lpf_ota_core_hybrid_bm_half$1_0.iqmod_mfb_lpf_ota_core_inv_NF20$2_1.vin iqmod_mfb_lpf_0.iqmod_mfb_lpf_half_0.iqmod_mfb_lpf_ota_core_hybrid_bm_half$1_0.iqmod_mfb_lpf_ota_core_tg$2_0.v_a VDD sg13_lv_pmos ad=1.14p pd=6.38u as=1.14p ps=6.38u w=6u l=1u
X141 iqmod_spdt_switch_0.v_c iqmod_mfb_lpf_0.iqmod_mfb_lpf_half_1.iqmod_mfb_lpf_ota_core_hybrid_bm_half$1_0.iqmod_mfb_lpf_ota_core_tg$2_0.di_tg_ctrl_n iqmod_mfb_lpf_0.iqmod_mfb_lpf_half_1.iqmod_mfb_lpf_ota_core_hybrid_bm_half$1_0.iqmod_mfb_lpf_ota_core_inv_NF20$2_1.vin VDD sg13_lv_pmos ad=1.14p pd=6.38u as=1.14p ps=6.38u w=6u l=0.13u
X142 VDD iqmod_mixer_0.iqmod_mixer_half_0.iqmod_mixer_se2diff$1_0.iqmod_mixer_se2diff_half_tg$2_0.iqmod_mixer_se2diff_inv_NF18$6_0.vin iqmod_mixer_0.iqmod_mixer_half_0.iqmod_mixer_se2diff$1_0.iqmod_mixer_se2diff_half_tg$2_0.iqmod_mixer_se2diff_inv_NF54$6_0.vin VDD sg13_lv_pmos ad=0.57p pd=3.38u as=0.57p ps=3.38u w=3u l=0.13u
X143 VDD VDD VDD VDD sg13_lv_pmos ad=0.57p pd=3.38u as=0 ps=0 w=3u l=0.13u
X144 VSS iqmod_mixer_0.iqmod_mixer_half_0.iqmod_mixer_se2diff$1_0.iqmod_mixer_se2diff_half_tg$2_0.iqmod_mixer_se2diff_inv_NF54$6_0.vin iqmod_mixer_0.iqmod_mixer_half_0.iqmod_mixer_tg$1_0.di_tg_ctrl_n VSS sg13_lv_nmos ad=0.19p pd=1.38u as=0.19p ps=1.38u w=1u l=0.13u
X145 iqmod_spdt_switch_1.v_c a_17187_10452# VSS rhigh l=27u w=0.5u
X146 iqmod_mixer_0.iqmod_mixer_half_0.iqmod_mixer_se2diff$1_0.iqmod_mixer_se2diff_half_inv$2_0.iqmod_mixer_se2diff_inv_NF6$7_1.vin iqmod_mixer_0.iqmod_mixer_half_0.iqmod_mixer_se2diff$1_0.iqmod_mixer_se2diff_half_inv$2_0.iqmod_mixer_se2diff_inv_NF2$7_1.vout VSS VSS sg13_lv_nmos ad=0.19p pd=1.38u as=0.19p ps=1.38u w=1u l=0.13u
X147 VSS di_lo_I iqmod_mixer_0.iqmod_mixer_half_1.iqmod_mixer_se2diff$1_0.iqmod_mixer_se2diff_half_inv$2_0.iqmod_mixer_se2diff_inv_NF6$7_0.vin VSS sg13_lv_nmos ad=0.19p pd=1.38u as=0.19p ps=1.38u w=1u l=0.13u
X148 VDD iqmod_mfb_lpf_0.iqmod_mfb_lpf_half_0.iqmod_mfb_lpf_ota_core_hybrid_bm_half$1_0.iqmod_mfb_lpf_ota_core_inv_NF20$2_1.vin iqmod_mixer_0.vinn_IF VDD sg13_lv_pmos ad=1.14p pd=6.38u as=1.14p ps=6.38u w=6u l=1u
X149 iqmod_mfb_lpf_0.iqmod_mfb_lpf_half_0.C2_half iqmod_mfb_lpf_0.iqmod_mfb_lpf_half_0.iqmod_mfb_lpf_R3$1_0.v_a cap_cmim l=8u w=8u
X150 iqmod_mfb_lpf_0.iqmod_mfb_lpf_half_0.iqmod_mfb_lpf_ota_core_hybrid_bm_half$1_0.iqmod_mfb_lpf_ota_core_inv_NF20$2_1.vin iqmod_mfb_lpf_0.iqmod_mfb_lpf_half_0.iqmod_mfb_lpf_ota_core_hybrid_bm_half$1_0.iqmod_mfb_lpf_ota_core_spdt_switch$2_0.iqmod_mfb_lpf_ota_core_spdt_switch_inv$3_0.vout iqmod_spdt_switch_1.v_c VSS sg13_lv_nmos ad=0.19p pd=1.38u as=0.34p ps=2.68u w=1u l=0.13u
X151 iqmod_mfb_lpf_0.iqmod_mfb_lpf_half_0.iqmod_mfb_lpf_ota_core_hybrid_bm_half$1_0.iqmod_mfb_lpf_ota_core_spdt_switch$2_0.iqmod_mfb_lpf_ota_core_spdt_switch_inv$3_0.vout iqmod_mfb_lpf_0.iqmod_mfb_lpf_half_0.iqmod_mfb_lpf_ota_core_hybrid_bm_half$1_0.iqmod_mfb_lpf_ota_core_tg$2_0.di_tg_ctrl_n VSS VSS sg13_lv_nmos ad=0.19p pd=1.38u as=0.19p ps=1.38u w=1u l=0.13u
X152 VSS iqmod_mixer_0.iqmod_mixer_half_0.iqmod_mixer_se2diff$1_0.iqmod_mixer_se2diff_half_inv$2_0.iqmod_mixer_se2diff_inv_NF6$7_0.vout iqmod_mixer_0.iqmod_mixer_half_0.iqmod_mixer_se2diff$1_0.iqmod_mixer_se2diff_half_inv$2_0.iqmod_mixer_se2diff_inv_NF6$7_1.vin VSS sg13_lv_nmos ad=0.19p pd=1.38u as=0.19p ps=1.38u w=1u l=0.13u
X153 iqmod_mixer_0.vinn_IF iqmod_mfb_lpf_0.iqmod_mfb_lpf_half_0.iqmod_mfb_lpf_ota_core_hybrid_bm_half$1_0.iqmod_mfb_lpf_ota_core_inv_NF20$2_1.vin VSS VSS sg13_lv_nmos ad=0.19p pd=1.38u as=0.19p ps=1.38u w=1u l=1u
X154 iqmod_mixer_0.iqmod_mixer_half_0.iqmod_mixer_tg$1_0.di_tg_ctrl_n iqmod_mixer_0.iqmod_mixer_half_0.iqmod_mixer_se2diff$1_0.iqmod_mixer_se2diff_half_tg$2_0.iqmod_mixer_se2diff_inv_NF54$6_0.vin VSS VSS sg13_lv_nmos ad=0.19p pd=1.38u as=0.19p ps=1.38u w=1u l=0.13u
X155 VSS VSS VSS rhigh l=60u w=0.5u
X156 iqmod_spdt_switch_0.v_c iqmod_spdt_switch_0.spdt_switch_inv_0.vout di_ds_I_n VDD sg13_lv_pmos ad=1.14p pd=6.38u as=2.04p ps=12.68u w=6u l=0.13u
X157 VSS iqmod_mixer_0.iqmod_mixer_half_1.iqmod_mixer_se2diff$1_0.iqmod_mixer_se2diff_half_tg$2_0.iqmod_mixer_se2diff_inv_NF54$6_0.vin iqmod_mixer_0.iqmod_mixer_half_1.iqmod_mixer_tg$1_0.di_tg_ctrl_n VSS sg13_lv_nmos ad=0.19p pd=1.38u as=0.19p ps=1.38u w=1u l=0.13u
X158 VDD di_lo_Ix iqmod_mixer_0.iqmod_mixer_half_0.iqmod_mixer_se2diff$1_0.iqmod_mixer_se2diff_half_inv$2_0.iqmod_mixer_se2diff_inv_NF6$7_0.vin VDD sg13_lv_pmos ad=0.57p pd=3.38u as=0.57p ps=3.38u w=3u l=0.13u
X159 vinn_I iqmod_spdt_switch_0.spdt_switch_inv_0.vin iqmod_spdt_switch_0.v_c VDD sg13_lv_pmos ad=1.14p pd=6.38u as=1.14p ps=6.38u w=6u l=0.13u
X160 iqmod_mixer_0.iqmod_mixer_half_0.iqmod_mixer_se2diff$1_0.iqmod_mixer_se2diff_half_inv$2_0.iqmod_mixer_se2diff_inv_NF6$7_1.vin iqmod_mixer_0.iqmod_mixer_half_0.iqmod_mixer_se2diff$1_0.iqmod_mixer_se2diff_half_inv$2_0.iqmod_mixer_se2diff_inv_NF6$7_0.vout VSS VSS sg13_lv_nmos ad=0.19p pd=1.38u as=0.19p ps=1.38u w=1u l=0.13u
X161 iqmod_mixer_0.iqmod_mixer_half_0.iqmod_mixer_se2diff$1_0.iqmod_mixer_se2diff_half_inv$2_0.iqmod_mixer_se2diff_inv_NF2$7_1.vout iqmod_mixer_0.iqmod_mixer_half_0.iqmod_mixer_se2diff$1_0.iqmod_mixer_se2diff_half_tg$2_0.iqmod_mixer_se2diff_tg_NF6$3_0.v_b VDD VDD sg13_lv_pmos ad=0.57p pd=3.38u as=0.57p ps=3.38u w=3u l=0.13u
X162 VSS VSS VSS VSS sg13_lv_nmos ad=0.34p pd=2.68u as=0 ps=0 w=1u l=0.13u
X163 VSS iqmod_mixer_0.iqmod_mixer_half_0.iqmod_mixer_se2diff$1_0.iqmod_mixer_se2diff_half_tg$2_0.iqmod_mixer_se2diff_inv_NF54$6_0.vin iqmod_mixer_0.iqmod_mixer_half_0.iqmod_mixer_tg$1_0.di_tg_ctrl_n VSS sg13_lv_nmos ad=0.19p pd=1.38u as=0.19p ps=1.38u w=1u l=0.13u
X164 iqmod_mixer_0.vinn_IF iqmod_mixer_0.iqmod_mixer_half_0.iqmod_mixer_tg$1_0.di_tg_ctrl_n voutn_I_RF VDD sg13_lv_pmos ad=1.71p pd=9.38u as=1.71p ps=9.38u w=9u l=0.13u
X165 iqmod_mixer_0.iqmod_mixer_half_1.iqmod_mixer_tg$1_0.di_tg_ctrl_n iqmod_mixer_0.iqmod_mixer_half_1.iqmod_mixer_se2diff$1_0.iqmod_mixer_se2diff_half_tg$2_0.iqmod_mixer_se2diff_inv_NF54$6_0.vin VSS VSS sg13_lv_nmos ad=0.19p pd=1.38u as=0.19p ps=1.38u w=1u l=0.13u
X166 VDD di_analog_en iqmod_mfb_lpf_0.iqmod_mfb_lpf_half_0.iqmod_mfb_lpf_ota_core_hybrid_bm_half$1_0.iqmod_mfb_lpf_ota_core_tg$2_0.di_tg_ctrl_n VDD sg13_lv_pmos ad=1.14p pd=6.38u as=1.14p ps=6.38u w=6u l=0.13u
X167 VSS iqmod_mfb_lpf_0.iqmod_mfb_lpf_half_1.iqmod_mfb_lpf_ota_core_hybrid_bm_half$1_0.iqmod_mfb_lpf_ota_core_inv_NF20$2_1.vin iqmod_mixer_0.vinp_IF VSS sg13_lv_nmos ad=0.19p pd=1.38u as=0.19p ps=1.38u w=1u l=1u
X168 VSS iqmod_mfb_lpf_0.iqmod_mfb_lpf_half_0.iqmod_mfb_lpf_ota_core_hybrid_bm_half$1_0.iqmod_mfb_lpf_ota_core_inv_NF20$2_1.vin iqmod_mixer_0.vinn_IF VSS sg13_lv_nmos ad=0.19p pd=1.38u as=0.19p ps=1.38u w=1u l=1u
X169 VDD iqmod_mixer_0.iqmod_mixer_half_0.iqmod_mixer_se2diff$1_0.iqmod_mixer_se2diff_half_tg$2_0.iqmod_mixer_se2diff_tg_NF6$3_0.v_b iqmod_mixer_0.iqmod_mixer_half_0.iqmod_mixer_se2diff$1_0.iqmod_mixer_se2diff_half_inv$2_0.iqmod_mixer_se2diff_inv_NF2$7_1.vout VDD sg13_lv_pmos ad=0.57p pd=3.38u as=0.57p ps=3.38u w=3u l=0.13u
X170 voutp_I_RF iqmod_mixer_0.iqmod_mixer_half_1.iqmod_mixer_tg$1_0.di_tg_ctrl_n iqmod_mixer_0.vinp_IF VDD sg13_lv_pmos ad=1.71p pd=9.38u as=1.71p ps=9.38u w=9u l=0.13u
X171 VSS VSS VSS VSS sg13_lv_nmos ad=0.19p pd=1.38u as=0 ps=0 w=1u l=0.13u
X172 VDD iqmod_mixer_0.iqmod_mixer_half_1.iqmod_mixer_se2diff$1_0.iqmod_mixer_se2diff_half_inv$2_0.iqmod_mixer_se2diff_inv_NF18$7_0.vin iqmod_mixer_0.iqmod_mixer_half_1.iqmod_mixer_se2diff$1_0.iqmod_mixer_se2diff_half_inv$2_0.iqmod_mixer_se2diff_inv_NF54$7_0.vin VDD sg13_lv_pmos ad=0.57p pd=3.38u as=0.57p ps=3.38u w=3u l=0.13u
X173 voutn_I_RF iqmod_mixer_0.iqmod_mixer_half_0.iqmod_mixer_tg$1_0.di_tg_ctrl_n voutn_I_RF VSS sg13_lv_nmos ad=0.57p pd=3.38u as=93.24p ps=0.91908m w=3u l=0.13u
X174 iqmod_mixer_0.vinp_IF iqmod_mixer_0.iqmod_mixer_half_1.iqmod_mixer_tg$1_0.di_tg_ctrl_n voutp_I_RF VDD sg13_lv_pmos ad=1.71p pd=9.38u as=1.71p ps=9.38u w=9u l=0.13u
X175 iqmod_mixer_0.iqmod_mixer_half_0.iqmod_mixer_se2diff$1_0.iqmod_mixer_se2diff_half_inv$2_0.iqmod_mixer_se2diff_inv_NF6$7_0.vin di_lo_Ix VSS VSS sg13_lv_nmos ad=0.19p pd=1.38u as=0.19p ps=1.38u w=1u l=0.13u
X176 iqmod_mfb_lpf_0.iqmod_mfb_lpf_half_0.iqmod_mfb_lpf_ota_core_hybrid_bm_half$1_0.iqmod_mfb_lpf_ota_core_tg$2_0.v_b iqmod_mfb_lpf_0.iqmod_mfb_lpf_half_0.iqmod_mfb_lpf_ota_core_hybrid_bm_half$1_0.iqmod_mfb_lpf_ota_core_inv_NF6$2_1.vout VDD VDD sg13_lv_pmos ad=1.14p pd=6.38u as=1.14p ps=6.38u w=6u l=1u
X177 VDD iqmod_mixer_0.iqmod_mixer_half_1.iqmod_mixer_se2diff$1_0.iqmod_mixer_se2diff_half_tg$2_0.iqmod_mixer_se2diff_inv_NF18$6_0.vin iqmod_mixer_0.iqmod_mixer_half_1.iqmod_mixer_se2diff$1_0.iqmod_mixer_se2diff_half_tg$2_0.iqmod_mixer_se2diff_inv_NF54$6_0.vin VDD sg13_lv_pmos ad=0.57p pd=3.38u as=0.57p ps=3.38u w=3u l=0.13u
X178 iqmod_mixer_0.iqmod_mixer_half_0.iqmod_mixer_tg$1_0.di_tg_ctrl iqmod_mixer_0.iqmod_mixer_half_0.iqmod_mixer_se2diff$1_0.iqmod_mixer_se2diff_half_inv$2_0.iqmod_mixer_se2diff_inv_NF54$7_0.vin VSS VSS sg13_lv_nmos ad=0.19p pd=1.38u as=0.19p ps=1.38u w=1u l=0.13u
X179 VDD iqmod_mixer_0.iqmod_mixer_half_1.iqmod_mixer_se2diff$1_0.iqmod_mixer_se2diff_half_inv$2_0.iqmod_mixer_se2diff_inv_NF18$7_0.vin iqmod_mixer_0.iqmod_mixer_half_1.iqmod_mixer_se2diff$1_0.iqmod_mixer_se2diff_half_inv$2_0.iqmod_mixer_se2diff_inv_NF54$7_0.vin VDD sg13_lv_pmos ad=0.57p pd=3.38u as=0.57p ps=3.38u w=3u l=0.13u
X180 a_36853_1946# a_48939_2246# VSS rhigh l=60u w=0.5u
X181 iqmod_mixer_0.iqmod_mixer_half_1.iqmod_mixer_se2diff$1_0.iqmod_mixer_se2diff_half_tg$2_0.iqmod_mixer_se2diff_inv_NF54$6_0.vin iqmod_mixer_0.iqmod_mixer_half_1.iqmod_mixer_se2diff$1_0.iqmod_mixer_se2diff_half_tg$2_0.iqmod_mixer_se2diff_inv_NF18$6_0.vin VDD VDD sg13_lv_pmos ad=0.57p pd=3.38u as=0.57p ps=3.38u w=3u l=0.13u
X182 a_11701_1946# a_17187_2246# VSS rhigh l=27u w=0.5u
X183 VSS iqmod_mfb_lpf_0.iqmod_mfb_lpf_half_0.iqmod_mfb_lpf_ota_core_hybrid_bm_half$1_0.iqmod_mfb_lpf_ota_core_tg$2_0.v_b iqmod_mixer_0.vinn_IF VSS sg13_lv_nmos ad=0.19p pd=1.38u as=0.19p ps=1.38u w=1u l=1u
X184 VSS iqmod_mixer_0.iqmod_mixer_half_0.iqmod_mixer_se2diff$1_0.iqmod_mixer_se2diff_half_inv$2_0.iqmod_mixer_se2diff_inv_NF54$7_0.vin iqmod_mixer_0.iqmod_mixer_half_0.iqmod_mixer_tg$1_0.di_tg_ctrl VSS sg13_lv_nmos ad=0.19p pd=1.38u as=0.19p ps=1.38u w=1u l=0.13u
X185 VDD iqmod_mixer_0.iqmod_mixer_half_0.iqmod_mixer_se2diff$1_0.iqmod_mixer_se2diff_half_tg$2_0.iqmod_mixer_se2diff_inv_NF54$6_0.vin iqmod_mixer_0.iqmod_mixer_half_0.iqmod_mixer_tg$1_0.di_tg_ctrl_n VDD sg13_lv_pmos ad=0.57p pd=3.38u as=0.57p ps=3.38u w=3u l=0.13u
X186 iqmod_mixer_0.iqmod_mixer_half_1.iqmod_mixer_tg$1_0.di_tg_ctrl_n iqmod_mixer_0.iqmod_mixer_half_1.iqmod_mixer_se2diff$1_0.iqmod_mixer_se2diff_half_tg$2_0.iqmod_mixer_se2diff_inv_NF54$6_0.vin VSS VSS sg13_lv_nmos ad=0.19p pd=1.38u as=0.19p ps=1.38u w=1u l=0.13u
X187 VDD iqmod_mixer_0.iqmod_mixer_half_1.iqmod_mixer_se2diff$1_0.iqmod_mixer_se2diff_half_inv$2_0.iqmod_mixer_se2diff_inv_NF18$7_0.vin iqmod_mixer_0.iqmod_mixer_half_1.iqmod_mixer_se2diff$1_0.iqmod_mixer_se2diff_half_inv$2_0.iqmod_mixer_se2diff_inv_NF54$7_0.vin VDD sg13_lv_pmos ad=0.57p pd=3.38u as=0.57p ps=3.38u w=3u l=0.13u
X188 VDD VDD VDD VDD sg13_lv_pmos ad=0.57p pd=3.38u as=0 ps=0 w=3u l=0.13u
X189 iqmod_mixer_0.iqmod_mixer_half_0.iqmod_mixer_tg$1_0.di_tg_ctrl_n iqmod_mixer_0.iqmod_mixer_half_0.iqmod_mixer_se2diff$1_0.iqmod_mixer_se2diff_half_tg$2_0.iqmod_mixer_se2diff_inv_NF54$6_0.vin VDD VDD sg13_lv_pmos ad=0.57p pd=3.38u as=0.57p ps=3.38u w=3u l=0.13u
X190 VSS iqmod_mixer_0.iqmod_mixer_half_1.iqmod_mixer_se2diff$1_0.iqmod_mixer_se2diff_half_inv$2_0.iqmod_mixer_se2diff_inv_NF18$7_0.vin iqmod_mixer_0.iqmod_mixer_half_1.iqmod_mixer_se2diff$1_0.iqmod_mixer_se2diff_half_inv$2_0.iqmod_mixer_se2diff_inv_NF54$7_0.vin VSS sg13_lv_nmos ad=0.19p pd=1.38u as=0.19p ps=1.38u w=1u l=0.13u
X191 voutn_I_RF iqmod_mixer_0.iqmod_mixer_half_0.iqmod_mixer_tg$1_0.di_tg_ctrl_n iqmod_mixer_0.vinn_IF VDD sg13_lv_pmos ad=1.71p pd=9.38u as=1.71p ps=9.38u w=9u l=0.13u
X192 iqmod_mfb_lpf_0.iqmod_mfb_lpf_half_0.iqmod_mfb_lpf_ota_core_hybrid_bm_half$1_0.iqmod_mfb_lpf_ota_core_inv_NF20$2_0.vout iqmod_mfb_lpf_0.iqmod_mfb_lpf_half_1.iqmod_mfb_lpf_ota_core_hybrid_bm_half$1_0.iqmod_mfb_lpf_ota_core_tg$2_0.di_tg_ctrl_n iqmod_mfb_lpf_0.iqmod_mfb_lpf_half_0.iqmod_mfb_lpf_ota_core_hybrid_bm_half$1_0.iqmod_mfb_lpf_ota_core_inv_NF6$2_1.vout VDD sg13_lv_pmos ad=1.14p pd=6.38u as=1.14p ps=6.38u w=6u l=0.13u
X193 iqmod_mixer_0.vinn_IF iqmod_mfb_lpf_0.iqmod_mfb_lpf_half_0.iqmod_mfb_lpf_ota_core_hybrid_bm_half$1_0.iqmod_mfb_lpf_ota_core_tg$2_0.v_b VSS VSS sg13_lv_nmos ad=0.19p pd=1.38u as=0.19p ps=1.38u w=1u l=1u
X194 voutp_I_RF iqmod_mixer_0.iqmod_mixer_half_1.iqmod_mixer_tg$1_0.di_tg_ctrl voutp_I_RF VDD sg13_lv_pmos ad=1.71p pd=9.38u as=0 ps=0 w=9u l=0.13u
X195 VDD iqmod_mixer_0.iqmod_mixer_half_0.iqmod_mixer_se2diff$1_0.iqmod_mixer_se2diff_half_inv$2_0.iqmod_mixer_se2diff_inv_NF18$7_0.vin iqmod_mixer_0.iqmod_mixer_half_0.iqmod_mixer_se2diff$1_0.iqmod_mixer_se2diff_half_inv$2_0.iqmod_mixer_se2diff_inv_NF54$7_0.vin VDD sg13_lv_pmos ad=0.57p pd=3.38u as=0.57p ps=3.38u w=3u l=0.13u
X196 iqmod_mfb_lpf_0.iqmod_mfb_lpf_half_0.iqmod_mfb_lpf_ota_core_hybrid_bm_half$1_0.iqmod_mfb_lpf_ota_core_inv_NF20$2_0.vout iqmod_mixer_0.vinn_IF VDD VDD sg13_lv_pmos ad=1.14p pd=6.38u as=1.14p ps=6.38u w=6u l=1u
X197 iqmod_mixer_0.vinp_IF iqmod_mixer_0.iqmod_mixer_half_1.iqmod_mixer_tg$1_0.di_tg_ctrl_n voutp_I_RF VDD sg13_lv_pmos ad=1.71p pd=9.38u as=1.71p ps=9.38u w=9u l=0.13u
X198 VDD iqmod_mixer_0.iqmod_mixer_half_0.iqmod_mixer_se2diff$1_0.iqmod_mixer_se2diff_half_tg$2_0.iqmod_mixer_se2diff_inv_NF54$6_0.vin iqmod_mixer_0.iqmod_mixer_half_0.iqmod_mixer_tg$1_0.di_tg_ctrl_n VDD sg13_lv_pmos ad=0.57p pd=3.38u as=0.57p ps=3.38u w=3u l=0.13u
X199 iqmod_mixer_0.iqmod_mixer_half_1.iqmod_mixer_se2diff$1_0.iqmod_mixer_se2diff_half_inv$2_0.iqmod_mixer_se2diff_inv_NF54$7_0.vin iqmod_mixer_0.iqmod_mixer_half_1.iqmod_mixer_se2diff$1_0.iqmod_mixer_se2diff_half_inv$2_0.iqmod_mixer_se2diff_inv_NF18$7_0.vin VSS VSS sg13_lv_nmos ad=0.19p pd=1.38u as=0.19p ps=1.38u w=1u l=0.13u
X200 voutn_I_RF iqmod_mixer_0.iqmod_mixer_half_0.iqmod_mixer_tg$1_0.di_tg_ctrl_n voutn_I_RF VSS sg13_lv_nmos ad=0.57p pd=3.38u as=0 ps=0 w=3u l=0.13u
X201 iqmod_mixer_0.iqmod_mixer_half_1.iqmod_mixer_tg$1_0.di_tg_ctrl_n iqmod_mixer_0.iqmod_mixer_half_1.iqmod_mixer_se2diff$1_0.iqmod_mixer_se2diff_half_tg$2_0.iqmod_mixer_se2diff_inv_NF54$6_0.vin VDD VDD sg13_lv_pmos ad=0.57p pd=3.38u as=0.57p ps=3.38u w=3u l=0.13u
X202 voutn_I_RF iqmod_mixer_0.iqmod_mixer_half_0.iqmod_mixer_tg$1_0.di_tg_ctrl iqmod_mixer_0.vinn_IF VSS sg13_lv_nmos ad=0.57p pd=3.38u as=0.57p ps=3.38u w=3u l=0.13u
X203 iqmod_mfb_lpf_0.iqmod_mfb_lpf_half_0.iqmod_mfb_lpf_ota_core_hybrid_bm_half$1_0.iqmod_mfb_lpf_ota_core_tg$2_0.v_b iqmod_mfb_lpf_0.iqmod_mfb_lpf_half_0.iqmod_mfb_lpf_ota_core_hybrid_bm_half$1_0.iqmod_mfb_lpf_ota_core_inv_NF6$2_1.vout VDD VDD sg13_lv_pmos ad=1.14p pd=6.38u as=1.14p ps=6.38u w=6u l=1u
X204 iqmod_mixer_0.iqmod_mixer_half_1.iqmod_mixer_tg$1_0.di_tg_ctrl_n iqmod_mixer_0.iqmod_mixer_half_1.iqmod_mixer_se2diff$1_0.iqmod_mixer_se2diff_half_tg$2_0.iqmod_mixer_se2diff_inv_NF54$6_0.vin VDD VDD sg13_lv_pmos ad=0.57p pd=3.38u as=0.57p ps=3.38u w=3u l=0.13u
X205 voutp_I_RF iqmod_mixer_0.iqmod_mixer_half_1.iqmod_mixer_tg$1_0.di_tg_ctrl voutp_I_RF VDD sg13_lv_pmos ad=1.71p pd=9.38u as=0 ps=0 w=9u l=0.13u
X206 iqmod_mixer_0.iqmod_mixer_half_0.iqmod_mixer_se2diff$1_0.iqmod_mixer_se2diff_half_inv$2_0.iqmod_mixer_se2diff_inv_NF54$7_0.vin iqmod_mixer_0.iqmod_mixer_half_0.iqmod_mixer_se2diff$1_0.iqmod_mixer_se2diff_half_inv$2_0.iqmod_mixer_se2diff_inv_NF18$7_0.vin VDD VDD sg13_lv_pmos ad=0.57p pd=3.38u as=0.57p ps=3.38u w=3u l=0.13u
X207 iqmod_mixer_0.vinp_IF iqmod_mixer_0.iqmod_mixer_half_1.iqmod_mixer_tg$1_0.di_tg_ctrl voutp_I_RF VSS sg13_lv_nmos ad=0.57p pd=3.38u as=0.57p ps=3.38u w=3u l=0.13u
X208 VDD iqmod_mixer_0.iqmod_mixer_half_1.iqmod_mixer_se2diff$1_0.iqmod_mixer_se2diff_half_tg$2_0.iqmod_mixer_se2diff_inv_NF54$6_0.vin iqmod_mixer_0.iqmod_mixer_half_1.iqmod_mixer_tg$1_0.di_tg_ctrl_n VDD sg13_lv_pmos ad=0.57p pd=3.38u as=0.57p ps=3.38u w=3u l=0.13u
X209 VDD iqmod_mixer_0.iqmod_mixer_half_1.iqmod_mixer_se2diff$1_0.iqmod_mixer_se2diff_half_tg$2_0.iqmod_mixer_se2diff_inv_NF54$6_0.vin iqmod_mixer_0.iqmod_mixer_half_1.iqmod_mixer_tg$1_0.di_tg_ctrl_n VDD sg13_lv_pmos ad=0.57p pd=3.38u as=0.57p ps=3.38u w=3u l=0.13u
X210 iqmod_mfb_lpf_0.iqmod_mfb_lpf_half_0.iqmod_mfb_lpf_ota_core_hybrid_bm_half$1_0.iqmod_mfb_lpf_ota_core_inv_NF20$2_0.vout iqmod_mixer_0.vinp_IF VSS VSS sg13_lv_nmos ad=0.19p pd=1.38u as=0.19p ps=1.38u w=1u l=1u
X211 voutp_I_RF iqmod_mixer_0.iqmod_mixer_half_1.iqmod_mixer_tg$1_0.di_tg_ctrl iqmod_mixer_0.vinp_IF VSS sg13_lv_nmos ad=0.57p pd=3.38u as=0.57p ps=3.38u w=3u l=0.13u
X212 VDD iqmod_mfb_lpf_0.iqmod_mfb_lpf_half_0.iqmod_mfb_lpf_ota_core_hybrid_bm_half$1_0.iqmod_mfb_lpf_ota_core_inv_NF6$2_1.vout iqmod_mfb_lpf_0.iqmod_mfb_lpf_half_0.iqmod_mfb_lpf_ota_core_hybrid_bm_half$1_0.iqmod_mfb_lpf_ota_core_tg$2_0.v_b VDD sg13_lv_pmos ad=1.14p pd=6.38u as=1.14p ps=6.38u w=6u l=1u
X213 iqmod_mfb_lpf_0.iqmod_mfb_lpf_half_1.iqmod_mfb_lpf_ota_core_hybrid_bm_half$1_0.iqmod_mfb_lpf_ota_core_inv_NF20$2_1.vin iqmod_mfb_lpf_0.iqmod_mfb_lpf_half_1.iqmod_mfb_lpf_ota_core_hybrid_bm_half$1_0.iqmod_mfb_lpf_ota_core_tg$2_0.di_tg_ctrl_n VDD VSS sg13_lv_nmos ad=0.19p pd=1.38u as=0.34p ps=2.68u w=1u l=0.13u
X214 iqmod_spdt_switch_0.v_c iqmod_mfb_lpf_0.iqmod_mfb_lpf_half_1.iqmod_mfb_lpf_ota_core_hybrid_bm_half$1_0.iqmod_mfb_lpf_ota_core_spdt_switch$2_0.iqmod_mfb_lpf_ota_core_spdt_switch_inv$3_0.vout iqmod_mfb_lpf_0.iqmod_mfb_lpf_half_1.iqmod_mfb_lpf_ota_core_hybrid_bm_half$1_0.iqmod_mfb_lpf_ota_core_inv_NF20$2_1.vin VSS sg13_lv_nmos ad=0.19p pd=1.38u as=0.19p ps=1.38u w=1u l=0.13u
X215 iqmod_mixer_0.iqmod_mixer_half_1.iqmod_mixer_tg$1_0.di_tg_ctrl iqmod_mixer_0.iqmod_mixer_half_1.iqmod_mixer_se2diff$1_0.iqmod_mixer_se2diff_half_inv$2_0.iqmod_mixer_se2diff_inv_NF54$7_0.vin VSS VSS sg13_lv_nmos ad=0.19p pd=1.38u as=0.19p ps=1.38u w=1u l=0.13u
X216 iqmod_mfb_lpf_0.iqmod_mfb_lpf_half_0.iqmod_mfb_lpf_ota_core_hybrid_bm_half$1_0.iqmod_mfb_lpf_ota_core_inv_NF20$2_0.vout iqmod_mixer_0.vinp_IF VDD VDD sg13_lv_pmos ad=1.14p pd=6.38u as=1.14p ps=6.38u w=6u l=1u
X217 iqmod_mixer_0.iqmod_mixer_half_1.iqmod_mixer_tg$1_0.di_tg_ctrl iqmod_mixer_0.iqmod_mixer_half_1.iqmod_mixer_se2diff$1_0.iqmod_mixer_se2diff_half_inv$2_0.iqmod_mixer_se2diff_inv_NF54$7_0.vin VSS VSS sg13_lv_nmos ad=0.19p pd=1.38u as=0.19p ps=1.38u w=1u l=0.13u
X218 iqmod_mixer_0.iqmod_mixer_half_0.iqmod_mixer_tg$1_0.di_tg_ctrl iqmod_mixer_0.iqmod_mixer_half_0.iqmod_mixer_se2diff$1_0.iqmod_mixer_se2diff_half_inv$2_0.iqmod_mixer_se2diff_inv_NF54$7_0.vin VDD VDD sg13_lv_pmos ad=0.57p pd=3.38u as=0.57p ps=3.38u w=3u l=0.13u
X219 VSS iqmod_mixer_0.iqmod_mixer_half_1.iqmod_mixer_se2diff$1_0.iqmod_mixer_se2diff_half_inv$2_0.iqmod_mixer_se2diff_inv_NF54$7_0.vin iqmod_mixer_0.iqmod_mixer_half_1.iqmod_mixer_tg$1_0.di_tg_ctrl VSS sg13_lv_nmos ad=0.19p pd=1.38u as=0.19p ps=1.38u w=1u l=0.13u
X220 VSS iqmod_mixer_0.vinp_IF iqmod_mfb_lpf_0.iqmod_mfb_lpf_half_0.iqmod_mfb_lpf_ota_core_hybrid_bm_half$1_0.iqmod_mfb_lpf_ota_core_inv_NF20$2_0.vout VSS sg13_lv_nmos ad=0.19p pd=1.38u as=0.19p ps=1.38u w=1u l=1u
X221 VSS iqmod_mixer_0.iqmod_mixer_half_0.iqmod_mixer_se2diff$1_0.iqmod_mixer_se2diff_half_inv$2_0.iqmod_mixer_se2diff_inv_NF18$7_0.vin iqmod_mixer_0.iqmod_mixer_half_0.iqmod_mixer_se2diff$1_0.iqmod_mixer_se2diff_half_inv$2_0.iqmod_mixer_se2diff_inv_NF54$7_0.vin VSS sg13_lv_nmos ad=0.19p pd=1.38u as=0.19p ps=1.38u w=1u l=0.13u
X222 iqmod_mixer_0.vinn_IF iqmod_mfb_lpf_0.iqmod_mfb_lpf_half_0.iqmod_mfb_lpf_ota_core_hybrid_bm_half$1_0.iqmod_mfb_lpf_ota_core_inv_NF20$2_1.vin VSS VSS sg13_lv_nmos ad=0.19p pd=1.38u as=0.19p ps=1.38u w=1u l=1u
X223 iqmod_mixer_0.iqmod_mixer_half_0.iqmod_mixer_tg$1_0.di_tg_ctrl iqmod_mixer_0.iqmod_mixer_half_0.iqmod_mixer_se2diff$1_0.iqmod_mixer_se2diff_half_inv$2_0.iqmod_mixer_se2diff_inv_NF54$7_0.vin VDD VDD sg13_lv_pmos ad=0.57p pd=3.38u as=0.57p ps=3.38u w=3u l=0.13u
X224 VDD iqmod_mixer_0.iqmod_mixer_half_0.iqmod_mixer_se2diff$1_0.iqmod_mixer_se2diff_half_tg$2_0.iqmod_mixer_se2diff_inv_NF18$6_0.vin iqmod_mixer_0.iqmod_mixer_half_0.iqmod_mixer_se2diff$1_0.iqmod_mixer_se2diff_half_tg$2_0.iqmod_mixer_se2diff_inv_NF54$6_0.vin VDD sg13_lv_pmos ad=0.57p pd=3.38u as=0.57p ps=3.38u w=3u l=0.13u
X225 iqmod_mixer_0.iqmod_mixer_half_1.iqmod_mixer_se2diff$1_0.iqmod_mixer_se2diff_half_tg$2_0.iqmod_mixer_se2diff_inv_NF54$6_0.vin iqmod_mixer_0.iqmod_mixer_half_1.iqmod_mixer_se2diff$1_0.iqmod_mixer_se2diff_half_tg$2_0.iqmod_mixer_se2diff_inv_NF18$6_0.vin VSS VSS sg13_lv_nmos ad=0.19p pd=1.38u as=0.19p ps=1.38u w=1u l=0.13u
X226 VSS iqmod_mixer_0.iqmod_mixer_half_1.iqmod_mixer_se2diff$1_0.iqmod_mixer_se2diff_half_inv$2_0.iqmod_mixer_se2diff_inv_NF54$7_0.vin iqmod_mixer_0.iqmod_mixer_half_1.iqmod_mixer_tg$1_0.di_tg_ctrl VSS sg13_lv_nmos ad=0.19p pd=1.38u as=0.19p ps=1.38u w=1u l=0.13u
X227 VDD VDD VDD VDD sg13_lv_pmos ad=1.14p pd=6.38u as=0 ps=0 w=6u l=1u
X228 VDD iqmod_mixer_0.iqmod_mixer_half_1.iqmod_mixer_se2diff$1_0.iqmod_mixer_se2diff_half_inv$2_0.iqmod_mixer_se2diff_inv_NF54$7_0.vin iqmod_mixer_0.iqmod_mixer_half_1.iqmod_mixer_tg$1_0.di_tg_ctrl VDD sg13_lv_pmos ad=0.57p pd=3.38u as=0.57p ps=3.38u w=3u l=0.13u
X229 iqmod_mfb_lpf_0.iqmod_mfb_lpf_half_0.iqmod_mfb_lpf_ota_core_hybrid_bm_half$1_0.iqmod_mfb_lpf_ota_core_tg$2_0.v_a iqmod_mfb_lpf_0.iqmod_mfb_lpf_half_1.iqmod_mfb_lpf_ota_core_hybrid_bm_half$1_0.iqmod_mfb_lpf_ota_core_inv_NF20$2_1.vin VSS VSS sg13_lv_nmos ad=0.19p pd=1.38u as=0.19p ps=1.38u w=1u l=1u
X230 VDD iqmod_mixer_0.iqmod_mixer_half_0.iqmod_mixer_se2diff$1_0.iqmod_mixer_se2diff_half_inv$2_0.iqmod_mixer_se2diff_inv_NF54$7_0.vin iqmod_mixer_0.iqmod_mixer_half_0.iqmod_mixer_tg$1_0.di_tg_ctrl VDD sg13_lv_pmos ad=0.57p pd=3.38u as=0.57p ps=3.38u w=3u l=0.13u
X231 iqmod_mfb_lpf_0.iqmod_mfb_lpf_half_0.iqmod_mfb_lpf_ota_core_hybrid_bm_half$1_0.iqmod_mfb_lpf_ota_core_tg$2_0.v_a iqmod_mfb_lpf_0.iqmod_mfb_lpf_half_0.iqmod_mfb_lpf_ota_core_hybrid_bm_half$1_0.iqmod_mfb_lpf_ota_core_tg$2_0.di_tg_ctrl_n iqmod_mfb_lpf_0.iqmod_mfb_lpf_half_0.iqmod_mfb_lpf_ota_core_hybrid_bm_half$1_0.iqmod_mfb_lpf_ota_core_tg$2_0.v_b VDD sg13_lv_pmos ad=2.04p pd=12.68u as=1.14p ps=6.38u w=6u l=0.13u
X232 VDD iqmod_mixer_0.iqmod_mixer_half_0.iqmod_mixer_se2diff$1_0.iqmod_mixer_se2diff_half_inv$2_0.iqmod_mixer_se2diff_inv_NF54$7_0.vin iqmod_mixer_0.iqmod_mixer_half_0.iqmod_mixer_tg$1_0.di_tg_ctrl VDD sg13_lv_pmos ad=0.57p pd=3.38u as=0.57p ps=3.38u w=3u l=0.13u
X233 iqmod_mixer_0.iqmod_mixer_half_0.iqmod_mixer_se2diff$1_0.iqmod_mixer_se2diff_half_tg$2_0.iqmod_mixer_se2diff_inv_NF54$6_0.vin iqmod_mixer_0.iqmod_mixer_half_0.iqmod_mixer_se2diff$1_0.iqmod_mixer_se2diff_half_tg$2_0.iqmod_mixer_se2diff_inv_NF18$6_0.vin VDD VDD sg13_lv_pmos ad=0.57p pd=3.38u as=0.57p ps=3.38u w=3u l=0.13u
X234 VSS iqmod_mixer_0.iqmod_mixer_half_1.iqmod_mixer_se2diff$1_0.iqmod_mixer_se2diff_half_tg$2_0.iqmod_mixer_se2diff_inv_NF18$6_0.vin iqmod_mixer_0.iqmod_mixer_half_1.iqmod_mixer_se2diff$1_0.iqmod_mixer_se2diff_half_tg$2_0.iqmod_mixer_se2diff_inv_NF54$6_0.vin VSS sg13_lv_nmos ad=0.19p pd=1.38u as=0.19p ps=1.38u w=1u l=0.13u
X235 VDD iqmod_mfb_lpf_0.iqmod_mfb_lpf_half_1.iqmod_mfb_lpf_ota_core_hybrid_bm_half$1_0.iqmod_mfb_lpf_ota_core_inv_NF20$2_1.vin iqmod_mixer_0.vinp_IF VDD sg13_lv_pmos ad=1.14p pd=6.38u as=1.14p ps=6.38u w=6u l=1u
X236 vinn_I iqmod_spdt_switch_0.spdt_switch_inv_0.vout iqmod_spdt_switch_0.v_c VSS sg13_lv_nmos ad=0.34p pd=2.68u as=0.19p ps=1.38u w=1u l=0.13u
X237 iqmod_mixer_0.iqmod_mixer_half_1.iqmod_mixer_se2diff$1_0.iqmod_mixer_se2diff_half_tg$2_0.iqmod_mixer_se2diff_inv_NF18$6_0.vin iqmod_mixer_0.iqmod_mixer_half_1.iqmod_mixer_se2diff$1_0.iqmod_mixer_se2diff_half_inv$2_0.iqmod_mixer_se2diff_inv_NF2$7_1.vout VDD VDD sg13_lv_pmos ad=0.57p pd=3.38u as=0.57p ps=3.38u w=3u l=0.13u
X238 VSS iqmod_mfb_lpf_0.iqmod_mfb_lpf_half_0.iqmod_mfb_lpf_ota_core_hybrid_bm_half$1_0.iqmod_mfb_lpf_ota_core_inv_NF20$2_1.vin iqmod_mixer_0.vinn_IF VSS sg13_lv_nmos ad=0.19p pd=1.38u as=0.19p ps=1.38u w=1u l=1u
X239 VDD iqmod_mixer_0.iqmod_mixer_half_1.iqmod_mixer_se2diff$1_0.iqmod_mixer_se2diff_half_inv$2_0.iqmod_mixer_se2diff_inv_NF54$7_0.vin iqmod_mixer_0.iqmod_mixer_half_1.iqmod_mixer_tg$1_0.di_tg_ctrl VDD sg13_lv_pmos ad=0.57p pd=3.38u as=0.57p ps=3.38u w=3u l=0.13u
X240 VDD iqmod_mixer_0.iqmod_mixer_half_1.iqmod_mixer_se2diff$1_0.iqmod_mixer_se2diff_half_inv$2_0.iqmod_mixer_se2diff_inv_NF54$7_0.vin iqmod_mixer_0.iqmod_mixer_half_1.iqmod_mixer_tg$1_0.di_tg_ctrl VDD sg13_lv_pmos ad=0.57p pd=3.38u as=0.57p ps=3.38u w=3u l=0.13u
X241 iqmod_spdt_switch_0.v_c iqmod_spdt_switch_0.spdt_switch_inv_0.vout vinn_I VSS sg13_lv_nmos ad=0.19p pd=1.38u as=0.19p ps=1.38u w=1u l=0.13u
X242 VSS iqmod_mfb_lpf_0.iqmod_mfb_lpf_half_1.iqmod_mfb_lpf_ota_core_hybrid_bm_half$1_0.iqmod_mfb_lpf_ota_core_inv_NF20$2_1.vin iqmod_mfb_lpf_0.iqmod_mfb_lpf_half_0.iqmod_mfb_lpf_ota_core_hybrid_bm_half$1_0.iqmod_mfb_lpf_ota_core_tg$2_0.v_a VSS sg13_lv_nmos ad=0.19p pd=1.38u as=0.19p ps=1.38u w=1u l=1u
X243 VDD VDD VDD VDD sg13_lv_pmos ad=1.02p pd=6.68u as=0 ps=0 w=3u l=0.13u
X244 VSS iqmod_mixer_0.iqmod_mixer_half_0.iqmod_mixer_se2diff$1_0.iqmod_mixer_se2diff_half_tg$2_0.iqmod_mixer_se2diff_inv_NF54$6_0.vin iqmod_mixer_0.iqmod_mixer_half_0.iqmod_mixer_tg$1_0.di_tg_ctrl_n VSS sg13_lv_nmos ad=0.19p pd=1.38u as=0.19p ps=1.38u w=1u l=0.13u
X245 VSS iqmod_mixer_0.iqmod_mixer_half_0.iqmod_mixer_se2diff$1_0.iqmod_mixer_se2diff_half_tg$2_0.iqmod_mixer_se2diff_inv_NF54$6_0.vin iqmod_mixer_0.iqmod_mixer_half_0.iqmod_mixer_tg$1_0.di_tg_ctrl_n VSS sg13_lv_nmos ad=0.19p pd=1.38u as=0.19p ps=1.38u w=1u l=0.13u
X246 VDD di_analog_en iqmod_mfb_lpf_0.iqmod_mfb_lpf_half_1.iqmod_mfb_lpf_ota_core_hybrid_bm_half$1_0.iqmod_mfb_lpf_ota_core_tg$2_0.di_tg_ctrl_n VDD sg13_lv_pmos ad=1.14p pd=6.38u as=1.14p ps=6.38u w=6u l=0.13u
X247 iqmod_mixer_0.iqmod_mixer_half_1.iqmod_mixer_tg$1_0.di_tg_ctrl_n iqmod_mixer_0.iqmod_mixer_half_1.iqmod_mixer_se2diff$1_0.iqmod_mixer_se2diff_half_tg$2_0.iqmod_mixer_se2diff_inv_NF54$6_0.vin VSS VSS sg13_lv_nmos ad=0.19p pd=1.38u as=0.19p ps=1.38u w=1u l=0.13u
X248 VDD iqmod_mfb_lpf_0.iqmod_mfb_lpf_half_0.iqmod_mfb_lpf_ota_core_hybrid_bm_half$1_0.iqmod_mfb_lpf_ota_core_inv_NF20$2_0.vout iqmod_mfb_lpf_0.iqmod_mfb_lpf_half_0.iqmod_mfb_lpf_ota_core_hybrid_bm_half$1_0.iqmod_mfb_lpf_ota_core_inv_NF6$2_1.vout VDD sg13_lv_pmos ad=1.14p pd=6.38u as=1.14p ps=6.38u w=6u l=1u
X249 VDD iqmod_mfb_lpf_0.iqmod_mfb_lpf_half_0.iqmod_mfb_lpf_ota_core_hybrid_bm_half$1_0.iqmod_mfb_lpf_ota_core_tg$2_0.v_b iqmod_mixer_0.vinn_IF VDD sg13_lv_pmos ad=1.14p pd=6.38u as=1.14p ps=6.38u w=6u l=1u
X250 VSS VSS VSS VSS sg13_lv_nmos ad=0.19p pd=1.38u as=0 ps=0 w=1u l=0.13u
X251 iqmod_mixer_0.iqmod_mixer_half_0.iqmod_mixer_tg$1_0.di_tg_ctrl_n iqmod_mixer_0.iqmod_mixer_half_0.iqmod_mixer_se2diff$1_0.iqmod_mixer_se2diff_half_tg$2_0.iqmod_mixer_se2diff_inv_NF54$6_0.vin VSS VSS sg13_lv_nmos ad=0.19p pd=1.38u as=0.19p ps=1.38u w=1u l=0.13u
X252 VSS iqmod_mixer_0.iqmod_mixer_half_0.iqmod_mixer_se2diff$1_0.iqmod_mixer_se2diff_half_inv$2_0.iqmod_mixer_se2diff_inv_NF2$7_1.vout iqmod_mixer_0.iqmod_mixer_half_0.iqmod_mixer_se2diff$1_0.iqmod_mixer_se2diff_half_tg$2_0.iqmod_mixer_se2diff_inv_NF18$6_0.vin VSS sg13_lv_nmos ad=0.19p pd=1.38u as=0.19p ps=1.38u w=1u l=0.13u
X253 VSS iqmod_mixer_0.vinp_IF iqmod_mfb_lpf_0.iqmod_mfb_lpf_half_0.iqmod_mfb_lpf_ota_core_hybrid_bm_half$1_0.iqmod_mfb_lpf_ota_core_inv_NF20$2_0.vout VSS sg13_lv_nmos ad=0.19p pd=1.38u as=0.19p ps=1.38u w=1u l=1u
X254 VSS iqmod_mixer_0.iqmod_mixer_half_1.iqmod_mixer_se2diff$1_0.iqmod_mixer_se2diff_half_inv$2_0.iqmod_mixer_se2diff_inv_NF2$7_1.vout iqmod_mixer_0.iqmod_mixer_half_1.iqmod_mixer_se2diff$1_0.iqmod_mixer_se2diff_half_inv$2_0.iqmod_mixer_se2diff_inv_NF6$7_1.vin VSS sg13_lv_nmos ad=0.19p pd=1.38u as=0.19p ps=1.38u w=1u l=0.13u
X255 iqmod_mixer_0.iqmod_mixer_half_1.iqmod_mixer_se2diff$1_0.iqmod_mixer_se2diff_half_inv$2_0.iqmod_mixer_se2diff_inv_NF18$7_0.vin iqmod_mixer_0.iqmod_mixer_half_1.iqmod_mixer_se2diff$1_0.iqmod_mixer_se2diff_half_inv$2_0.iqmod_mixer_se2diff_inv_NF6$7_1.vin VSS VSS sg13_lv_nmos ad=0.19p pd=1.38u as=0.19p ps=1.38u w=1u l=0.13u
X256 VSS iqmod_mixer_0.iqmod_mixer_half_0.iqmod_mixer_se2diff$1_0.iqmod_mixer_se2diff_half_inv$2_0.iqmod_mixer_se2diff_inv_NF18$7_0.vin iqmod_mixer_0.iqmod_mixer_half_0.iqmod_mixer_se2diff$1_0.iqmod_mixer_se2diff_half_inv$2_0.iqmod_mixer_se2diff_inv_NF54$7_0.vin VSS sg13_lv_nmos ad=0.19p pd=1.38u as=0.19p ps=1.38u w=1u l=0.13u
X257 VSS VSS VSS VSS sg13_lv_nmos ad=0.19p pd=1.38u as=0 ps=0 w=1u l=1u
X258 VDD iqmod_mixer_0.iqmod_mixer_half_1.iqmod_mixer_se2diff$1_0.iqmod_mixer_se2diff_half_inv$2_0.iqmod_mixer_se2diff_inv_NF54$7_0.vin iqmod_mixer_0.iqmod_mixer_half_1.iqmod_mixer_tg$1_0.di_tg_ctrl VDD sg13_lv_pmos ad=0.57p pd=3.38u as=0.57p ps=3.38u w=3u l=0.13u
X259 iqmod_mixer_0.iqmod_mixer_half_0.iqmod_mixer_tg$1_0.di_tg_ctrl_n iqmod_mixer_0.iqmod_mixer_half_0.iqmod_mixer_se2diff$1_0.iqmod_mixer_se2diff_half_tg$2_0.iqmod_mixer_se2diff_inv_NF54$6_0.vin VDD VDD sg13_lv_pmos ad=0.57p pd=3.38u as=0.57p ps=3.38u w=3u l=0.13u
X260 VSS iqmod_mixer_0.iqmod_mixer_half_1.iqmod_mixer_se2diff$1_0.iqmod_mixer_se2diff_half_tg$2_0.iqmod_mixer_se2diff_inv_NF54$6_0.vin iqmod_mixer_0.iqmod_mixer_half_1.iqmod_mixer_tg$1_0.di_tg_ctrl_n VSS sg13_lv_nmos ad=0.19p pd=1.38u as=0.19p ps=1.38u w=1u l=0.13u
X261 VDD VDD VDD VDD sg13_lv_pmos ad=0.57p pd=3.38u as=0 ps=0 w=3u l=0.13u
X262 voutn_I_RF iqmod_mixer_0.iqmod_mixer_half_0.iqmod_mixer_tg$1_0.di_tg_ctrl_n iqmod_mixer_0.vinn_IF VDD sg13_lv_pmos ad=1.71p pd=9.38u as=1.71p ps=9.38u w=9u l=0.13u
X263 a_11701_10752# a_17187_10452# VSS rhigh l=27u w=0.5u
X264 iqmod_mixer_0.iqmod_mixer_half_0.iqmod_mixer_se2diff$1_0.iqmod_mixer_se2diff_half_inv$2_0.iqmod_mixer_se2diff_inv_NF18$7_0.vin iqmod_mixer_0.iqmod_mixer_half_0.iqmod_mixer_se2diff$1_0.iqmod_mixer_se2diff_half_inv$2_0.iqmod_mixer_se2diff_inv_NF6$7_1.vin VDD VDD sg13_lv_pmos ad=0.57p pd=3.38u as=0.57p ps=3.38u w=3u l=0.13u
X265 VSS VSS VSS VSS sg13_lv_nmos ad=0.34p pd=2.68u as=0 ps=0 w=1u l=0.13u
X266 iqmod_mfb_lpf_0.iqmod_mfb_lpf_half_0.iqmod_mfb_lpf_ota_core_hybrid_bm_half$1_0.iqmod_mfb_lpf_ota_core_tg$2_0.v_a iqmod_mfb_lpf_0.iqmod_mfb_lpf_half_0.iqmod_mfb_lpf_ota_core_hybrid_bm_half$1_0.iqmod_mfb_lpf_ota_core_tg$2_0.di_tg_ctrl_n iqmod_mfb_lpf_0.iqmod_mfb_lpf_half_0.iqmod_mfb_lpf_ota_core_hybrid_bm_half$1_0.iqmod_mfb_lpf_ota_core_tg$2_0.v_b VDD sg13_lv_pmos ad=1.14p pd=6.38u as=1.14p ps=6.38u w=6u l=0.13u
X267 iqmod_mixer_0.iqmod_mixer_half_0.iqmod_mixer_se2diff$1_0.iqmod_mixer_se2diff_half_inv$2_0.iqmod_mixer_se2diff_inv_NF54$7_0.vin iqmod_mixer_0.iqmod_mixer_half_0.iqmod_mixer_se2diff$1_0.iqmod_mixer_se2diff_half_inv$2_0.iqmod_mixer_se2diff_inv_NF18$7_0.vin VSS VSS sg13_lv_nmos ad=0.19p pd=1.38u as=0.19p ps=1.38u w=1u l=0.13u
X268 voutp_I_RF iqmod_mixer_0.iqmod_mixer_half_1.iqmod_mixer_tg$1_0.di_tg_ctrl voutp_I_RF VDD sg13_lv_pmos ad=1.71p pd=9.38u as=0 ps=0 w=9u l=0.13u
X269 VSS iqmod_mfb_lpf_0.iqmod_mfb_lpf_half_0.iqmod_mfb_lpf_ota_core_hybrid_bm_half$1_0.iqmod_mfb_lpf_ota_core_tg$2_0.v_b iqmod_mixer_0.vinp_IF VSS sg13_lv_nmos ad=0.19p pd=1.38u as=0.19p ps=1.38u w=1u l=1u
X270 iqmod_mixer_0.vinn_IF iqmod_mixer_0.iqmod_mixer_half_0.iqmod_mixer_tg$1_0.di_tg_ctrl_n voutn_I_RF VDD sg13_lv_pmos ad=1.71p pd=9.38u as=1.71p ps=9.38u w=9u l=0.13u
X271 iqmod_mixer_0.vinn_IF iqmod_mfb_lpf_0.iqmod_mfb_lpf_half_0.iqmod_mfb_lpf_ota_core_hybrid_bm_half$1_0.iqmod_mfb_lpf_ota_core_tg$2_0.v_b VDD VDD sg13_lv_pmos ad=1.14p pd=6.38u as=1.14p ps=6.38u w=6u l=1u
X272 voutn_I_RF iqmod_mixer_0.iqmod_mixer_half_0.iqmod_mixer_tg$1_0.di_tg_ctrl_n voutn_I_RF VSS sg13_lv_nmos ad=0.57p pd=3.38u as=0 ps=0 w=3u l=0.13u
X273 iqmod_mfb_lpf_0.iqmod_mfb_lpf_half_0.iqmod_mfb_lpf_ota_core_hybrid_bm_half$1_0.iqmod_mfb_lpf_ota_core_tg$2_0.v_b iqmod_mfb_lpf_0.iqmod_mfb_lpf_half_0.iqmod_mfb_lpf_ota_core_hybrid_bm_half$1_0.iqmod_mfb_lpf_ota_core_inv_NF6$2_1.vout VDD VDD sg13_lv_pmos ad=1.14p pd=6.38u as=1.14p ps=6.38u w=6u l=1u
X274 VDD VDD VDD VDD sg13_lv_pmos ad=1.02p pd=6.68u as=0 ps=0 w=3u l=0.13u
X275 voutp_I_RF iqmod_mixer_0.iqmod_mixer_half_1.iqmod_mixer_tg$1_0.di_tg_ctrl_n iqmod_mixer_0.vinp_IF VDD sg13_lv_pmos ad=1.71p pd=9.38u as=1.71p ps=9.38u w=9u l=0.13u
X276 VDD iqmod_mixer_0.iqmod_mixer_half_1.iqmod_mixer_se2diff$1_0.iqmod_mixer_se2diff_half_inv$2_0.iqmod_mixer_se2diff_inv_NF54$7_0.vin iqmod_mixer_0.iqmod_mixer_half_1.iqmod_mixer_tg$1_0.di_tg_ctrl VDD sg13_lv_pmos ad=0.57p pd=3.38u as=0.57p ps=3.38u w=3u l=0.13u
X277 VDD iqmod_mixer_0.iqmod_mixer_half_1.iqmod_mixer_se2diff$1_0.iqmod_mixer_se2diff_half_inv$2_0.iqmod_mixer_se2diff_inv_NF54$7_0.vin iqmod_mixer_0.iqmod_mixer_half_1.iqmod_mixer_tg$1_0.di_tg_ctrl VDD sg13_lv_pmos ad=0.57p pd=3.38u as=0.57p ps=3.38u w=3u l=0.13u
X278 iqmod_mfb_lpf_0.iqmod_mfb_lpf_half_0.iqmod_mfb_lpf_ota_core_hybrid_bm_half$1_0.iqmod_mfb_lpf_ota_core_inv_NF6$2_1.vout iqmod_mfb_lpf_0.iqmod_mfb_lpf_half_0.iqmod_mfb_lpf_ota_core_hybrid_bm_half$1_0.iqmod_mfb_lpf_ota_core_inv_NF20$2_0.vout VSS VSS sg13_lv_nmos ad=0.19p pd=1.38u as=0.19p ps=1.38u w=1u l=1u
X279 iqmod_mixer_0.vinn_IF iqmod_mixer_0.iqmod_mixer_half_0.iqmod_mixer_tg$1_0.di_tg_ctrl voutn_I_RF VSS sg13_lv_nmos ad=0.57p pd=3.38u as=0.57p ps=3.38u w=3u l=0.13u
X280 voutp_I_RF iqmod_mixer_0.iqmod_mixer_half_1.iqmod_mixer_tg$1_0.di_tg_ctrl voutp_I_RF VDD sg13_lv_pmos ad=1.71p pd=9.38u as=0 ps=0 w=9u l=0.13u
X281 voutn_I_RF iqmod_mixer_0.iqmod_mixer_half_0.iqmod_mixer_tg$1_0.di_tg_ctrl_n voutn_I_RF VSS sg13_lv_nmos ad=0.57p pd=3.38u as=0 ps=0 w=3u l=0.13u
X282 VSS iqmod_mfb_lpf_0.iqmod_mfb_lpf_half_0.iqmod_mfb_lpf_ota_core_hybrid_bm_half$1_0.iqmod_mfb_lpf_ota_core_tg$2_0.v_a iqmod_mfb_lpf_0.iqmod_mfb_lpf_half_0.iqmod_mfb_lpf_ota_core_hybrid_bm_half$1_0.iqmod_mfb_lpf_ota_core_tg$2_0.v_b VSS sg13_lv_nmos ad=0.19p pd=1.38u as=0.19p ps=1.38u w=1u l=1u
X283 VSS iqmod_mixer_0.iqmod_mixer_half_0.iqmod_mixer_se2diff$1_0.iqmod_mixer_se2diff_half_inv$2_0.iqmod_mixer_se2diff_inv_NF54$7_0.vin iqmod_mixer_0.iqmod_mixer_half_0.iqmod_mixer_tg$1_0.di_tg_ctrl VSS sg13_lv_nmos ad=0.19p pd=1.38u as=0.19p ps=1.38u w=1u l=0.13u
X284 iqmod_mixer_0.vinp_IF iqmod_mfb_lpf_0.iqmod_mfb_lpf_half_0.iqmod_mfb_lpf_ota_core_hybrid_bm_half$1_0.iqmod_mfb_lpf_ota_core_tg$2_0.v_b VSS VSS sg13_lv_nmos ad=0.19p pd=1.38u as=0.19p ps=1.38u w=1u l=1u
X285 VDD iqmod_mfb_lpf_0.iqmod_mfb_lpf_half_0.iqmod_mfb_lpf_ota_core_hybrid_bm_half$1_0.iqmod_mfb_lpf_ota_core_tg$2_0.v_b iqmod_mixer_0.vinn_IF VDD sg13_lv_pmos ad=1.14p pd=6.38u as=1.14p ps=6.38u w=6u l=1u
X286 iqmod_mixer_0.iqmod_mixer_half_0.iqmod_mixer_se2diff$1_0.iqmod_mixer_se2diff_half_inv$2_0.iqmod_mixer_se2diff_inv_NF6$7_0.vin VDD iqmod_mixer_0.iqmod_mixer_half_0.iqmod_mixer_se2diff$1_0.iqmod_mixer_se2diff_half_tg$2_0.iqmod_mixer_se2diff_tg_NF6$3_0.v_b VSS sg13_lv_nmos ad=0.34p pd=2.68u as=0.19p ps=1.38u w=1u l=0.13u
X287 iqmod_mfb_lpf_0.iqmod_mfb_lpf_half_0.iqmod_mfb_lpf_ota_core_hybrid_bm_half$1_0.iqmod_mfb_lpf_ota_core_inv_NF20$2_0.vout iqmod_mixer_0.vinn_IF VDD VDD sg13_lv_pmos ad=1.14p pd=6.38u as=1.14p ps=6.38u w=6u l=1u
X288 di_ds_I_p iqmod_spdt_switch_1.spdt_switch_inv_0.vout iqmod_spdt_switch_1.v_c VDD sg13_lv_pmos ad=1.14p pd=6.38u as=1.14p ps=6.38u w=6u l=0.13u
X289 iqmod_mixer_0.iqmod_mixer_half_0.iqmod_mixer_se2diff$1_0.iqmod_mixer_se2diff_half_inv$2_0.iqmod_mixer_se2diff_inv_NF2$7_1.vout iqmod_mixer_0.iqmod_mixer_half_0.iqmod_mixer_se2diff$1_0.iqmod_mixer_se2diff_half_inv$2_0.iqmod_mixer_se2diff_inv_NF6$7_1.vin VSS VSS sg13_lv_nmos ad=0.19p pd=1.38u as=0.19p ps=1.38u w=1u l=0.13u
X290 VSS di_lo_I iqmod_mixer_0.iqmod_mixer_half_1.iqmod_mixer_se2diff$1_0.iqmod_mixer_se2diff_half_inv$2_0.iqmod_mixer_se2diff_inv_NF6$7_0.vin VSS sg13_lv_nmos ad=0.19p pd=1.38u as=0.19p ps=1.38u w=1u l=0.13u
X291 iqmod_mfb_lpf_0.iqmod_mfb_lpf_half_0.iqmod_mfb_lpf_ota_core_hybrid_bm_half$1_0.iqmod_mfb_lpf_ota_core_inv_NF20$2_1.vin iqmod_mfb_lpf_0.iqmod_mfb_lpf_half_0.iqmod_mfb_lpf_ota_core_hybrid_bm_half$1_0.iqmod_mfb_lpf_ota_core_spdt_switch$2_0.iqmod_mfb_lpf_ota_core_spdt_switch_inv$3_0.vout iqmod_spdt_switch_1.v_c VSS sg13_lv_nmos ad=0.19p pd=1.38u as=0.19p ps=1.38u w=1u l=0.13u
X292 VDD iqmod_mixer_0.iqmod_mixer_half_1.iqmod_mixer_se2diff$1_0.iqmod_mixer_se2diff_half_inv$2_0.iqmod_mixer_se2diff_inv_NF54$7_0.vin iqmod_mixer_0.iqmod_mixer_half_1.iqmod_mixer_tg$1_0.di_tg_ctrl VDD sg13_lv_pmos ad=0.57p pd=3.38u as=0.57p ps=3.38u w=3u l=0.13u
X293 iqmod_mixer_0.iqmod_mixer_half_1.iqmod_mixer_tg$1_0.di_tg_ctrl_n iqmod_mixer_0.iqmod_mixer_half_1.iqmod_mixer_se2diff$1_0.iqmod_mixer_se2diff_half_tg$2_0.iqmod_mixer_se2diff_inv_NF54$6_0.vin VDD VDD sg13_lv_pmos ad=0.57p pd=3.38u as=0.57p ps=3.38u w=3u l=0.13u
X294 voutp_I_RF iqmod_mixer_0.iqmod_mixer_half_1.iqmod_mixer_tg$1_0.di_tg_ctrl_n iqmod_mixer_0.vinp_IF VDD sg13_lv_pmos ad=1.71p pd=9.38u as=1.71p ps=9.38u w=9u l=0.13u
X295 iqmod_mixer_0.iqmod_mixer_half_0.iqmod_mixer_tg$1_0.di_tg_ctrl iqmod_mixer_0.iqmod_mixer_half_0.iqmod_mixer_se2diff$1_0.iqmod_mixer_se2diff_half_inv$2_0.iqmod_mixer_se2diff_inv_NF54$7_0.vin VSS VSS sg13_lv_nmos ad=0.19p pd=1.38u as=0.19p ps=1.38u w=1u l=0.13u
X296 iqmod_mixer_0.vinn_IF iqmod_mixer_0.iqmod_mixer_half_0.iqmod_mixer_tg$1_0.di_tg_ctrl voutn_I_RF VSS sg13_lv_nmos ad=0.57p pd=3.38u as=0.57p ps=3.38u w=3u l=0.13u
X297 iqmod_mixer_0.iqmod_mixer_half_0.iqmod_mixer_se2diff$1_0.iqmod_mixer_se2diff_half_tg$2_0.iqmod_mixer_se2diff_tg_NF6$3_0.v_b VDD iqmod_mixer_0.iqmod_mixer_half_0.iqmod_mixer_se2diff$1_0.iqmod_mixer_se2diff_half_inv$2_0.iqmod_mixer_se2diff_inv_NF6$7_0.vin VSS sg13_lv_nmos ad=0.19p pd=1.38u as=0.19p ps=1.38u w=1u l=0.13u
X298 VSS VSS VSS VSS sg13_lv_nmos ad=0.34p pd=2.68u as=0 ps=0 w=1u l=0.13u
X299 VDD VDD VDD VDD sg13_lv_pmos ad=1.02p pd=6.68u as=0 ps=0 w=3u l=0.13u
X300 iqmod_mfb_lpf_0.iqmod_mfb_lpf_half_0.iqmod_mfb_lpf_ota_core_hybrid_bm_half$1_0.iqmod_mfb_lpf_ota_core_inv_NF6$2_1.vout di_analog_en iqmod_mfb_lpf_0.iqmod_mfb_lpf_half_0.iqmod_mfb_lpf_ota_core_hybrid_bm_half$1_0.iqmod_mfb_lpf_ota_core_inv_NF20$2_0.vout VSS sg13_lv_nmos ad=0.19p pd=1.38u as=0.34p ps=2.68u w=1u l=0.13u
X301 VDD iqmod_mixer_0.iqmod_mixer_half_1.iqmod_mixer_se2diff$1_0.iqmod_mixer_se2diff_half_tg$2_0.iqmod_mixer_se2diff_inv_NF54$6_0.vin iqmod_mixer_0.iqmod_mixer_half_1.iqmod_mixer_tg$1_0.di_tg_ctrl_n VDD sg13_lv_pmos ad=0.57p pd=3.38u as=0.57p ps=3.38u w=3u l=0.13u
X302 iqmod_mfb_lpf_0.iqmod_mfb_lpf_half_0.iqmod_mfb_lpf_ota_core_hybrid_bm_half$1_0.iqmod_mfb_lpf_ota_core_tg$2_0.v_b iqmod_mfb_lpf_0.iqmod_mfb_lpf_half_0.iqmod_mfb_lpf_ota_core_hybrid_bm_half$1_0.iqmod_mfb_lpf_ota_core_tg$2_0.v_a VSS VSS sg13_lv_nmos ad=0.19p pd=1.38u as=0.19p ps=1.38u w=1u l=1u
X303 iqmod_mfb_lpf_0.iqmod_mfb_lpf_half_0.iqmod_mfb_lpf_ota_core_hybrid_bm_half$1_0.iqmod_mfb_lpf_ota_core_inv_NF20$2_0.vout iqmod_mixer_0.vinp_IF VDD VDD sg13_lv_pmos ad=1.14p pd=6.38u as=1.14p ps=6.38u w=6u l=1u
X304 VSS iqmod_mixer_0.iqmod_mixer_half_0.iqmod_mixer_se2diff$1_0.iqmod_mixer_se2diff_half_inv$2_0.iqmod_mixer_se2diff_inv_NF54$7_0.vin iqmod_mixer_0.iqmod_mixer_half_0.iqmod_mixer_tg$1_0.di_tg_ctrl VSS sg13_lv_nmos ad=0.19p pd=1.38u as=0.19p ps=1.38u w=1u l=0.13u
X305 voutn_I_RF iqmod_mixer_0.iqmod_mixer_half_0.iqmod_mixer_tg$1_0.di_tg_ctrl voutn_I_RF VDD sg13_lv_pmos ad=1.71p pd=9.38u as=0 ps=0 w=9u l=0.13u
X306 VSS iqmod_mfb_lpf_0.iqmod_mfb_lpf_half_0.iqmod_mfb_lpf_ota_core_hybrid_bm_half$1_0.iqmod_mfb_lpf_ota_core_tg$2_0.v_b iqmod_mixer_0.vinp_IF VSS sg13_lv_nmos ad=0.19p pd=1.38u as=0.19p ps=1.38u w=1u l=1u
X307 VDD iqmod_mixer_0.iqmod_mixer_half_0.iqmod_mixer_se2diff$1_0.iqmod_mixer_se2diff_half_tg$2_0.iqmod_mixer_se2diff_inv_NF54$6_0.vin iqmod_mixer_0.iqmod_mixer_half_0.iqmod_mixer_tg$1_0.di_tg_ctrl_n VDD sg13_lv_pmos ad=0.57p pd=3.38u as=0.57p ps=3.38u w=3u l=0.13u
X308 iqmod_mixer_0.vinn_IF iqmod_mixer_0.iqmod_mixer_half_0.iqmod_mixer_tg$1_0.di_tg_ctrl_n voutn_I_RF VDD sg13_lv_pmos ad=1.71p pd=9.38u as=1.71p ps=9.38u w=9u l=0.13u
X309 VDD VDD VDD VDD sg13_lv_pmos ad=1.14p pd=6.38u as=0 ps=0 w=6u l=0.13u
X310 VDD VDD VDD VDD sg13_lv_pmos ad=1.02p pd=6.68u as=0 ps=0 w=3u l=0.13u
X311 iqmod_mfb_lpf_0.iqmod_mfb_lpf_half_0.iqmod_mfb_lpf_ota_core_hybrid_bm_half$1_0.iqmod_mfb_lpf_ota_core_tg$2_0.v_b iqmod_mfb_lpf_0.iqmod_mfb_lpf_half_0.iqmod_mfb_lpf_ota_core_hybrid_bm_half$1_0.iqmod_mfb_lpf_ota_core_inv_NF6$2_1.vout VDD VDD sg13_lv_pmos ad=1.14p pd=6.38u as=1.14p ps=6.38u w=6u l=1u
X312 iqmod_mfb_lpf_0.iqmod_mfb_lpf_half_0.C2_half a_48939_2246# VSS rhigh l=60u w=0.5u
X313 iqmod_spdt_switch_0.v_c a_17187_2246# VSS rhigh l=27u w=0.5u
X314 VSS iqmod_mixer_0.iqmod_mixer_half_0.iqmod_mixer_se2diff$1_0.iqmod_mixer_se2diff_half_tg$2_0.iqmod_mixer_se2diff_inv_NF54$6_0.vin iqmod_mixer_0.iqmod_mixer_half_0.iqmod_mixer_tg$1_0.di_tg_ctrl_n VSS sg13_lv_nmos ad=0.19p pd=1.38u as=0.19p ps=1.38u w=1u l=0.13u
X315 voutn_I_RF iqmod_mixer_0.iqmod_mixer_half_0.iqmod_mixer_tg$1_0.di_tg_ctrl voutn_I_RF VDD sg13_lv_pmos ad=1.71p pd=9.38u as=0 ps=0 w=9u l=0.13u
X316 iqmod_spdt_switch_1.v_c iqmod_spdt_switch_1.spdt_switch_inv_0.vout vinp_I VSS sg13_lv_nmos ad=0.19p pd=1.38u as=0.19p ps=1.38u w=1u l=0.13u
X317 iqmod_mixer_0.iqmod_mixer_half_1.iqmod_mixer_tg$1_0.di_tg_ctrl iqmod_mixer_0.iqmod_mixer_half_1.iqmod_mixer_se2diff$1_0.iqmod_mixer_se2diff_half_inv$2_0.iqmod_mixer_se2diff_inv_NF54$7_0.vin VSS VSS sg13_lv_nmos ad=0.19p pd=1.38u as=0.19p ps=1.38u w=1u l=0.13u
X318 VSS VSS VSS VSS sg13_lv_nmos ad=0.19p pd=1.38u as=0 ps=0 w=1u l=1u
X319 VDD iqmod_mixer_0.iqmod_mixer_half_1.iqmod_mixer_se2diff$1_0.iqmod_mixer_se2diff_half_tg$2_0.iqmod_mixer_se2diff_inv_NF54$6_0.vin iqmod_mixer_0.iqmod_mixer_half_1.iqmod_mixer_tg$1_0.di_tg_ctrl_n VDD sg13_lv_pmos ad=0.57p pd=3.38u as=0.57p ps=3.38u w=3u l=0.13u
X320 iqmod_mfb_lpf_0.iqmod_mfb_lpf_half_0.iqmod_mfb_lpf_R1$1_0.v_b a_23971_10752# VSS rhigh l=31u w=0.5u
X321 VDD VDD VDD VDD sg13_lv_pmos ad=2.04p pd=12.68u as=0 ps=0 w=6u l=0.13u
X322 voutn_I_RF iqmod_mixer_0.iqmod_mixer_half_0.iqmod_mixer_tg$1_0.di_tg_ctrl_n voutn_I_RF VSS sg13_lv_nmos ad=0.57p pd=3.38u as=0 ps=0 w=3u l=0.13u
X323 iqmod_mixer_0.iqmod_mixer_half_0.iqmod_mixer_tg$1_0.di_tg_ctrl iqmod_mixer_0.iqmod_mixer_half_0.iqmod_mixer_se2diff$1_0.iqmod_mixer_se2diff_half_inv$2_0.iqmod_mixer_se2diff_inv_NF54$7_0.vin VDD VDD sg13_lv_pmos ad=0.57p pd=3.38u as=0.57p ps=3.38u w=3u l=0.13u
X324 iqmod_mixer_0.vinp_IF iqmod_mfb_lpf_0.iqmod_mfb_lpf_half_0.iqmod_mfb_lpf_ota_core_hybrid_bm_half$1_0.iqmod_mfb_lpf_ota_core_tg$2_0.v_b VSS VSS sg13_lv_nmos ad=0.19p pd=1.38u as=0.19p ps=1.38u w=1u l=1u
X325 voutp_I_RF iqmod_mixer_0.iqmod_mixer_half_1.iqmod_mixer_tg$1_0.di_tg_ctrl iqmod_mixer_0.vinp_IF VSS sg13_lv_nmos ad=0.57p pd=3.38u as=0.57p ps=3.38u w=3u l=0.13u
X326 vinp_I iqmod_spdt_switch_1.spdt_switch_inv_0.vout iqmod_spdt_switch_1.v_c VSS sg13_lv_nmos ad=0.19p pd=1.38u as=0.19p ps=1.38u w=1u l=0.13u
X327 VSS iqmod_mixer_0.iqmod_mixer_half_1.iqmod_mixer_se2diff$1_0.iqmod_mixer_se2diff_half_inv$2_0.iqmod_mixer_se2diff_inv_NF54$7_0.vin iqmod_mixer_0.iqmod_mixer_half_1.iqmod_mixer_tg$1_0.di_tg_ctrl VSS sg13_lv_nmos ad=0.19p pd=1.38u as=0.19p ps=1.38u w=1u l=0.13u
X328 iqmod_mfb_lpf_0.iqmod_mfb_lpf_half_0.iqmod_mfb_lpf_ota_core_hybrid_bm_half$1_0.iqmod_mfb_lpf_ota_core_inv_NF20$2_0.vout iqmod_mixer_0.vinn_IF VDD VDD sg13_lv_pmos ad=1.14p pd=6.38u as=1.14p ps=6.38u w=6u l=1u
X329 iqmod_mixer_0.iqmod_mixer_half_0.iqmod_mixer_se2diff$1_0.iqmod_mixer_se2diff_half_inv$2_0.iqmod_mixer_se2diff_inv_NF6$7_0.vin di_lo_Ix VSS VSS sg13_lv_nmos ad=0.19p pd=1.38u as=0.19p ps=1.38u w=1u l=0.13u
X330 VDD iqmod_mfb_lpf_0.iqmod_mfb_lpf_half_0.iqmod_mfb_lpf_ota_core_hybrid_bm_half$1_0.iqmod_mfb_lpf_ota_core_inv_NF6$2_1.vout iqmod_mfb_lpf_0.iqmod_mfb_lpf_half_0.iqmod_mfb_lpf_ota_core_hybrid_bm_half$1_0.iqmod_mfb_lpf_ota_core_tg$2_0.v_b VDD sg13_lv_pmos ad=1.14p pd=6.38u as=1.14p ps=6.38u w=6u l=1u
X331 iqmod_mixer_0.iqmod_mixer_half_1.iqmod_mixer_tg$1_0.di_tg_ctrl_n iqmod_mixer_0.iqmod_mixer_half_1.iqmod_mixer_se2diff$1_0.iqmod_mixer_se2diff_half_tg$2_0.iqmod_mixer_se2diff_inv_NF54$6_0.vin VDD VDD sg13_lv_pmos ad=0.57p pd=3.38u as=0.57p ps=3.38u w=3u l=0.13u
X332 VSS VSS VSS VSS sg13_lv_nmos ad=0.34p pd=2.68u as=0 ps=0 w=1u l=1u
X333 VDD iqmod_mixer_0.iqmod_mixer_half_0.iqmod_mixer_se2diff$1_0.iqmod_mixer_se2diff_half_inv$2_0.iqmod_mixer_se2diff_inv_NF54$7_0.vin iqmod_mixer_0.iqmod_mixer_half_0.iqmod_mixer_tg$1_0.di_tg_ctrl VDD sg13_lv_pmos ad=0.57p pd=3.38u as=0.57p ps=3.38u w=3u l=0.13u
X334 iqmod_mixer_0.vinp_IF iqmod_mixer_0.iqmod_mixer_half_1.iqmod_mixer_tg$1_0.di_tg_ctrl voutp_I_RF VSS sg13_lv_nmos ad=0.57p pd=3.38u as=0.57p ps=3.38u w=3u l=0.13u
X335 VDD VDD VDD VDD sg13_lv_pmos ad=1.02p pd=6.68u as=0 ps=0 w=3u l=0.13u
X336 VDD iqmod_mixer_0.iqmod_mixer_half_1.iqmod_mixer_se2diff$1_0.iqmod_mixer_se2diff_half_tg$2_0.iqmod_mixer_se2diff_inv_NF54$6_0.vin iqmod_mixer_0.iqmod_mixer_half_1.iqmod_mixer_tg$1_0.di_tg_ctrl_n VDD sg13_lv_pmos ad=0.57p pd=3.38u as=0.57p ps=3.38u w=3u l=0.13u
X337 iqmod_mixer_0.iqmod_mixer_half_0.iqmod_mixer_tg$1_0.di_tg_ctrl_n iqmod_mixer_0.iqmod_mixer_half_0.iqmod_mixer_se2diff$1_0.iqmod_mixer_se2diff_half_tg$2_0.iqmod_mixer_se2diff_inv_NF54$6_0.vin VSS VSS sg13_lv_nmos ad=0.19p pd=1.38u as=0.19p ps=1.38u w=1u l=0.13u
X338 VSS iqmod_mixer_0.iqmod_mixer_half_1.iqmod_mixer_se2diff$1_0.iqmod_mixer_se2diff_half_inv$2_0.iqmod_mixer_se2diff_inv_NF54$7_0.vin iqmod_mixer_0.iqmod_mixer_half_1.iqmod_mixer_tg$1_0.di_tg_ctrl VSS sg13_lv_nmos ad=0.19p pd=1.38u as=0.19p ps=1.38u w=1u l=0.13u
X339 VDD iqmod_spdt_switch_1.spdt_switch_inv_0.vin iqmod_spdt_switch_1.spdt_switch_inv_0.vout VDD sg13_lv_pmos ad=1.14p pd=6.38u as=1.14p ps=6.38u w=6u l=0.13u
X340 VSS VSS VSS rhigh l=31u w=0.5u
X341 voutp_I_RF iqmod_mixer_0.iqmod_mixer_half_1.iqmod_mixer_tg$1_0.di_tg_ctrl iqmod_mixer_0.vinp_IF VSS sg13_lv_nmos ad=0.57p pd=3.38u as=0.57p ps=3.38u w=3u l=0.13u
X342 VDD iqmod_mixer_0.vinn_IF iqmod_mfb_lpf_0.iqmod_mfb_lpf_half_0.iqmod_mfb_lpf_ota_core_hybrid_bm_half$1_0.iqmod_mfb_lpf_ota_core_inv_NF20$2_0.vout VDD sg13_lv_pmos ad=1.14p pd=6.38u as=1.14p ps=6.38u w=6u l=1u
X343 VDD VDD VDD VDD sg13_lv_pmos ad=1.14p pd=6.38u as=0 ps=0 w=6u l=1u
X344 iqmod_mfb_lpf_0.iqmod_mfb_lpf_half_0.iqmod_mfb_lpf_ota_core_hybrid_bm_half$1_0.iqmod_mfb_lpf_ota_core_inv_NF20$2_0.vout iqmod_mixer_0.vinn_IF VSS VSS sg13_lv_nmos ad=0.19p pd=1.38u as=0.19p ps=1.38u w=1u l=1u
X345 VDD iqmod_mixer_0.iqmod_mixer_half_0.iqmod_mixer_se2diff$1_0.iqmod_mixer_se2diff_half_inv$2_0.iqmod_mixer_se2diff_inv_NF54$7_0.vin iqmod_mixer_0.iqmod_mixer_half_0.iqmod_mixer_tg$1_0.di_tg_ctrl VDD sg13_lv_pmos ad=0.57p pd=3.38u as=0.57p ps=3.38u w=3u l=0.13u
X346 iqmod_mfb_lpf_0.iqmod_mfb_lpf_half_0.iqmod_mfb_lpf_ota_core_hybrid_bm_half$1_0.iqmod_mfb_lpf_ota_core_tg$2_0.v_a iqmod_mfb_lpf_0.iqmod_mfb_lpf_half_1.iqmod_mfb_lpf_ota_core_hybrid_bm_half$1_0.iqmod_mfb_lpf_ota_core_tg$2_0.di_tg_ctrl_n iqmod_mfb_lpf_0.iqmod_mfb_lpf_half_0.iqmod_mfb_lpf_ota_core_hybrid_bm_half$1_0.iqmod_mfb_lpf_ota_core_tg$2_0.v_b VDD sg13_lv_pmos ad=2.04p pd=12.68u as=1.14p ps=6.38u w=6u l=0.13u
X347 iqmod_mixer_0.iqmod_mixer_half_1.iqmod_mixer_tg$1_0.di_tg_ctrl iqmod_mixer_0.iqmod_mixer_half_1.iqmod_mixer_se2diff$1_0.iqmod_mixer_se2diff_half_inv$2_0.iqmod_mixer_se2diff_inv_NF54$7_0.vin VSS VSS sg13_lv_nmos ad=0.19p pd=1.38u as=0.19p ps=1.38u w=1u l=0.13u
X348 VSS iqmod_mixer_0.iqmod_mixer_half_0.iqmod_mixer_se2diff$1_0.iqmod_mixer_se2diff_half_tg$2_0.iqmod_mixer_se2diff_inv_NF54$6_0.vin iqmod_mixer_0.iqmod_mixer_half_0.iqmod_mixer_tg$1_0.di_tg_ctrl_n VSS sg13_lv_nmos ad=0.19p pd=1.38u as=0.19p ps=1.38u w=1u l=0.13u
X349 VSS iqmod_mixer_0.iqmod_mixer_half_1.iqmod_mixer_se2diff$1_0.iqmod_mixer_se2diff_half_tg$2_0.iqmod_mixer_se2diff_inv_NF18$6_0.vin iqmod_mixer_0.iqmod_mixer_half_1.iqmod_mixer_se2diff$1_0.iqmod_mixer_se2diff_half_tg$2_0.iqmod_mixer_se2diff_inv_NF54$6_0.vin VSS sg13_lv_nmos ad=0.19p pd=1.38u as=0.19p ps=1.38u w=1u l=0.13u
X350 iqmod_mixer_0.iqmod_mixer_half_0.iqmod_mixer_tg$1_0.di_tg_ctrl iqmod_mixer_0.iqmod_mixer_half_0.iqmod_mixer_se2diff$1_0.iqmod_mixer_se2diff_half_inv$2_0.iqmod_mixer_se2diff_inv_NF54$7_0.vin VDD VDD sg13_lv_pmos ad=0.57p pd=3.38u as=0.57p ps=3.38u w=3u l=0.13u
X351 VDD iqmod_mfb_lpf_0.iqmod_mfb_lpf_half_1.iqmod_mfb_lpf_ota_core_hybrid_bm_half$1_0.iqmod_mfb_lpf_ota_core_tg$2_0.di_tg_ctrl_n iqmod_mfb_lpf_0.iqmod_mfb_lpf_half_1.iqmod_mfb_lpf_ota_core_hybrid_bm_half$1_0.iqmod_mfb_lpf_ota_core_inv_NF20$2_1.vin VSS sg13_lv_nmos ad=0.19p pd=1.38u as=0.19p ps=1.38u w=1u l=0.13u
X352 VSS iqmod_mixer_0.iqmod_mixer_half_1.iqmod_mixer_se2diff$1_0.iqmod_mixer_se2diff_half_inv$2_0.iqmod_mixer_se2diff_inv_NF54$7_0.vin iqmod_mixer_0.iqmod_mixer_half_1.iqmod_mixer_tg$1_0.di_tg_ctrl VSS sg13_lv_nmos ad=0.19p pd=1.38u as=0.19p ps=1.38u w=1u l=0.13u
X353 iqmod_mixer_0.iqmod_mixer_half_0.iqmod_mixer_tg$1_0.di_tg_ctrl_n iqmod_mixer_0.iqmod_mixer_half_0.iqmod_mixer_se2diff$1_0.iqmod_mixer_se2diff_half_tg$2_0.iqmod_mixer_se2diff_inv_NF54$6_0.vin VSS VSS sg13_lv_nmos ad=0.19p pd=1.38u as=0.19p ps=1.38u w=1u l=0.13u
X354 iqmod_mixer_0.iqmod_mixer_half_1.iqmod_mixer_tg$1_0.di_tg_ctrl iqmod_mixer_0.iqmod_mixer_half_1.iqmod_mixer_se2diff$1_0.iqmod_mixer_se2diff_half_inv$2_0.iqmod_mixer_se2diff_inv_NF54$7_0.vin VDD VDD sg13_lv_pmos ad=0.57p pd=3.38u as=0.57p ps=3.38u w=3u l=0.13u
X355 VSS iqmod_mixer_0.vinp_IF iqmod_mfb_lpf_0.iqmod_mfb_lpf_half_0.iqmod_mfb_lpf_ota_core_hybrid_bm_half$1_0.iqmod_mfb_lpf_ota_core_inv_NF20$2_0.vout VSS sg13_lv_nmos ad=0.19p pd=1.38u as=0.19p ps=1.38u w=1u l=1u
X356 iqmod_mixer_0.vinp_IF iqmod_mfb_lpf_0.iqmod_mfb_lpf_half_1.iqmod_mfb_lpf_ota_core_hybrid_bm_half$1_0.iqmod_mfb_lpf_ota_core_inv_NF20$2_1.vin VSS VSS sg13_lv_nmos ad=0.19p pd=1.38u as=0.19p ps=1.38u w=1u l=1u
X357 iqmod_mixer_0.iqmod_mixer_half_1.iqmod_mixer_se2diff$1_0.iqmod_mixer_se2diff_half_tg$2_0.iqmod_mixer_se2diff_inv_NF54$6_0.vin iqmod_mixer_0.iqmod_mixer_half_1.iqmod_mixer_se2diff$1_0.iqmod_mixer_se2diff_half_tg$2_0.iqmod_mixer_se2diff_inv_NF18$6_0.vin VSS VSS sg13_lv_nmos ad=0.19p pd=1.38u as=0.19p ps=1.38u w=1u l=0.13u
X358 iqmod_mfb_lpf_0.iqmod_mfb_lpf_half_0.iqmod_mfb_lpf_ota_core_hybrid_bm_half$1_0.iqmod_mfb_lpf_ota_core_inv_NF20$2_0.vout iqmod_mixer_0.vinn_IF VDD VDD sg13_lv_pmos ad=1.14p pd=6.38u as=1.14p ps=6.38u w=6u l=1u
X359 VDD iqmod_mixer_0.iqmod_mixer_half_0.iqmod_mixer_se2diff$1_0.iqmod_mixer_se2diff_half_inv$2_0.iqmod_mixer_se2diff_inv_NF54$7_0.vin iqmod_mixer_0.iqmod_mixer_half_0.iqmod_mixer_tg$1_0.di_tg_ctrl VDD sg13_lv_pmos ad=0.57p pd=3.38u as=0.57p ps=3.38u w=3u l=0.13u
X360 VDD iqmod_mfb_lpf_0.iqmod_mfb_lpf_half_0.iqmod_mfb_lpf_ota_core_hybrid_bm_half$1_0.iqmod_mfb_lpf_ota_core_inv_NF20$2_0.vout iqmod_mfb_lpf_0.iqmod_mfb_lpf_half_0.iqmod_mfb_lpf_ota_core_hybrid_bm_half$1_0.iqmod_mfb_lpf_ota_core_inv_NF6$2_1.vout VDD sg13_lv_pmos ad=1.14p pd=6.38u as=1.14p ps=6.38u w=6u l=1u
X361 VDD iqmod_mfb_lpf_0.iqmod_mfb_lpf_half_0.iqmod_mfb_lpf_ota_core_hybrid_bm_half$1_0.iqmod_mfb_lpf_ota_core_tg$2_0.v_b iqmod_mixer_0.vinp_IF VDD sg13_lv_pmos ad=1.14p pd=6.38u as=1.14p ps=6.38u w=6u l=1u
X362 VDD VDD VDD VDD sg13_lv_pmos ad=1.02p pd=6.68u as=0 ps=0 w=3u l=0.13u
X363 iqmod_mixer_0.iqmod_mixer_half_0.iqmod_mixer_se2diff$1_0.iqmod_mixer_se2diff_half_tg$2_0.iqmod_mixer_se2diff_inv_NF54$6_0.vin iqmod_mixer_0.iqmod_mixer_half_0.iqmod_mixer_se2diff$1_0.iqmod_mixer_se2diff_half_tg$2_0.iqmod_mixer_se2diff_inv_NF18$6_0.vin VDD VDD sg13_lv_pmos ad=0.57p pd=3.38u as=0.57p ps=3.38u w=3u l=0.13u
X364 iqmod_mfb_lpf_0.iqmod_mfb_lpf_half_1.iqmod_mfb_lpf_ota_core_hybrid_bm_half$1_0.iqmod_mfb_lpf_ota_core_tg$2_0.di_tg_ctrl_n di_analog_en VSS VSS sg13_lv_nmos ad=0.19p pd=1.38u as=0.19p ps=1.38u w=1u l=0.13u
X365 VDD iqmod_mixer_0.iqmod_mixer_half_1.iqmod_mixer_se2diff$1_0.iqmod_mixer_se2diff_half_tg$2_0.iqmod_mixer_se2diff_inv_NF18$6_0.vin iqmod_mixer_0.iqmod_mixer_half_1.iqmod_mixer_se2diff$1_0.iqmod_mixer_se2diff_half_tg$2_0.iqmod_mixer_se2diff_inv_NF54$6_0.vin VDD sg13_lv_pmos ad=0.57p pd=3.38u as=0.57p ps=3.38u w=3u l=0.13u
X366 VSS VSS VSS VSS sg13_lv_nmos ad=0.19p pd=1.38u as=0 ps=0 w=1u l=1u
X367 iqmod_mixer_0.iqmod_mixer_half_1.iqmod_mixer_tg$1_0.di_tg_ctrl iqmod_mixer_0.iqmod_mixer_half_1.iqmod_mixer_se2diff$1_0.iqmod_mixer_se2diff_half_inv$2_0.iqmod_mixer_se2diff_inv_NF54$7_0.vin VDD VDD sg13_lv_pmos ad=0.57p pd=3.38u as=0.57p ps=3.38u w=3u l=0.13u
X368 VSS iqmod_mfb_lpf_0.iqmod_mfb_lpf_half_1.iqmod_mfb_lpf_ota_core_hybrid_bm_half$1_0.iqmod_mfb_lpf_ota_core_inv_NF20$2_1.vin iqmod_mixer_0.vinp_IF VSS sg13_lv_nmos ad=0.19p pd=1.38u as=0.19p ps=1.38u w=1u l=1u
X369 iqmod_mixer_0.iqmod_mixer_half_1.iqmod_mixer_se2diff$1_0.iqmod_mixer_se2diff_half_tg$2_0.iqmod_mixer_se2diff_inv_NF54$6_0.vin iqmod_mixer_0.iqmod_mixer_half_1.iqmod_mixer_se2diff$1_0.iqmod_mixer_se2diff_half_tg$2_0.iqmod_mixer_se2diff_inv_NF18$6_0.vin VDD VDD sg13_lv_pmos ad=0.57p pd=3.38u as=0.57p ps=3.38u w=3u l=0.13u
X370 VSS iqmod_mixer_0.iqmod_mixer_half_0.iqmod_mixer_se2diff$1_0.iqmod_mixer_se2diff_half_tg$2_0.iqmod_mixer_se2diff_inv_NF54$6_0.vin iqmod_mixer_0.iqmod_mixer_half_0.iqmod_mixer_tg$1_0.di_tg_ctrl_n VSS sg13_lv_nmos ad=0.19p pd=1.38u as=0.19p ps=1.38u w=1u l=0.13u
X371 iqmod_mfb_lpf_0.iqmod_mfb_lpf_half_0.iqmod_mfb_lpf_ota_core_hybrid_bm_half$1_0.iqmod_mfb_lpf_ota_core_tg$2_0.v_a iqmod_mfb_lpf_0.iqmod_mfb_lpf_half_1.iqmod_mfb_lpf_ota_core_hybrid_bm_half$1_0.iqmod_mfb_lpf_ota_core_tg$2_0.di_tg_ctrl_n iqmod_mfb_lpf_0.iqmod_mfb_lpf_half_0.iqmod_mfb_lpf_ota_core_hybrid_bm_half$1_0.iqmod_mfb_lpf_ota_core_tg$2_0.v_b VDD sg13_lv_pmos ad=1.14p pd=6.38u as=1.14p ps=6.38u w=6u l=0.13u
X372 iqmod_mixer_0.iqmod_mixer_half_1.iqmod_mixer_tg$1_0.di_tg_ctrl_n iqmod_mixer_0.iqmod_mixer_half_1.iqmod_mixer_se2diff$1_0.iqmod_mixer_se2diff_half_tg$2_0.iqmod_mixer_se2diff_inv_NF54$6_0.vin VSS VSS sg13_lv_nmos ad=0.19p pd=1.38u as=0.19p ps=1.38u w=1u l=0.13u
X373 iqmod_mixer_0.vinp_IF iqmod_mfb_lpf_0.iqmod_mfb_lpf_half_0.iqmod_mfb_lpf_ota_core_hybrid_bm_half$1_0.iqmod_mfb_lpf_ota_core_tg$2_0.v_b VDD VDD sg13_lv_pmos ad=1.14p pd=6.38u as=1.14p ps=6.38u w=6u l=1u
X374 iqmod_mixer_0.iqmod_mixer_half_1.iqmod_mixer_tg$1_0.di_tg_ctrl_n iqmod_mixer_0.iqmod_mixer_half_1.iqmod_mixer_se2diff$1_0.iqmod_mixer_se2diff_half_tg$2_0.iqmod_mixer_se2diff_inv_NF54$6_0.vin VSS VSS sg13_lv_nmos ad=0.19p pd=1.38u as=0.19p ps=1.38u w=1u l=0.13u
X375 voutn_I_RF iqmod_mixer_0.iqmod_mixer_half_0.iqmod_mixer_tg$1_0.di_tg_ctrl voutn_I_RF VDD sg13_lv_pmos ad=1.71p pd=9.38u as=0 ps=0 w=9u l=0.13u
X376 iqmod_mixer_0.iqmod_mixer_half_1.iqmod_mixer_tg$1_0.di_tg_ctrl iqmod_mixer_0.iqmod_mixer_half_1.iqmod_mixer_se2diff$1_0.iqmod_mixer_se2diff_half_inv$2_0.iqmod_mixer_se2diff_inv_NF54$7_0.vin VDD VDD sg13_lv_pmos ad=0.57p pd=3.38u as=0.57p ps=3.38u w=3u l=0.13u
X377 iqmod_mixer_0.iqmod_mixer_half_0.iqmod_mixer_tg$1_0.di_tg_ctrl_n iqmod_mixer_0.iqmod_mixer_half_0.iqmod_mixer_se2diff$1_0.iqmod_mixer_se2diff_half_tg$2_0.iqmod_mixer_se2diff_inv_NF54$6_0.vin VDD VDD sg13_lv_pmos ad=0.57p pd=3.38u as=0.57p ps=3.38u w=3u l=0.13u
X378 VSS iqmod_mixer_0.iqmod_mixer_half_1.iqmod_mixer_se2diff$1_0.iqmod_mixer_se2diff_half_inv$2_0.iqmod_mixer_se2diff_inv_NF18$7_0.vin iqmod_mixer_0.iqmod_mixer_half_1.iqmod_mixer_se2diff$1_0.iqmod_mixer_se2diff_half_inv$2_0.iqmod_mixer_se2diff_inv_NF54$7_0.vin VSS sg13_lv_nmos ad=0.19p pd=1.38u as=0.19p ps=1.38u w=1u l=0.13u
X379 voutn_I_RF iqmod_mixer_0.iqmod_mixer_half_0.iqmod_mixer_tg$1_0.di_tg_ctrl_n iqmod_mixer_0.vinn_IF VDD sg13_lv_pmos ad=1.71p pd=9.38u as=1.71p ps=9.38u w=9u l=0.13u
X380 VSS VSS VSS VSS sg13_lv_nmos ad=0.19p pd=1.38u as=0 ps=0 w=1u l=0.13u
X381 VSS iqmod_mixer_0.iqmod_mixer_half_1.iqmod_mixer_se2diff$1_0.iqmod_mixer_se2diff_half_tg$2_0.iqmod_mixer_se2diff_inv_NF54$6_0.vin iqmod_mixer_0.iqmod_mixer_half_1.iqmod_mixer_tg$1_0.di_tg_ctrl_n VSS sg13_lv_nmos ad=0.19p pd=1.38u as=0.19p ps=1.38u w=1u l=0.13u
X382 iqmod_mixer_0.iqmod_mixer_half_1.iqmod_mixer_tg$1_0.di_tg_ctrl iqmod_mixer_0.iqmod_mixer_half_1.iqmod_mixer_se2diff$1_0.iqmod_mixer_se2diff_half_inv$2_0.iqmod_mixer_se2diff_inv_NF54$7_0.vin VDD VDD sg13_lv_pmos ad=0.57p pd=3.38u as=0.57p ps=3.38u w=3u l=0.13u
X383 voutn_I_RF iqmod_mixer_0.iqmod_mixer_half_0.iqmod_mixer_tg$1_0.di_tg_ctrl voutn_I_RF VDD sg13_lv_pmos ad=1.71p pd=9.38u as=0 ps=0 w=9u l=0.13u
X384 VDD VDD VDD VDD sg13_lv_pmos ad=0.57p pd=3.38u as=0 ps=0 w=3u l=0.13u
X385 VSS iqmod_mixer_0.iqmod_mixer_half_1.iqmod_mixer_se2diff$1_0.iqmod_mixer_se2diff_half_tg$2_0.iqmod_mixer_se2diff_inv_NF54$6_0.vin iqmod_mixer_0.iqmod_mixer_half_1.iqmod_mixer_tg$1_0.di_tg_ctrl_n VSS sg13_lv_nmos ad=0.19p pd=1.38u as=0.19p ps=1.38u w=1u l=0.13u
X386 VDD VDD VDD VDD sg13_lv_pmos ad=2.04p pd=12.68u as=0 ps=0 w=6u l=1u
X387 VDD iqmod_mixer_0.iqmod_mixer_half_0.iqmod_mixer_se2diff$1_0.iqmod_mixer_se2diff_half_inv$2_0.iqmod_mixer_se2diff_inv_NF18$7_0.vin iqmod_mixer_0.iqmod_mixer_half_0.iqmod_mixer_se2diff$1_0.iqmod_mixer_se2diff_half_inv$2_0.iqmod_mixer_se2diff_inv_NF54$7_0.vin VDD sg13_lv_pmos ad=0.57p pd=3.38u as=0.57p ps=3.38u w=3u l=0.13u
X388 iqmod_mixer_0.vinp_IF iqmod_mixer_0.iqmod_mixer_half_1.iqmod_mixer_tg$1_0.di_tg_ctrl_n voutp_I_RF VDD sg13_lv_pmos ad=1.71p pd=9.38u as=1.71p ps=9.38u w=9u l=0.13u
X389 iqmod_mixer_0.iqmod_mixer_half_1.iqmod_mixer_se2diff$1_0.iqmod_mixer_se2diff_half_inv$2_0.iqmod_mixer_se2diff_inv_NF54$7_0.vin iqmod_mixer_0.iqmod_mixer_half_1.iqmod_mixer_se2diff$1_0.iqmod_mixer_se2diff_half_inv$2_0.iqmod_mixer_se2diff_inv_NF18$7_0.vin VSS VSS sg13_lv_nmos ad=0.19p pd=1.38u as=0.19p ps=1.38u w=1u l=0.13u
X390 VSS VSS VSS VSS sg13_lv_nmos ad=0.34p pd=2.68u as=0 ps=0 w=1u l=0.13u
X391 voutn_I_RF iqmod_mixer_0.iqmod_mixer_half_0.iqmod_mixer_tg$1_0.di_tg_ctrl iqmod_mixer_0.vinn_IF VSS sg13_lv_nmos ad=0.57p pd=3.38u as=0.57p ps=3.38u w=3u l=0.13u
X392 iqmod_mfb_lpf_0.iqmod_mfb_lpf_half_0.iqmod_mfb_lpf_ota_core_hybrid_bm_half$1_0.iqmod_mfb_lpf_ota_core_inv_NF20$2_0.vout iqmod_mixer_0.vinp_IF VDD VDD sg13_lv_pmos ad=1.14p pd=6.38u as=1.14p ps=6.38u w=6u l=1u
X393 VDD iqmod_mfb_lpf_0.iqmod_mfb_lpf_half_0.iqmod_mfb_lpf_ota_core_hybrid_bm_half$1_0.iqmod_mfb_lpf_ota_core_tg$2_0.v_b iqmod_mixer_0.vinp_IF VDD sg13_lv_pmos ad=1.14p pd=6.38u as=1.14p ps=6.38u w=6u l=1u
X394 VDD iqmod_mixer_0.iqmod_mixer_half_1.iqmod_mixer_se2diff$1_0.iqmod_mixer_se2diff_half_tg$2_0.iqmod_mixer_se2diff_tg_NF6$3_0.v_b iqmod_mixer_0.iqmod_mixer_half_1.iqmod_mixer_se2diff$1_0.iqmod_mixer_se2diff_half_inv$2_0.iqmod_mixer_se2diff_inv_NF2$7_1.vout VDD sg13_lv_pmos ad=0.57p pd=3.38u as=0.57p ps=3.38u w=3u l=0.13u
X395 di_ds_I_n iqmod_spdt_switch_0.spdt_switch_inv_0.vout iqmod_spdt_switch_0.v_c VDD sg13_lv_pmos ad=1.14p pd=6.38u as=1.14p ps=6.38u w=6u l=0.13u
X396 iqmod_mixer_0.iqmod_mixer_half_1.iqmod_mixer_tg$1_0.di_tg_ctrl_n iqmod_mixer_0.iqmod_mixer_half_1.iqmod_mixer_se2diff$1_0.iqmod_mixer_se2diff_half_tg$2_0.iqmod_mixer_se2diff_inv_NF54$6_0.vin VDD VDD sg13_lv_pmos ad=0.57p pd=3.38u as=0.57p ps=3.38u w=3u l=0.13u
X397 iqmod_mixer_0.iqmod_mixer_half_0.iqmod_mixer_se2diff$1_0.iqmod_mixer_se2diff_half_inv$2_0.iqmod_mixer_se2diff_inv_NF54$7_0.vin iqmod_mixer_0.iqmod_mixer_half_0.iqmod_mixer_se2diff$1_0.iqmod_mixer_se2diff_half_inv$2_0.iqmod_mixer_se2diff_inv_NF18$7_0.vin VDD VDD sg13_lv_pmos ad=0.57p pd=3.38u as=0.57p ps=3.38u w=3u l=0.13u
X398 VSS iqmod_mfb_lpf_0.iqmod_mfb_lpf_half_0.iqmod_mfb_lpf_ota_core_hybrid_bm_half$1_0.iqmod_mfb_lpf_ota_core_tg$2_0.v_b iqmod_mixer_0.vinn_IF VSS sg13_lv_nmos ad=0.19p pd=1.38u as=0.19p ps=1.38u w=1u l=1u
X399 voutp_I_RF iqmod_mixer_0.iqmod_mixer_half_1.iqmod_mixer_tg$1_0.di_tg_ctrl_n iqmod_mixer_0.vinp_IF VDD sg13_lv_pmos ad=1.71p pd=9.38u as=1.71p ps=9.38u w=9u l=0.13u
X400 VDD iqmod_mixer_0.iqmod_mixer_half_1.iqmod_mixer_se2diff$1_0.iqmod_mixer_se2diff_half_inv$2_0.iqmod_mixer_se2diff_inv_NF18$7_0.vin iqmod_mixer_0.iqmod_mixer_half_1.iqmod_mixer_se2diff$1_0.iqmod_mixer_se2diff_half_inv$2_0.iqmod_mixer_se2diff_inv_NF54$7_0.vin VDD sg13_lv_pmos ad=0.57p pd=3.38u as=0.57p ps=3.38u w=3u l=0.13u
X401 voutp_I_RF iqmod_mixer_0.iqmod_mixer_half_1.iqmod_mixer_tg$1_0.di_tg_ctrl_n voutp_I_RF VSS sg13_lv_nmos ad=0.57p pd=3.38u as=0 ps=0 w=3u l=0.13u
X402 iqmod_mixer_0.vinn_IF iqmod_mixer_0.iqmod_mixer_half_0.iqmod_mixer_tg$1_0.di_tg_ctrl voutn_I_RF VSS sg13_lv_nmos ad=0.57p pd=3.38u as=0.57p ps=3.38u w=3u l=0.13u
X403 voutn_I_RF iqmod_mixer_0.iqmod_mixer_half_0.iqmod_mixer_tg$1_0.di_tg_ctrl_n iqmod_mixer_0.vinn_IF VDD sg13_lv_pmos ad=1.71p pd=9.38u as=1.71p ps=9.38u w=9u l=0.13u
X404 iqmod_mixer_0.iqmod_mixer_half_1.iqmod_mixer_se2diff$1_0.iqmod_mixer_se2diff_half_inv$2_0.iqmod_mixer_se2diff_inv_NF2$7_1.vout iqmod_mixer_0.iqmod_mixer_half_1.iqmod_mixer_se2diff$1_0.iqmod_mixer_se2diff_half_tg$2_0.iqmod_mixer_se2diff_tg_NF6$3_0.v_b VDD VDD sg13_lv_pmos ad=0.57p pd=3.38u as=0.57p ps=3.38u w=3u l=0.13u
X405 iqmod_mfb_lpf_0.iqmod_mfb_lpf_half_0.iqmod_mfb_lpf_ota_core_hybrid_bm_half$1_0.iqmod_mfb_lpf_ota_core_tg$2_0.v_a iqmod_mfb_lpf_0.iqmod_mfb_lpf_half_1.iqmod_mfb_lpf_ota_core_hybrid_bm_half$1_0.iqmod_mfb_lpf_ota_core_inv_NF20$2_1.vin VSS VSS sg13_lv_nmos ad=0.19p pd=1.38u as=0.19p ps=1.38u w=1u l=1u
X406 iqmod_mfb_lpf_0.iqmod_mfb_lpf_half_0.iqmod_mfb_lpf_ota_core_hybrid_bm_half$1_0.iqmod_mfb_lpf_ota_core_tg$2_0.v_b iqmod_mfb_lpf_0.iqmod_mfb_lpf_half_0.iqmod_mfb_lpf_ota_core_hybrid_bm_half$1_0.iqmod_mfb_lpf_ota_core_inv_NF6$2_1.vout VDD VDD sg13_lv_pmos ad=1.14p pd=6.38u as=1.14p ps=6.38u w=6u l=1u
X407 VDD VDD VDD VDD sg13_lv_pmos ad=2.04p pd=12.68u as=0 ps=0 w=6u l=1u
X408 VSS iqmod_mixer_0.iqmod_mixer_half_0.iqmod_mixer_se2diff$1_0.iqmod_mixer_se2diff_half_inv$2_0.iqmod_mixer_se2diff_inv_NF54$7_0.vin iqmod_mixer_0.iqmod_mixer_half_0.iqmod_mixer_tg$1_0.di_tg_ctrl VSS sg13_lv_nmos ad=0.19p pd=1.38u as=0.19p ps=1.38u w=1u l=0.13u
X409 VSS iqmod_mixer_0.iqmod_mixer_half_0.iqmod_mixer_se2diff$1_0.iqmod_mixer_se2diff_half_inv$2_0.iqmod_mixer_se2diff_inv_NF54$7_0.vin iqmod_mixer_0.iqmod_mixer_half_0.iqmod_mixer_tg$1_0.di_tg_ctrl VSS sg13_lv_nmos ad=0.19p pd=1.38u as=0.19p ps=1.38u w=1u l=0.13u
X410 iqmod_mixer_0.iqmod_mixer_half_1.iqmod_mixer_tg$1_0.di_tg_ctrl iqmod_mixer_0.iqmod_mixer_half_1.iqmod_mixer_se2diff$1_0.iqmod_mixer_se2diff_half_inv$2_0.iqmod_mixer_se2diff_inv_NF54$7_0.vin VDD VDD sg13_lv_pmos ad=0.57p pd=3.38u as=0.57p ps=3.38u w=3u l=0.13u
X411 VSS VSS VSS VSS sg13_lv_nmos ad=0.19p pd=1.38u as=0 ps=0 w=1u l=0.13u
X412 VDD VDD VDD VDD sg13_lv_pmos ad=1.14p pd=6.38u as=0 ps=0 w=6u l=0.13u
X413 VSS iqmod_mixer_0.iqmod_mixer_half_0.iqmod_mixer_se2diff$1_0.iqmod_mixer_se2diff_half_inv$2_0.iqmod_mixer_se2diff_inv_NF6$7_1.vin iqmod_mixer_0.iqmod_mixer_half_0.iqmod_mixer_se2diff$1_0.iqmod_mixer_se2diff_half_inv$2_0.iqmod_mixer_se2diff_inv_NF18$7_0.vin VSS sg13_lv_nmos ad=0.19p pd=1.38u as=0.19p ps=1.38u w=1u l=0.13u
X414 iqmod_mixer_0.iqmod_mixer_half_0.iqmod_mixer_se2diff$1_0.iqmod_mixer_se2diff_half_tg$2_0.iqmod_mixer_se2diff_inv_NF54$6_0.vin iqmod_mixer_0.iqmod_mixer_half_0.iqmod_mixer_se2diff$1_0.iqmod_mixer_se2diff_half_tg$2_0.iqmod_mixer_se2diff_inv_NF18$6_0.vin VSS VSS sg13_lv_nmos ad=0.19p pd=1.38u as=0.19p ps=1.38u w=1u l=0.13u
X415 VSS iqmod_mixer_0.iqmod_mixer_half_1.iqmod_mixer_se2diff$1_0.iqmod_mixer_se2diff_half_inv$2_0.iqmod_mixer_se2diff_inv_NF6$7_0.vout iqmod_mixer_0.iqmod_mixer_half_1.iqmod_mixer_se2diff$1_0.iqmod_mixer_se2diff_half_inv$2_0.iqmod_mixer_se2diff_inv_NF6$7_1.vin VSS sg13_lv_nmos ad=0.19p pd=1.38u as=0.19p ps=1.38u w=1u l=0.13u
X416 iqmod_mixer_0.iqmod_mixer_half_0.iqmod_mixer_tg$1_0.di_tg_ctrl iqmod_mixer_0.iqmod_mixer_half_0.iqmod_mixer_se2diff$1_0.iqmod_mixer_se2diff_half_inv$2_0.iqmod_mixer_se2diff_inv_NF54$7_0.vin VSS VSS sg13_lv_nmos ad=0.19p pd=1.38u as=0.19p ps=1.38u w=1u l=0.13u
X417 VDD iqmod_mfb_lpf_0.iqmod_mfb_lpf_half_0.iqmod_mfb_lpf_ota_core_hybrid_bm_half$1_0.iqmod_mfb_lpf_ota_core_tg$2_0.di_tg_ctrl_n iqmod_mfb_lpf_0.iqmod_mfb_lpf_half_0.iqmod_mfb_lpf_ota_core_hybrid_bm_half$1_0.iqmod_mfb_lpf_ota_core_inv_NF20$2_1.vin VSS sg13_lv_nmos ad=0.34p pd=2.68u as=0.19p ps=1.38u w=1u l=0.13u
X418 iqmod_mixer_0.iqmod_mixer_half_1.iqmod_mixer_se2diff$1_0.iqmod_mixer_se2diff_half_tg$2_0.iqmod_mixer_se2diff_inv_NF18$6_0.vin iqmod_mixer_0.iqmod_mixer_half_1.iqmod_mixer_se2diff$1_0.iqmod_mixer_se2diff_half_inv$2_0.iqmod_mixer_se2diff_inv_NF2$7_1.vout VSS VSS sg13_lv_nmos ad=0.19p pd=1.38u as=0.19p ps=1.38u w=1u l=0.13u
X419 iqmod_mixer_0.iqmod_mixer_half_1.iqmod_mixer_tg$1_0.di_tg_ctrl iqmod_mixer_0.iqmod_mixer_half_1.iqmod_mixer_se2diff$1_0.iqmod_mixer_se2diff_half_inv$2_0.iqmod_mixer_se2diff_inv_NF54$7_0.vin VSS VSS sg13_lv_nmos ad=0.19p pd=1.38u as=0.19p ps=1.38u w=1u l=0.13u
X420 iqmod_mixer_0.iqmod_mixer_half_0.iqmod_mixer_tg$1_0.di_tg_ctrl_n iqmod_mixer_0.iqmod_mixer_half_0.iqmod_mixer_se2diff$1_0.iqmod_mixer_se2diff_half_tg$2_0.iqmod_mixer_se2diff_inv_NF54$6_0.vin VDD VDD sg13_lv_pmos ad=0.57p pd=3.38u as=0.57p ps=3.38u w=3u l=0.13u
X421 VDD VDD VDD VDD sg13_lv_pmos ad=2.04p pd=12.68u as=0 ps=0 w=6u l=0.13u
X422 VDD iqmod_mixer_0.iqmod_mixer_half_0.iqmod_mixer_se2diff$1_0.iqmod_mixer_se2diff_half_inv$2_0.iqmod_mixer_se2diff_inv_NF6$7_0.vout iqmod_mixer_0.iqmod_mixer_half_0.iqmod_mixer_se2diff$1_0.iqmod_mixer_se2diff_half_inv$2_0.iqmod_mixer_se2diff_inv_NF6$7_1.vin VDD sg13_lv_pmos ad=0.57p pd=3.38u as=0.57p ps=3.38u w=3u l=0.13u
X423 VSS iqmod_mfb_lpf_0.iqmod_mfb_lpf_half_1.iqmod_mfb_lpf_ota_core_hybrid_bm_half$1_0.iqmod_mfb_lpf_ota_core_inv_NF20$2_1.vin iqmod_mfb_lpf_0.iqmod_mfb_lpf_half_0.iqmod_mfb_lpf_ota_core_hybrid_bm_half$1_0.iqmod_mfb_lpf_ota_core_tg$2_0.v_a VSS sg13_lv_nmos ad=0.19p pd=1.38u as=0.19p ps=1.38u w=1u l=1u
X424 VDD iqmod_mfb_lpf_0.iqmod_mfb_lpf_half_0.iqmod_mfb_lpf_ota_core_hybrid_bm_half$1_0.iqmod_mfb_lpf_ota_core_inv_NF6$2_1.vout iqmod_mfb_lpf_0.iqmod_mfb_lpf_half_0.iqmod_mfb_lpf_ota_core_hybrid_bm_half$1_0.iqmod_mfb_lpf_ota_core_tg$2_0.v_b VDD sg13_lv_pmos ad=1.14p pd=6.38u as=1.14p ps=6.38u w=6u l=1u
X425 iqmod_mfb_lpf_0.iqmod_mfb_lpf_half_0.iqmod_mfb_lpf_ota_core_hybrid_bm_half$1_0.iqmod_mfb_lpf_ota_core_tg$2_0.v_a iqmod_mfb_lpf_0.iqmod_mfb_lpf_half_0.iqmod_mfb_lpf_ota_core_hybrid_bm_half$1_0.iqmod_mfb_lpf_ota_core_inv_NF20$2_1.vin VDD VDD sg13_lv_pmos ad=1.14p pd=6.38u as=1.14p ps=6.38u w=6u l=1u
X426 VSS VSS VSS VSS sg13_lv_nmos ad=0.34p pd=2.68u as=0 ps=0 w=1u l=0.13u
X427 iqmod_mixer_0.iqmod_mixer_half_1.iqmod_mixer_se2diff$1_0.iqmod_mixer_se2diff_half_inv$2_0.iqmod_mixer_se2diff_inv_NF6$7_1.vin iqmod_mixer_0.iqmod_mixer_half_1.iqmod_mixer_se2diff$1_0.iqmod_mixer_se2diff_half_inv$2_0.iqmod_mixer_se2diff_inv_NF6$7_0.vout VSS VSS sg13_lv_nmos ad=0.19p pd=1.38u as=0.19p ps=1.38u w=1u l=0.13u
X428 iqmod_mixer_0.iqmod_mixer_half_0.iqmod_mixer_tg$1_0.di_tg_ctrl iqmod_mixer_0.iqmod_mixer_half_0.iqmod_mixer_se2diff$1_0.iqmod_mixer_se2diff_half_inv$2_0.iqmod_mixer_se2diff_inv_NF54$7_0.vin VDD VDD sg13_lv_pmos ad=0.57p pd=3.38u as=0.57p ps=3.38u w=3u l=0.13u
X429 iqmod_mfb_lpf_0.iqmod_mfb_lpf_half_0.iqmod_mfb_lpf_ota_core_hybrid_bm_half$1_0.iqmod_mfb_lpf_ota_core_inv_NF20$2_1.vin iqmod_mfb_lpf_0.iqmod_mfb_lpf_half_0.iqmod_mfb_lpf_ota_core_hybrid_bm_half$1_0.iqmod_mfb_lpf_ota_core_tg$2_0.di_tg_ctrl_n VDD VSS sg13_lv_nmos ad=0.19p pd=1.38u as=0.19p ps=1.38u w=1u l=0.13u
X430 iqmod_mixer_0.iqmod_mixer_half_0.iqmod_mixer_se2diff$1_0.iqmod_mixer_se2diff_half_tg$2_0.iqmod_mixer_se2diff_inv_NF18$6_0.vin iqmod_mixer_0.iqmod_mixer_half_0.iqmod_mixer_se2diff$1_0.iqmod_mixer_se2diff_half_inv$2_0.iqmod_mixer_se2diff_inv_NF2$7_1.vout VDD VDD sg13_lv_pmos ad=0.57p pd=3.38u as=0.57p ps=3.38u w=3u l=0.13u
X431 VSS VSS VSS VSS sg13_lv_nmos ad=0.34p pd=2.68u as=0 ps=0 w=1u l=0.13u
X432 VDD iqmod_mixer_0.iqmod_mixer_half_0.iqmod_mixer_se2diff$1_0.iqmod_mixer_se2diff_half_tg$2_0.iqmod_mixer_se2diff_inv_NF54$6_0.vin iqmod_mixer_0.iqmod_mixer_half_0.iqmod_mixer_tg$1_0.di_tg_ctrl_n VDD sg13_lv_pmos ad=0.57p pd=3.38u as=0.57p ps=3.38u w=3u l=0.13u
X433 iqmod_mfb_lpf_0.iqmod_mfb_lpf_half_0.iqmod_mfb_lpf_ota_core_hybrid_bm_half$1_0.iqmod_mfb_lpf_ota_core_tg$2_0.v_b iqmod_mfb_lpf_0.iqmod_mfb_lpf_half_0.iqmod_mfb_lpf_ota_core_hybrid_bm_half$1_0.iqmod_mfb_lpf_ota_core_tg$2_0.v_a VSS VSS sg13_lv_nmos ad=0.19p pd=1.38u as=0.19p ps=1.38u w=1u l=1u
X434 iqmod_mfb_lpf_0.iqmod_mfb_lpf_half_0.iqmod_mfb_lpf_ota_core_hybrid_bm_half$1_0.iqmod_mfb_lpf_ota_core_inv_NF20$2_0.vout iqmod_mixer_0.vinp_IF VDD VDD sg13_lv_pmos ad=1.14p pd=6.38u as=1.14p ps=6.38u w=6u l=1u
X435 iqmod_mixer_0.iqmod_mixer_half_0.iqmod_mixer_se2diff$1_0.iqmod_mixer_se2diff_half_inv$2_0.iqmod_mixer_se2diff_inv_NF6$7_1.vin iqmod_mixer_0.iqmod_mixer_half_0.iqmod_mixer_se2diff$1_0.iqmod_mixer_se2diff_half_inv$2_0.iqmod_mixer_se2diff_inv_NF6$7_0.vout VDD VDD sg13_lv_pmos ad=0.57p pd=3.38u as=0.57p ps=3.38u w=3u l=0.13u
X436 VDD iqmod_mixer_0.iqmod_mixer_half_0.iqmod_mixer_se2diff$1_0.iqmod_mixer_se2diff_half_inv$2_0.iqmod_mixer_se2diff_inv_NF2$7_1.vout iqmod_mixer_0.iqmod_mixer_half_0.iqmod_mixer_se2diff$1_0.iqmod_mixer_se2diff_half_tg$2_0.iqmod_mixer_se2diff_inv_NF18$6_0.vin VDD sg13_lv_pmos ad=0.57p pd=3.38u as=0.57p ps=3.38u w=3u l=0.13u
X437 VSS VSS VSS VSS sg13_lv_nmos ad=0.34p pd=2.68u as=0 ps=0 w=1u l=1u
X438 iqmod_mfb_lpf_0.iqmod_mfb_lpf_half_0.iqmod_mfb_lpf_ota_core_hybrid_bm_half$1_0.iqmod_mfb_lpf_ota_core_inv_NF20$2_0.vout di_analog_en iqmod_mfb_lpf_0.iqmod_mfb_lpf_half_0.iqmod_mfb_lpf_ota_core_hybrid_bm_half$1_0.iqmod_mfb_lpf_ota_core_inv_NF6$2_1.vout VSS sg13_lv_nmos ad=0.19p pd=1.38u as=0.19p ps=1.38u w=1u l=0.13u
X439 iqmod_mixer_0.vinn_IF iqmod_mfb_lpf_0.iqmod_mfb_lpf_half_0.iqmod_mfb_lpf_ota_core_hybrid_bm_half$1_0.iqmod_mfb_lpf_ota_core_inv_NF20$2_1.vin VSS VSS sg13_lv_nmos ad=0.19p pd=1.38u as=0.19p ps=1.38u w=1u l=1u
X440 iqmod_mixer_0.vinn_IF iqmod_mixer_0.iqmod_mixer_half_0.iqmod_mixer_tg$1_0.di_tg_ctrl voutn_I_RF VSS sg13_lv_nmos ad=0.57p pd=3.38u as=0.57p ps=3.38u w=3u l=0.13u
X441 VSS VSS VSS VSS sg13_lv_nmos ad=0.34p pd=2.68u as=0 ps=0 w=1u l=0.13u
X442 iqmod_spdt_switch_1.v_c iqmod_mfb_lpf_0.iqmod_mfb_lpf_half_0.iqmod_mfb_lpf_ota_core_hybrid_bm_half$1_0.iqmod_mfb_lpf_ota_core_tg$2_0.di_tg_ctrl_n iqmod_mfb_lpf_0.iqmod_mfb_lpf_half_0.iqmod_mfb_lpf_ota_core_hybrid_bm_half$1_0.iqmod_mfb_lpf_ota_core_inv_NF20$2_1.vin VDD sg13_lv_pmos ad=2.04p pd=12.68u as=1.14p ps=6.38u w=6u l=0.13u
X443 iqmod_mfb_lpf_0.iqmod_mfb_lpf_half_0.iqmod_mfb_lpf_ota_core_hybrid_bm_half$1_0.iqmod_mfb_lpf_ota_core_tg$2_0.v_a iqmod_mfb_lpf_0.iqmod_mfb_lpf_half_1.iqmod_mfb_lpf_ota_core_hybrid_bm_half$1_0.iqmod_mfb_lpf_ota_core_inv_NF20$2_1.vin VSS VSS sg13_lv_nmos ad=0.19p pd=1.38u as=0.19p ps=1.38u w=1u l=1u
X444 VDD iqmod_mixer_0.iqmod_mixer_half_1.iqmod_mixer_se2diff$1_0.iqmod_mixer_se2diff_half_tg$2_0.iqmod_mixer_se2diff_inv_NF54$6_0.vin iqmod_mixer_0.iqmod_mixer_half_1.iqmod_mixer_tg$1_0.di_tg_ctrl_n VDD sg13_lv_pmos ad=0.57p pd=3.38u as=0.57p ps=3.38u w=3u l=0.13u
X445 VSS VSS VSS rhigh l=60u w=0.5u
X446 VSS iqmod_mfb_lpf_0.iqmod_mfb_lpf_half_0.iqmod_mfb_lpf_ota_core_hybrid_bm_half$1_0.iqmod_mfb_lpf_ota_core_inv_NF6$2_1.vout iqmod_mfb_lpf_0.iqmod_mfb_lpf_half_0.iqmod_mfb_lpf_ota_core_hybrid_bm_half$1_0.iqmod_mfb_lpf_ota_core_tg$2_0.v_b VSS sg13_lv_nmos ad=0.19p pd=1.38u as=0.19p ps=1.38u w=1u l=1u
X447 VSS VSS VSS rhigh l=27u w=0.5u
X448 VDD iqmod_spdt_switch_0.spdt_switch_inv_0.vin iqmod_spdt_switch_0.spdt_switch_inv_0.vout VDD sg13_lv_pmos ad=1.14p pd=6.38u as=1.14p ps=6.38u w=6u l=0.13u
X449 voutp_I_RF iqmod_mixer_0.iqmod_mixer_half_1.iqmod_mixer_tg$1_0.di_tg_ctrl_n voutp_I_RF VSS sg13_lv_nmos ad=0.57p pd=3.38u as=0 ps=0 w=3u l=0.13u
X450 VDD iqmod_mixer_0.vinp_IF iqmod_mfb_lpf_0.iqmod_mfb_lpf_half_0.iqmod_mfb_lpf_ota_core_hybrid_bm_half$1_0.iqmod_mfb_lpf_ota_core_inv_NF20$2_0.vout VDD sg13_lv_pmos ad=1.14p pd=6.38u as=1.14p ps=6.38u w=6u l=1u
X451 voutp_I_RF iqmod_mixer_0.iqmod_mixer_half_1.iqmod_mixer_tg$1_0.di_tg_ctrl iqmod_mixer_0.vinp_IF VSS sg13_lv_nmos ad=0.57p pd=3.38u as=0.57p ps=3.38u w=3u l=0.13u
X452 VSS iqmod_mixer_0.iqmod_mixer_half_0.iqmod_mixer_se2diff$1_0.iqmod_mixer_se2diff_half_inv$2_0.iqmod_mixer_se2diff_inv_NF6$7_0.vin iqmod_mixer_0.iqmod_mixer_half_0.iqmod_mixer_se2diff$1_0.iqmod_mixer_se2diff_half_inv$2_0.iqmod_mixer_se2diff_inv_NF6$7_0.vout VSS sg13_lv_nmos ad=0.19p pd=1.38u as=0.19p ps=1.38u w=1u l=0.13u
X453 iqmod_mixer_0.vinn_IF iqmod_mfb_lpf_0.iqmod_mfb_lpf_half_0.iqmod_mfb_lpf_ota_core_hybrid_bm_half$1_0.iqmod_mfb_lpf_ota_core_tg$2_0.v_b VDD VDD sg13_lv_pmos ad=1.14p pd=6.38u as=1.14p ps=6.38u w=6u l=1u
X454 VSS VSS VSS rhigh l=31u w=0.5u
X455 VDD VDD VDD VDD sg13_lv_pmos ad=0.57p pd=3.38u as=0 ps=0 w=3u l=0.13u
X456 VSS iqmod_mixer_0.iqmod_mixer_half_0.iqmod_mixer_se2diff$1_0.iqmod_mixer_se2diff_half_tg$2_0.iqmod_mixer_se2diff_inv_NF54$6_0.vin iqmod_mixer_0.iqmod_mixer_half_0.iqmod_mixer_tg$1_0.di_tg_ctrl_n VSS sg13_lv_nmos ad=0.19p pd=1.38u as=0.19p ps=1.38u w=1u l=0.13u
X457 iqmod_mfb_lpf_0.iqmod_mfb_lpf_half_0.iqmod_mfb_lpf_ota_core_hybrid_bm_half$1_0.iqmod_mfb_lpf_ota_core_inv_NF20$2_0.vout iqmod_mixer_0.vinp_IF VSS VSS sg13_lv_nmos ad=0.19p pd=1.38u as=0.19p ps=1.38u w=1u l=1u
X458 iqmod_mfb_lpf_0.iqmod_mfb_lpf_half_0.iqmod_mfb_lpf_ota_core_hybrid_bm_half$1_0.iqmod_mfb_lpf_ota_core_tg$2_0.v_b di_analog_en iqmod_mfb_lpf_0.iqmod_mfb_lpf_half_0.iqmod_mfb_lpf_ota_core_hybrid_bm_half$1_0.iqmod_mfb_lpf_ota_core_tg$2_0.v_a VSS sg13_lv_nmos ad=0.19p pd=1.38u as=0.19p ps=1.38u w=1u l=0.13u
X459 VSS iqmod_mfb_lpf_0.iqmod_mfb_lpf_half_0.iqmod_mfb_lpf_ota_core_hybrid_bm_half$1_0.iqmod_mfb_lpf_ota_core_inv_NF20$2_1.vin iqmod_mixer_0.vinn_IF VSS sg13_lv_nmos ad=0.19p pd=1.38u as=0.19p ps=1.38u w=1u l=1u
X460 iqmod_mixer_0.iqmod_mixer_half_0.iqmod_mixer_se2diff$1_0.iqmod_mixer_se2diff_half_inv$2_0.iqmod_mixer_se2diff_inv_NF6$7_0.vout iqmod_mixer_0.iqmod_mixer_half_0.iqmod_mixer_se2diff$1_0.iqmod_mixer_se2diff_half_inv$2_0.iqmod_mixer_se2diff_inv_NF6$7_0.vin VSS VSS sg13_lv_nmos ad=0.19p pd=1.38u as=0.19p ps=1.38u w=1u l=0.13u
X461 VSS VSS VSS VSS sg13_lv_nmos ad=0.34p pd=2.68u as=0 ps=0 w=1u l=0.13u
X462 VSS iqmod_mfb_lpf_0.iqmod_mfb_lpf_half_1.iqmod_mfb_lpf_ota_core_hybrid_bm_half$1_0.iqmod_mfb_lpf_ota_core_inv_NF20$2_1.vin iqmod_mfb_lpf_0.iqmod_mfb_lpf_half_0.iqmod_mfb_lpf_ota_core_hybrid_bm_half$1_0.iqmod_mfb_lpf_ota_core_tg$2_0.v_a VSS sg13_lv_nmos ad=0.19p pd=1.38u as=0.19p ps=1.38u w=1u l=1u
X463 iqmod_mixer_0.iqmod_mixer_half_0.iqmod_mixer_se2diff$1_0.iqmod_mixer_se2diff_half_tg$2_0.iqmod_mixer_se2diff_tg_NF6$3_0.v_b VSS iqmod_mixer_0.iqmod_mixer_half_0.iqmod_mixer_se2diff$1_0.iqmod_mixer_se2diff_half_inv$2_0.iqmod_mixer_se2diff_inv_NF6$7_0.vin VDD sg13_lv_pmos ad=0.57p pd=3.38u as=0.57p ps=3.38u w=3u l=0.13u
X464 iqmod_mixer_0.iqmod_mixer_half_0.iqmod_mixer_tg$1_0.di_tg_ctrl_n iqmod_mixer_0.iqmod_mixer_half_0.iqmod_mixer_se2diff$1_0.iqmod_mixer_se2diff_half_tg$2_0.iqmod_mixer_se2diff_inv_NF54$6_0.vin VSS VSS sg13_lv_nmos ad=0.19p pd=1.38u as=0.19p ps=1.38u w=1u l=0.13u
X465 VSS di_spdt_ctrl_I iqmod_spdt_switch_1.spdt_switch_inv_0.vin VSS sg13_lv_nmos ad=0.19p pd=1.38u as=0.19p ps=1.38u w=1u l=0.13u
X466 VSS iqmod_mixer_0.iqmod_mixer_half_1.iqmod_mixer_se2diff$1_0.iqmod_mixer_se2diff_half_inv$2_0.iqmod_mixer_se2diff_inv_NF54$7_0.vin iqmod_mixer_0.iqmod_mixer_half_1.iqmod_mixer_tg$1_0.di_tg_ctrl VSS sg13_lv_nmos ad=0.19p pd=1.38u as=0.19p ps=1.38u w=1u l=0.13u
X467 iqmod_mfb_lpf_0.iqmod_mfb_lpf_half_0.iqmod_mfb_lpf_ota_core_hybrid_bm_half$1_0.iqmod_mfb_lpf_ota_core_inv_NF20$2_0.vout iqmod_mixer_0.vinp_IF VDD VDD sg13_lv_pmos ad=1.14p pd=6.38u as=1.14p ps=6.38u w=6u l=1u
X468 iqmod_mixer_0.iqmod_mixer_half_1.iqmod_mixer_se2diff$1_0.iqmod_mixer_se2diff_half_inv$2_0.iqmod_mixer_se2diff_inv_NF6$7_1.vin iqmod_mixer_0.iqmod_mixer_half_1.iqmod_mixer_se2diff$1_0.iqmod_mixer_se2diff_half_inv$2_0.iqmod_mixer_se2diff_inv_NF6$7_0.vout VDD VDD sg13_lv_pmos ad=0.57p pd=3.38u as=0.57p ps=3.38u w=3u l=0.13u
X469 VDD iqmod_mfb_lpf_0.iqmod_mfb_lpf_half_0.iqmod_mfb_lpf_ota_core_hybrid_bm_half$1_0.iqmod_mfb_lpf_ota_core_tg$2_0.v_b iqmod_mixer_0.vinn_IF VDD sg13_lv_pmos ad=1.14p pd=6.38u as=1.14p ps=6.38u w=6u l=1u
X470 iqmod_mixer_0.iqmod_mixer_half_0.iqmod_mixer_se2diff$1_0.iqmod_mixer_se2diff_half_inv$2_0.iqmod_mixer_se2diff_inv_NF6$7_0.vin VSS iqmod_mixer_0.iqmod_mixer_half_0.iqmod_mixer_se2diff$1_0.iqmod_mixer_se2diff_half_tg$2_0.iqmod_mixer_se2diff_tg_NF6$3_0.v_b VDD sg13_lv_pmos ad=0.57p pd=3.38u as=0.57p ps=3.38u w=3u l=0.13u
X471 VDD iqmod_mixer_0.iqmod_mixer_half_0.iqmod_mixer_se2diff$1_0.iqmod_mixer_se2diff_half_inv$2_0.iqmod_mixer_se2diff_inv_NF54$7_0.vin iqmod_mixer_0.iqmod_mixer_half_0.iqmod_mixer_tg$1_0.di_tg_ctrl VDD sg13_lv_pmos ad=0.57p pd=3.38u as=0.57p ps=3.38u w=3u l=0.13u
X472 VSS iqmod_mfb_lpf_0.iqmod_mfb_lpf_half_0.iqmod_mfb_lpf_ota_core_hybrid_bm_half$1_0.iqmod_mfb_lpf_ota_core_inv_NF20$2_0.vout iqmod_mfb_lpf_0.iqmod_mfb_lpf_half_0.iqmod_mfb_lpf_ota_core_hybrid_bm_half$1_0.iqmod_mfb_lpf_ota_core_inv_NF6$2_1.vout VSS sg13_lv_nmos ad=0.19p pd=1.38u as=0.19p ps=1.38u w=1u l=1u
X473 VSS iqmod_mixer_0.iqmod_mixer_half_0.iqmod_mixer_se2diff$1_0.iqmod_mixer_se2diff_half_inv$2_0.iqmod_mixer_se2diff_inv_NF54$7_0.vin iqmod_mixer_0.iqmod_mixer_half_0.iqmod_mixer_tg$1_0.di_tg_ctrl VSS sg13_lv_nmos ad=0.19p pd=1.38u as=0.19p ps=1.38u w=1u l=0.13u
X474 iqmod_mfb_lpf_0.iqmod_mfb_lpf_half_0.C1_half a_23971_1946# VSS rhigh l=31u w=0.5u
X475 iqmod_mixer_0.iqmod_mixer_half_1.iqmod_mixer_tg$1_0.di_tg_ctrl_n iqmod_mixer_0.iqmod_mixer_half_1.iqmod_mixer_se2diff$1_0.iqmod_mixer_se2diff_half_tg$2_0.iqmod_mixer_se2diff_inv_NF54$6_0.vin VSS VSS sg13_lv_nmos ad=0.19p pd=1.38u as=0.19p ps=1.38u w=1u l=0.13u
X476 iqmod_mixer_0.iqmod_mixer_half_0.iqmod_mixer_tg$1_0.di_tg_ctrl_n iqmod_mixer_0.iqmod_mixer_half_0.iqmod_mixer_se2diff$1_0.iqmod_mixer_se2diff_half_tg$2_0.iqmod_mixer_se2diff_inv_NF54$6_0.vin VDD VDD sg13_lv_pmos ad=0.57p pd=3.38u as=0.57p ps=3.38u w=3u l=0.13u
X477 VSS iqmod_mixer_0.iqmod_mixer_half_1.iqmod_mixer_se2diff$1_0.iqmod_mixer_se2diff_half_tg$2_0.iqmod_mixer_se2diff_inv_NF54$6_0.vin iqmod_mixer_0.iqmod_mixer_half_1.iqmod_mixer_tg$1_0.di_tg_ctrl_n VSS sg13_lv_nmos ad=0.19p pd=1.38u as=0.19p ps=1.38u w=1u l=0.13u
X478 iqmod_mixer_0.vinn_IF iqmod_mfb_lpf_0.iqmod_mfb_lpf_half_0.iqmod_mfb_lpf_ota_core_hybrid_bm_half$1_0.iqmod_mfb_lpf_ota_core_tg$2_0.v_b VDD VDD sg13_lv_pmos ad=1.14p pd=6.38u as=1.14p ps=6.38u w=6u l=1u
X479 iqmod_mixer_0.iqmod_mixer_half_1.iqmod_mixer_se2diff$1_0.iqmod_mixer_se2diff_half_tg$2_0.iqmod_mixer_se2diff_inv_NF54$6_0.vin iqmod_mixer_0.iqmod_mixer_half_1.iqmod_mixer_se2diff$1_0.iqmod_mixer_se2diff_half_tg$2_0.iqmod_mixer_se2diff_inv_NF18$6_0.vin VDD VDD sg13_lv_pmos ad=0.57p pd=3.38u as=0.57p ps=3.38u w=3u l=0.13u
X480 VSS VSS VSS VSS sg13_lv_nmos ad=0.34p pd=2.68u as=0 ps=0 w=1u l=1u
X481 VSS VSS VSS VSS sg13_lv_nmos ad=0.19p pd=1.38u as=0 ps=0 w=1u l=1u
X482 a_11701_10752# iqmod_mfb_lpf_0.iqmod_mfb_lpf_half_0.iqmod_mfb_lpf_R1$1_0.v_b VSS rhigh l=27u w=0.5u
X483 VDD iqmod_mixer_0.iqmod_mixer_half_1.iqmod_mixer_se2diff$1_0.iqmod_mixer_se2diff_half_tg$2_0.iqmod_mixer_se2diff_inv_NF18$6_0.vin iqmod_mixer_0.iqmod_mixer_half_1.iqmod_mixer_se2diff$1_0.iqmod_mixer_se2diff_half_tg$2_0.iqmod_mixer_se2diff_inv_NF54$6_0.vin VDD sg13_lv_pmos ad=0.57p pd=3.38u as=0.57p ps=3.38u w=3u l=0.13u
X484 iqmod_mixer_0.iqmod_mixer_half_0.iqmod_mixer_tg$1_0.di_tg_ctrl iqmod_mixer_0.iqmod_mixer_half_0.iqmod_mixer_se2diff$1_0.iqmod_mixer_se2diff_half_inv$2_0.iqmod_mixer_se2diff_inv_NF54$7_0.vin VSS VSS sg13_lv_nmos ad=0.19p pd=1.38u as=0.19p ps=1.38u w=1u l=0.13u
X485 iqmod_mixer_0.iqmod_mixer_half_0.iqmod_mixer_tg$1_0.di_tg_ctrl_n iqmod_mixer_0.iqmod_mixer_half_0.iqmod_mixer_se2diff$1_0.iqmod_mixer_se2diff_half_tg$2_0.iqmod_mixer_se2diff_inv_NF54$6_0.vin VSS VSS sg13_lv_nmos ad=0.19p pd=1.38u as=0.19p ps=1.38u w=1u l=0.13u
X486 VDD iqmod_mixer_0.iqmod_mixer_half_1.iqmod_mixer_se2diff$1_0.iqmod_mixer_se2diff_half_inv$2_0.iqmod_mixer_se2diff_inv_NF54$7_0.vin iqmod_mixer_0.iqmod_mixer_half_1.iqmod_mixer_tg$1_0.di_tg_ctrl VDD sg13_lv_pmos ad=0.57p pd=3.38u as=0.57p ps=3.38u w=3u l=0.13u
X487 VSS iqmod_mfb_lpf_0.iqmod_mfb_lpf_half_0.iqmod_mfb_lpf_ota_core_hybrid_bm_half$1_0.iqmod_mfb_lpf_ota_core_tg$2_0.v_a iqmod_mfb_lpf_0.iqmod_mfb_lpf_half_0.iqmod_mfb_lpf_ota_core_hybrid_bm_half$1_0.iqmod_mfb_lpf_ota_core_tg$2_0.v_b VSS sg13_lv_nmos ad=0.19p pd=1.38u as=0.19p ps=1.38u w=1u l=1u
X488 VSS iqmod_mixer_0.iqmod_mixer_half_1.iqmod_mixer_se2diff$1_0.iqmod_mixer_se2diff_half_tg$2_0.iqmod_mixer_se2diff_inv_NF54$6_0.vin iqmod_mixer_0.iqmod_mixer_half_1.iqmod_mixer_tg$1_0.di_tg_ctrl_n VSS sg13_lv_nmos ad=0.19p pd=1.38u as=0.19p ps=1.38u w=1u l=0.13u
X489 VDD VDD VDD VDD sg13_lv_pmos ad=0.57p pd=3.38u as=0 ps=0 w=3u l=0.13u
X490 iqmod_mixer_0.vinp_IF iqmod_mfb_lpf_0.iqmod_mfb_lpf_half_0.iqmod_mfb_lpf_ota_core_hybrid_bm_half$1_0.iqmod_mfb_lpf_ota_core_tg$2_0.v_b VSS VSS sg13_lv_nmos ad=0.19p pd=1.38u as=0.19p ps=1.38u w=1u l=1u
X491 VDD VDD VDD VDD sg13_lv_pmos ad=2.04p pd=12.68u as=0 ps=0 w=6u l=1u
X492 iqmod_mixer_0.iqmod_mixer_half_1.iqmod_mixer_se2diff$1_0.iqmod_mixer_se2diff_half_tg$2_0.iqmod_mixer_se2diff_inv_NF54$6_0.vin iqmod_mixer_0.iqmod_mixer_half_1.iqmod_mixer_se2diff$1_0.iqmod_mixer_se2diff_half_tg$2_0.iqmod_mixer_se2diff_inv_NF18$6_0.vin VDD VDD sg13_lv_pmos ad=0.57p pd=3.38u as=0.57p ps=3.38u w=3u l=0.13u
X493 iqmod_mfb_lpf_0.iqmod_mfb_lpf_half_0.iqmod_mfb_lpf_ota_core_hybrid_bm_half$1_0.iqmod_mfb_lpf_ota_core_inv_NF20$2_0.vout di_analog_en iqmod_mfb_lpf_0.iqmod_mfb_lpf_half_0.iqmod_mfb_lpf_ota_core_hybrid_bm_half$1_0.iqmod_mfb_lpf_ota_core_inv_NF6$2_1.vout VSS sg13_lv_nmos ad=0.34p pd=2.68u as=0.19p ps=1.38u w=1u l=0.13u
X494 VDD iqmod_mixer_0.iqmod_mixer_half_0.iqmod_mixer_se2diff$1_0.iqmod_mixer_se2diff_half_tg$2_0.iqmod_mixer_se2diff_inv_NF54$6_0.vin iqmod_mixer_0.iqmod_mixer_half_0.iqmod_mixer_tg$1_0.di_tg_ctrl_n VDD sg13_lv_pmos ad=0.57p pd=3.38u as=0.57p ps=3.38u w=3u l=0.13u
X495 iqmod_mixer_0.iqmod_mixer_half_1.iqmod_mixer_se2diff$1_0.iqmod_mixer_se2diff_half_inv$2_0.iqmod_mixer_se2diff_inv_NF54$7_0.vin iqmod_mixer_0.iqmod_mixer_half_1.iqmod_mixer_se2diff$1_0.iqmod_mixer_se2diff_half_inv$2_0.iqmod_mixer_se2diff_inv_NF18$7_0.vin VSS VSS sg13_lv_nmos ad=0.19p pd=1.38u as=0.19p ps=1.38u w=1u l=0.13u
X496 iqmod_mixer_0.vinn_IF iqmod_mixer_0.iqmod_mixer_half_0.iqmod_mixer_tg$1_0.di_tg_ctrl_n voutn_I_RF VDD sg13_lv_pmos ad=1.71p pd=9.38u as=1.71p ps=9.38u w=9u l=0.13u
X497 iqmod_mixer_0.iqmod_mixer_half_1.iqmod_mixer_tg$1_0.di_tg_ctrl_n iqmod_mixer_0.iqmod_mixer_half_1.iqmod_mixer_se2diff$1_0.iqmod_mixer_se2diff_half_tg$2_0.iqmod_mixer_se2diff_inv_NF54$6_0.vin VSS VSS sg13_lv_nmos ad=0.19p pd=1.38u as=0.19p ps=1.38u w=1u l=0.13u
X498 VSS iqmod_mixer_0.iqmod_mixer_half_0.iqmod_mixer_se2diff$1_0.iqmod_mixer_se2diff_half_inv$2_0.iqmod_mixer_se2diff_inv_NF54$7_0.vin iqmod_mixer_0.iqmod_mixer_half_0.iqmod_mixer_tg$1_0.di_tg_ctrl VSS sg13_lv_nmos ad=0.19p pd=1.38u as=0.19p ps=1.38u w=1u l=0.13u
X499 iqmod_spdt_switch_0.v_c iqmod_spdt_switch_0.spdt_switch_inv_0.vin di_ds_I_n VSS sg13_lv_nmos ad=0.19p pd=1.38u as=0.19p ps=1.38u w=1u l=0.13u
X500 VDD iqmod_mixer_0.iqmod_mixer_half_1.iqmod_mixer_se2diff$1_0.iqmod_mixer_se2diff_half_inv$2_0.iqmod_mixer_se2diff_inv_NF54$7_0.vin iqmod_mixer_0.iqmod_mixer_half_1.iqmod_mixer_tg$1_0.di_tg_ctrl VDD sg13_lv_pmos ad=0.57p pd=3.38u as=0.57p ps=3.38u w=3u l=0.13u
X501 iqmod_mixer_0.iqmod_mixer_half_0.iqmod_mixer_se2diff$1_0.iqmod_mixer_se2diff_half_inv$2_0.iqmod_mixer_se2diff_inv_NF54$7_0.vin iqmod_mixer_0.iqmod_mixer_half_0.iqmod_mixer_se2diff$1_0.iqmod_mixer_se2diff_half_inv$2_0.iqmod_mixer_se2diff_inv_NF18$7_0.vin VDD VDD sg13_lv_pmos ad=0.57p pd=3.38u as=0.57p ps=3.38u w=3u l=0.13u
X502 iqmod_mixer_0.iqmod_mixer_half_1.iqmod_mixer_se2diff$1_0.iqmod_mixer_se2diff_half_inv$2_0.iqmod_mixer_se2diff_inv_NF54$7_0.vin iqmod_mixer_0.iqmod_mixer_half_1.iqmod_mixer_se2diff$1_0.iqmod_mixer_se2diff_half_inv$2_0.iqmod_mixer_se2diff_inv_NF18$7_0.vin VDD VDD sg13_lv_pmos ad=0.57p pd=3.38u as=0.57p ps=3.38u w=3u l=0.13u
X503 iqmod_mixer_0.iqmod_mixer_half_1.iqmod_mixer_se2diff$1_0.iqmod_mixer_se2diff_half_inv$2_0.iqmod_mixer_se2diff_inv_NF54$7_0.vin iqmod_mixer_0.iqmod_mixer_half_1.iqmod_mixer_se2diff$1_0.iqmod_mixer_se2diff_half_inv$2_0.iqmod_mixer_se2diff_inv_NF18$7_0.vin VDD VDD sg13_lv_pmos ad=0.57p pd=3.38u as=0.57p ps=3.38u w=3u l=0.13u
X504 iqmod_mfb_lpf_0.iqmod_mfb_lpf_half_0.iqmod_mfb_lpf_ota_core_hybrid_bm_half$1_0.iqmod_mfb_lpf_ota_core_inv_NF6$2_1.vout di_analog_en iqmod_mfb_lpf_0.iqmod_mfb_lpf_half_0.iqmod_mfb_lpf_ota_core_hybrid_bm_half$1_0.iqmod_mfb_lpf_ota_core_inv_NF20$2_0.vout VSS sg13_lv_nmos ad=0.19p pd=1.38u as=0.19p ps=1.38u w=1u l=0.13u
X505 voutp_I_RF iqmod_mixer_0.iqmod_mixer_half_1.iqmod_mixer_tg$1_0.di_tg_ctrl_n iqmod_mixer_0.vinp_IF VDD sg13_lv_pmos ad=1.71p pd=9.38u as=1.71p ps=9.38u w=9u l=0.13u
X506 iqmod_mixer_0.iqmod_mixer_half_0.iqmod_mixer_tg$1_0.di_tg_ctrl_n iqmod_mixer_0.iqmod_mixer_half_0.iqmod_mixer_se2diff$1_0.iqmod_mixer_se2diff_half_tg$2_0.iqmod_mixer_se2diff_inv_NF54$6_0.vin VDD VDD sg13_lv_pmos ad=0.57p pd=3.38u as=0.57p ps=3.38u w=3u l=0.13u
X507 VSS iqmod_mixer_0.iqmod_mixer_half_1.iqmod_mixer_se2diff$1_0.iqmod_mixer_se2diff_half_inv$2_0.iqmod_mixer_se2diff_inv_NF18$7_0.vin iqmod_mixer_0.iqmod_mixer_half_1.iqmod_mixer_se2diff$1_0.iqmod_mixer_se2diff_half_inv$2_0.iqmod_mixer_se2diff_inv_NF54$7_0.vin VSS sg13_lv_nmos ad=0.19p pd=1.38u as=0.19p ps=1.38u w=1u l=0.13u
X508 VDD iqmod_mixer_0.iqmod_mixer_half_1.iqmod_mixer_se2diff$1_0.iqmod_mixer_se2diff_half_inv$2_0.iqmod_mixer_se2diff_inv_NF6$7_1.vin iqmod_mixer_0.iqmod_mixer_half_1.iqmod_mixer_se2diff$1_0.iqmod_mixer_se2diff_half_inv$2_0.iqmod_mixer_se2diff_inv_NF18$7_0.vin VDD sg13_lv_pmos ad=0.57p pd=3.38u as=0.57p ps=3.38u w=3u l=0.13u
X509 voutn_I_RF iqmod_mixer_0.iqmod_mixer_half_0.iqmod_mixer_tg$1_0.di_tg_ctrl_n iqmod_mixer_0.vinn_IF VDD sg13_lv_pmos ad=1.71p pd=9.38u as=1.71p ps=9.38u w=9u l=0.13u
X510 VSS iqmod_mixer_0.iqmod_mixer_half_1.iqmod_mixer_se2diff$1_0.iqmod_mixer_se2diff_half_tg$2_0.iqmod_mixer_se2diff_inv_NF54$6_0.vin iqmod_mixer_0.iqmod_mixer_half_1.iqmod_mixer_tg$1_0.di_tg_ctrl_n VSS sg13_lv_nmos ad=0.19p pd=1.38u as=0.19p ps=1.38u w=1u l=0.13u
X511 iqmod_mixer_0.iqmod_mixer_half_0.iqmod_mixer_tg$1_0.di_tg_ctrl iqmod_mixer_0.iqmod_mixer_half_0.iqmod_mixer_se2diff$1_0.iqmod_mixer_se2diff_half_inv$2_0.iqmod_mixer_se2diff_inv_NF54$7_0.vin VSS VSS sg13_lv_nmos ad=0.19p pd=1.38u as=0.19p ps=1.38u w=1u l=0.13u
X512 iqmod_mixer_0.iqmod_mixer_half_1.iqmod_mixer_se2diff$1_0.iqmod_mixer_se2diff_half_inv$2_0.iqmod_mixer_se2diff_inv_NF2$7_1.vout iqmod_mixer_0.iqmod_mixer_half_1.iqmod_mixer_se2diff$1_0.iqmod_mixer_se2diff_half_inv$2_0.iqmod_mixer_se2diff_inv_NF6$7_1.vin VDD VDD sg13_lv_pmos ad=0.57p pd=3.38u as=0.57p ps=3.38u w=3u l=0.13u
X513 iqmod_mixer_0.vinn_IF iqmod_mixer_0.iqmod_mixer_half_0.iqmod_mixer_tg$1_0.di_tg_ctrl voutn_I_RF VSS sg13_lv_nmos ad=0.57p pd=3.38u as=0.57p ps=3.38u w=3u l=0.13u
X514 iqmod_mixer_0.vinn_IF iqmod_mfb_lpf_0.iqmod_mfb_lpf_half_0.iqmod_mfb_lpf_ota_core_hybrid_bm_half$1_0.iqmod_mfb_lpf_ota_core_tg$2_0.v_b VDD VDD sg13_lv_pmos ad=1.14p pd=6.38u as=1.14p ps=6.38u w=6u l=1u
X515 VDD iqmod_mixer_0.vinn_IF iqmod_mfb_lpf_0.iqmod_mfb_lpf_half_0.iqmod_mfb_lpf_ota_core_hybrid_bm_half$1_0.iqmod_mfb_lpf_ota_core_inv_NF20$2_0.vout VDD sg13_lv_pmos ad=1.14p pd=6.38u as=1.14p ps=6.38u w=6u l=1u
X516 iqmod_mixer_0.vinn_IF iqmod_mfb_lpf_0.iqmod_mfb_lpf_half_0.iqmod_mfb_lpf_ota_core_hybrid_bm_half$1_0.iqmod_mfb_lpf_ota_core_inv_NF20$2_1.vin VDD VDD sg13_lv_pmos ad=1.14p pd=6.38u as=1.14p ps=6.38u w=6u l=1u
X517 iqmod_mfb_lpf_0.iqmod_mfb_lpf_half_0.iqmod_mfb_lpf_ota_core_hybrid_bm_half$1_0.iqmod_mfb_lpf_ota_core_tg$2_0.v_b iqmod_mfb_lpf_0.iqmod_mfb_lpf_half_0.iqmod_mfb_lpf_ota_core_hybrid_bm_half$1_0.iqmod_mfb_lpf_ota_core_inv_NF6$2_1.vout VDD VDD sg13_lv_pmos ad=1.14p pd=6.38u as=1.14p ps=6.38u w=6u l=1u
X518 VDD iqmod_mixer_0.iqmod_mixer_half_1.iqmod_mixer_se2diff$1_0.iqmod_mixer_se2diff_half_tg$2_0.iqmod_mixer_se2diff_inv_NF54$6_0.vin iqmod_mixer_0.iqmod_mixer_half_1.iqmod_mixer_tg$1_0.di_tg_ctrl_n VDD sg13_lv_pmos ad=0.57p pd=3.38u as=0.57p ps=3.38u w=3u l=0.13u
X519 VDD VDD VDD VDD sg13_lv_pmos ad=2.04p pd=12.68u as=0 ps=0 w=6u l=1u
X520 VDD iqmod_mixer_0.iqmod_mixer_half_0.iqmod_mixer_se2diff$1_0.iqmod_mixer_se2diff_half_inv$2_0.iqmod_mixer_se2diff_inv_NF18$7_0.vin iqmod_mixer_0.iqmod_mixer_half_0.iqmod_mixer_se2diff$1_0.iqmod_mixer_se2diff_half_inv$2_0.iqmod_mixer_se2diff_inv_NF54$7_0.vin VDD sg13_lv_pmos ad=0.57p pd=3.38u as=0.57p ps=3.38u w=3u l=0.13u
X521 iqmod_mixer_0.vinp_IF iqmod_mixer_0.iqmod_mixer_half_1.iqmod_mixer_tg$1_0.di_tg_ctrl_n voutp_I_RF VDD sg13_lv_pmos ad=1.71p pd=9.38u as=1.71p ps=9.38u w=9u l=0.13u
X522 VDD VDD VDD VDD sg13_lv_pmos ad=0.57p pd=3.38u as=0 ps=0 w=3u l=0.13u
X523 iqmod_mixer_0.iqmod_mixer_half_1.iqmod_mixer_se2diff$1_0.iqmod_mixer_se2diff_half_inv$2_0.iqmod_mixer_se2diff_inv_NF54$7_0.vin iqmod_mixer_0.iqmod_mixer_half_1.iqmod_mixer_se2diff$1_0.iqmod_mixer_se2diff_half_inv$2_0.iqmod_mixer_se2diff_inv_NF18$7_0.vin VSS VSS sg13_lv_nmos ad=0.19p pd=1.38u as=0.19p ps=1.38u w=1u l=0.13u
X524 voutn_I_RF iqmod_mixer_0.iqmod_mixer_half_0.iqmod_mixer_tg$1_0.di_tg_ctrl iqmod_mixer_0.vinn_IF VSS sg13_lv_nmos ad=0.57p pd=3.38u as=0.57p ps=3.38u w=3u l=0.13u
X525 voutp_I_RF iqmod_mixer_0.iqmod_mixer_half_1.iqmod_mixer_tg$1_0.di_tg_ctrl_n voutp_I_RF VSS sg13_lv_nmos ad=0.57p pd=3.38u as=0 ps=0 w=3u l=0.13u
X526 VDD iqmod_mixer_0.iqmod_mixer_half_0.iqmod_mixer_se2diff$1_0.iqmod_mixer_se2diff_half_tg$2_0.iqmod_mixer_se2diff_inv_NF54$6_0.vin iqmod_mixer_0.iqmod_mixer_half_0.iqmod_mixer_tg$1_0.di_tg_ctrl_n VDD sg13_lv_pmos ad=0.57p pd=3.38u as=0.57p ps=3.38u w=3u l=0.13u
X527 iqmod_mixer_0.iqmod_mixer_half_1.iqmod_mixer_tg$1_0.di_tg_ctrl_n iqmod_mixer_0.iqmod_mixer_half_1.iqmod_mixer_se2diff$1_0.iqmod_mixer_se2diff_half_tg$2_0.iqmod_mixer_se2diff_inv_NF54$6_0.vin VDD VDD sg13_lv_pmos ad=0.57p pd=3.38u as=0.57p ps=3.38u w=3u l=0.13u
X528 VDD VDD VDD VDD sg13_lv_pmos ad=1.14p pd=6.38u as=0 ps=0 w=6u l=1u
X529 iqmod_mixer_0.iqmod_mixer_half_0.iqmod_mixer_se2diff$1_0.iqmod_mixer_se2diff_half_inv$2_0.iqmod_mixer_se2diff_inv_NF54$7_0.vin iqmod_mixer_0.iqmod_mixer_half_0.iqmod_mixer_se2diff$1_0.iqmod_mixer_se2diff_half_inv$2_0.iqmod_mixer_se2diff_inv_NF18$7_0.vin VDD VDD sg13_lv_pmos ad=0.57p pd=3.38u as=0.57p ps=3.38u w=3u l=0.13u
X530 VDD VDD VDD VDD sg13_lv_pmos ad=1.02p pd=6.68u as=0 ps=0 w=3u l=0.13u
X531 iqmod_mixer_0.vinp_IF iqmod_mixer_0.iqmod_mixer_half_1.iqmod_mixer_tg$1_0.di_tg_ctrl voutp_I_RF VSS sg13_lv_nmos ad=0.57p pd=3.38u as=0.57p ps=3.38u w=3u l=0.13u
X532 iqmod_mfb_lpf_0.iqmod_mfb_lpf_half_0.iqmod_mfb_lpf_ota_core_hybrid_bm_half$1_0.iqmod_mfb_lpf_ota_core_tg$2_0.v_a di_analog_en iqmod_mfb_lpf_0.iqmod_mfb_lpf_half_0.iqmod_mfb_lpf_ota_core_hybrid_bm_half$1_0.iqmod_mfb_lpf_ota_core_tg$2_0.v_b VSS sg13_lv_nmos ad=0.19p pd=1.38u as=0.19p ps=1.38u w=1u l=0.13u
X533 voutp_I_RF iqmod_mixer_0.iqmod_mixer_half_1.iqmod_mixer_tg$1_0.di_tg_ctrl_n iqmod_mixer_0.vinp_IF VDD sg13_lv_pmos ad=1.71p pd=9.38u as=1.71p ps=9.38u w=9u l=0.13u
X534 voutp_I_RF iqmod_mixer_0.iqmod_mixer_half_1.iqmod_mixer_tg$1_0.di_tg_ctrl_n voutp_I_RF VSS sg13_lv_nmos ad=0.57p pd=3.38u as=0 ps=0 w=3u l=0.13u
X535 iqmod_mfb_lpf_0.iqmod_mfb_lpf_half_0.iqmod_mfb_lpf_ota_core_hybrid_bm_half$1_0.iqmod_mfb_lpf_ota_core_inv_NF20$2_0.vout iqmod_mixer_0.vinn_IF VDD VDD sg13_lv_pmos ad=1.14p pd=6.38u as=1.14p ps=6.38u w=6u l=1u
X536 VDD iqmod_mfb_lpf_0.iqmod_mfb_lpf_half_0.iqmod_mfb_lpf_ota_core_hybrid_bm_half$1_0.iqmod_mfb_lpf_ota_core_inv_NF6$2_1.vout iqmod_mfb_lpf_0.iqmod_mfb_lpf_half_0.iqmod_mfb_lpf_ota_core_hybrid_bm_half$1_0.iqmod_mfb_lpf_ota_core_tg$2_0.v_b VDD sg13_lv_pmos ad=1.14p pd=6.38u as=1.14p ps=6.38u w=6u l=1u
X537 iqmod_mixer_0.vinp_IF iqmod_mfb_lpf_0.iqmod_mfb_lpf_half_1.iqmod_mfb_lpf_ota_core_hybrid_bm_half$1_0.iqmod_mfb_lpf_ota_core_inv_NF20$2_1.vin VSS VSS sg13_lv_nmos ad=0.19p pd=1.38u as=0.19p ps=1.38u w=1u l=1u
X538 VDD iqmod_mfb_lpf_0.iqmod_mfb_lpf_half_0.iqmod_mfb_lpf_ota_core_hybrid_bm_half$1_0.iqmod_mfb_lpf_ota_core_inv_NF20$2_1.vin iqmod_mixer_0.vinn_IF VDD sg13_lv_pmos ad=1.14p pd=6.38u as=1.14p ps=6.38u w=6u l=1u
X539 VSS iqmod_mixer_0.vinn_IF iqmod_mfb_lpf_0.iqmod_mfb_lpf_half_0.iqmod_mfb_lpf_ota_core_hybrid_bm_half$1_0.iqmod_mfb_lpf_ota_core_inv_NF20$2_0.vout VSS sg13_lv_nmos ad=0.19p pd=1.38u as=0.19p ps=1.38u w=1u l=1u
X540 iqmod_mfb_lpf_0.iqmod_mfb_lpf_half_0.iqmod_mfb_lpf_ota_core_hybrid_bm_half$1_0.iqmod_mfb_lpf_ota_core_tg$2_0.v_a iqmod_mfb_lpf_0.iqmod_mfb_lpf_half_1.iqmod_mfb_lpf_ota_core_hybrid_bm_half$1_0.iqmod_mfb_lpf_ota_core_inv_NF20$2_1.vin VDD VDD sg13_lv_pmos ad=1.14p pd=6.38u as=1.14p ps=6.38u w=6u l=1u
X541 VSS iqmod_mixer_0.iqmod_mixer_half_0.iqmod_mixer_se2diff$1_0.iqmod_mixer_se2diff_half_inv$2_0.iqmod_mixer_se2diff_inv_NF54$7_0.vin iqmod_mixer_0.iqmod_mixer_half_0.iqmod_mixer_tg$1_0.di_tg_ctrl VSS sg13_lv_nmos ad=0.19p pd=1.38u as=0.19p ps=1.38u w=1u l=0.13u
X542 iqmod_mfb_lpf_0.iqmod_mfb_lpf_half_0.iqmod_mfb_lpf_ota_core_hybrid_bm_half$1_0.iqmod_mfb_lpf_ota_core_tg$2_0.v_b di_analog_en iqmod_mfb_lpf_0.iqmod_mfb_lpf_half_0.iqmod_mfb_lpf_ota_core_hybrid_bm_half$1_0.iqmod_mfb_lpf_ota_core_tg$2_0.v_a VSS sg13_lv_nmos ad=0.19p pd=1.38u as=0.34p ps=2.68u w=1u l=0.13u
X543 VSS iqmod_mixer_0.iqmod_mixer_half_1.iqmod_mixer_se2diff$1_0.iqmod_mixer_se2diff_half_inv$2_0.iqmod_mixer_se2diff_inv_NF54$7_0.vin iqmod_mixer_0.iqmod_mixer_half_1.iqmod_mixer_tg$1_0.di_tg_ctrl VSS sg13_lv_nmos ad=0.19p pd=1.38u as=0.19p ps=1.38u w=1u l=0.13u
X544 VSS iqmod_mfb_lpf_0.iqmod_mfb_lpf_half_0.iqmod_mfb_lpf_ota_core_hybrid_bm_half$1_0.iqmod_mfb_lpf_ota_core_inv_NF20$2_1.vin iqmod_mfb_lpf_0.iqmod_mfb_lpf_half_0.iqmod_mfb_lpf_ota_core_hybrid_bm_half$1_0.iqmod_mfb_lpf_ota_core_tg$2_0.v_a VSS sg13_lv_nmos ad=0.19p pd=1.38u as=0.19p ps=1.38u w=1u l=1u
X545 VSS VSS VSS VSS sg13_lv_nmos ad=0.19p pd=1.38u as=0 ps=0 w=1u l=0.13u
X546 iqmod_mfb_lpf_0.iqmod_mfb_lpf_half_0.iqmod_mfb_lpf_R1$1_0.v_b iqmod_mfb_lpf_0.iqmod_mfb_lpf_half_0.C1_half cap_cmim l=8u w=8u
X547 VDD iqmod_mixer_0.iqmod_mixer_half_0.iqmod_mixer_se2diff$1_0.iqmod_mixer_se2diff_half_inv$2_0.iqmod_mixer_se2diff_inv_NF54$7_0.vin iqmod_mixer_0.iqmod_mixer_half_0.iqmod_mixer_tg$1_0.di_tg_ctrl VDD sg13_lv_pmos ad=0.57p pd=3.38u as=0.57p ps=3.38u w=3u l=0.13u
X548 iqmod_mixer_0.iqmod_mixer_half_0.iqmod_mixer_se2diff$1_0.iqmod_mixer_se2diff_half_tg$2_0.iqmod_mixer_se2diff_inv_NF54$6_0.vin iqmod_mixer_0.iqmod_mixer_half_0.iqmod_mixer_se2diff$1_0.iqmod_mixer_se2diff_half_tg$2_0.iqmod_mixer_se2diff_inv_NF18$6_0.vin VSS VSS sg13_lv_nmos ad=0.19p pd=1.38u as=0.19p ps=1.38u w=1u l=0.13u
X549 iqmod_mfb_lpf_0.iqmod_mfb_lpf_half_0.iqmod_mfb_lpf_ota_core_hybrid_bm_half$1_0.iqmod_mfb_lpf_ota_core_tg$2_0.v_b iqmod_mfb_lpf_0.iqmod_mfb_lpf_half_0.iqmod_mfb_lpf_ota_core_hybrid_bm_half$1_0.iqmod_mfb_lpf_ota_core_tg$2_0.v_a VSS VSS sg13_lv_nmos ad=0.19p pd=1.38u as=0.19p ps=1.38u w=1u l=1u
X550 iqmod_mixer_0.iqmod_mixer_half_0.iqmod_mixer_tg$1_0.di_tg_ctrl_n iqmod_mixer_0.iqmod_mixer_half_0.iqmod_mixer_se2diff$1_0.iqmod_mixer_se2diff_half_tg$2_0.iqmod_mixer_se2diff_inv_NF54$6_0.vin VDD VDD sg13_lv_pmos ad=0.57p pd=3.38u as=0.57p ps=3.38u w=3u l=0.13u
X551 VSS iqmod_mixer_0.iqmod_mixer_half_1.iqmod_mixer_se2diff$1_0.iqmod_mixer_se2diff_half_tg$2_0.iqmod_mixer_se2diff_inv_NF18$6_0.vin iqmod_mixer_0.iqmod_mixer_half_1.iqmod_mixer_se2diff$1_0.iqmod_mixer_se2diff_half_tg$2_0.iqmod_mixer_se2diff_inv_NF54$6_0.vin VSS sg13_lv_nmos ad=0.19p pd=1.38u as=0.19p ps=1.38u w=1u l=0.13u
X552 iqmod_mixer_0.iqmod_mixer_half_1.iqmod_mixer_tg$1_0.di_tg_ctrl iqmod_mixer_0.iqmod_mixer_half_1.iqmod_mixer_se2diff$1_0.iqmod_mixer_se2diff_half_inv$2_0.iqmod_mixer_se2diff_inv_NF54$7_0.vin VSS VSS sg13_lv_nmos ad=0.19p pd=1.38u as=0.19p ps=1.38u w=1u l=0.13u
X553 iqmod_mixer_0.vinp_IF iqmod_mixer_0.iqmod_mixer_half_1.iqmod_mixer_tg$1_0.di_tg_ctrl voutp_I_RF VSS sg13_lv_nmos ad=0.57p pd=3.38u as=0.57p ps=3.38u w=3u l=0.13u
X554 VDD VDD VDD VDD sg13_lv_pmos ad=0.57p pd=3.38u as=0 ps=0 w=3u l=0.13u
X555 VSS iqmod_mfb_lpf_0.iqmod_mfb_lpf_half_1.iqmod_mfb_lpf_ota_core_hybrid_bm_half$1_0.iqmod_mfb_lpf_ota_core_inv_NF20$2_1.vin iqmod_mixer_0.vinp_IF VSS sg13_lv_nmos ad=0.19p pd=1.38u as=0.19p ps=1.38u w=1u l=1u
X556 VDD iqmod_mixer_0.vinn_IF iqmod_mfb_lpf_0.iqmod_mfb_lpf_half_0.iqmod_mfb_lpf_ota_core_hybrid_bm_half$1_0.iqmod_mfb_lpf_ota_core_inv_NF20$2_0.vout VDD sg13_lv_pmos ad=1.14p pd=6.38u as=1.14p ps=6.38u w=6u l=1u
X557 iqmod_mixer_0.vinn_IF iqmod_mfb_lpf_0.iqmod_mfb_lpf_half_0.iqmod_mfb_lpf_ota_core_hybrid_bm_half$1_0.iqmod_mfb_lpf_ota_core_inv_NF20$2_1.vin VDD VDD sg13_lv_pmos ad=1.14p pd=6.38u as=1.14p ps=6.38u w=6u l=1u
X558 iqmod_spdt_switch_0.v_c iqmod_mfb_lpf_0.iqmod_mfb_lpf_half_1.iqmod_mfb_lpf_ota_core_hybrid_bm_half$1_0.iqmod_mfb_lpf_ota_core_tg$2_0.di_tg_ctrl_n iqmod_mfb_lpf_0.iqmod_mfb_lpf_half_1.iqmod_mfb_lpf_ota_core_hybrid_bm_half$1_0.iqmod_mfb_lpf_ota_core_inv_NF20$2_1.vin VDD sg13_lv_pmos ad=2.04p pd=12.68u as=1.14p ps=6.38u w=6u l=0.13u
X559 iqmod_mfb_lpf_0.iqmod_mfb_lpf_half_0.iqmod_mfb_lpf_ota_core_hybrid_bm_half$1_0.iqmod_mfb_lpf_ota_core_inv_NF20$2_0.vout iqmod_mixer_0.vinn_IF VSS VSS sg13_lv_nmos ad=0.19p pd=1.38u as=0.19p ps=1.38u w=1u l=1u
X560 di_ds_I_p iqmod_spdt_switch_1.spdt_switch_inv_0.vin iqmod_spdt_switch_1.v_c VSS sg13_lv_nmos ad=0.34p pd=2.68u as=0.19p ps=1.38u w=1u l=0.13u
X561 iqmod_mixer_0.iqmod_mixer_half_0.iqmod_mixer_tg$1_0.di_tg_ctrl iqmod_mixer_0.iqmod_mixer_half_0.iqmod_mixer_se2diff$1_0.iqmod_mixer_se2diff_half_inv$2_0.iqmod_mixer_se2diff_inv_NF54$7_0.vin VDD VDD sg13_lv_pmos ad=0.57p pd=3.38u as=0.57p ps=3.38u w=3u l=0.13u
X562 VSS iqmod_mixer_0.iqmod_mixer_half_0.iqmod_mixer_se2diff$1_0.iqmod_mixer_se2diff_half_tg$2_0.iqmod_mixer_se2diff_inv_NF18$6_0.vin iqmod_mixer_0.iqmod_mixer_half_0.iqmod_mixer_se2diff$1_0.iqmod_mixer_se2diff_half_tg$2_0.iqmod_mixer_se2diff_inv_NF54$6_0.vin VSS sg13_lv_nmos ad=0.19p pd=1.38u as=0.19p ps=1.38u w=1u l=0.13u
X563 VDD VDD VDD VDD sg13_lv_pmos ad=0.57p pd=3.38u as=0 ps=0 w=3u l=0.13u
X564 iqmod_spdt_switch_0.v_c iqmod_spdt_switch_0.spdt_switch_inv_0.vout vinn_I VSS sg13_lv_nmos ad=0.19p pd=1.38u as=0.34p ps=2.68u w=1u l=0.13u
X565 iqmod_mixer_0.iqmod_mixer_half_1.iqmod_mixer_se2diff$1_0.iqmod_mixer_se2diff_half_tg$2_0.iqmod_mixer_se2diff_inv_NF54$6_0.vin iqmod_mixer_0.iqmod_mixer_half_1.iqmod_mixer_se2diff$1_0.iqmod_mixer_se2diff_half_tg$2_0.iqmod_mixer_se2diff_inv_NF18$6_0.vin VSS VSS sg13_lv_nmos ad=0.19p pd=1.38u as=0.19p ps=1.38u w=1u l=0.13u
X566 iqmod_spdt_switch_0.spdt_switch_inv_0.vout iqmod_spdt_switch_0.spdt_switch_inv_0.vin VSS VSS sg13_lv_nmos ad=0.19p pd=1.38u as=0.19p ps=1.38u w=1u l=0.13u
X567 iqmod_mixer_0.vinp_IF iqmod_mfb_lpf_0.iqmod_mfb_lpf_half_0.iqmod_mfb_lpf_ota_core_hybrid_bm_half$1_0.iqmod_mfb_lpf_ota_core_tg$2_0.v_b VDD VDD sg13_lv_pmos ad=1.14p pd=6.38u as=1.14p ps=6.38u w=6u l=1u
X568 iqmod_mixer_0.iqmod_mixer_half_1.iqmod_mixer_tg$1_0.di_tg_ctrl_n iqmod_mixer_0.iqmod_mixer_half_1.iqmod_mixer_se2diff$1_0.iqmod_mixer_se2diff_half_tg$2_0.iqmod_mixer_se2diff_inv_NF54$6_0.vin VDD VDD sg13_lv_pmos ad=0.57p pd=3.38u as=0.57p ps=3.38u w=3u l=0.13u
X569 VSS iqmod_mixer_0.vinp_IF iqmod_mfb_lpf_0.iqmod_mfb_lpf_half_0.iqmod_mfb_lpf_ota_core_hybrid_bm_half$1_0.iqmod_mfb_lpf_ota_core_inv_NF20$2_0.vout VSS sg13_lv_nmos ad=0.19p pd=1.38u as=0.19p ps=1.38u w=1u l=1u
X570 iqmod_mixer_0.vinp_IF iqmod_mfb_lpf_0.iqmod_mfb_lpf_half_1.iqmod_mfb_lpf_ota_core_hybrid_bm_half$1_0.iqmod_mfb_lpf_ota_core_inv_NF20$2_1.vin VSS VSS sg13_lv_nmos ad=0.19p pd=1.38u as=0.19p ps=1.38u w=1u l=1u
X571 voutp_I_RF iqmod_mixer_0.iqmod_mixer_half_1.iqmod_mixer_tg$1_0.di_tg_ctrl_n voutp_I_RF VSS sg13_lv_nmos ad=0.57p pd=3.38u as=0 ps=0 w=3u l=0.13u
X572 VSS iqmod_mixer_0.vinn_IF iqmod_mfb_lpf_0.iqmod_mfb_lpf_half_0.iqmod_mfb_lpf_ota_core_hybrid_bm_half$1_0.iqmod_mfb_lpf_ota_core_inv_NF20$2_0.vout VSS sg13_lv_nmos ad=0.19p pd=1.38u as=0.19p ps=1.38u w=1u l=1u
X573 iqmod_mixer_0.iqmod_mixer_half_0.iqmod_mixer_tg$1_0.di_tg_ctrl_n iqmod_mixer_0.iqmod_mixer_half_0.iqmod_mixer_se2diff$1_0.iqmod_mixer_se2diff_half_tg$2_0.iqmod_mixer_se2diff_inv_NF54$6_0.vin VSS VSS sg13_lv_nmos ad=0.19p pd=1.38u as=0.19p ps=1.38u w=1u l=0.13u
X574 VDD iqmod_mixer_0.iqmod_mixer_half_1.iqmod_mixer_se2diff$1_0.iqmod_mixer_se2diff_half_inv$2_0.iqmod_mixer_se2diff_inv_NF6$7_0.vout iqmod_mixer_0.iqmod_mixer_half_1.iqmod_mixer_se2diff$1_0.iqmod_mixer_se2diff_half_inv$2_0.iqmod_mixer_se2diff_inv_NF6$7_1.vin VDD sg13_lv_pmos ad=0.57p pd=3.38u as=0.57p ps=3.38u w=3u l=0.13u
X575 iqmod_mixer_0.iqmod_mixer_half_1.iqmod_mixer_tg$1_0.di_tg_ctrl iqmod_mixer_0.iqmod_mixer_half_1.iqmod_mixer_se2diff$1_0.iqmod_mixer_se2diff_half_inv$2_0.iqmod_mixer_se2diff_inv_NF54$7_0.vin VDD VDD sg13_lv_pmos ad=0.57p pd=3.38u as=0.57p ps=3.38u w=3u l=0.13u
X576 iqmod_mfb_lpf_0.iqmod_mfb_lpf_half_0.iqmod_mfb_lpf_R1$1_0.v_b iqmod_mfb_lpf_0.iqmod_mfb_lpf_half_0.C1_half cap_cmim l=8u w=8u
X577 VSS iqmod_mixer_0.iqmod_mixer_half_0.iqmod_mixer_se2diff$1_0.iqmod_mixer_se2diff_half_inv$2_0.iqmod_mixer_se2diff_inv_NF2$7_1.vout iqmod_mixer_0.iqmod_mixer_half_0.iqmod_mixer_se2diff$1_0.iqmod_mixer_se2diff_half_inv$2_0.iqmod_mixer_se2diff_inv_NF6$7_1.vin VSS sg13_lv_nmos ad=0.19p pd=1.38u as=0.19p ps=1.38u w=1u l=0.13u
X578 VDD iqmod_mfb_lpf_0.iqmod_mfb_lpf_half_0.iqmod_mfb_lpf_ota_core_hybrid_bm_half$1_0.iqmod_mfb_lpf_ota_core_tg$2_0.v_b iqmod_mixer_0.vinp_IF VDD sg13_lv_pmos ad=1.14p pd=6.38u as=1.14p ps=6.38u w=6u l=1u
X579 VSS iqmod_mfb_lpf_0.iqmod_mfb_lpf_half_0.iqmod_mfb_lpf_ota_core_hybrid_bm_half$1_0.iqmod_mfb_lpf_ota_core_tg$2_0.di_tg_ctrl_n iqmod_mfb_lpf_0.iqmod_mfb_lpf_half_0.iqmod_mfb_lpf_ota_core_hybrid_bm_half$1_0.iqmod_mfb_lpf_ota_core_spdt_switch$2_0.iqmod_mfb_lpf_ota_core_spdt_switch_inv$3_0.vout VSS sg13_lv_nmos ad=0.19p pd=1.38u as=0.19p ps=1.38u w=1u l=0.13u
X580 VSS VSS VSS VSS sg13_lv_nmos ad=0.19p pd=1.38u as=0 ps=0 w=1u l=0.13u
X581 iqmod_mixer_0.iqmod_mixer_half_1.iqmod_mixer_se2diff$1_0.iqmod_mixer_se2diff_half_inv$2_0.iqmod_mixer_se2diff_inv_NF6$7_0.vout iqmod_mixer_0.iqmod_mixer_half_1.iqmod_mixer_se2diff$1_0.iqmod_mixer_se2diff_half_inv$2_0.iqmod_mixer_se2diff_inv_NF6$7_0.vin VDD VDD sg13_lv_pmos ad=0.57p pd=3.38u as=0.57p ps=3.38u w=3u l=0.13u
X582 VSS VSS VSS VSS sg13_lv_nmos ad=0.19p pd=1.38u as=0 ps=0 w=1u l=0.13u
X583 VDD di_lo_I iqmod_mixer_0.iqmod_mixer_half_1.iqmod_mixer_se2diff$1_0.iqmod_mixer_se2diff_half_inv$2_0.iqmod_mixer_se2diff_inv_NF6$7_0.vin VDD sg13_lv_pmos ad=0.57p pd=3.38u as=0.57p ps=3.38u w=3u l=0.13u
X584 VSS iqmod_mixer_0.iqmod_mixer_half_0.iqmod_mixer_se2diff$1_0.iqmod_mixer_se2diff_half_tg$2_0.iqmod_mixer_se2diff_inv_NF54$6_0.vin iqmod_mixer_0.iqmod_mixer_half_0.iqmod_mixer_tg$1_0.di_tg_ctrl_n VSS sg13_lv_nmos ad=0.19p pd=1.38u as=0.19p ps=1.38u w=1u l=0.13u
X585 iqmod_mixer_0.iqmod_mixer_half_0.iqmod_mixer_se2diff$1_0.iqmod_mixer_se2diff_half_inv$2_0.iqmod_mixer_se2diff_inv_NF54$7_0.vin iqmod_mixer_0.iqmod_mixer_half_0.iqmod_mixer_se2diff$1_0.iqmod_mixer_se2diff_half_inv$2_0.iqmod_mixer_se2diff_inv_NF18$7_0.vin VSS VSS sg13_lv_nmos ad=0.19p pd=1.38u as=0.19p ps=1.38u w=1u l=0.13u
X586 VSS iqmod_mixer_0.iqmod_mixer_half_1.iqmod_mixer_se2diff$1_0.iqmod_mixer_se2diff_half_tg$2_0.iqmod_mixer_se2diff_tg_NF6$3_0.v_b iqmod_mixer_0.iqmod_mixer_half_1.iqmod_mixer_se2diff$1_0.iqmod_mixer_se2diff_half_inv$2_0.iqmod_mixer_se2diff_inv_NF2$7_1.vout VSS sg13_lv_nmos ad=0.19p pd=1.38u as=0.19p ps=1.38u w=1u l=0.13u
X587 VSS iqmod_mfb_lpf_0.iqmod_mfb_lpf_half_0.iqmod_mfb_lpf_ota_core_hybrid_bm_half$1_0.iqmod_mfb_lpf_ota_core_tg$2_0.v_b iqmod_mixer_0.vinn_IF VSS sg13_lv_nmos ad=0.19p pd=1.38u as=0.19p ps=1.38u w=1u l=1u
X588 iqmod_mixer_0.iqmod_mixer_half_1.iqmod_mixer_tg$1_0.di_tg_ctrl_n iqmod_mixer_0.iqmod_mixer_half_1.iqmod_mixer_se2diff$1_0.iqmod_mixer_se2diff_half_tg$2_0.iqmod_mixer_se2diff_inv_NF54$6_0.vin VSS VSS sg13_lv_nmos ad=0.19p pd=1.38u as=0.19p ps=1.38u w=1u l=0.13u
X589 VDD VDD VDD VDD sg13_lv_pmos ad=0.57p pd=3.38u as=0 ps=0 w=3u l=0.13u
X590 iqmod_mixer_0.iqmod_mixer_half_1.iqmod_mixer_tg$1_0.di_tg_ctrl iqmod_mixer_0.iqmod_mixer_half_1.iqmod_mixer_se2diff$1_0.iqmod_mixer_se2diff_half_inv$2_0.iqmod_mixer_se2diff_inv_NF54$7_0.vin VSS VSS sg13_lv_nmos ad=0.19p pd=1.38u as=0.19p ps=1.38u w=1u l=0.13u
X591 VSS iqmod_mfb_lpf_0.iqmod_mfb_lpf_half_1.iqmod_mfb_lpf_ota_core_hybrid_bm_half$1_0.iqmod_mfb_lpf_ota_core_inv_NF20$2_1.vin iqmod_mixer_0.vinp_IF VSS sg13_lv_nmos ad=0.19p pd=1.38u as=0.19p ps=1.38u w=1u l=1u
X592 iqmod_mfb_lpf_0.iqmod_mfb_lpf_half_0.iqmod_mfb_lpf_R3$1_0.v_a iqmod_mfb_lpf_0.iqmod_mfb_lpf_half_0.C2_half cap_cmim l=8u w=8u
X593 di_ds_I_p iqmod_spdt_switch_1.spdt_switch_inv_0.vin iqmod_spdt_switch_1.v_c VSS sg13_lv_nmos ad=0.19p pd=1.38u as=0.19p ps=1.38u w=1u l=0.13u
X594 VDD iqmod_mixer_0.iqmod_mixer_half_0.iqmod_mixer_se2diff$1_0.iqmod_mixer_se2diff_half_tg$2_0.iqmod_mixer_se2diff_tg_NF6$3_0.v_b iqmod_mixer_0.iqmod_mixer_half_0.iqmod_mixer_se2diff$1_0.iqmod_mixer_se2diff_half_inv$2_0.iqmod_mixer_se2diff_inv_NF2$7_1.vout VDD sg13_lv_pmos ad=0.57p pd=3.38u as=0.57p ps=3.38u w=3u l=0.13u
X595 VSS iqmod_mfb_lpf_0.iqmod_mfb_lpf_half_0.iqmod_mfb_lpf_ota_core_hybrid_bm_half$1_0.iqmod_mfb_lpf_ota_core_inv_NF20$2_0.vout iqmod_mfb_lpf_0.iqmod_mfb_lpf_half_0.iqmod_mfb_lpf_ota_core_hybrid_bm_half$1_0.iqmod_mfb_lpf_ota_core_inv_NF6$2_1.vout VSS sg13_lv_nmos ad=0.19p pd=1.38u as=0.19p ps=1.38u w=1u l=1u
X596 iqmod_mixer_0.iqmod_mixer_half_1.iqmod_mixer_se2diff$1_0.iqmod_mixer_se2diff_half_inv$2_0.iqmod_mixer_se2diff_inv_NF2$7_1.vout iqmod_mixer_0.iqmod_mixer_half_1.iqmod_mixer_se2diff$1_0.iqmod_mixer_se2diff_half_tg$2_0.iqmod_mixer_se2diff_tg_NF6$3_0.v_b VSS VSS sg13_lv_nmos ad=0.19p pd=1.38u as=0.19p ps=1.38u w=1u l=0.13u
X597 VSS VSS VSS VSS sg13_lv_nmos ad=0.34p pd=2.68u as=0 ps=0 w=1u l=0.13u
X598 iqmod_mixer_0.iqmod_mixer_half_0.iqmod_mixer_tg$1_0.di_tg_ctrl iqmod_mixer_0.iqmod_mixer_half_0.iqmod_mixer_se2diff$1_0.iqmod_mixer_se2diff_half_inv$2_0.iqmod_mixer_se2diff_inv_NF54$7_0.vin VDD VDD sg13_lv_pmos ad=0.57p pd=3.38u as=0.57p ps=3.38u w=3u l=0.13u
X599 VDD VDD VDD VDD sg13_lv_pmos ad=1.02p pd=6.68u as=0 ps=0 w=3u l=0.13u
X600 iqmod_mixer_0.iqmod_mixer_half_1.iqmod_mixer_tg$1_0.di_tg_ctrl iqmod_mixer_0.iqmod_mixer_half_1.iqmod_mixer_se2diff$1_0.iqmod_mixer_se2diff_half_inv$2_0.iqmod_mixer_se2diff_inv_NF54$7_0.vin VDD VDD sg13_lv_pmos ad=0.57p pd=3.38u as=0.57p ps=3.38u w=3u l=0.13u
X601 iqmod_mixer_0.iqmod_mixer_half_1.iqmod_mixer_se2diff$1_0.iqmod_mixer_se2diff_half_inv$2_0.iqmod_mixer_se2diff_inv_NF6$7_0.vout iqmod_mixer_0.iqmod_mixer_half_1.iqmod_mixer_se2diff$1_0.iqmod_mixer_se2diff_half_inv$2_0.iqmod_mixer_se2diff_inv_NF6$7_0.vin VDD VDD sg13_lv_pmos ad=0.57p pd=3.38u as=0.57p ps=3.38u w=3u l=0.13u
X602 VDD VDD VDD VDD sg13_lv_pmos ad=1.14p pd=6.38u as=0 ps=0 w=6u l=0.13u
X603 iqmod_mixer_0.vinp_IF iqmod_mfb_lpf_0.iqmod_mfb_lpf_half_0.iqmod_mfb_lpf_ota_core_hybrid_bm_half$1_0.iqmod_mfb_lpf_ota_core_tg$2_0.v_b VDD VDD sg13_lv_pmos ad=1.14p pd=6.38u as=1.14p ps=6.38u w=6u l=1u
X604 iqmod_mixer_0.iqmod_mixer_half_0.iqmod_mixer_se2diff$1_0.iqmod_mixer_se2diff_half_inv$2_0.iqmod_mixer_se2diff_inv_NF2$7_1.vout iqmod_mixer_0.iqmod_mixer_half_0.iqmod_mixer_se2diff$1_0.iqmod_mixer_se2diff_half_tg$2_0.iqmod_mixer_se2diff_tg_NF6$3_0.v_b VDD VDD sg13_lv_pmos ad=0.57p pd=3.38u as=0.57p ps=3.38u w=3u l=0.13u
X605 voutp_I_RF iqmod_mixer_0.iqmod_mixer_half_1.iqmod_mixer_tg$1_0.di_tg_ctrl voutp_I_RF VDD sg13_lv_pmos ad=1.71p pd=9.38u as=0 ps=0 w=9u l=0.13u
X606 iqmod_mfb_lpf_0.iqmod_mfb_lpf_half_0.iqmod_mfb_lpf_ota_core_hybrid_bm_half$1_0.iqmod_mfb_lpf_ota_core_inv_NF20$2_1.vin iqmod_mfb_lpf_0.iqmod_mfb_lpf_half_0.iqmod_mfb_lpf_ota_core_hybrid_bm_half$1_0.iqmod_mfb_lpf_ota_core_spdt_switch$2_0.iqmod_mfb_lpf_ota_core_spdt_switch_inv$3_0.vout VDD VDD sg13_lv_pmos ad=1.14p pd=6.38u as=1.14p ps=6.38u w=6u l=0.13u
X607 iqmod_mixer_0.iqmod_mixer_half_1.iqmod_mixer_tg$1_0.di_tg_ctrl iqmod_mixer_0.iqmod_mixer_half_1.iqmod_mixer_se2diff$1_0.iqmod_mixer_se2diff_half_inv$2_0.iqmod_mixer_se2diff_inv_NF54$7_0.vin VDD VDD sg13_lv_pmos ad=0.57p pd=3.38u as=0.57p ps=3.38u w=3u l=0.13u
X608 iqmod_mfb_lpf_0.iqmod_mfb_lpf_half_0.iqmod_mfb_lpf_R1$1_0.v_b iqmod_mfb_lpf_0.iqmod_mfb_lpf_half_0.C1_half cap_cmim l=8u w=8u
X609 VSS di_lo_Ix iqmod_mixer_0.iqmod_mixer_half_0.iqmod_mixer_se2diff$1_0.iqmod_mixer_se2diff_half_inv$2_0.iqmod_mixer_se2diff_inv_NF6$7_0.vin VSS sg13_lv_nmos ad=0.19p pd=1.38u as=0.19p ps=1.38u w=1u l=0.13u
X610 VDD VDD VDD VDD sg13_lv_pmos ad=0.57p pd=3.38u as=0 ps=0 w=3u l=0.13u
X611 VDD iqmod_mfb_lpf_0.iqmod_mfb_lpf_half_0.iqmod_mfb_lpf_ota_core_hybrid_bm_half$1_0.iqmod_mfb_lpf_ota_core_spdt_switch$2_0.iqmod_mfb_lpf_ota_core_spdt_switch_inv$3_0.vout iqmod_mfb_lpf_0.iqmod_mfb_lpf_half_0.iqmod_mfb_lpf_ota_core_hybrid_bm_half$1_0.iqmod_mfb_lpf_ota_core_inv_NF20$2_1.vin VDD sg13_lv_pmos ad=1.14p pd=6.38u as=1.14p ps=6.38u w=6u l=0.13u
X612 iqmod_mixer_0.vinn_IF iqmod_mfb_lpf_0.iqmod_mfb_lpf_half_0.iqmod_mfb_lpf_ota_core_hybrid_bm_half$1_0.iqmod_mfb_lpf_ota_core_tg$2_0.v_b VDD VDD sg13_lv_pmos ad=1.14p pd=6.38u as=1.14p ps=6.38u w=6u l=1u
X613 VSS iqmod_mixer_0.iqmod_mixer_half_0.iqmod_mixer_se2diff$1_0.iqmod_mixer_se2diff_half_inv$2_0.iqmod_mixer_se2diff_inv_NF54$7_0.vin iqmod_mixer_0.iqmod_mixer_half_0.iqmod_mixer_tg$1_0.di_tg_ctrl VSS sg13_lv_nmos ad=0.19p pd=1.38u as=0.19p ps=1.38u w=1u l=0.13u
X614 VSS iqmod_mfb_lpf_0.iqmod_mfb_lpf_half_0.iqmod_mfb_lpf_ota_core_hybrid_bm_half$1_0.iqmod_mfb_lpf_ota_core_tg$2_0.v_b iqmod_mixer_0.vinn_IF VSS sg13_lv_nmos ad=0.19p pd=1.38u as=0.19p ps=1.38u w=1u l=1u
X615 iqmod_mfb_lpf_0.iqmod_mfb_lpf_half_0.iqmod_mfb_lpf_R3$1_0.v_a iqmod_mfb_lpf_0.iqmod_mfb_lpf_half_0.C2_half cap_cmim l=8u w=8u
X616 VSS VSS VSS VSS sg13_lv_nmos ad=0.34p pd=2.68u as=0 ps=0 w=1u l=0.13u
X617 VDD iqmod_mixer_0.iqmod_mixer_half_1.iqmod_mixer_se2diff$1_0.iqmod_mixer_se2diff_half_tg$2_0.iqmod_mixer_se2diff_inv_NF18$6_0.vin iqmod_mixer_0.iqmod_mixer_half_1.iqmod_mixer_se2diff$1_0.iqmod_mixer_se2diff_half_tg$2_0.iqmod_mixer_se2diff_inv_NF54$6_0.vin VDD sg13_lv_pmos ad=0.57p pd=3.38u as=0.57p ps=3.38u w=3u l=0.13u
X618 iqmod_mixer_0.iqmod_mixer_half_1.iqmod_mixer_tg$1_0.di_tg_ctrl iqmod_mixer_0.iqmod_mixer_half_1.iqmod_mixer_se2diff$1_0.iqmod_mixer_se2diff_half_inv$2_0.iqmod_mixer_se2diff_inv_NF54$7_0.vin VDD VDD sg13_lv_pmos ad=0.57p pd=3.38u as=0.57p ps=3.38u w=3u l=0.13u
X619 iqmod_mixer_0.iqmod_mixer_half_0.iqmod_mixer_tg$1_0.di_tg_ctrl iqmod_mixer_0.iqmod_mixer_half_0.iqmod_mixer_se2diff$1_0.iqmod_mixer_se2diff_half_inv$2_0.iqmod_mixer_se2diff_inv_NF54$7_0.vin VSS VSS sg13_lv_nmos ad=0.19p pd=1.38u as=0.19p ps=1.38u w=1u l=0.13u
X620 iqmod_mixer_0.iqmod_mixer_half_0.iqmod_mixer_tg$1_0.di_tg_ctrl_n iqmod_mixer_0.iqmod_mixer_half_0.iqmod_mixer_se2diff$1_0.iqmod_mixer_se2diff_half_tg$2_0.iqmod_mixer_se2diff_inv_NF54$6_0.vin VDD VDD sg13_lv_pmos ad=0.57p pd=3.38u as=0.57p ps=3.38u w=3u l=0.13u
X621 VSS iqmod_mixer_0.iqmod_mixer_half_1.iqmod_mixer_se2diff$1_0.iqmod_mixer_se2diff_half_tg$2_0.iqmod_mixer_se2diff_inv_NF54$6_0.vin iqmod_mixer_0.iqmod_mixer_half_1.iqmod_mixer_tg$1_0.di_tg_ctrl_n VSS sg13_lv_nmos ad=0.19p pd=1.38u as=0.19p ps=1.38u w=1u l=0.13u
X622 voutn_I_RF iqmod_mixer_0.iqmod_mixer_half_0.iqmod_mixer_tg$1_0.di_tg_ctrl_n iqmod_mixer_0.vinn_IF VDD sg13_lv_pmos ad=1.71p pd=9.38u as=1.71p ps=9.38u w=9u l=0.13u
X623 VSS VSS VSS VSS sg13_lv_nmos ad=0.34p pd=2.68u as=0 ps=0 w=1u l=1u
X624 VSS VSS VSS rhigh l=27u w=0.5u
X625 VDD iqmod_mixer_0.vinp_IF iqmod_mfb_lpf_0.iqmod_mfb_lpf_half_0.iqmod_mfb_lpf_ota_core_hybrid_bm_half$1_0.iqmod_mfb_lpf_ota_core_inv_NF20$2_0.vout VDD sg13_lv_pmos ad=1.14p pd=6.38u as=1.14p ps=6.38u w=6u l=1u
X626 iqmod_mixer_0.vinp_IF iqmod_mfb_lpf_0.iqmod_mfb_lpf_half_0.iqmod_mfb_lpf_ota_core_hybrid_bm_half$1_0.iqmod_mfb_lpf_ota_core_tg$2_0.v_b VDD VDD sg13_lv_pmos ad=1.14p pd=6.38u as=1.14p ps=6.38u w=6u l=1u
X627 iqmod_mixer_0.vinp_IF iqmod_mfb_lpf_0.iqmod_mfb_lpf_half_1.iqmod_mfb_lpf_ota_core_hybrid_bm_half$1_0.iqmod_mfb_lpf_ota_core_inv_NF20$2_1.vin VDD VDD sg13_lv_pmos ad=1.14p pd=6.38u as=1.14p ps=6.38u w=6u l=1u
X628 VSS VSS VSS VSS sg13_lv_nmos ad=0.19p pd=1.38u as=0 ps=0 w=1u l=1u
X629 VDD iqmod_mfb_lpf_0.iqmod_mfb_lpf_half_0.iqmod_mfb_lpf_ota_core_hybrid_bm_half$1_0.iqmod_mfb_lpf_ota_core_tg$2_0.v_b iqmod_mixer_0.vinn_IF VDD sg13_lv_pmos ad=1.14p pd=6.38u as=1.14p ps=6.38u w=6u l=1u
X630 iqmod_mixer_0.vinn_IF iqmod_mfb_lpf_0.iqmod_mfb_lpf_half_0.iqmod_mfb_lpf_ota_core_hybrid_bm_half$1_0.iqmod_mfb_lpf_ota_core_tg$2_0.v_b VSS VSS sg13_lv_nmos ad=0.19p pd=1.38u as=0.19p ps=1.38u w=1u l=1u
X631 VSS VSS VSS VSS sg13_lv_nmos ad=0.34p pd=2.68u as=0 ps=0 w=1u l=0.13u
X632 VDD iqmod_mixer_0.iqmod_mixer_half_0.iqmod_mixer_se2diff$1_0.iqmod_mixer_se2diff_half_tg$2_0.iqmod_mixer_se2diff_inv_NF54$6_0.vin iqmod_mixer_0.iqmod_mixer_half_0.iqmod_mixer_tg$1_0.di_tg_ctrl_n VDD sg13_lv_pmos ad=0.57p pd=3.38u as=0.57p ps=3.38u w=3u l=0.13u
X633 VSS VSS VSS VSS sg13_lv_nmos ad=0.19p pd=1.38u as=0 ps=0 w=1u l=0.13u
X634 iqmod_mixer_0.vinn_IF iqmod_mixer_0.iqmod_mixer_half_0.iqmod_mixer_tg$1_0.di_tg_ctrl_n voutn_I_RF VDD sg13_lv_pmos ad=1.71p pd=9.38u as=1.71p ps=9.38u w=9u l=0.13u
X635 voutn_I_RF iqmod_mixer_0.iqmod_mixer_half_0.iqmod_mixer_tg$1_0.di_tg_ctrl iqmod_mixer_0.vinn_IF VSS sg13_lv_nmos ad=0.57p pd=3.38u as=0.57p ps=3.38u w=3u l=0.13u
X636 VDD VDD VDD VDD sg13_lv_pmos ad=1.14p pd=6.38u as=0 ps=0 w=6u l=1u
X637 VDD VDD VDD VDD sg13_lv_pmos ad=0.57p pd=3.38u as=0 ps=0 w=3u l=0.13u
X638 voutp_I_RF iqmod_mixer_0.iqmod_mixer_half_1.iqmod_mixer_tg$1_0.di_tg_ctrl voutp_I_RF VDD sg13_lv_pmos ad=1.71p pd=9.38u as=0 ps=0 w=9u l=0.13u
X639 voutp_I_RF iqmod_mixer_0.iqmod_mixer_half_1.iqmod_mixer_tg$1_0.di_tg_ctrl_n iqmod_mixer_0.vinp_IF VDD sg13_lv_pmos ad=1.71p pd=9.38u as=1.71p ps=9.38u w=9u l=0.13u
X640 VSS iqmod_mixer_0.iqmod_mixer_half_1.iqmod_mixer_se2diff$1_0.iqmod_mixer_se2diff_half_inv$2_0.iqmod_mixer_se2diff_inv_NF18$7_0.vin iqmod_mixer_0.iqmod_mixer_half_1.iqmod_mixer_se2diff$1_0.iqmod_mixer_se2diff_half_inv$2_0.iqmod_mixer_se2diff_inv_NF54$7_0.vin VSS sg13_lv_nmos ad=0.19p pd=1.38u as=0.19p ps=1.38u w=1u l=0.13u
X641 voutn_I_RF iqmod_mixer_0.iqmod_mixer_half_0.iqmod_mixer_tg$1_0.di_tg_ctrl_n voutn_I_RF VSS sg13_lv_nmos ad=0.57p pd=3.38u as=0 ps=0 w=3u l=0.13u
X642 voutn_I_RF iqmod_mixer_0.iqmod_mixer_half_0.iqmod_mixer_tg$1_0.di_tg_ctrl_n iqmod_mixer_0.vinn_IF VDD sg13_lv_pmos ad=1.71p pd=9.38u as=1.71p ps=9.38u w=9u l=0.13u
X643 iqmod_mfb_lpf_0.iqmod_mfb_lpf_half_0.iqmod_mfb_lpf_ota_core_hybrid_bm_half$1_0.iqmod_mfb_lpf_ota_core_inv_NF20$2_0.vout iqmod_mixer_0.vinp_IF VDD VDD sg13_lv_pmos ad=1.14p pd=6.38u as=1.14p ps=6.38u w=6u l=1u
X644 VDD iqmod_mixer_0.iqmod_mixer_half_1.iqmod_mixer_se2diff$1_0.iqmod_mixer_se2diff_half_tg$2_0.iqmod_mixer_se2diff_inv_NF54$6_0.vin iqmod_mixer_0.iqmod_mixer_half_1.iqmod_mixer_tg$1_0.di_tg_ctrl_n VDD sg13_lv_pmos ad=0.57p pd=3.38u as=0.57p ps=3.38u w=3u l=0.13u
X645 iqmod_mixer_0.vinn_IF iqmod_mixer_0.iqmod_mixer_half_0.iqmod_mixer_tg$1_0.di_tg_ctrl voutn_I_RF VSS sg13_lv_nmos ad=0.57p pd=3.38u as=0.57p ps=3.38u w=3u l=0.13u
X646 VDD iqmod_mfb_lpf_0.iqmod_mfb_lpf_half_1.iqmod_mfb_lpf_ota_core_hybrid_bm_half$1_0.iqmod_mfb_lpf_ota_core_inv_NF20$2_1.vin iqmod_mixer_0.vinp_IF VDD sg13_lv_pmos ad=1.14p pd=6.38u as=1.14p ps=6.38u w=6u l=1u
X647 iqmod_mixer_0.vinp_IF iqmod_spdt_switch_0.v_c cap_cmim l=8u w=8u
X648 VDD iqmod_mixer_0.iqmod_mixer_half_1.iqmod_mixer_se2diff$1_0.iqmod_mixer_se2diff_half_tg$2_0.iqmod_mixer_se2diff_inv_NF54$6_0.vin iqmod_mixer_0.iqmod_mixer_half_1.iqmod_mixer_tg$1_0.di_tg_ctrl_n VDD sg13_lv_pmos ad=0.57p pd=3.38u as=0.57p ps=3.38u w=3u l=0.13u
X649 iqmod_spdt_switch_1.spdt_switch_inv_0.vin di_spdt_ctrl_I VDD VDD sg13_lv_pmos ad=1.14p pd=6.38u as=1.14p ps=6.38u w=6u l=0.13u
X650 VDD iqmod_mixer_0.iqmod_mixer_half_0.iqmod_mixer_se2diff$1_0.iqmod_mixer_se2diff_half_inv$2_0.iqmod_mixer_se2diff_inv_NF18$7_0.vin iqmod_mixer_0.iqmod_mixer_half_0.iqmod_mixer_se2diff$1_0.iqmod_mixer_se2diff_half_inv$2_0.iqmod_mixer_se2diff_inv_NF54$7_0.vin VDD sg13_lv_pmos ad=0.57p pd=3.38u as=0.57p ps=3.38u w=3u l=0.13u
X651 voutp_I_RF iqmod_mixer_0.iqmod_mixer_half_1.iqmod_mixer_tg$1_0.di_tg_ctrl iqmod_mixer_0.vinp_IF VSS sg13_lv_nmos ad=0.57p pd=3.38u as=0.57p ps=3.38u w=3u l=0.13u
X652 iqmod_mixer_0.iqmod_mixer_half_1.iqmod_mixer_tg$1_0.di_tg_ctrl_n iqmod_mixer_0.iqmod_mixer_half_1.iqmod_mixer_se2diff$1_0.iqmod_mixer_se2diff_half_tg$2_0.iqmod_mixer_se2diff_inv_NF54$6_0.vin VDD VDD sg13_lv_pmos ad=0.57p pd=3.38u as=0.57p ps=3.38u w=3u l=0.13u
X653 voutn_I_RF iqmod_mixer_0.iqmod_mixer_half_0.iqmod_mixer_tg$1_0.di_tg_ctrl iqmod_mixer_0.vinn_IF VSS sg13_lv_nmos ad=0.57p pd=3.38u as=0.57p ps=3.38u w=3u l=0.13u
X654 iqmod_mixer_0.iqmod_mixer_half_0.iqmod_mixer_tg$1_0.di_tg_ctrl iqmod_mixer_0.iqmod_mixer_half_0.iqmod_mixer_se2diff$1_0.iqmod_mixer_se2diff_half_inv$2_0.iqmod_mixer_se2diff_inv_NF54$7_0.vin VSS VSS sg13_lv_nmos ad=0.19p pd=1.38u as=0.19p ps=1.38u w=1u l=0.13u
X655 iqmod_mixer_0.vinp_IF iqmod_mixer_0.iqmod_mixer_half_1.iqmod_mixer_tg$1_0.di_tg_ctrl voutp_I_RF VSS sg13_lv_nmos ad=0.57p pd=3.38u as=0.57p ps=3.38u w=3u l=0.13u
X656 VDD iqmod_mixer_0.vinp_IF iqmod_mfb_lpf_0.iqmod_mfb_lpf_half_0.iqmod_mfb_lpf_ota_core_hybrid_bm_half$1_0.iqmod_mfb_lpf_ota_core_inv_NF20$2_0.vout VDD sg13_lv_pmos ad=1.14p pd=6.38u as=1.14p ps=6.38u w=6u l=1u
X657 iqmod_mixer_0.vinp_IF iqmod_mfb_lpf_0.iqmod_mfb_lpf_half_1.iqmod_mfb_lpf_ota_core_hybrid_bm_half$1_0.iqmod_mfb_lpf_ota_core_inv_NF20$2_1.vin VDD VDD sg13_lv_pmos ad=1.14p pd=6.38u as=1.14p ps=6.38u w=6u l=1u
X658 iqmod_mfb_lpf_0.iqmod_mfb_lpf_half_0.iqmod_mfb_lpf_ota_core_hybrid_bm_half$1_0.iqmod_mfb_lpf_ota_core_inv_NF6$2_1.vout iqmod_mfb_lpf_0.iqmod_mfb_lpf_half_0.iqmod_mfb_lpf_ota_core_hybrid_bm_half$1_0.iqmod_mfb_lpf_ota_core_inv_NF20$2_0.vout VSS VSS sg13_lv_nmos ad=0.19p pd=1.38u as=0.19p ps=1.38u w=1u l=1u
X659 VDD VDD VDD VDD sg13_lv_pmos ad=2.04p pd=12.68u as=0 ps=0 w=6u l=1u
X660 iqmod_mfb_lpf_0.iqmod_mfb_lpf_half_1.iqmod_mfb_lpf_ota_core_hybrid_bm_half$1_0.iqmod_mfb_lpf_ota_core_inv_NF20$2_1.vin iqmod_mfb_lpf_0.iqmod_mfb_lpf_half_1.iqmod_mfb_lpf_ota_core_hybrid_bm_half$1_0.iqmod_mfb_lpf_ota_core_spdt_switch$2_0.iqmod_mfb_lpf_ota_core_spdt_switch_inv$3_0.vout iqmod_spdt_switch_0.v_c VSS sg13_lv_nmos ad=0.19p pd=1.38u as=0.19p ps=1.38u w=1u l=0.13u
X661 VSS iqmod_mixer_0.iqmod_mixer_half_1.iqmod_mixer_se2diff$1_0.iqmod_mixer_se2diff_half_inv$2_0.iqmod_mixer_se2diff_inv_NF54$7_0.vin iqmod_mixer_0.iqmod_mixer_half_1.iqmod_mixer_tg$1_0.di_tg_ctrl VSS sg13_lv_nmos ad=0.19p pd=1.38u as=0.19p ps=1.38u w=1u l=0.13u
X662 VSS iqmod_mixer_0.vinp_IF iqmod_mfb_lpf_0.iqmod_mfb_lpf_half_0.iqmod_mfb_lpf_ota_core_hybrid_bm_half$1_0.iqmod_mfb_lpf_ota_core_inv_NF20$2_0.vout VSS sg13_lv_nmos ad=0.19p pd=1.38u as=0.19p ps=1.38u w=1u l=1u
X663 VSS iqmod_mixer_0.iqmod_mixer_half_0.iqmod_mixer_se2diff$1_0.iqmod_mixer_se2diff_half_tg$2_0.iqmod_mixer_se2diff_inv_NF18$6_0.vin iqmod_mixer_0.iqmod_mixer_half_0.iqmod_mixer_se2diff$1_0.iqmod_mixer_se2diff_half_tg$2_0.iqmod_mixer_se2diff_inv_NF54$6_0.vin VSS sg13_lv_nmos ad=0.19p pd=1.38u as=0.19p ps=1.38u w=1u l=0.13u
X664 iqmod_mixer_0.iqmod_mixer_half_1.iqmod_mixer_se2diff$1_0.iqmod_mixer_se2diff_half_tg$2_0.iqmod_mixer_se2diff_inv_NF54$6_0.vin iqmod_mixer_0.iqmod_mixer_half_1.iqmod_mixer_se2diff$1_0.iqmod_mixer_se2diff_half_tg$2_0.iqmod_mixer_se2diff_inv_NF18$6_0.vin VSS VSS sg13_lv_nmos ad=0.19p pd=1.38u as=0.19p ps=1.38u w=1u l=0.13u
X665 iqmod_mfb_lpf_0.iqmod_mfb_lpf_half_0.iqmod_mfb_lpf_ota_core_hybrid_bm_half$1_0.iqmod_mfb_lpf_ota_core_inv_NF6$2_1.vout iqmod_mfb_lpf_0.iqmod_mfb_lpf_half_0.iqmod_mfb_lpf_ota_core_hybrid_bm_half$1_0.iqmod_mfb_lpf_ota_core_inv_NF20$2_0.vout VSS VSS sg13_lv_nmos ad=0.19p pd=1.38u as=0.19p ps=1.38u w=1u l=1u
X666 VSS iqmod_mixer_0.iqmod_mixer_half_1.iqmod_mixer_se2diff$1_0.iqmod_mixer_se2diff_half_inv$2_0.iqmod_mixer_se2diff_inv_NF54$7_0.vin iqmod_mixer_0.iqmod_mixer_half_1.iqmod_mixer_tg$1_0.di_tg_ctrl VSS sg13_lv_nmos ad=0.19p pd=1.38u as=0.19p ps=1.38u w=1u l=0.13u
X667 VSS iqmod_mfb_lpf_0.iqmod_mfb_lpf_half_0.iqmod_mfb_lpf_ota_core_hybrid_bm_half$1_0.iqmod_mfb_lpf_ota_core_inv_NF20$2_1.vin iqmod_mixer_0.vinn_IF VSS sg13_lv_nmos ad=0.19p pd=1.38u as=0.19p ps=1.38u w=1u l=1u
X668 VDD iqmod_mixer_0.iqmod_mixer_half_0.iqmod_mixer_se2diff$1_0.iqmod_mixer_se2diff_half_inv$2_0.iqmod_mixer_se2diff_inv_NF54$7_0.vin iqmod_mixer_0.iqmod_mixer_half_0.iqmod_mixer_tg$1_0.di_tg_ctrl VDD sg13_lv_pmos ad=0.57p pd=3.38u as=0.57p ps=3.38u w=3u l=0.13u
X669 VSS iqmod_mfb_lpf_0.iqmod_mfb_lpf_half_1.iqmod_mfb_lpf_ota_core_hybrid_bm_half$1_0.iqmod_mfb_lpf_ota_core_inv_NF20$2_1.vin iqmod_mfb_lpf_0.iqmod_mfb_lpf_half_0.iqmod_mfb_lpf_ota_core_hybrid_bm_half$1_0.iqmod_mfb_lpf_ota_core_tg$2_0.v_a VSS sg13_lv_nmos ad=0.19p pd=1.38u as=0.19p ps=1.38u w=1u l=1u
X670 iqmod_spdt_switch_0.v_c iqmod_mfb_lpf_0.iqmod_mfb_lpf_half_1.iqmod_mfb_lpf_ota_core_hybrid_bm_half$1_0.iqmod_mfb_lpf_ota_core_spdt_switch$2_0.iqmod_mfb_lpf_ota_core_spdt_switch_inv$3_0.vout iqmod_mfb_lpf_0.iqmod_mfb_lpf_half_1.iqmod_mfb_lpf_ota_core_hybrid_bm_half$1_0.iqmod_mfb_lpf_ota_core_inv_NF20$2_1.vin VSS sg13_lv_nmos ad=0.19p pd=1.38u as=0.19p ps=1.38u w=1u l=0.13u
X671 iqmod_mixer_0.iqmod_mixer_half_1.iqmod_mixer_tg$1_0.di_tg_ctrl iqmod_mixer_0.iqmod_mixer_half_1.iqmod_mixer_se2diff$1_0.iqmod_mixer_se2diff_half_inv$2_0.iqmod_mixer_se2diff_inv_NF54$7_0.vin VSS VSS sg13_lv_nmos ad=0.19p pd=1.38u as=0.19p ps=1.38u w=1u l=0.13u
X672 iqmod_mixer_0.iqmod_mixer_half_0.iqmod_mixer_se2diff$1_0.iqmod_mixer_se2diff_half_tg$2_0.iqmod_mixer_se2diff_inv_NF54$6_0.vin iqmod_mixer_0.iqmod_mixer_half_0.iqmod_mixer_se2diff$1_0.iqmod_mixer_se2diff_half_tg$2_0.iqmod_mixer_se2diff_inv_NF18$6_0.vin VSS VSS sg13_lv_nmos ad=0.19p pd=1.38u as=0.19p ps=1.38u w=1u l=0.13u
X673 VDD iqmod_mixer_0.iqmod_mixer_half_0.iqmod_mixer_se2diff$1_0.iqmod_mixer_se2diff_half_inv$2_0.iqmod_mixer_se2diff_inv_NF54$7_0.vin iqmod_mixer_0.iqmod_mixer_half_0.iqmod_mixer_tg$1_0.di_tg_ctrl VDD sg13_lv_pmos ad=0.57p pd=3.38u as=0.57p ps=3.38u w=3u l=0.13u
X674 VSS iqmod_mixer_0.iqmod_mixer_half_1.iqmod_mixer_se2diff$1_0.iqmod_mixer_se2diff_half_tg$2_0.iqmod_mixer_se2diff_inv_NF18$6_0.vin iqmod_mixer_0.iqmod_mixer_half_1.iqmod_mixer_se2diff$1_0.iqmod_mixer_se2diff_half_tg$2_0.iqmod_mixer_se2diff_inv_NF54$6_0.vin VSS sg13_lv_nmos ad=0.19p pd=1.38u as=0.19p ps=1.38u w=1u l=0.13u
X675 voutn_I_RF iqmod_mixer_0.iqmod_mixer_half_0.iqmod_mixer_tg$1_0.di_tg_ctrl_n voutn_I_RF VSS sg13_lv_nmos ad=0.57p pd=3.38u as=0 ps=0 w=3u l=0.13u
X676 iqmod_mixer_0.iqmod_mixer_half_0.iqmod_mixer_tg$1_0.di_tg_ctrl iqmod_mixer_0.iqmod_mixer_half_0.iqmod_mixer_se2diff$1_0.iqmod_mixer_se2diff_half_inv$2_0.iqmod_mixer_se2diff_inv_NF54$7_0.vin VDD VDD sg13_lv_pmos ad=0.57p pd=3.38u as=0.57p ps=3.38u w=3u l=0.13u
X677 iqmod_mixer_0.vinn_IF iqmod_mfb_lpf_0.iqmod_mfb_lpf_half_0.iqmod_mfb_lpf_ota_core_hybrid_bm_half$1_0.iqmod_mfb_lpf_ota_core_inv_NF20$2_1.vin VDD VDD sg13_lv_pmos ad=1.14p pd=6.38u as=1.14p ps=6.38u w=6u l=1u
X678 VDD iqmod_mixer_0.iqmod_mixer_half_0.iqmod_mixer_se2diff$1_0.iqmod_mixer_se2diff_half_tg$2_0.iqmod_mixer_se2diff_inv_NF18$6_0.vin iqmod_mixer_0.iqmod_mixer_half_0.iqmod_mixer_se2diff$1_0.iqmod_mixer_se2diff_half_tg$2_0.iqmod_mixer_se2diff_inv_NF54$6_0.vin VDD sg13_lv_pmos ad=0.57p pd=3.38u as=0.57p ps=3.38u w=3u l=0.13u
X679 iqmod_mixer_0.iqmod_mixer_half_1.iqmod_mixer_se2diff$1_0.iqmod_mixer_se2diff_half_tg$2_0.iqmod_mixer_se2diff_inv_NF54$6_0.vin iqmod_mixer_0.iqmod_mixer_half_1.iqmod_mixer_se2diff$1_0.iqmod_mixer_se2diff_half_tg$2_0.iqmod_mixer_se2diff_inv_NF18$6_0.vin VSS VSS sg13_lv_nmos ad=0.19p pd=1.38u as=0.19p ps=1.38u w=1u l=0.13u
X680 VDD iqmod_mixer_0.iqmod_mixer_half_1.iqmod_mixer_se2diff$1_0.iqmod_mixer_se2diff_half_inv$2_0.iqmod_mixer_se2diff_inv_NF2$7_1.vout iqmod_mixer_0.iqmod_mixer_half_1.iqmod_mixer_se2diff$1_0.iqmod_mixer_se2diff_half_tg$2_0.iqmod_mixer_se2diff_inv_NF18$6_0.vin VDD sg13_lv_pmos ad=0.57p pd=3.38u as=0.57p ps=3.38u w=3u l=0.13u
X681 iqmod_mixer_0.iqmod_mixer_half_1.iqmod_mixer_tg$1_0.di_tg_ctrl_n iqmod_mixer_0.iqmod_mixer_half_1.iqmod_mixer_se2diff$1_0.iqmod_mixer_se2diff_half_tg$2_0.iqmod_mixer_se2diff_inv_NF54$6_0.vin VDD VDD sg13_lv_pmos ad=0.57p pd=3.38u as=0.57p ps=3.38u w=3u l=0.13u
X682 iqmod_mfb_lpf_0.iqmod_mfb_lpf_half_0.iqmod_mfb_lpf_ota_core_hybrid_bm_half$1_0.iqmod_mfb_lpf_ota_core_inv_NF6$2_1.vout iqmod_mfb_lpf_0.iqmod_mfb_lpf_half_0.iqmod_mfb_lpf_ota_core_hybrid_bm_half$1_0.iqmod_mfb_lpf_ota_core_tg$2_0.di_tg_ctrl_n iqmod_mfb_lpf_0.iqmod_mfb_lpf_half_0.iqmod_mfb_lpf_ota_core_hybrid_bm_half$1_0.iqmod_mfb_lpf_ota_core_inv_NF20$2_0.vout VDD sg13_lv_pmos ad=1.14p pd=6.38u as=1.14p ps=6.38u w=6u l=0.13u
X683 iqmod_mixer_0.vinp_IF iqmod_mixer_0.iqmod_mixer_half_1.iqmod_mixer_tg$1_0.di_tg_ctrl voutp_I_RF VSS sg13_lv_nmos ad=0.57p pd=3.38u as=0.57p ps=3.38u w=3u l=0.13u
X684 iqmod_spdt_switch_0.v_c iqmod_spdt_switch_0.spdt_switch_inv_0.vin di_ds_I_n VSS sg13_lv_nmos ad=0.19p pd=1.38u as=0.34p ps=2.68u w=1u l=0.13u
X685 vinn_I iqmod_spdt_switch_0.spdt_switch_inv_0.vout iqmod_spdt_switch_0.v_c VSS sg13_lv_nmos ad=0.19p pd=1.38u as=0.19p ps=1.38u w=1u l=0.13u
X686 iqmod_mixer_0.iqmod_mixer_half_1.iqmod_mixer_se2diff$1_0.iqmod_mixer_se2diff_half_tg$2_0.iqmod_mixer_se2diff_inv_NF18$6_0.vin iqmod_mixer_0.iqmod_mixer_half_1.iqmod_mixer_se2diff$1_0.iqmod_mixer_se2diff_half_inv$2_0.iqmod_mixer_se2diff_inv_NF2$7_1.vout VDD VDD sg13_lv_pmos ad=0.57p pd=3.38u as=0.57p ps=3.38u w=3u l=0.13u
X687 iqmod_mixer_0.iqmod_mixer_half_0.iqmod_mixer_tg$1_0.di_tg_ctrl_n iqmod_mixer_0.iqmod_mixer_half_0.iqmod_mixer_se2diff$1_0.iqmod_mixer_se2diff_half_tg$2_0.iqmod_mixer_se2diff_inv_NF54$6_0.vin VSS VSS sg13_lv_nmos ad=0.19p pd=1.38u as=0.19p ps=1.38u w=1u l=0.13u
X688 iqmod_mixer_0.iqmod_mixer_half_0.iqmod_mixer_tg$1_0.di_tg_ctrl_n iqmod_mixer_0.iqmod_mixer_half_0.iqmod_mixer_se2diff$1_0.iqmod_mixer_se2diff_half_tg$2_0.iqmod_mixer_se2diff_inv_NF54$6_0.vin VSS VSS sg13_lv_nmos ad=0.19p pd=1.38u as=0.19p ps=1.38u w=1u l=0.13u
X689 a_17685_2246# a_23971_1946# VSS rhigh l=31u w=0.5u
X690 VDD VDD VDD VDD sg13_lv_pmos ad=1.14p pd=6.38u as=0 ps=0 w=6u l=0.13u
X691 VSS iqmod_mixer_0.iqmod_mixer_half_1.iqmod_mixer_se2diff$1_0.iqmod_mixer_se2diff_half_tg$2_0.iqmod_mixer_se2diff_inv_NF54$6_0.vin iqmod_mixer_0.iqmod_mixer_half_1.iqmod_mixer_tg$1_0.di_tg_ctrl_n VSS sg13_lv_nmos ad=0.19p pd=1.38u as=0.19p ps=1.38u w=1u l=0.13u
X692 VSS iqmod_mixer_0.iqmod_mixer_half_0.iqmod_mixer_se2diff$1_0.iqmod_mixer_se2diff_half_tg$2_0.iqmod_mixer_se2diff_inv_NF54$6_0.vin iqmod_mixer_0.iqmod_mixer_half_0.iqmod_mixer_tg$1_0.di_tg_ctrl_n VSS sg13_lv_nmos ad=0.19p pd=1.38u as=0.19p ps=1.38u w=1u l=0.13u
X693 VSS VSS VSS VSS sg13_lv_nmos ad=0.19p pd=1.38u as=0 ps=0 w=1u l=0.13u
X694 VSS iqmod_mixer_0.iqmod_mixer_half_1.iqmod_mixer_se2diff$1_0.iqmod_mixer_se2diff_half_inv$2_0.iqmod_mixer_se2diff_inv_NF6$7_1.vin iqmod_mixer_0.iqmod_mixer_half_1.iqmod_mixer_se2diff$1_0.iqmod_mixer_se2diff_half_inv$2_0.iqmod_mixer_se2diff_inv_NF18$7_0.vin VSS sg13_lv_nmos ad=0.19p pd=1.38u as=0.19p ps=1.38u w=1u l=0.13u
X695 iqmod_mixer_0.iqmod_mixer_half_1.iqmod_mixer_tg$1_0.di_tg_ctrl iqmod_mixer_0.iqmod_mixer_half_1.iqmod_mixer_se2diff$1_0.iqmod_mixer_se2diff_half_inv$2_0.iqmod_mixer_se2diff_inv_NF54$7_0.vin VSS VSS sg13_lv_nmos ad=0.19p pd=1.38u as=0.19p ps=1.38u w=1u l=0.13u
X696 iqmod_mixer_0.iqmod_mixer_half_0.iqmod_mixer_se2diff$1_0.iqmod_mixer_se2diff_half_inv$2_0.iqmod_mixer_se2diff_inv_NF54$7_0.vin iqmod_mixer_0.iqmod_mixer_half_0.iqmod_mixer_se2diff$1_0.iqmod_mixer_se2diff_half_inv$2_0.iqmod_mixer_se2diff_inv_NF18$7_0.vin VSS VSS sg13_lv_nmos ad=0.19p pd=1.38u as=0.19p ps=1.38u w=1u l=0.13u
X697 VSS iqmod_mixer_0.iqmod_mixer_half_0.iqmod_mixer_se2diff$1_0.iqmod_mixer_se2diff_half_tg$2_0.iqmod_mixer_se2diff_inv_NF54$6_0.vin iqmod_mixer_0.iqmod_mixer_half_0.iqmod_mixer_tg$1_0.di_tg_ctrl_n VSS sg13_lv_nmos ad=0.19p pd=1.38u as=0.19p ps=1.38u w=1u l=0.13u
X698 voutn_I_RF iqmod_mixer_0.iqmod_mixer_half_0.iqmod_mixer_tg$1_0.di_tg_ctrl voutn_I_RF VDD sg13_lv_pmos ad=1.71p pd=9.38u as=0 ps=0 w=9u l=0.13u
X699 iqmod_mixer_0.iqmod_mixer_half_1.iqmod_mixer_tg$1_0.di_tg_ctrl_n iqmod_mixer_0.iqmod_mixer_half_1.iqmod_mixer_se2diff$1_0.iqmod_mixer_se2diff_half_tg$2_0.iqmod_mixer_se2diff_inv_NF54$6_0.vin VSS VSS sg13_lv_nmos ad=0.19p pd=1.38u as=0.19p ps=1.38u w=1u l=0.13u
X700 VDD iqmod_mixer_0.iqmod_mixer_half_0.iqmod_mixer_se2diff$1_0.iqmod_mixer_se2diff_half_inv$2_0.iqmod_mixer_se2diff_inv_NF6$7_1.vin iqmod_mixer_0.iqmod_mixer_half_0.iqmod_mixer_se2diff$1_0.iqmod_mixer_se2diff_half_inv$2_0.iqmod_mixer_se2diff_inv_NF18$7_0.vin VDD sg13_lv_pmos ad=0.57p pd=3.38u as=0.57p ps=3.38u w=3u l=0.13u
X701 VDD iqmod_mfb_lpf_0.iqmod_mfb_lpf_half_0.iqmod_mfb_lpf_ota_core_hybrid_bm_half$1_0.iqmod_mfb_lpf_ota_core_inv_NF20$2_1.vin iqmod_mixer_0.vinn_IF VDD sg13_lv_pmos ad=1.14p pd=6.38u as=1.14p ps=6.38u w=6u l=1u
X702 iqmod_mixer_0.iqmod_mixer_half_0.iqmod_mixer_tg$1_0.di_tg_ctrl iqmod_mixer_0.iqmod_mixer_half_0.iqmod_mixer_se2diff$1_0.iqmod_mixer_se2diff_half_inv$2_0.iqmod_mixer_se2diff_inv_NF54$7_0.vin VDD VDD sg13_lv_pmos ad=0.57p pd=3.38u as=0.57p ps=3.38u w=3u l=0.13u
X703 iqmod_mfb_lpf_0.iqmod_mfb_lpf_half_1.iqmod_mfb_lpf_ota_core_hybrid_bm_half$1_0.iqmod_mfb_lpf_ota_core_inv_NF20$2_1.vin iqmod_mfb_lpf_0.iqmod_mfb_lpf_half_1.iqmod_mfb_lpf_ota_core_hybrid_bm_half$1_0.iqmod_mfb_lpf_ota_core_spdt_switch$2_0.iqmod_mfb_lpf_ota_core_spdt_switch_inv$3_0.vout VDD VDD sg13_lv_pmos ad=1.14p pd=6.38u as=1.14p ps=6.38u w=6u l=0.13u
X704 iqmod_mixer_0.iqmod_mixer_half_1.iqmod_mixer_se2diff$1_0.iqmod_mixer_se2diff_half_inv$2_0.iqmod_mixer_se2diff_inv_NF18$7_0.vin iqmod_mixer_0.iqmod_mixer_half_1.iqmod_mixer_se2diff$1_0.iqmod_mixer_se2diff_half_inv$2_0.iqmod_mixer_se2diff_inv_NF6$7_1.vin VSS VSS sg13_lv_nmos ad=0.19p pd=1.38u as=0.19p ps=1.38u w=1u l=0.13u
X705 iqmod_mfb_lpf_0.iqmod_mfb_lpf_half_0.iqmod_mfb_lpf_ota_core_hybrid_bm_half$1_0.iqmod_mfb_lpf_ota_core_tg$2_0.v_b iqmod_mfb_lpf_0.iqmod_mfb_lpf_half_0.iqmod_mfb_lpf_ota_core_hybrid_bm_half$1_0.iqmod_mfb_lpf_ota_core_tg$2_0.di_tg_ctrl_n iqmod_mfb_lpf_0.iqmod_mfb_lpf_half_0.iqmod_mfb_lpf_ota_core_hybrid_bm_half$1_0.iqmod_mfb_lpf_ota_core_tg$2_0.v_a VDD sg13_lv_pmos ad=1.14p pd=6.38u as=1.14p ps=6.38u w=6u l=0.13u
X706 VSS iqmod_mixer_0.iqmod_mixer_half_0.iqmod_mixer_se2diff$1_0.iqmod_mixer_se2diff_half_inv$2_0.iqmod_mixer_se2diff_inv_NF18$7_0.vin iqmod_mixer_0.iqmod_mixer_half_0.iqmod_mixer_se2diff$1_0.iqmod_mixer_se2diff_half_inv$2_0.iqmod_mixer_se2diff_inv_NF54$7_0.vin VSS sg13_lv_nmos ad=0.19p pd=1.38u as=0.19p ps=1.38u w=1u l=0.13u
X707 iqmod_mixer_0.iqmod_mixer_half_1.iqmod_mixer_se2diff$1_0.iqmod_mixer_se2diff_half_inv$2_0.iqmod_mixer_se2diff_inv_NF6$7_0.vin VSS iqmod_mixer_0.iqmod_mixer_half_1.iqmod_mixer_se2diff$1_0.iqmod_mixer_se2diff_half_tg$2_0.iqmod_mixer_se2diff_tg_NF6$3_0.v_b VDD sg13_lv_pmos ad=0.57p pd=3.38u as=0.57p ps=3.38u w=3u l=0.13u
X708 voutp_I_RF iqmod_mixer_0.iqmod_mixer_half_1.iqmod_mixer_tg$1_0.di_tg_ctrl voutp_I_RF VDD sg13_lv_pmos ad=1.71p pd=9.38u as=0 ps=0 w=9u l=0.13u
X709 VDD iqmod_mixer_0.iqmod_mixer_half_0.iqmod_mixer_se2diff$1_0.iqmod_mixer_se2diff_half_tg$2_0.iqmod_mixer_se2diff_inv_NF18$6_0.vin iqmod_mixer_0.iqmod_mixer_half_0.iqmod_mixer_se2diff$1_0.iqmod_mixer_se2diff_half_tg$2_0.iqmod_mixer_se2diff_inv_NF54$6_0.vin VDD sg13_lv_pmos ad=0.57p pd=3.38u as=0.57p ps=3.38u w=3u l=0.13u
X710 voutn_I_RF iqmod_mixer_0.iqmod_mixer_half_0.iqmod_mixer_tg$1_0.di_tg_ctrl_n voutn_I_RF VSS sg13_lv_nmos ad=0.57p pd=3.38u as=0 ps=0 w=3u l=0.13u
X711 iqmod_mixer_0.iqmod_mixer_half_0.iqmod_mixer_se2diff$1_0.iqmod_mixer_se2diff_half_inv$2_0.iqmod_mixer_se2diff_inv_NF18$7_0.vin iqmod_mixer_0.iqmod_mixer_half_0.iqmod_mixer_se2diff$1_0.iqmod_mixer_se2diff_half_inv$2_0.iqmod_mixer_se2diff_inv_NF6$7_1.vin VDD VDD sg13_lv_pmos ad=0.57p pd=3.38u as=0.57p ps=3.38u w=3u l=0.13u
X712 iqmod_mixer_0.vinp_IF iqmod_mfb_lpf_0.iqmod_mfb_lpf_half_0.iqmod_mfb_lpf_ota_core_hybrid_bm_half$1_0.iqmod_mfb_lpf_ota_core_tg$2_0.v_b VDD VDD sg13_lv_pmos ad=1.14p pd=6.38u as=1.14p ps=6.38u w=6u l=1u
X713 VDD iqmod_mfb_lpf_0.iqmod_mfb_lpf_half_1.iqmod_mfb_lpf_ota_core_hybrid_bm_half$1_0.iqmod_mfb_lpf_ota_core_spdt_switch$2_0.iqmod_mfb_lpf_ota_core_spdt_switch_inv$3_0.vout iqmod_mfb_lpf_0.iqmod_mfb_lpf_half_1.iqmod_mfb_lpf_ota_core_hybrid_bm_half$1_0.iqmod_mfb_lpf_ota_core_inv_NF20$2_1.vin VDD sg13_lv_pmos ad=1.14p pd=6.38u as=1.14p ps=6.38u w=6u l=0.13u
X714 iqmod_mixer_0.vinp_IF iqmod_mixer_0.iqmod_mixer_half_1.iqmod_mixer_tg$1_0.di_tg_ctrl_n voutp_I_RF VDD sg13_lv_pmos ad=1.71p pd=9.38u as=1.71p ps=9.38u w=9u l=0.13u
X715 iqmod_mixer_0.iqmod_mixer_half_1.iqmod_mixer_se2diff$1_0.iqmod_mixer_se2diff_half_tg$2_0.iqmod_mixer_se2diff_tg_NF6$3_0.v_b VSS iqmod_mixer_0.iqmod_mixer_half_1.iqmod_mixer_se2diff$1_0.iqmod_mixer_se2diff_half_inv$2_0.iqmod_mixer_se2diff_inv_NF6$7_0.vin VDD sg13_lv_pmos ad=0.57p pd=3.38u as=1.02p ps=6.68u w=3u l=0.13u
X716 voutp_I_RF iqmod_mixer_0.iqmod_mixer_half_1.iqmod_mixer_tg$1_0.di_tg_ctrl voutp_I_RF VDD sg13_lv_pmos ad=1.71p pd=9.38u as=0 ps=0 w=9u l=0.13u
X717 iqmod_mfb_lpf_0.iqmod_mfb_lpf_half_0.C1_half iqmod_mfb_lpf_0.iqmod_mfb_lpf_half_0.iqmod_mfb_lpf_R1$1_0.v_b cap_cmim l=8u w=8u
X718 iqmod_mixer_0.iqmod_mixer_half_0.iqmod_mixer_se2diff$1_0.iqmod_mixer_se2diff_half_tg$2_0.iqmod_mixer_se2diff_inv_NF54$6_0.vin iqmod_mixer_0.iqmod_mixer_half_0.iqmod_mixer_se2diff$1_0.iqmod_mixer_se2diff_half_tg$2_0.iqmod_mixer_se2diff_inv_NF18$6_0.vin VDD VDD sg13_lv_pmos ad=0.57p pd=3.38u as=0.57p ps=3.38u w=3u l=0.13u
X719 iqmod_mixer_0.vinn_IF iqmod_mfb_lpf_0.iqmod_mfb_lpf_half_0.iqmod_mfb_lpf_ota_core_hybrid_bm_half$1_0.iqmod_mfb_lpf_ota_core_inv_NF20$2_1.vin VDD VDD sg13_lv_pmos ad=1.14p pd=6.38u as=1.14p ps=6.38u w=6u l=1u
X720 iqmod_mfb_lpf_0.iqmod_mfb_lpf_half_0.iqmod_mfb_lpf_ota_core_hybrid_bm_half$1_0.iqmod_mfb_lpf_ota_core_inv_NF20$2_0.vout iqmod_mixer_0.vinn_IF VSS VSS sg13_lv_nmos ad=0.19p pd=1.38u as=0.19p ps=1.38u w=1u l=1u
X721 iqmod_mixer_0.iqmod_mixer_half_0.iqmod_mixer_tg$1_0.di_tg_ctrl iqmod_mixer_0.iqmod_mixer_half_0.iqmod_mixer_se2diff$1_0.iqmod_mixer_se2diff_half_inv$2_0.iqmod_mixer_se2diff_inv_NF54$7_0.vin VSS VSS sg13_lv_nmos ad=0.19p pd=1.38u as=0.19p ps=1.38u w=1u l=0.13u
X722 iqmod_mixer_0.iqmod_mixer_half_1.iqmod_mixer_se2diff$1_0.iqmod_mixer_se2diff_half_inv$2_0.iqmod_mixer_se2diff_inv_NF54$7_0.vin iqmod_mixer_0.iqmod_mixer_half_1.iqmod_mixer_se2diff$1_0.iqmod_mixer_se2diff_half_inv$2_0.iqmod_mixer_se2diff_inv_NF18$7_0.vin VDD VDD sg13_lv_pmos ad=0.57p pd=3.38u as=0.57p ps=3.38u w=3u l=0.13u
X723 iqmod_mfb_lpf_0.iqmod_mfb_lpf_half_0.iqmod_mfb_lpf_ota_core_hybrid_bm_half$1_0.iqmod_mfb_lpf_ota_core_tg$2_0.v_a iqmod_mfb_lpf_0.iqmod_mfb_lpf_half_0.iqmod_mfb_lpf_ota_core_hybrid_bm_half$1_0.iqmod_mfb_lpf_ota_core_inv_NF20$2_1.vin VDD VDD sg13_lv_pmos ad=1.14p pd=6.38u as=1.14p ps=6.38u w=6u l=1u
X724 VSS iqmod_mixer_0.iqmod_mixer_half_0.iqmod_mixer_se2diff$1_0.iqmod_mixer_se2diff_half_inv$2_0.iqmod_mixer_se2diff_inv_NF6$7_1.vin iqmod_mixer_0.iqmod_mixer_half_0.iqmod_mixer_se2diff$1_0.iqmod_mixer_se2diff_half_inv$2_0.iqmod_mixer_se2diff_inv_NF2$7_1.vout VSS sg13_lv_nmos ad=0.19p pd=1.38u as=0.19p ps=1.38u w=1u l=0.13u
X725 iqmod_mixer_0.iqmod_mixer_half_0.iqmod_mixer_se2diff$1_0.iqmod_mixer_se2diff_half_tg$2_0.iqmod_mixer_se2diff_inv_NF18$6_0.vin iqmod_mixer_0.iqmod_mixer_half_0.iqmod_mixer_se2diff$1_0.iqmod_mixer_se2diff_half_inv$2_0.iqmod_mixer_se2diff_inv_NF2$7_1.vout VSS VSS sg13_lv_nmos ad=0.19p pd=1.38u as=0.19p ps=1.38u w=1u l=0.13u
X726 VSS VSS VSS VSS sg13_lv_nmos ad=0.19p pd=1.38u as=0 ps=0 w=1u l=0.13u
X727 VSS iqmod_mixer_0.iqmod_mixer_half_1.iqmod_mixer_se2diff$1_0.iqmod_mixer_se2diff_half_inv$2_0.iqmod_mixer_se2diff_inv_NF6$7_0.vin iqmod_mixer_0.iqmod_mixer_half_1.iqmod_mixer_se2diff$1_0.iqmod_mixer_se2diff_half_inv$2_0.iqmod_mixer_se2diff_inv_NF6$7_0.vout VSS sg13_lv_nmos ad=0.19p pd=1.38u as=0.19p ps=1.38u w=1u l=0.13u
X728 iqmod_spdt_switch_1.v_c iqmod_spdt_switch_1.spdt_switch_inv_0.vout di_ds_I_p VDD sg13_lv_pmos ad=1.14p pd=6.38u as=1.14p ps=6.38u w=6u l=0.13u
X729 VDD iqmod_mfb_lpf_0.iqmod_mfb_lpf_half_0.iqmod_mfb_lpf_ota_core_hybrid_bm_half$1_0.iqmod_mfb_lpf_ota_core_tg$2_0.v_b iqmod_mixer_0.vinp_IF VDD sg13_lv_pmos ad=1.14p pd=6.38u as=1.14p ps=6.38u w=6u l=1u
X730 iqmod_mfb_lpf_0.iqmod_mfb_lpf_half_0.iqmod_mfb_lpf_ota_core_hybrid_bm_half$1_0.iqmod_mfb_lpf_ota_core_inv_NF20$2_1.vin iqmod_mfb_lpf_0.iqmod_mfb_lpf_half_0.iqmod_mfb_lpf_ota_core_hybrid_bm_half$1_0.iqmod_mfb_lpf_ota_core_tg$2_0.di_tg_ctrl_n VDD VSS sg13_lv_nmos ad=0.19p pd=1.38u as=0.34p ps=2.68u w=1u l=0.13u
X731 iqmod_spdt_switch_1.v_c iqmod_mfb_lpf_0.iqmod_mfb_lpf_half_0.iqmod_mfb_lpf_ota_core_hybrid_bm_half$1_0.iqmod_mfb_lpf_ota_core_spdt_switch$2_0.iqmod_mfb_lpf_ota_core_spdt_switch_inv$3_0.vout iqmod_mfb_lpf_0.iqmod_mfb_lpf_half_0.iqmod_mfb_lpf_ota_core_hybrid_bm_half$1_0.iqmod_mfb_lpf_ota_core_inv_NF20$2_1.vin VSS sg13_lv_nmos ad=0.19p pd=1.38u as=0.19p ps=1.38u w=1u l=0.13u
X732 VDD iqmod_mfb_lpf_0.iqmod_mfb_lpf_half_0.iqmod_mfb_lpf_ota_core_hybrid_bm_half$1_0.iqmod_mfb_lpf_ota_core_tg$2_0.v_a iqmod_mfb_lpf_0.iqmod_mfb_lpf_half_0.iqmod_mfb_lpf_ota_core_hybrid_bm_half$1_0.iqmod_mfb_lpf_ota_core_tg$2_0.v_b VDD sg13_lv_pmos ad=1.14p pd=6.38u as=1.14p ps=6.38u w=6u l=1u
X733 VDD iqmod_mixer_0.iqmod_mixer_half_1.iqmod_mixer_se2diff$1_0.iqmod_mixer_se2diff_half_tg$2_0.iqmod_mixer_se2diff_inv_NF54$6_0.vin iqmod_mixer_0.iqmod_mixer_half_1.iqmod_mixer_tg$1_0.di_tg_ctrl_n VDD sg13_lv_pmos ad=0.57p pd=3.38u as=0.57p ps=3.38u w=3u l=0.13u
X734 iqmod_mixer_0.vinp_IF iqmod_mixer_0.iqmod_mixer_half_1.iqmod_mixer_tg$1_0.di_tg_ctrl_n voutp_I_RF VDD sg13_lv_pmos ad=1.71p pd=9.38u as=1.71p ps=9.38u w=9u l=0.13u
X735 VSS iqmod_mixer_0.iqmod_mixer_half_0.iqmod_mixer_se2diff$1_0.iqmod_mixer_se2diff_half_inv$2_0.iqmod_mixer_se2diff_inv_NF54$7_0.vin iqmod_mixer_0.iqmod_mixer_half_0.iqmod_mixer_tg$1_0.di_tg_ctrl VSS sg13_lv_nmos ad=0.19p pd=1.38u as=0.19p ps=1.38u w=1u l=0.13u
X736 VDD iqmod_mixer_0.iqmod_mixer_half_0.iqmod_mixer_se2diff$1_0.iqmod_mixer_se2diff_half_tg$2_0.iqmod_mixer_se2diff_inv_NF54$6_0.vin iqmod_mixer_0.iqmod_mixer_half_0.iqmod_mixer_tg$1_0.di_tg_ctrl_n VDD sg13_lv_pmos ad=0.57p pd=3.38u as=0.57p ps=3.38u w=3u l=0.13u
X737 iqmod_mixer_0.iqmod_mixer_half_1.iqmod_mixer_tg$1_0.di_tg_ctrl_n iqmod_mixer_0.iqmod_mixer_half_1.iqmod_mixer_se2diff$1_0.iqmod_mixer_se2diff_half_tg$2_0.iqmod_mixer_se2diff_inv_NF54$6_0.vin VSS VSS sg13_lv_nmos ad=0.19p pd=1.38u as=0.19p ps=1.38u w=1u l=0.13u
X738 VDD iqmod_mixer_0.iqmod_mixer_half_0.iqmod_mixer_se2diff$1_0.iqmod_mixer_se2diff_half_inv$2_0.iqmod_mixer_se2diff_inv_NF6$7_0.vin iqmod_mixer_0.iqmod_mixer_half_0.iqmod_mixer_se2diff$1_0.iqmod_mixer_se2diff_half_inv$2_0.iqmod_mixer_se2diff_inv_NF6$7_0.vout VDD sg13_lv_pmos ad=0.57p pd=3.38u as=0.57p ps=3.38u w=3u l=0.13u
X739 VSS VSS VSS VSS sg13_lv_nmos ad=0.34p pd=2.68u as=0 ps=0 w=1u l=0.13u
X740 iqmod_mixer_0.iqmod_mixer_half_1.iqmod_mixer_se2diff$1_0.iqmod_mixer_se2diff_half_inv$2_0.iqmod_mixer_se2diff_inv_NF6$7_0.vout iqmod_mixer_0.iqmod_mixer_half_1.iqmod_mixer_se2diff$1_0.iqmod_mixer_se2diff_half_inv$2_0.iqmod_mixer_se2diff_inv_NF6$7_0.vin VSS VSS sg13_lv_nmos ad=0.19p pd=1.38u as=0.19p ps=1.38u w=1u l=0.13u
X741 iqmod_mixer_0.iqmod_mixer_half_0.iqmod_mixer_se2diff$1_0.iqmod_mixer_se2diff_half_inv$2_0.iqmod_mixer_se2diff_inv_NF6$7_1.vin iqmod_mixer_0.iqmod_mixer_half_0.iqmod_mixer_se2diff$1_0.iqmod_mixer_se2diff_half_inv$2_0.iqmod_mixer_se2diff_inv_NF2$7_1.vout VDD VDD sg13_lv_pmos ad=0.57p pd=3.38u as=0.57p ps=3.38u w=3u l=0.13u
X742 iqmod_mfb_lpf_0.iqmod_mfb_lpf_half_0.iqmod_mfb_lpf_ota_core_hybrid_bm_half$1_0.iqmod_mfb_lpf_ota_core_inv_NF20$2_0.vout di_analog_en iqmod_mfb_lpf_0.iqmod_mfb_lpf_half_0.iqmod_mfb_lpf_ota_core_hybrid_bm_half$1_0.iqmod_mfb_lpf_ota_core_inv_NF6$2_1.vout VSS sg13_lv_nmos ad=0.19p pd=1.38u as=0.19p ps=1.38u w=1u l=0.13u
X743 iqmod_mixer_0.iqmod_mixer_half_1.iqmod_mixer_tg$1_0.di_tg_ctrl_n iqmod_mixer_0.iqmod_mixer_half_1.iqmod_mixer_se2diff$1_0.iqmod_mixer_se2diff_half_tg$2_0.iqmod_mixer_se2diff_inv_NF54$6_0.vin VDD VDD sg13_lv_pmos ad=0.57p pd=3.38u as=0.57p ps=3.38u w=3u l=0.13u
X744 VSS iqmod_mixer_0.vinn_IF iqmod_mfb_lpf_0.iqmod_mfb_lpf_half_0.iqmod_mfb_lpf_ota_core_hybrid_bm_half$1_0.iqmod_mfb_lpf_ota_core_inv_NF20$2_0.vout VSS sg13_lv_nmos ad=0.19p pd=1.38u as=0.19p ps=1.38u w=1u l=1u
X745 iqmod_mixer_0.iqmod_mixer_half_1.iqmod_mixer_se2diff$1_0.iqmod_mixer_se2diff_half_inv$2_0.iqmod_mixer_se2diff_inv_NF54$7_0.vin iqmod_mixer_0.iqmod_mixer_half_1.iqmod_mixer_se2diff$1_0.iqmod_mixer_se2diff_half_inv$2_0.iqmod_mixer_se2diff_inv_NF18$7_0.vin VDD VDD sg13_lv_pmos ad=0.57p pd=3.38u as=0.57p ps=3.38u w=3u l=0.13u
X746 voutn_I_RF iqmod_mixer_0.iqmod_mixer_half_0.iqmod_mixer_tg$1_0.di_tg_ctrl voutn_I_RF VDD sg13_lv_pmos ad=1.71p pd=9.38u as=0 ps=0 w=9u l=0.13u
X747 voutn_I_RF iqmod_mixer_0.iqmod_mixer_half_0.iqmod_mixer_tg$1_0.di_tg_ctrl_n iqmod_mixer_0.vinn_IF VDD sg13_lv_pmos ad=1.71p pd=9.38u as=1.71p ps=9.38u w=9u l=0.13u
X748 iqmod_mixer_0.iqmod_mixer_half_0.iqmod_mixer_tg$1_0.di_tg_ctrl_n iqmod_mixer_0.iqmod_mixer_half_0.iqmod_mixer_se2diff$1_0.iqmod_mixer_se2diff_half_tg$2_0.iqmod_mixer_se2diff_inv_NF54$6_0.vin VDD VDD sg13_lv_pmos ad=0.57p pd=3.38u as=0.57p ps=3.38u w=3u l=0.13u
X749 iqmod_mixer_0.iqmod_mixer_half_0.iqmod_mixer_se2diff$1_0.iqmod_mixer_se2diff_half_inv$2_0.iqmod_mixer_se2diff_inv_NF6$7_0.vout iqmod_mixer_0.iqmod_mixer_half_0.iqmod_mixer_se2diff$1_0.iqmod_mixer_se2diff_half_inv$2_0.iqmod_mixer_se2diff_inv_NF6$7_0.vin VDD VDD sg13_lv_pmos ad=0.57p pd=3.38u as=0.57p ps=3.38u w=3u l=0.13u
X750 iqmod_mfb_lpf_0.iqmod_mfb_lpf_half_0.iqmod_mfb_lpf_ota_core_hybrid_bm_half$1_0.iqmod_mfb_lpf_ota_core_tg$2_0.v_a iqmod_mfb_lpf_0.iqmod_mfb_lpf_half_0.iqmod_mfb_lpf_ota_core_hybrid_bm_half$1_0.iqmod_mfb_lpf_ota_core_inv_NF20$2_1.vin VSS VSS sg13_lv_nmos ad=0.19p pd=1.38u as=0.19p ps=1.38u w=1u l=1u
X751 iqmod_spdt_switch_0.spdt_switch_inv_0.vin di_spdt_ctrl_I VDD VDD sg13_lv_pmos ad=1.14p pd=6.38u as=1.14p ps=6.38u w=6u l=0.13u
X752 iqmod_mfb_lpf_0.iqmod_mfb_lpf_half_0.C1_half iqmod_mfb_lpf_0.iqmod_mfb_lpf_half_0.iqmod_mfb_lpf_R1$1_0.v_b cap_cmim l=8u w=8u
X753 voutn_I_RF iqmod_mixer_0.iqmod_mixer_half_0.iqmod_mixer_tg$1_0.di_tg_ctrl iqmod_mixer_0.vinn_IF VSS sg13_lv_nmos ad=0.57p pd=3.38u as=0.57p ps=3.38u w=3u l=0.13u
X754 voutp_I_RF iqmod_mixer_0.iqmod_mixer_half_1.iqmod_mixer_tg$1_0.di_tg_ctrl voutp_I_RF VDD sg13_lv_pmos ad=1.71p pd=9.38u as=0 ps=0 w=9u l=0.13u
X755 VDD iqmod_mixer_0.iqmod_mixer_half_0.iqmod_mixer_se2diff$1_0.iqmod_mixer_se2diff_half_tg$2_0.iqmod_mixer_se2diff_inv_NF54$6_0.vin iqmod_mixer_0.iqmod_mixer_half_0.iqmod_mixer_tg$1_0.di_tg_ctrl_n VDD sg13_lv_pmos ad=0.57p pd=3.38u as=0.57p ps=3.38u w=3u l=0.13u
X756 vinp_I iqmod_spdt_switch_1.spdt_switch_inv_0.vout iqmod_spdt_switch_1.v_c VSS sg13_lv_nmos ad=0.34p pd=2.68u as=0.19p ps=1.38u w=1u l=0.13u
X757 VSS iqmod_mixer_0.iqmod_mixer_half_1.iqmod_mixer_se2diff$1_0.iqmod_mixer_se2diff_half_inv$2_0.iqmod_mixer_se2diff_inv_NF54$7_0.vin iqmod_mixer_0.iqmod_mixer_half_1.iqmod_mixer_tg$1_0.di_tg_ctrl VSS sg13_lv_nmos ad=0.19p pd=1.38u as=0.19p ps=1.38u w=1u l=0.13u
X758 iqmod_mfb_lpf_0.iqmod_mfb_lpf_half_0.iqmod_mfb_lpf_ota_core_hybrid_bm_half$1_0.iqmod_mfb_lpf_ota_core_spdt_switch$2_0.iqmod_mfb_lpf_ota_core_spdt_switch_inv$3_0.vout iqmod_mfb_lpf_0.iqmod_mfb_lpf_half_0.iqmod_mfb_lpf_ota_core_hybrid_bm_half$1_0.iqmod_mfb_lpf_ota_core_tg$2_0.di_tg_ctrl_n VDD VDD sg13_lv_pmos ad=1.14p pd=6.38u as=1.14p ps=6.38u w=6u l=0.13u
X759 iqmod_mfb_lpf_0.iqmod_mfb_lpf_half_0.iqmod_mfb_lpf_ota_core_hybrid_bm_half$1_0.iqmod_mfb_lpf_ota_core_inv_NF20$2_1.vin iqmod_mfb_lpf_0.iqmod_mfb_lpf_half_0.iqmod_mfb_lpf_ota_core_hybrid_bm_half$1_0.iqmod_mfb_lpf_ota_core_tg$2_0.di_tg_ctrl_n iqmod_spdt_switch_1.v_c VDD sg13_lv_pmos ad=1.14p pd=6.38u as=2.04p ps=12.68u w=6u l=0.13u
X760 iqmod_mixer_0.iqmod_mixer_half_1.iqmod_mixer_tg$1_0.di_tg_ctrl_n iqmod_mixer_0.iqmod_mixer_half_1.iqmod_mixer_se2diff$1_0.iqmod_mixer_se2diff_half_tg$2_0.iqmod_mixer_se2diff_inv_NF54$6_0.vin VDD VDD sg13_lv_pmos ad=0.57p pd=3.38u as=0.57p ps=3.38u w=3u l=0.13u
X761 voutn_I_RF iqmod_mixer_0.iqmod_mixer_half_0.iqmod_mixer_tg$1_0.di_tg_ctrl_n voutn_I_RF VSS sg13_lv_nmos ad=0.57p pd=3.38u as=0 ps=0 w=3u l=0.13u
X762 iqmod_mixer_0.vinn_IF iqmod_mfb_lpf_0.iqmod_mfb_lpf_half_0.iqmod_mfb_lpf_ota_core_hybrid_bm_half$1_0.iqmod_mfb_lpf_ota_core_inv_NF20$2_1.vin VDD VDD sg13_lv_pmos ad=1.14p pd=6.38u as=1.14p ps=6.38u w=6u l=1u
X763 VDD iqmod_mixer_0.iqmod_mixer_half_0.iqmod_mixer_se2diff$1_0.iqmod_mixer_se2diff_half_inv$2_0.iqmod_mixer_se2diff_inv_NF54$7_0.vin iqmod_mixer_0.iqmod_mixer_half_0.iqmod_mixer_tg$1_0.di_tg_ctrl VDD sg13_lv_pmos ad=0.57p pd=3.38u as=0.57p ps=3.38u w=3u l=0.13u
X764 iqmod_mixer_0.vinp_IF iqmod_mixer_0.iqmod_mixer_half_1.iqmod_mixer_tg$1_0.di_tg_ctrl voutp_I_RF VSS sg13_lv_nmos ad=0.57p pd=3.38u as=0.57p ps=3.38u w=3u l=0.13u
X765 VSS di_lo_Ix iqmod_mixer_0.iqmod_mixer_half_0.iqmod_mixer_se2diff$1_0.iqmod_mixer_se2diff_half_inv$2_0.iqmod_mixer_se2diff_inv_NF6$7_0.vin VSS sg13_lv_nmos ad=0.19p pd=1.38u as=0.19p ps=1.38u w=1u l=0.13u
X766 VSS iqmod_mfb_lpf_0.iqmod_mfb_lpf_half_0.iqmod_mfb_lpf_ota_core_hybrid_bm_half$1_0.iqmod_mfb_lpf_ota_core_inv_NF20$2_1.vin iqmod_mfb_lpf_0.iqmod_mfb_lpf_half_0.iqmod_mfb_lpf_ota_core_hybrid_bm_half$1_0.iqmod_mfb_lpf_ota_core_tg$2_0.v_a VSS sg13_lv_nmos ad=0.19p pd=1.38u as=0.19p ps=1.38u w=1u l=1u
X767 iqmod_spdt_switch_1.v_c iqmod_spdt_switch_1.spdt_switch_inv_0.vout vinp_I VSS sg13_lv_nmos ad=0.19p pd=1.38u as=0.19p ps=1.38u w=1u l=0.13u
X768 iqmod_mixer_0.iqmod_mixer_half_1.iqmod_mixer_tg$1_0.di_tg_ctrl iqmod_mixer_0.iqmod_mixer_half_1.iqmod_mixer_se2diff$1_0.iqmod_mixer_se2diff_half_inv$2_0.iqmod_mixer_se2diff_inv_NF54$7_0.vin VSS VSS sg13_lv_nmos ad=0.19p pd=1.38u as=0.19p ps=1.38u w=1u l=0.13u
X769 VDD VDD VDD VDD sg13_lv_pmos ad=2.04p pd=12.68u as=0 ps=0 w=6u l=1u
X770 VDD iqmod_mixer_0.iqmod_mixer_half_1.iqmod_mixer_se2diff$1_0.iqmod_mixer_se2diff_half_tg$2_0.iqmod_mixer_se2diff_inv_NF54$6_0.vin iqmod_mixer_0.iqmod_mixer_half_1.iqmod_mixer_tg$1_0.di_tg_ctrl_n VDD sg13_lv_pmos ad=0.57p pd=3.38u as=0.57p ps=3.38u w=3u l=0.13u
X771 iqmod_mixer_0.iqmod_mixer_half_0.iqmod_mixer_tg$1_0.di_tg_ctrl iqmod_mixer_0.iqmod_mixer_half_0.iqmod_mixer_se2diff$1_0.iqmod_mixer_se2diff_half_inv$2_0.iqmod_mixer_se2diff_inv_NF54$7_0.vin VDD VDD sg13_lv_pmos ad=0.57p pd=3.38u as=0.57p ps=3.38u w=3u l=0.13u
X772 iqmod_mfb_lpf_0.iqmod_mfb_lpf_half_0.iqmod_mfb_lpf_ota_core_hybrid_bm_half$1_0.iqmod_mfb_lpf_ota_core_inv_NF20$2_0.vout iqmod_mixer_0.vinp_IF VSS VSS sg13_lv_nmos ad=0.19p pd=1.38u as=0.19p ps=1.38u w=1u l=1u
X773 voutp_I_RF iqmod_mixer_0.iqmod_mixer_half_1.iqmod_mixer_tg$1_0.di_tg_ctrl iqmod_mixer_0.vinp_IF VSS sg13_lv_nmos ad=0.57p pd=3.38u as=0.57p ps=3.38u w=3u l=0.13u
X774 VDD iqmod_mfb_lpf_0.iqmod_mfb_lpf_half_0.iqmod_mfb_lpf_ota_core_hybrid_bm_half$1_0.iqmod_mfb_lpf_ota_core_inv_NF20$2_1.vin iqmod_mixer_0.vinn_IF VDD sg13_lv_pmos ad=1.14p pd=6.38u as=1.14p ps=6.38u w=6u l=1u
X775 iqmod_mixer_0.iqmod_mixer_half_0.iqmod_mixer_se2diff$1_0.iqmod_mixer_se2diff_half_inv$2_0.iqmod_mixer_se2diff_inv_NF6$7_0.vin di_lo_Ix VDD VDD sg13_lv_pmos ad=0.57p pd=3.38u as=0.57p ps=3.38u w=3u l=0.13u
X776 VSS iqmod_mixer_0.vinn_IF iqmod_mfb_lpf_0.iqmod_mfb_lpf_half_0.iqmod_mfb_lpf_ota_core_hybrid_bm_half$1_0.iqmod_mfb_lpf_ota_core_inv_NF20$2_0.vout VSS sg13_lv_nmos ad=0.19p pd=1.38u as=0.19p ps=1.38u w=1u l=1u
X777 iqmod_mixer_0.iqmod_mixer_half_1.iqmod_mixer_tg$1_0.di_tg_ctrl_n iqmod_mixer_0.iqmod_mixer_half_1.iqmod_mixer_se2diff$1_0.iqmod_mixer_se2diff_half_tg$2_0.iqmod_mixer_se2diff_inv_NF54$6_0.vin VDD VDD sg13_lv_pmos ad=0.57p pd=3.38u as=0.57p ps=3.38u w=3u l=0.13u
X778 iqmod_mixer_0.iqmod_mixer_half_1.iqmod_mixer_tg$1_0.di_tg_ctrl iqmod_mixer_0.iqmod_mixer_half_1.iqmod_mixer_se2diff$1_0.iqmod_mixer_se2diff_half_inv$2_0.iqmod_mixer_se2diff_inv_NF54$7_0.vin VSS VSS sg13_lv_nmos ad=0.19p pd=1.38u as=0.19p ps=1.38u w=1u l=0.13u
X779 VDD VDD VDD VDD sg13_lv_pmos ad=1.14p pd=6.38u as=0 ps=0 w=6u l=0.13u
X780 iqmod_mixer_0.iqmod_mixer_half_0.iqmod_mixer_tg$1_0.di_tg_ctrl iqmod_mixer_0.iqmod_mixer_half_0.iqmod_mixer_se2diff$1_0.iqmod_mixer_se2diff_half_inv$2_0.iqmod_mixer_se2diff_inv_NF54$7_0.vin VDD VDD sg13_lv_pmos ad=0.57p pd=3.38u as=0.57p ps=3.38u w=3u l=0.13u
X781 iqmod_mixer_0.vinp_IF iqmod_mfb_lpf_0.iqmod_mfb_lpf_half_1.iqmod_mfb_lpf_ota_core_hybrid_bm_half$1_0.iqmod_mfb_lpf_ota_core_inv_NF20$2_1.vin VDD VDD sg13_lv_pmos ad=1.14p pd=6.38u as=1.14p ps=6.38u w=6u l=1u
X782 VSS iqmod_mixer_0.iqmod_mixer_half_1.iqmod_mixer_se2diff$1_0.iqmod_mixer_se2diff_half_inv$2_0.iqmod_mixer_se2diff_inv_NF54$7_0.vin iqmod_mixer_0.iqmod_mixer_half_1.iqmod_mixer_tg$1_0.di_tg_ctrl VSS sg13_lv_nmos ad=0.19p pd=1.38u as=0.19p ps=1.38u w=1u l=0.13u
X783 iqmod_mixer_0.iqmod_mixer_half_0.iqmod_mixer_tg$1_0.di_tg_ctrl_n iqmod_mixer_0.iqmod_mixer_half_0.iqmod_mixer_se2diff$1_0.iqmod_mixer_se2diff_half_tg$2_0.iqmod_mixer_se2diff_inv_NF54$6_0.vin VSS VSS sg13_lv_nmos ad=0.19p pd=1.38u as=0.19p ps=1.38u w=1u l=0.13u
X784 VSS iqmod_mfb_lpf_0.iqmod_mfb_lpf_half_0.iqmod_mfb_lpf_ota_core_hybrid_bm_half$1_0.iqmod_mfb_lpf_ota_core_tg$2_0.v_b iqmod_mixer_0.vinn_IF VSS sg13_lv_nmos ad=0.19p pd=1.38u as=0.19p ps=1.38u w=1u l=1u
X785 VSS VSS VSS VSS sg13_lv_nmos ad=0.19p pd=1.38u as=0 ps=0 w=1u l=0.13u
X786 VSS iqmod_mfb_lpf_0.iqmod_mfb_lpf_half_1.iqmod_mfb_lpf_ota_core_hybrid_bm_half$1_0.iqmod_mfb_lpf_ota_core_inv_NF20$2_1.vin iqmod_mixer_0.vinp_IF VSS sg13_lv_nmos ad=0.19p pd=1.38u as=0.19p ps=1.38u w=1u l=1u
X787 VDD VDD VDD VDD sg13_lv_pmos ad=0.57p pd=3.38u as=0 ps=0 w=3u l=0.13u
X788 VDD iqmod_mixer_0.iqmod_mixer_half_0.iqmod_mixer_se2diff$1_0.iqmod_mixer_se2diff_half_inv$2_0.iqmod_mixer_se2diff_inv_NF54$7_0.vin iqmod_mixer_0.iqmod_mixer_half_0.iqmod_mixer_tg$1_0.di_tg_ctrl VDD sg13_lv_pmos ad=0.57p pd=3.38u as=0.57p ps=3.38u w=3u l=0.13u
X789 iqmod_mfb_lpf_0.iqmod_mfb_lpf_half_0.iqmod_mfb_lpf_ota_core_hybrid_bm_half$1_0.iqmod_mfb_lpf_ota_core_inv_NF6$2_1.vout iqmod_mfb_lpf_0.iqmod_mfb_lpf_half_0.iqmod_mfb_lpf_ota_core_hybrid_bm_half$1_0.iqmod_mfb_lpf_ota_core_inv_NF20$2_0.vout VSS VSS sg13_lv_nmos ad=0.19p pd=1.38u as=0.19p ps=1.38u w=1u l=1u
X790 iqmod_mfb_lpf_0.iqmod_mfb_lpf_half_0.iqmod_mfb_lpf_ota_core_hybrid_bm_half$1_0.iqmod_mfb_lpf_ota_core_inv_NF6$2_1.vout iqmod_mfb_lpf_0.iqmod_mfb_lpf_half_1.iqmod_mfb_lpf_ota_core_hybrid_bm_half$1_0.iqmod_mfb_lpf_ota_core_tg$2_0.di_tg_ctrl_n iqmod_mfb_lpf_0.iqmod_mfb_lpf_half_0.iqmod_mfb_lpf_ota_core_hybrid_bm_half$1_0.iqmod_mfb_lpf_ota_core_inv_NF20$2_0.vout VDD sg13_lv_pmos ad=1.14p pd=6.38u as=1.14p ps=6.38u w=6u l=0.13u
X791 VSS iqmod_mixer_0.iqmod_mixer_half_0.iqmod_mixer_se2diff$1_0.iqmod_mixer_se2diff_half_tg$2_0.iqmod_mixer_se2diff_inv_NF54$6_0.vin iqmod_mixer_0.iqmod_mixer_half_0.iqmod_mixer_tg$1_0.di_tg_ctrl_n VSS sg13_lv_nmos ad=0.19p pd=1.38u as=0.19p ps=1.38u w=1u l=0.13u
X792 VSS iqmod_mixer_0.iqmod_mixer_half_1.iqmod_mixer_se2diff$1_0.iqmod_mixer_se2diff_half_tg$2_0.iqmod_mixer_se2diff_inv_NF18$6_0.vin iqmod_mixer_0.iqmod_mixer_half_1.iqmod_mixer_se2diff$1_0.iqmod_mixer_se2diff_half_tg$2_0.iqmod_mixer_se2diff_inv_NF54$6_0.vin VSS sg13_lv_nmos ad=0.19p pd=1.38u as=0.19p ps=1.38u w=1u l=0.13u
X793 iqmod_mixer_0.iqmod_mixer_half_1.iqmod_mixer_tg$1_0.di_tg_ctrl iqmod_mixer_0.iqmod_mixer_half_1.iqmod_mixer_se2diff$1_0.iqmod_mixer_se2diff_half_inv$2_0.iqmod_mixer_se2diff_inv_NF54$7_0.vin VSS VSS sg13_lv_nmos ad=0.19p pd=1.38u as=0.19p ps=1.38u w=1u l=0.13u
X794 iqmod_mfb_lpf_0.iqmod_mfb_lpf_half_0.C1_half iqmod_mfb_lpf_0.iqmod_mfb_lpf_half_0.iqmod_mfb_lpf_R1$1_0.v_b cap_cmim l=8u w=8u
X795 VDD iqmod_mfb_lpf_0.iqmod_mfb_lpf_half_0.iqmod_mfb_lpf_ota_core_hybrid_bm_half$1_0.iqmod_mfb_lpf_ota_core_tg$2_0.v_b iqmod_mixer_0.vinn_IF VDD sg13_lv_pmos ad=1.14p pd=6.38u as=1.14p ps=6.38u w=6u l=1u
X796 iqmod_mixer_0.iqmod_mixer_half_0.iqmod_mixer_tg$1_0.di_tg_ctrl iqmod_mixer_0.iqmod_mixer_half_0.iqmod_mixer_se2diff$1_0.iqmod_mixer_se2diff_half_inv$2_0.iqmod_mixer_se2diff_inv_NF54$7_0.vin VDD VDD sg13_lv_pmos ad=0.57p pd=3.38u as=0.57p ps=3.38u w=3u l=0.13u
X797 iqmod_mixer_0.vinn_IF iqmod_mfb_lpf_0.iqmod_mfb_lpf_half_0.iqmod_mfb_lpf_ota_core_hybrid_bm_half$1_0.iqmod_mfb_lpf_ota_core_tg$2_0.v_b VSS VSS sg13_lv_nmos ad=0.19p pd=1.38u as=0.19p ps=1.38u w=1u l=1u
X798 iqmod_mixer_0.iqmod_mixer_half_1.iqmod_mixer_tg$1_0.di_tg_ctrl iqmod_mixer_0.iqmod_mixer_half_1.iqmod_mixer_se2diff$1_0.iqmod_mixer_se2diff_half_inv$2_0.iqmod_mixer_se2diff_inv_NF54$7_0.vin VDD VDD sg13_lv_pmos ad=0.57p pd=3.38u as=0.57p ps=3.38u w=3u l=0.13u
X799 VSS di_analog_en iqmod_mfb_lpf_0.iqmod_mfb_lpf_half_1.iqmod_mfb_lpf_ota_core_hybrid_bm_half$1_0.iqmod_mfb_lpf_ota_core_tg$2_0.di_tg_ctrl_n VSS sg13_lv_nmos ad=0.19p pd=1.38u as=0.19p ps=1.38u w=1u l=0.13u
X800 VSS iqmod_mixer_0.iqmod_mixer_half_0.iqmod_mixer_se2diff$1_0.iqmod_mixer_se2diff_half_tg$2_0.iqmod_mixer_se2diff_inv_NF54$6_0.vin iqmod_mixer_0.iqmod_mixer_half_0.iqmod_mixer_tg$1_0.di_tg_ctrl_n VSS sg13_lv_nmos ad=0.19p pd=1.38u as=0.19p ps=1.38u w=1u l=0.13u
X801 VDD iqmod_mixer_0.iqmod_mixer_half_1.iqmod_mixer_se2diff$1_0.iqmod_mixer_se2diff_half_tg$2_0.iqmod_mixer_se2diff_inv_NF18$6_0.vin iqmod_mixer_0.iqmod_mixer_half_1.iqmod_mixer_se2diff$1_0.iqmod_mixer_se2diff_half_tg$2_0.iqmod_mixer_se2diff_inv_NF54$6_0.vin VDD sg13_lv_pmos ad=0.57p pd=3.38u as=0.57p ps=3.38u w=3u l=0.13u
X802 VDD VDD VDD VDD sg13_lv_pmos ad=0.57p pd=3.38u as=0 ps=0 w=3u l=0.13u
X803 VDD iqmod_mfb_lpf_0.iqmod_mfb_lpf_half_1.iqmod_mfb_lpf_ota_core_hybrid_bm_half$1_0.iqmod_mfb_lpf_ota_core_inv_NF20$2_1.vin iqmod_mixer_0.vinp_IF VDD sg13_lv_pmos ad=1.14p pd=6.38u as=1.14p ps=6.38u w=6u l=1u
X804 iqmod_mixer_0.iqmod_mixer_half_0.iqmod_mixer_tg$1_0.di_tg_ctrl_n iqmod_mixer_0.iqmod_mixer_half_0.iqmod_mixer_se2diff$1_0.iqmod_mixer_se2diff_half_tg$2_0.iqmod_mixer_se2diff_inv_NF54$6_0.vin VSS VSS sg13_lv_nmos ad=0.19p pd=1.38u as=0.19p ps=1.38u w=1u l=0.13u
X805 iqmod_mfb_lpf_0.iqmod_mfb_lpf_half_0.iqmod_mfb_lpf_ota_core_hybrid_bm_half$1_0.iqmod_mfb_lpf_ota_core_inv_NF6$2_1.vout di_analog_en iqmod_mfb_lpf_0.iqmod_mfb_lpf_half_0.iqmod_mfb_lpf_ota_core_hybrid_bm_half$1_0.iqmod_mfb_lpf_ota_core_inv_NF20$2_0.vout VSS sg13_lv_nmos ad=0.19p pd=1.38u as=0.34p ps=2.68u w=1u l=0.13u
X806 iqmod_mixer_0.vinn_IF iqmod_mfb_lpf_0.iqmod_mfb_lpf_half_0.iqmod_mfb_lpf_ota_core_hybrid_bm_half$1_0.iqmod_mfb_lpf_ota_core_tg$2_0.v_b VDD VDD sg13_lv_pmos ad=1.14p pd=6.38u as=1.14p ps=6.38u w=6u l=1u
X807 iqmod_mfb_lpf_0.iqmod_mfb_lpf_half_0.iqmod_mfb_lpf_ota_core_hybrid_bm_half$1_0.iqmod_mfb_lpf_ota_core_tg$2_0.v_b iqmod_mfb_lpf_0.iqmod_mfb_lpf_half_1.iqmod_mfb_lpf_ota_core_hybrid_bm_half$1_0.iqmod_mfb_lpf_ota_core_tg$2_0.di_tg_ctrl_n iqmod_mfb_lpf_0.iqmod_mfb_lpf_half_0.iqmod_mfb_lpf_ota_core_hybrid_bm_half$1_0.iqmod_mfb_lpf_ota_core_tg$2_0.v_a VDD sg13_lv_pmos ad=1.14p pd=6.38u as=1.14p ps=6.38u w=6u l=0.13u
X808 VSS iqmod_mixer_0.iqmod_mixer_half_1.iqmod_mixer_se2diff$1_0.iqmod_mixer_se2diff_half_tg$2_0.iqmod_mixer_se2diff_inv_NF54$6_0.vin iqmod_mixer_0.iqmod_mixer_half_1.iqmod_mixer_tg$1_0.di_tg_ctrl_n VSS sg13_lv_nmos ad=0.19p pd=1.38u as=0.19p ps=1.38u w=1u l=0.13u
X809 VSS iqmod_mixer_0.iqmod_mixer_half_0.iqmod_mixer_se2diff$1_0.iqmod_mixer_se2diff_half_inv$2_0.iqmod_mixer_se2diff_inv_NF18$7_0.vin iqmod_mixer_0.iqmod_mixer_half_0.iqmod_mixer_se2diff$1_0.iqmod_mixer_se2diff_half_inv$2_0.iqmod_mixer_se2diff_inv_NF54$7_0.vin VSS sg13_lv_nmos ad=0.19p pd=1.38u as=0.19p ps=1.38u w=1u l=0.13u
X810 VSS iqmod_mfb_lpf_0.iqmod_mfb_lpf_half_0.iqmod_mfb_lpf_ota_core_hybrid_bm_half$1_0.iqmod_mfb_lpf_ota_core_tg$2_0.v_b iqmod_mixer_0.vinn_IF VSS sg13_lv_nmos ad=0.19p pd=1.38u as=0.19p ps=1.38u w=1u l=1u
X811 iqmod_mixer_0.iqmod_mixer_half_1.iqmod_mixer_tg$1_0.di_tg_ctrl iqmod_mixer_0.iqmod_mixer_half_1.iqmod_mixer_se2diff$1_0.iqmod_mixer_se2diff_half_inv$2_0.iqmod_mixer_se2diff_inv_NF54$7_0.vin VDD VDD sg13_lv_pmos ad=0.57p pd=3.38u as=0.57p ps=3.38u w=3u l=0.13u
X812 voutn_I_RF iqmod_mixer_0.iqmod_mixer_half_0.iqmod_mixer_tg$1_0.di_tg_ctrl voutn_I_RF VDD sg13_lv_pmos ad=1.71p pd=9.38u as=0 ps=0 w=9u l=0.13u
X813 VSS iqmod_mixer_0.iqmod_mixer_half_1.iqmod_mixer_se2diff$1_0.iqmod_mixer_se2diff_half_tg$2_0.iqmod_mixer_se2diff_inv_NF54$6_0.vin iqmod_mixer_0.iqmod_mixer_half_1.iqmod_mixer_tg$1_0.di_tg_ctrl_n VSS sg13_lv_nmos ad=0.19p pd=1.38u as=0.19p ps=1.38u w=1u l=0.13u
X814 iqmod_mfb_lpf_0.iqmod_mfb_lpf_half_0.iqmod_mfb_lpf_ota_core_hybrid_bm_half$1_0.iqmod_mfb_lpf_ota_core_tg$2_0.v_b iqmod_mfb_lpf_0.iqmod_mfb_lpf_half_0.iqmod_mfb_lpf_ota_core_hybrid_bm_half$1_0.iqmod_mfb_lpf_ota_core_inv_NF6$2_1.vout VSS VSS sg13_lv_nmos ad=0.19p pd=1.38u as=0.19p ps=1.38u w=1u l=1u
X815 VSS iqmod_mixer_0.iqmod_mixer_half_0.iqmod_mixer_se2diff$1_0.iqmod_mixer_se2diff_half_tg$2_0.iqmod_mixer_se2diff_inv_NF54$6_0.vin iqmod_mixer_0.iqmod_mixer_half_0.iqmod_mixer_tg$1_0.di_tg_ctrl_n VSS sg13_lv_nmos ad=0.19p pd=1.38u as=0.19p ps=1.38u w=1u l=0.13u
X816 iqmod_mixer_0.iqmod_mixer_half_1.iqmod_mixer_tg$1_0.di_tg_ctrl_n iqmod_mixer_0.iqmod_mixer_half_1.iqmod_mixer_se2diff$1_0.iqmod_mixer_se2diff_half_tg$2_0.iqmod_mixer_se2diff_inv_NF54$6_0.vin VSS VSS sg13_lv_nmos ad=0.19p pd=1.38u as=0.19p ps=1.38u w=1u l=0.13u
X817 iqmod_mixer_0.vinn_IF iqmod_mixer_0.iqmod_mixer_half_0.iqmod_mixer_tg$1_0.di_tg_ctrl_n voutn_I_RF VDD sg13_lv_pmos ad=1.71p pd=9.38u as=1.71p ps=9.38u w=9u l=0.13u
X818 iqmod_mixer_0.iqmod_mixer_half_0.iqmod_mixer_se2diff$1_0.iqmod_mixer_se2diff_half_inv$2_0.iqmod_mixer_se2diff_inv_NF54$7_0.vin iqmod_mixer_0.iqmod_mixer_half_0.iqmod_mixer_se2diff$1_0.iqmod_mixer_se2diff_half_inv$2_0.iqmod_mixer_se2diff_inv_NF18$7_0.vin VSS VSS sg13_lv_nmos ad=0.19p pd=1.38u as=0.19p ps=1.38u w=1u l=0.13u
X819 a_17685_2246# iqmod_mfb_lpf_0.iqmod_mfb_lpf_half_0.C2_half VSS rhigh l=31u w=0.5u
X820 voutn_I_RF iqmod_mixer_0.iqmod_mixer_half_0.iqmod_mixer_tg$1_0.di_tg_ctrl voutn_I_RF VDD sg13_lv_pmos ad=1.71p pd=9.38u as=0 ps=0 w=9u l=0.13u
X821 iqmod_mixer_0.vinp_IF iqmod_mfb_lpf_0.iqmod_mfb_lpf_half_1.iqmod_mfb_lpf_ota_core_hybrid_bm_half$1_0.iqmod_mfb_lpf_ota_core_inv_NF20$2_1.vin VDD VDD sg13_lv_pmos ad=1.14p pd=6.38u as=1.14p ps=6.38u w=6u l=1u
X822 voutp_I_RF iqmod_mixer_0.iqmod_mixer_half_1.iqmod_mixer_tg$1_0.di_tg_ctrl_n iqmod_mixer_0.vinp_IF VDD sg13_lv_pmos ad=1.71p pd=9.38u as=1.71p ps=9.38u w=9u l=0.13u
X823 VSS iqmod_mixer_0.iqmod_mixer_half_1.iqmod_mixer_se2diff$1_0.iqmod_mixer_se2diff_half_inv$2_0.iqmod_mixer_se2diff_inv_NF18$7_0.vin iqmod_mixer_0.iqmod_mixer_half_1.iqmod_mixer_se2diff$1_0.iqmod_mixer_se2diff_half_inv$2_0.iqmod_mixer_se2diff_inv_NF54$7_0.vin VSS sg13_lv_nmos ad=0.19p pd=1.38u as=0.19p ps=1.38u w=1u l=0.13u
X824 iqmod_mixer_0.iqmod_mixer_half_1.iqmod_mixer_tg$1_0.di_tg_ctrl iqmod_mixer_0.iqmod_mixer_half_1.iqmod_mixer_se2diff$1_0.iqmod_mixer_se2diff_half_inv$2_0.iqmod_mixer_se2diff_inv_NF54$7_0.vin VDD VDD sg13_lv_pmos ad=0.57p pd=3.38u as=0.57p ps=3.38u w=3u l=0.13u
X825 VSS VSS VSS VSS sg13_lv_nmos ad=0.19p pd=1.38u as=0 ps=0 w=1u l=0.13u
X826 iqmod_mixer_0.vinn_IF iqmod_mfb_lpf_0.iqmod_mfb_lpf_half_0.iqmod_mfb_lpf_ota_core_hybrid_bm_half$1_0.iqmod_mfb_lpf_ota_core_tg$2_0.v_b VSS VSS sg13_lv_nmos ad=0.19p pd=1.38u as=0.19p ps=1.38u w=1u l=1u
X827 iqmod_mixer_0.vinn_IF iqmod_mixer_0.iqmod_mixer_half_0.iqmod_mixer_tg$1_0.di_tg_ctrl voutn_I_RF VSS sg13_lv_nmos ad=0.57p pd=3.38u as=0.57p ps=3.38u w=3u l=0.13u
X828 iqmod_mfb_lpf_0.iqmod_mfb_lpf_half_0.iqmod_mfb_lpf_ota_core_hybrid_bm_half$1_0.iqmod_mfb_lpf_ota_core_tg$2_0.v_a iqmod_mfb_lpf_0.iqmod_mfb_lpf_half_1.iqmod_mfb_lpf_ota_core_hybrid_bm_half$1_0.iqmod_mfb_lpf_ota_core_inv_NF20$2_1.vin VDD VDD sg13_lv_pmos ad=1.14p pd=6.38u as=1.14p ps=6.38u w=6u l=1u
X829 iqmod_mixer_0.iqmod_mixer_half_1.iqmod_mixer_se2diff$1_0.iqmod_mixer_se2diff_half_inv$2_0.iqmod_mixer_se2diff_inv_NF2$7_1.vout iqmod_mixer_0.iqmod_mixer_half_1.iqmod_mixer_se2diff$1_0.iqmod_mixer_se2diff_half_tg$2_0.iqmod_mixer_se2diff_tg_NF6$3_0.v_b VDD VDD sg13_lv_pmos ad=0.57p pd=3.38u as=0.57p ps=3.38u w=3u l=0.13u
X830 iqmod_spdt_switch_0.v_c iqmod_spdt_switch_0.spdt_switch_inv_0.vout di_ds_I_n VDD sg13_lv_pmos ad=1.14p pd=6.38u as=1.14p ps=6.38u w=6u l=0.13u
X831 VDD iqmod_mfb_lpf_0.iqmod_mfb_lpf_half_0.iqmod_mfb_lpf_ota_core_hybrid_bm_half$1_0.iqmod_mfb_lpf_ota_core_tg$2_0.v_a iqmod_mfb_lpf_0.iqmod_mfb_lpf_half_0.iqmod_mfb_lpf_ota_core_hybrid_bm_half$1_0.iqmod_mfb_lpf_ota_core_tg$2_0.v_b VDD sg13_lv_pmos ad=1.14p pd=6.38u as=1.14p ps=6.38u w=6u l=1u
X832 VDD iqmod_mixer_0.iqmod_mixer_half_0.iqmod_mixer_se2diff$1_0.iqmod_mixer_se2diff_half_inv$2_0.iqmod_mixer_se2diff_inv_NF18$7_0.vin iqmod_mixer_0.iqmod_mixer_half_0.iqmod_mixer_se2diff$1_0.iqmod_mixer_se2diff_half_inv$2_0.iqmod_mixer_se2diff_inv_NF54$7_0.vin VDD sg13_lv_pmos ad=0.57p pd=3.38u as=0.57p ps=3.38u w=3u l=0.13u
X833 VDD VDD VDD VDD sg13_lv_pmos ad=0.57p pd=3.38u as=0 ps=0 w=3u l=0.13u
X834 iqmod_mixer_0.vinp_IF iqmod_mixer_0.iqmod_mixer_half_1.iqmod_mixer_tg$1_0.di_tg_ctrl_n voutp_I_RF VDD sg13_lv_pmos ad=1.71p pd=9.38u as=1.71p ps=9.38u w=9u l=0.13u
X835 iqmod_mixer_0.vinn_IF iqmod_mixer_0.iqmod_mixer_half_0.iqmod_mixer_tg$1_0.di_tg_ctrl_n voutn_I_RF VDD sg13_lv_pmos ad=1.71p pd=9.38u as=1.71p ps=9.38u w=9u l=0.13u
X836 VDD iqmod_mixer_0.iqmod_mixer_half_1.iqmod_mixer_se2diff$1_0.iqmod_mixer_se2diff_half_tg$2_0.iqmod_mixer_se2diff_tg_NF6$3_0.v_b iqmod_mixer_0.iqmod_mixer_half_1.iqmod_mixer_se2diff$1_0.iqmod_mixer_se2diff_half_inv$2_0.iqmod_mixer_se2diff_inv_NF2$7_1.vout VDD sg13_lv_pmos ad=0.57p pd=3.38u as=0.57p ps=3.38u w=3u l=0.13u
X837 iqmod_mixer_0.iqmod_mixer_half_0.iqmod_mixer_tg$1_0.di_tg_ctrl iqmod_mixer_0.iqmod_mixer_half_0.iqmod_mixer_se2diff$1_0.iqmod_mixer_se2diff_half_inv$2_0.iqmod_mixer_se2diff_inv_NF54$7_0.vin VSS VSS sg13_lv_nmos ad=0.19p pd=1.38u as=0.19p ps=1.38u w=1u l=0.13u
X838 VDD iqmod_mixer_0.iqmod_mixer_half_1.iqmod_mixer_se2diff$1_0.iqmod_mixer_se2diff_half_inv$2_0.iqmod_mixer_se2diff_inv_NF18$7_0.vin iqmod_mixer_0.iqmod_mixer_half_1.iqmod_mixer_se2diff$1_0.iqmod_mixer_se2diff_half_inv$2_0.iqmod_mixer_se2diff_inv_NF54$7_0.vin VDD sg13_lv_pmos ad=0.57p pd=3.38u as=0.57p ps=3.38u w=3u l=0.13u
X839 iqmod_mixer_0.iqmod_mixer_half_1.iqmod_mixer_tg$1_0.di_tg_ctrl iqmod_mixer_0.iqmod_mixer_half_1.iqmod_mixer_se2diff$1_0.iqmod_mixer_se2diff_half_inv$2_0.iqmod_mixer_se2diff_inv_NF54$7_0.vin VDD VDD sg13_lv_pmos ad=0.57p pd=3.38u as=0.57p ps=3.38u w=3u l=0.13u
X840 iqmod_mixer_0.vinn_IF iqmod_mfb_lpf_0.iqmod_mfb_lpf_half_0.iqmod_mfb_lpf_ota_core_hybrid_bm_half$1_0.iqmod_mfb_lpf_ota_core_inv_NF20$2_1.vin VDD VDD sg13_lv_pmos ad=1.14p pd=6.38u as=1.14p ps=6.38u w=6u l=1u
X841 iqmod_mfb_lpf_0.iqmod_mfb_lpf_half_0.iqmod_mfb_lpf_ota_core_hybrid_bm_half$1_0.iqmod_mfb_lpf_ota_core_inv_NF20$2_0.vout iqmod_mixer_0.vinp_IF VSS VSS sg13_lv_nmos ad=0.19p pd=1.38u as=0.19p ps=1.38u w=1u l=1u
X842 iqmod_mixer_0.iqmod_mixer_half_0.iqmod_mixer_tg$1_0.di_tg_ctrl iqmod_mixer_0.iqmod_mixer_half_0.iqmod_mixer_se2diff$1_0.iqmod_mixer_se2diff_half_inv$2_0.iqmod_mixer_se2diff_inv_NF54$7_0.vin VSS VSS sg13_lv_nmos ad=0.19p pd=1.38u as=0.19p ps=1.38u w=1u l=0.13u
X843 iqmod_mfb_lpf_0.iqmod_mfb_lpf_half_0.iqmod_mfb_lpf_ota_core_hybrid_bm_half$1_0.iqmod_mfb_lpf_ota_core_tg$2_0.v_b iqmod_mfb_lpf_0.iqmod_mfb_lpf_half_0.iqmod_mfb_lpf_ota_core_hybrid_bm_half$1_0.iqmod_mfb_lpf_ota_core_inv_NF6$2_1.vout VSS VSS sg13_lv_nmos ad=0.19p pd=1.38u as=0.19p ps=1.38u w=1u l=1u
X844 VSS iqmod_mixer_0.iqmod_mixer_half_0.iqmod_mixer_se2diff$1_0.iqmod_mixer_se2diff_half_inv$2_0.iqmod_mixer_se2diff_inv_NF54$7_0.vin iqmod_mixer_0.iqmod_mixer_half_0.iqmod_mixer_tg$1_0.di_tg_ctrl VSS sg13_lv_nmos ad=0.19p pd=1.38u as=0.19p ps=1.38u w=1u l=0.13u
X845 VSS iqmod_mixer_0.iqmod_mixer_half_0.iqmod_mixer_se2diff$1_0.iqmod_mixer_se2diff_half_tg$2_0.iqmod_mixer_se2diff_inv_NF18$6_0.vin iqmod_mixer_0.iqmod_mixer_half_0.iqmod_mixer_se2diff$1_0.iqmod_mixer_se2diff_half_tg$2_0.iqmod_mixer_se2diff_inv_NF54$6_0.vin VSS sg13_lv_nmos ad=0.19p pd=1.38u as=0.19p ps=1.38u w=1u l=0.13u
X846 iqmod_mixer_0.iqmod_mixer_half_1.iqmod_mixer_se2diff$1_0.iqmod_mixer_se2diff_half_inv$2_0.iqmod_mixer_se2diff_inv_NF6$7_1.vin iqmod_mixer_0.iqmod_mixer_half_1.iqmod_mixer_se2diff$1_0.iqmod_mixer_se2diff_half_inv$2_0.iqmod_mixer_se2diff_inv_NF6$7_0.vout VSS VSS sg13_lv_nmos ad=0.19p pd=1.38u as=0.19p ps=1.38u w=1u l=0.13u
X847 VDD iqmod_mixer_0.iqmod_mixer_half_0.iqmod_mixer_se2diff$1_0.iqmod_mixer_se2diff_half_tg$2_0.iqmod_mixer_se2diff_inv_NF54$6_0.vin iqmod_mixer_0.iqmod_mixer_half_0.iqmod_mixer_tg$1_0.di_tg_ctrl_n VDD sg13_lv_pmos ad=0.57p pd=3.38u as=0.57p ps=3.38u w=3u l=0.13u
X848 VSS iqmod_mixer_0.iqmod_mixer_half_1.iqmod_mixer_se2diff$1_0.iqmod_mixer_se2diff_half_inv$2_0.iqmod_mixer_se2diff_inv_NF2$7_1.vout iqmod_mixer_0.iqmod_mixer_half_1.iqmod_mixer_se2diff$1_0.iqmod_mixer_se2diff_half_tg$2_0.iqmod_mixer_se2diff_inv_NF18$6_0.vin VSS sg13_lv_nmos ad=0.19p pd=1.38u as=0.19p ps=1.38u w=1u l=0.13u
X849 iqmod_mixer_0.iqmod_mixer_half_1.iqmod_mixer_tg$1_0.di_tg_ctrl_n iqmod_mixer_0.iqmod_mixer_half_1.iqmod_mixer_se2diff$1_0.iqmod_mixer_se2diff_half_tg$2_0.iqmod_mixer_se2diff_inv_NF54$6_0.vin VSS VSS sg13_lv_nmos ad=0.19p pd=1.38u as=0.19p ps=1.38u w=1u l=0.13u
X850 VSS iqmod_mixer_0.iqmod_mixer_half_0.iqmod_mixer_se2diff$1_0.iqmod_mixer_se2diff_half_inv$2_0.iqmod_mixer_se2diff_inv_NF54$7_0.vin iqmod_mixer_0.iqmod_mixer_half_0.iqmod_mixer_tg$1_0.di_tg_ctrl VSS sg13_lv_nmos ad=0.19p pd=1.38u as=0.19p ps=1.38u w=1u l=0.13u
X851 VDD iqmod_mixer_0.iqmod_mixer_half_0.iqmod_mixer_se2diff$1_0.iqmod_mixer_se2diff_half_tg$2_0.iqmod_mixer_se2diff_inv_NF54$6_0.vin iqmod_mixer_0.iqmod_mixer_half_0.iqmod_mixer_tg$1_0.di_tg_ctrl_n VDD sg13_lv_pmos ad=0.57p pd=3.38u as=0.57p ps=3.38u w=3u l=0.13u
X852 iqmod_mfb_lpf_0.iqmod_mfb_lpf_half_1.iqmod_mfb_lpf_ota_core_hybrid_bm_half$1_0.iqmod_mfb_lpf_ota_core_inv_NF20$2_1.vin iqmod_mfb_lpf_0.iqmod_mfb_lpf_half_1.iqmod_mfb_lpf_ota_core_hybrid_bm_half$1_0.iqmod_mfb_lpf_ota_core_tg$2_0.di_tg_ctrl_n iqmod_spdt_switch_0.v_c VDD sg13_lv_pmos ad=1.14p pd=6.38u as=2.04p ps=12.68u w=6u l=0.13u
X853 iqmod_mixer_0.iqmod_mixer_half_0.iqmod_mixer_se2diff$1_0.iqmod_mixer_se2diff_half_inv$2_0.iqmod_mixer_se2diff_inv_NF6$7_1.vin iqmod_mixer_0.iqmod_mixer_half_0.iqmod_mixer_se2diff$1_0.iqmod_mixer_se2diff_half_inv$2_0.iqmod_mixer_se2diff_inv_NF6$7_0.vout VDD VDD sg13_lv_pmos ad=0.57p pd=3.38u as=0.57p ps=3.38u w=3u l=0.13u
X854 voutn_I_RF iqmod_mixer_0.iqmod_mixer_half_0.iqmod_mixer_tg$1_0.di_tg_ctrl voutn_I_RF VDD sg13_lv_pmos ad=1.71p pd=9.38u as=0 ps=0 w=9u l=0.13u
X855 iqmod_mfb_lpf_0.iqmod_mfb_lpf_half_1.iqmod_mfb_lpf_ota_core_hybrid_bm_half$1_0.iqmod_mfb_lpf_ota_core_spdt_switch$2_0.iqmod_mfb_lpf_ota_core_spdt_switch_inv$3_0.vout iqmod_mfb_lpf_0.iqmod_mfb_lpf_half_1.iqmod_mfb_lpf_ota_core_hybrid_bm_half$1_0.iqmod_mfb_lpf_ota_core_tg$2_0.di_tg_ctrl_n VDD VDD sg13_lv_pmos ad=1.14p pd=6.38u as=1.14p ps=6.38u w=6u l=0.13u
X856 iqmod_mixer_0.vinp_IF iqmod_mfb_lpf_0.iqmod_mfb_lpf_half_1.iqmod_mfb_lpf_ota_core_hybrid_bm_half$1_0.iqmod_mfb_lpf_ota_core_inv_NF20$2_1.vin VDD VDD sg13_lv_pmos ad=1.14p pd=6.38u as=1.14p ps=6.38u w=6u l=1u
X857 iqmod_mixer_0.iqmod_mixer_half_0.iqmod_mixer_se2diff$1_0.iqmod_mixer_se2diff_half_tg$2_0.iqmod_mixer_se2diff_inv_NF54$6_0.vin iqmod_mixer_0.iqmod_mixer_half_0.iqmod_mixer_se2diff$1_0.iqmod_mixer_se2diff_half_tg$2_0.iqmod_mixer_se2diff_inv_NF18$6_0.vin VSS VSS sg13_lv_nmos ad=0.19p pd=1.38u as=0.19p ps=1.38u w=1u l=0.13u
X858 VSS iqmod_mixer_0.iqmod_mixer_half_1.iqmod_mixer_se2diff$1_0.iqmod_mixer_se2diff_half_inv$2_0.iqmod_mixer_se2diff_inv_NF6$7_0.vout iqmod_mixer_0.iqmod_mixer_half_1.iqmod_mixer_se2diff$1_0.iqmod_mixer_se2diff_half_inv$2_0.iqmod_mixer_se2diff_inv_NF6$7_1.vin VSS sg13_lv_nmos ad=0.19p pd=1.38u as=0.19p ps=1.38u w=1u l=0.13u
X859 VDD iqmod_mfb_lpf_0.iqmod_mfb_lpf_half_0.iqmod_mfb_lpf_ota_core_hybrid_bm_half$1_0.iqmod_mfb_lpf_ota_core_tg$2_0.di_tg_ctrl_n iqmod_mfb_lpf_0.iqmod_mfb_lpf_half_0.iqmod_mfb_lpf_ota_core_hybrid_bm_half$1_0.iqmod_mfb_lpf_ota_core_inv_NF20$2_1.vin VSS sg13_lv_nmos ad=0.19p pd=1.38u as=0.19p ps=1.38u w=1u l=0.13u
X860 VDD iqmod_mixer_0.iqmod_mixer_half_0.iqmod_mixer_se2diff$1_0.iqmod_mixer_se2diff_half_inv$2_0.iqmod_mixer_se2diff_inv_NF2$7_1.vout iqmod_mixer_0.iqmod_mixer_half_0.iqmod_mixer_se2diff$1_0.iqmod_mixer_se2diff_half_tg$2_0.iqmod_mixer_se2diff_inv_NF18$6_0.vin VDD sg13_lv_pmos ad=0.57p pd=3.38u as=0.57p ps=3.38u w=3u l=0.13u
X861 iqmod_mixer_0.iqmod_mixer_half_0.iqmod_mixer_tg$1_0.di_tg_ctrl_n iqmod_mixer_0.iqmod_mixer_half_0.iqmod_mixer_se2diff$1_0.iqmod_mixer_se2diff_half_tg$2_0.iqmod_mixer_se2diff_inv_NF54$6_0.vin VDD VDD sg13_lv_pmos ad=0.57p pd=3.38u as=0.57p ps=3.38u w=3u l=0.13u
X862 iqmod_mixer_0.iqmod_mixer_half_1.iqmod_mixer_se2diff$1_0.iqmod_mixer_se2diff_half_tg$2_0.iqmod_mixer_se2diff_inv_NF18$6_0.vin iqmod_mixer_0.iqmod_mixer_half_1.iqmod_mixer_se2diff$1_0.iqmod_mixer_se2diff_half_inv$2_0.iqmod_mixer_se2diff_inv_NF2$7_1.vout VSS VSS sg13_lv_nmos ad=0.19p pd=1.38u as=0.19p ps=1.38u w=1u l=0.13u
X863 VDD iqmod_mfb_lpf_0.iqmod_mfb_lpf_half_0.iqmod_mfb_lpf_ota_core_hybrid_bm_half$1_0.iqmod_mfb_lpf_ota_core_inv_NF20$2_1.vin iqmod_mixer_0.vinn_IF VDD sg13_lv_pmos ad=1.14p pd=6.38u as=1.14p ps=6.38u w=6u l=1u
X864 VSS iqmod_mixer_0.vinn_IF iqmod_mfb_lpf_0.iqmod_mfb_lpf_half_0.iqmod_mfb_lpf_ota_core_hybrid_bm_half$1_0.iqmod_mfb_lpf_ota_core_inv_NF20$2_0.vout VSS sg13_lv_nmos ad=0.19p pd=1.38u as=0.19p ps=1.38u w=1u l=1u
X865 iqmod_mixer_0.vinn_IF iqmod_mfb_lpf_0.iqmod_mfb_lpf_half_0.iqmod_mfb_lpf_ota_core_hybrid_bm_half$1_0.iqmod_mfb_lpf_ota_core_inv_NF20$2_1.vin VSS VSS sg13_lv_nmos ad=0.19p pd=1.38u as=0.19p ps=1.38u w=1u l=1u
X866 VDD iqmod_mixer_0.iqmod_mixer_half_0.iqmod_mixer_se2diff$1_0.iqmod_mixer_se2diff_half_inv$2_0.iqmod_mixer_se2diff_inv_NF6$7_0.vout iqmod_mixer_0.iqmod_mixer_half_0.iqmod_mixer_se2diff$1_0.iqmod_mixer_se2diff_half_inv$2_0.iqmod_mixer_se2diff_inv_NF6$7_1.vin VDD sg13_lv_pmos ad=0.57p pd=3.38u as=0.57p ps=3.38u w=3u l=0.13u
X867 VSS iqmod_mfb_lpf_0.iqmod_mfb_lpf_half_0.iqmod_mfb_lpf_ota_core_hybrid_bm_half$1_0.iqmod_mfb_lpf_ota_core_inv_NF6$2_1.vout iqmod_mfb_lpf_0.iqmod_mfb_lpf_half_0.iqmod_mfb_lpf_ota_core_hybrid_bm_half$1_0.iqmod_mfb_lpf_ota_core_tg$2_0.v_b VSS sg13_lv_nmos ad=0.19p pd=1.38u as=0.19p ps=1.38u w=1u l=1u
X868 VDD iqmod_mixer_0.iqmod_mixer_half_1.iqmod_mixer_se2diff$1_0.iqmod_mixer_se2diff_half_tg$2_0.iqmod_mixer_se2diff_inv_NF54$6_0.vin iqmod_mixer_0.iqmod_mixer_half_1.iqmod_mixer_tg$1_0.di_tg_ctrl_n VDD sg13_lv_pmos ad=0.57p pd=3.38u as=0.57p ps=3.38u w=3u l=0.13u
X869 iqmod_mfb_lpf_0.iqmod_mfb_lpf_half_0.C1_half iqmod_mfb_lpf_0.iqmod_mfb_lpf_half_0.iqmod_mfb_lpf_R1$1_0.v_b cap_cmim l=8u w=8u
X870 iqmod_mixer_0.vinp_IF iqmod_mixer_0.iqmod_mixer_half_1.iqmod_mixer_tg$1_0.di_tg_ctrl_n voutp_I_RF VDD sg13_lv_pmos ad=1.71p pd=9.38u as=1.71p ps=9.38u w=9u l=0.13u
X871 voutn_I_RF iqmod_mixer_0.iqmod_mixer_half_0.iqmod_mixer_tg$1_0.di_tg_ctrl iqmod_mixer_0.vinn_IF VSS sg13_lv_nmos ad=0.57p pd=3.38u as=0.57p ps=3.38u w=3u l=0.13u
X872 voutp_I_RF iqmod_mixer_0.iqmod_mixer_half_1.iqmod_mixer_tg$1_0.di_tg_ctrl iqmod_mixer_0.vinp_IF VSS sg13_lv_nmos ad=0.57p pd=3.38u as=0.57p ps=3.38u w=3u l=0.13u
X873 iqmod_mfb_lpf_0.iqmod_mfb_lpf_half_0.iqmod_mfb_lpf_ota_core_hybrid_bm_half$1_0.iqmod_mfb_lpf_ota_core_tg$2_0.di_tg_ctrl_n di_analog_en VSS VSS sg13_lv_nmos ad=0.19p pd=1.38u as=0.19p ps=1.38u w=1u l=0.13u
X874 VDD iqmod_mfb_lpf_0.iqmod_mfb_lpf_half_1.iqmod_mfb_lpf_ota_core_hybrid_bm_half$1_0.iqmod_mfb_lpf_ota_core_inv_NF20$2_1.vin iqmod_mixer_0.vinp_IF VDD sg13_lv_pmos ad=1.14p pd=6.38u as=1.14p ps=6.38u w=6u l=1u
X875 iqmod_mixer_0.iqmod_mixer_half_1.iqmod_mixer_tg$1_0.di_tg_ctrl_n iqmod_mixer_0.iqmod_mixer_half_1.iqmod_mixer_se2diff$1_0.iqmod_mixer_se2diff_half_tg$2_0.iqmod_mixer_se2diff_inv_NF54$6_0.vin VDD VDD sg13_lv_pmos ad=0.57p pd=3.38u as=0.57p ps=3.38u w=3u l=0.13u
X876 VDD VDD VDD VDD sg13_lv_pmos ad=1.14p pd=6.38u as=0 ps=0 w=6u l=1u
X877 VDD VDD VDD VDD sg13_lv_pmos ad=1.14p pd=6.38u as=0 ps=0 w=6u l=0.13u
X878 voutp_I_RF iqmod_mixer_0.iqmod_mixer_half_1.iqmod_mixer_tg$1_0.di_tg_ctrl_n voutp_I_RF VSS sg13_lv_nmos ad=0.57p pd=3.38u as=0 ps=0 w=3u l=0.13u
X879 VSS VSS VSS VSS sg13_lv_nmos ad=0.19p pd=1.38u as=0 ps=0 w=1u l=1u
X880 VSS iqmod_mfb_lpf_0.iqmod_mfb_lpf_half_0.iqmod_mfb_lpf_ota_core_hybrid_bm_half$1_0.iqmod_mfb_lpf_ota_core_inv_NF20$2_1.vin iqmod_mixer_0.vinn_IF VSS sg13_lv_nmos ad=0.19p pd=1.38u as=0.19p ps=1.38u w=1u l=1u
X881 iqmod_mixer_0.vinp_IF iqmod_mixer_0.iqmod_mixer_half_1.iqmod_mixer_tg$1_0.di_tg_ctrl voutp_I_RF VSS sg13_lv_nmos ad=0.57p pd=3.38u as=0.57p ps=3.38u w=3u l=0.13u
X882 VSS VSS VSS VSS sg13_lv_nmos ad=0.19p pd=1.38u as=0 ps=0 w=1u l=0.13u
X883 VSS iqmod_mixer_0.iqmod_mixer_half_0.iqmod_mixer_se2diff$1_0.iqmod_mixer_se2diff_half_tg$2_0.iqmod_mixer_se2diff_tg_NF6$3_0.v_b iqmod_mixer_0.iqmod_mixer_half_0.iqmod_mixer_se2diff$1_0.iqmod_mixer_se2diff_half_inv$2_0.iqmod_mixer_se2diff_inv_NF2$7_1.vout VSS sg13_lv_nmos ad=0.19p pd=1.38u as=0.19p ps=1.38u w=1u l=0.13u
X884 VSS VSS VSS VSS sg13_lv_nmos ad=0.19p pd=1.38u as=0 ps=0 w=1u l=1u
X885 VDD iqmod_mixer_0.iqmod_mixer_half_1.iqmod_mixer_se2diff$1_0.iqmod_mixer_se2diff_half_tg$2_0.iqmod_mixer_se2diff_inv_NF54$6_0.vin iqmod_mixer_0.iqmod_mixer_half_1.iqmod_mixer_tg$1_0.di_tg_ctrl_n VDD sg13_lv_pmos ad=0.57p pd=3.38u as=0.57p ps=3.38u w=3u l=0.13u
X886 iqmod_mixer_0.iqmod_mixer_half_0.iqmod_mixer_tg$1_0.di_tg_ctrl_n iqmod_mixer_0.iqmod_mixer_half_0.iqmod_mixer_se2diff$1_0.iqmod_mixer_se2diff_half_tg$2_0.iqmod_mixer_se2diff_inv_NF54$6_0.vin VSS VSS sg13_lv_nmos ad=0.19p pd=1.38u as=0.19p ps=1.38u w=1u l=0.13u
X887 iqmod_mixer_0.iqmod_mixer_half_0.iqmod_mixer_se2diff$1_0.iqmod_mixer_se2diff_half_inv$2_0.iqmod_mixer_se2diff_inv_NF18$7_0.vin iqmod_mixer_0.iqmod_mixer_half_0.iqmod_mixer_se2diff$1_0.iqmod_mixer_se2diff_half_inv$2_0.iqmod_mixer_se2diff_inv_NF6$7_1.vin VSS VSS sg13_lv_nmos ad=0.19p pd=1.38u as=0.19p ps=1.38u w=1u l=0.13u
X888 iqmod_mixer_0.iqmod_mixer_half_1.iqmod_mixer_se2diff$1_0.iqmod_mixer_se2diff_half_inv$2_0.iqmod_mixer_se2diff_inv_NF6$7_0.vin VDD iqmod_mixer_0.iqmod_mixer_half_1.iqmod_mixer_se2diff$1_0.iqmod_mixer_se2diff_half_tg$2_0.iqmod_mixer_se2diff_tg_NF6$3_0.v_b VSS sg13_lv_nmos ad=0.19p pd=1.38u as=0.19p ps=1.38u w=1u l=0.13u
X889 iqmod_mfb_lpf_0.iqmod_mfb_lpf_half_0.iqmod_mfb_lpf_ota_core_hybrid_bm_half$1_0.iqmod_mfb_lpf_ota_core_tg$2_0.v_a di_analog_en iqmod_mfb_lpf_0.iqmod_mfb_lpf_half_0.iqmod_mfb_lpf_ota_core_hybrid_bm_half$1_0.iqmod_mfb_lpf_ota_core_tg$2_0.v_b VSS sg13_lv_nmos ad=0.34p pd=2.68u as=0.19p ps=1.38u w=1u l=0.13u
X890 VSS iqmod_mixer_0.iqmod_mixer_half_1.iqmod_mixer_se2diff$1_0.iqmod_mixer_se2diff_half_inv$2_0.iqmod_mixer_se2diff_inv_NF54$7_0.vin iqmod_mixer_0.iqmod_mixer_half_1.iqmod_mixer_tg$1_0.di_tg_ctrl VSS sg13_lv_nmos ad=0.19p pd=1.38u as=0.19p ps=1.38u w=1u l=0.13u
X891 voutp_I_RF iqmod_mixer_0.iqmod_mixer_half_1.iqmod_mixer_tg$1_0.di_tg_ctrl iqmod_mixer_0.vinp_IF VSS sg13_lv_nmos ad=0.57p pd=3.38u as=0.57p ps=3.38u w=3u l=0.13u
X892 iqmod_mixer_0.iqmod_mixer_half_0.iqmod_mixer_se2diff$1_0.iqmod_mixer_se2diff_half_inv$2_0.iqmod_mixer_se2diff_inv_NF2$7_1.vout iqmod_mixer_0.iqmod_mixer_half_0.iqmod_mixer_se2diff$1_0.iqmod_mixer_se2diff_half_tg$2_0.iqmod_mixer_se2diff_tg_NF6$3_0.v_b VSS VSS sg13_lv_nmos ad=0.19p pd=1.38u as=0.19p ps=1.38u w=1u l=0.13u
X893 VSS VSS VSS rhigh l=59u w=0.5u
X894 iqmod_mixer_0.iqmod_mixer_half_0.iqmod_mixer_se2diff$1_0.iqmod_mixer_se2diff_half_inv$2_0.iqmod_mixer_se2diff_inv_NF6$7_0.vin VSS iqmod_mixer_0.iqmod_mixer_half_0.iqmod_mixer_se2diff$1_0.iqmod_mixer_se2diff_half_tg$2_0.iqmod_mixer_se2diff_tg_NF6$3_0.v_b VDD sg13_lv_pmos ad=1.02p pd=6.68u as=0.57p ps=3.38u w=3u l=0.13u
X895 VSS VSS VSS VSS sg13_lv_nmos ad=0.34p pd=2.68u as=0 ps=0 w=1u l=0.13u
X896 VDD iqmod_mixer_0.iqmod_mixer_half_0.iqmod_mixer_se2diff$1_0.iqmod_mixer_se2diff_half_inv$2_0.iqmod_mixer_se2diff_inv_NF54$7_0.vin iqmod_mixer_0.iqmod_mixer_half_0.iqmod_mixer_tg$1_0.di_tg_ctrl VDD sg13_lv_pmos ad=0.57p pd=3.38u as=0.57p ps=3.38u w=3u l=0.13u
X897 iqmod_mixer_0.iqmod_mixer_half_1.iqmod_mixer_se2diff$1_0.iqmod_mixer_se2diff_half_tg$2_0.iqmod_mixer_se2diff_tg_NF6$3_0.v_b VDD iqmod_mixer_0.iqmod_mixer_half_1.iqmod_mixer_se2diff$1_0.iqmod_mixer_se2diff_half_inv$2_0.iqmod_mixer_se2diff_inv_NF6$7_0.vin VSS sg13_lv_nmos ad=0.19p pd=1.38u as=0.34p ps=2.68u w=1u l=0.13u
X898 VSS VSS VSS VSS sg13_lv_nmos ad=0.19p pd=1.38u as=0 ps=0 w=1u l=0.13u
X899 iqmod_mixer_0.iqmod_mixer_half_1.iqmod_mixer_tg$1_0.di_tg_ctrl iqmod_mixer_0.iqmod_mixer_half_1.iqmod_mixer_se2diff$1_0.iqmod_mixer_se2diff_half_inv$2_0.iqmod_mixer_se2diff_inv_NF54$7_0.vin VSS VSS sg13_lv_nmos ad=0.19p pd=1.38u as=0.19p ps=1.38u w=1u l=0.13u
X900 iqmod_mixer_0.iqmod_mixer_half_0.iqmod_mixer_se2diff$1_0.iqmod_mixer_se2diff_half_tg$2_0.iqmod_mixer_se2diff_tg_NF6$3_0.v_b VSS iqmod_mixer_0.iqmod_mixer_half_0.iqmod_mixer_se2diff$1_0.iqmod_mixer_se2diff_half_inv$2_0.iqmod_mixer_se2diff_inv_NF6$7_0.vin VDD sg13_lv_pmos ad=0.57p pd=3.38u as=0.57p ps=3.38u w=3u l=0.13u
X901 VDD iqmod_mfb_lpf_0.iqmod_mfb_lpf_half_0.iqmod_mfb_lpf_ota_core_hybrid_bm_half$1_0.iqmod_mfb_lpf_ota_core_tg$2_0.v_a iqmod_mfb_lpf_0.iqmod_mfb_lpf_half_0.iqmod_mfb_lpf_ota_core_hybrid_bm_half$1_0.iqmod_mfb_lpf_ota_core_tg$2_0.v_b VDD sg13_lv_pmos ad=1.14p pd=6.38u as=1.14p ps=6.38u w=6u l=1u
X902 iqmod_mixer_0.iqmod_mixer_half_0.iqmod_mixer_tg$1_0.di_tg_ctrl iqmod_mixer_0.iqmod_mixer_half_0.iqmod_mixer_se2diff$1_0.iqmod_mixer_se2diff_half_inv$2_0.iqmod_mixer_se2diff_inv_NF54$7_0.vin VDD VDD sg13_lv_pmos ad=0.57p pd=3.38u as=0.57p ps=3.38u w=3u l=0.13u
X903 VDD iqmod_mfb_lpf_0.iqmod_mfb_lpf_half_0.iqmod_mfb_lpf_ota_core_hybrid_bm_half$1_0.iqmod_mfb_lpf_ota_core_tg$2_0.v_b iqmod_mixer_0.vinp_IF VDD sg13_lv_pmos ad=1.14p pd=6.38u as=1.14p ps=6.38u w=6u l=1u
X904 VSS VSS VSS VSS sg13_lv_nmos ad=0.34p pd=2.68u as=0 ps=0 w=1u l=0.13u
X905 VSS iqmod_mixer_0.iqmod_mixer_half_1.iqmod_mixer_se2diff$1_0.iqmod_mixer_se2diff_half_inv$2_0.iqmod_mixer_se2diff_inv_NF54$7_0.vin iqmod_mixer_0.iqmod_mixer_half_1.iqmod_mixer_tg$1_0.di_tg_ctrl VSS sg13_lv_nmos ad=0.19p pd=1.38u as=0.19p ps=1.38u w=1u l=0.13u
X906 VDD iqmod_mixer_0.iqmod_mixer_half_1.iqmod_mixer_se2diff$1_0.iqmod_mixer_se2diff_half_inv$2_0.iqmod_mixer_se2diff_inv_NF54$7_0.vin iqmod_mixer_0.iqmod_mixer_half_1.iqmod_mixer_tg$1_0.di_tg_ctrl VDD sg13_lv_pmos ad=0.57p pd=3.38u as=0.57p ps=3.38u w=3u l=0.13u
X907 VSS iqmod_mixer_0.iqmod_mixer_half_1.iqmod_mixer_se2diff$1_0.iqmod_mixer_se2diff_half_tg$2_0.iqmod_mixer_se2diff_inv_NF54$6_0.vin iqmod_mixer_0.iqmod_mixer_half_1.iqmod_mixer_tg$1_0.di_tg_ctrl_n VSS sg13_lv_nmos ad=0.19p pd=1.38u as=0.19p ps=1.38u w=1u l=0.13u
X908 VSS iqmod_mfb_lpf_0.iqmod_mfb_lpf_half_0.iqmod_mfb_lpf_ota_core_hybrid_bm_half$1_0.iqmod_mfb_lpf_ota_core_inv_NF20$2_0.vout iqmod_mfb_lpf_0.iqmod_mfb_lpf_half_0.iqmod_mfb_lpf_ota_core_hybrid_bm_half$1_0.iqmod_mfb_lpf_ota_core_inv_NF6$2_1.vout VSS sg13_lv_nmos ad=0.19p pd=1.38u as=0.19p ps=1.38u w=1u l=1u
X909 VSS iqmod_mfb_lpf_0.iqmod_mfb_lpf_half_0.iqmod_mfb_lpf_ota_core_hybrid_bm_half$1_0.iqmod_mfb_lpf_ota_core_tg$2_0.v_b iqmod_mixer_0.vinp_IF VSS sg13_lv_nmos ad=0.19p pd=1.38u as=0.19p ps=1.38u w=1u l=1u
X910 iqmod_mfb_lpf_0.iqmod_mfb_lpf_half_0.iqmod_mfb_lpf_ota_core_hybrid_bm_half$1_0.iqmod_mfb_lpf_ota_core_inv_NF20$2_1.vin iqmod_mfb_lpf_0.iqmod_mfb_lpf_half_0.iqmod_mfb_lpf_ota_core_hybrid_bm_half$1_0.iqmod_mfb_lpf_ota_core_tg$2_0.di_tg_ctrl_n iqmod_spdt_switch_1.v_c VDD sg13_lv_pmos ad=1.14p pd=6.38u as=1.14p ps=6.38u w=6u l=0.13u
X911 VDD iqmod_mixer_0.iqmod_mixer_half_0.iqmod_mixer_se2diff$1_0.iqmod_mixer_se2diff_half_inv$2_0.iqmod_mixer_se2diff_inv_NF54$7_0.vin iqmod_mixer_0.iqmod_mixer_half_0.iqmod_mixer_tg$1_0.di_tg_ctrl VDD sg13_lv_pmos ad=0.57p pd=3.38u as=0.57p ps=3.38u w=3u l=0.13u
X912 voutp_I_RF iqmod_mixer_0.iqmod_mixer_half_1.iqmod_mixer_tg$1_0.di_tg_ctrl_n voutp_I_RF VSS sg13_lv_nmos ad=0.57p pd=3.38u as=0 ps=0 w=3u l=0.13u
X913 VDD iqmod_mixer_0.iqmod_mixer_half_0.iqmod_mixer_se2diff$1_0.iqmod_mixer_se2diff_half_tg$2_0.iqmod_mixer_se2diff_inv_NF54$6_0.vin iqmod_mixer_0.iqmod_mixer_half_0.iqmod_mixer_tg$1_0.di_tg_ctrl_n VDD sg13_lv_pmos ad=0.57p pd=3.38u as=0.57p ps=3.38u w=3u l=0.13u
X914 iqmod_mixer_0.iqmod_mixer_half_1.iqmod_mixer_tg$1_0.di_tg_ctrl_n iqmod_mixer_0.iqmod_mixer_half_1.iqmod_mixer_se2diff$1_0.iqmod_mixer_se2diff_half_tg$2_0.iqmod_mixer_se2diff_inv_NF54$6_0.vin VSS VSS sg13_lv_nmos ad=0.19p pd=1.38u as=0.19p ps=1.38u w=1u l=0.13u
X915 VDD iqmod_mixer_0.iqmod_mixer_half_1.iqmod_mixer_se2diff$1_0.iqmod_mixer_se2diff_half_tg$2_0.iqmod_mixer_se2diff_inv_NF18$6_0.vin iqmod_mixer_0.iqmod_mixer_half_1.iqmod_mixer_se2diff$1_0.iqmod_mixer_se2diff_half_tg$2_0.iqmod_mixer_se2diff_inv_NF54$6_0.vin VDD sg13_lv_pmos ad=0.57p pd=3.38u as=0.57p ps=3.38u w=3u l=0.13u
X916 iqmod_mfb_lpf_0.iqmod_mfb_lpf_half_0.iqmod_mfb_lpf_ota_core_hybrid_bm_half$1_0.iqmod_mfb_lpf_ota_core_tg$2_0.v_a iqmod_mfb_lpf_0.iqmod_mfb_lpf_half_0.iqmod_mfb_lpf_ota_core_hybrid_bm_half$1_0.iqmod_mfb_lpf_ota_core_inv_NF20$2_1.vin VSS VSS sg13_lv_nmos ad=0.19p pd=1.38u as=0.19p ps=1.38u w=1u l=1u
X917 iqmod_mfb_lpf_0.iqmod_mfb_lpf_half_0.iqmod_mfb_lpf_ota_core_hybrid_bm_half$1_0.iqmod_mfb_lpf_ota_core_tg$2_0.v_b iqmod_mfb_lpf_0.iqmod_mfb_lpf_half_0.iqmod_mfb_lpf_ota_core_hybrid_bm_half$1_0.iqmod_mfb_lpf_ota_core_tg$2_0.v_a VDD VDD sg13_lv_pmos ad=1.14p pd=6.38u as=1.14p ps=6.38u w=6u l=1u
X918 iqmod_mixer_0.vinp_IF iqmod_mfb_lpf_0.iqmod_mfb_lpf_half_0.iqmod_mfb_lpf_ota_core_hybrid_bm_half$1_0.iqmod_mfb_lpf_ota_core_tg$2_0.v_b VDD VDD sg13_lv_pmos ad=1.14p pd=6.38u as=1.14p ps=6.38u w=6u l=1u
X919 VDD iqmod_mixer_0.iqmod_mixer_half_1.iqmod_mixer_se2diff$1_0.iqmod_mixer_se2diff_half_inv$2_0.iqmod_mixer_se2diff_inv_NF54$7_0.vin iqmod_mixer_0.iqmod_mixer_half_1.iqmod_mixer_tg$1_0.di_tg_ctrl VDD sg13_lv_pmos ad=0.57p pd=3.38u as=0.57p ps=3.38u w=3u l=0.13u
X920 iqmod_mfb_lpf_0.iqmod_mfb_lpf_half_0.iqmod_mfb_lpf_ota_core_hybrid_bm_half$1_0.iqmod_mfb_lpf_ota_core_tg$2_0.v_a di_analog_en iqmod_mfb_lpf_0.iqmod_mfb_lpf_half_0.iqmod_mfb_lpf_ota_core_hybrid_bm_half$1_0.iqmod_mfb_lpf_ota_core_tg$2_0.v_b VSS sg13_lv_nmos ad=0.19p pd=1.38u as=0.19p ps=1.38u w=1u l=0.13u
X921 VDD iqmod_mixer_0.iqmod_mixer_half_1.iqmod_mixer_se2diff$1_0.iqmod_mixer_se2diff_half_inv$2_0.iqmod_mixer_se2diff_inv_NF54$7_0.vin iqmod_mixer_0.iqmod_mixer_half_1.iqmod_mixer_tg$1_0.di_tg_ctrl VDD sg13_lv_pmos ad=0.57p pd=3.38u as=0.57p ps=3.38u w=3u l=0.13u
X922 iqmod_mixer_0.vinp_IF iqmod_mfb_lpf_0.iqmod_mfb_lpf_half_0.iqmod_mfb_lpf_ota_core_hybrid_bm_half$1_0.iqmod_mfb_lpf_ota_core_tg$2_0.v_b VSS VSS sg13_lv_nmos ad=0.19p pd=1.38u as=0.19p ps=1.38u w=1u l=1u
X923 VSS VSS VSS VSS sg13_lv_nmos ad=0.34p pd=2.68u as=0 ps=0 w=1u l=0.13u
X924 iqmod_mixer_0.iqmod_mixer_half_1.iqmod_mixer_se2diff$1_0.iqmod_mixer_se2diff_half_tg$2_0.iqmod_mixer_se2diff_inv_NF54$6_0.vin iqmod_mixer_0.iqmod_mixer_half_1.iqmod_mixer_se2diff$1_0.iqmod_mixer_se2diff_half_tg$2_0.iqmod_mixer_se2diff_inv_NF18$6_0.vin VDD VDD sg13_lv_pmos ad=0.57p pd=3.38u as=0.57p ps=3.38u w=3u l=0.13u
X925 VSS iqmod_mixer_0.iqmod_mixer_half_0.iqmod_mixer_se2diff$1_0.iqmod_mixer_se2diff_half_tg$2_0.iqmod_mixer_se2diff_inv_NF54$6_0.vin iqmod_mixer_0.iqmod_mixer_half_0.iqmod_mixer_tg$1_0.di_tg_ctrl_n VSS sg13_lv_nmos ad=0.19p pd=1.38u as=0.19p ps=1.38u w=1u l=0.13u
X926 iqmod_mixer_0.iqmod_mixer_half_1.iqmod_mixer_tg$1_0.di_tg_ctrl_n iqmod_mixer_0.iqmod_mixer_half_1.iqmod_mixer_se2diff$1_0.iqmod_mixer_se2diff_half_tg$2_0.iqmod_mixer_se2diff_inv_NF54$6_0.vin VSS VSS sg13_lv_nmos ad=0.19p pd=1.38u as=0.19p ps=1.38u w=1u l=0.13u
X927 iqmod_spdt_switch_1.v_c iqmod_spdt_switch_1.spdt_switch_inv_0.vin vinp_I VDD sg13_lv_pmos ad=1.14p pd=6.38u as=1.14p ps=6.38u w=6u l=0.13u
X928 VDD VDD VDD VDD sg13_lv_pmos ad=1.14p pd=6.38u as=0 ps=0 w=6u l=1u
X929 VSS iqmod_mfb_lpf_0.iqmod_mfb_lpf_half_0.iqmod_mfb_lpf_ota_core_hybrid_bm_half$1_0.iqmod_mfb_lpf_ota_core_inv_NF20$2_1.vin iqmod_mfb_lpf_0.iqmod_mfb_lpf_half_0.iqmod_mfb_lpf_ota_core_hybrid_bm_half$1_0.iqmod_mfb_lpf_ota_core_tg$2_0.v_a VSS sg13_lv_nmos ad=0.19p pd=1.38u as=0.19p ps=1.38u w=1u l=1u
X930 VDD iqmod_mixer_0.iqmod_mixer_half_1.iqmod_mixer_se2diff$1_0.iqmod_mixer_se2diff_half_inv$2_0.iqmod_mixer_se2diff_inv_NF54$7_0.vin iqmod_mixer_0.iqmod_mixer_half_1.iqmod_mixer_tg$1_0.di_tg_ctrl VDD sg13_lv_pmos ad=0.57p pd=3.38u as=0.57p ps=3.38u w=3u l=0.13u
X931 VSS iqmod_mixer_0.iqmod_mixer_half_1.iqmod_mixer_se2diff$1_0.iqmod_mixer_se2diff_half_inv$2_0.iqmod_mixer_se2diff_inv_NF18$7_0.vin iqmod_mixer_0.iqmod_mixer_half_1.iqmod_mixer_se2diff$1_0.iqmod_mixer_se2diff_half_inv$2_0.iqmod_mixer_se2diff_inv_NF54$7_0.vin VSS sg13_lv_nmos ad=0.19p pd=1.38u as=0.19p ps=1.38u w=1u l=0.13u
X932 voutn_I_RF iqmod_mixer_0.iqmod_mixer_half_0.iqmod_mixer_tg$1_0.di_tg_ctrl_n iqmod_mixer_0.vinn_IF VDD sg13_lv_pmos ad=1.71p pd=9.38u as=1.71p ps=9.38u w=9u l=0.13u
X933 iqmod_mixer_0.iqmod_mixer_half_0.iqmod_mixer_tg$1_0.di_tg_ctrl_n iqmod_mixer_0.iqmod_mixer_half_0.iqmod_mixer_se2diff$1_0.iqmod_mixer_se2diff_half_tg$2_0.iqmod_mixer_se2diff_inv_NF54$6_0.vin VDD VDD sg13_lv_pmos ad=0.57p pd=3.38u as=0.57p ps=3.38u w=3u l=0.13u
X934 iqmod_mfb_lpf_0.iqmod_mfb_lpf_half_0.iqmod_mfb_lpf_ota_core_hybrid_bm_half$1_0.iqmod_mfb_lpf_ota_core_tg$2_0.v_b iqmod_mfb_lpf_0.iqmod_mfb_lpf_half_0.iqmod_mfb_lpf_ota_core_hybrid_bm_half$1_0.iqmod_mfb_lpf_ota_core_tg$2_0.v_a VSS VSS sg13_lv_nmos ad=0.19p pd=1.38u as=0.19p ps=1.38u w=1u l=1u
X935 VSS iqmod_mixer_0.iqmod_mixer_half_1.iqmod_mixer_se2diff$1_0.iqmod_mixer_se2diff_half_tg$2_0.iqmod_mixer_se2diff_inv_NF54$6_0.vin iqmod_mixer_0.iqmod_mixer_half_1.iqmod_mixer_tg$1_0.di_tg_ctrl_n VSS sg13_lv_nmos ad=0.19p pd=1.38u as=0.19p ps=1.38u w=1u l=0.13u
X936 iqmod_mixer_0.iqmod_mixer_half_0.iqmod_mixer_tg$1_0.di_tg_ctrl iqmod_mixer_0.iqmod_mixer_half_0.iqmod_mixer_se2diff$1_0.iqmod_mixer_se2diff_half_inv$2_0.iqmod_mixer_se2diff_inv_NF54$7_0.vin VSS VSS sg13_lv_nmos ad=0.19p pd=1.38u as=0.19p ps=1.38u w=1u l=0.13u
X937 vinp_I iqmod_spdt_switch_1.spdt_switch_inv_0.vin iqmod_spdt_switch_1.v_c VDD sg13_lv_pmos ad=1.14p pd=6.38u as=1.14p ps=6.38u w=6u l=0.13u
X938 iqmod_mfb_lpf_0.iqmod_mfb_lpf_half_0.iqmod_mfb_lpf_ota_core_hybrid_bm_half$1_0.iqmod_mfb_lpf_ota_core_inv_NF20$2_0.vout iqmod_mixer_0.vinp_IF VSS VSS sg13_lv_nmos ad=0.19p pd=1.38u as=0.19p ps=1.38u w=1u l=1u
X939 VSS iqmod_mfb_lpf_0.iqmod_mfb_lpf_half_0.iqmod_mfb_lpf_ota_core_hybrid_bm_half$1_0.iqmod_mfb_lpf_ota_core_tg$2_0.v_b iqmod_mixer_0.vinp_IF VSS sg13_lv_nmos ad=0.19p pd=1.38u as=0.19p ps=1.38u w=1u l=1u
X940 di_ds_I_n iqmod_spdt_switch_0.spdt_switch_inv_0.vin iqmod_spdt_switch_0.v_c VSS sg13_lv_nmos ad=0.19p pd=1.38u as=0.19p ps=1.38u w=1u l=0.13u
X941 VDD VDD VDD VDD sg13_lv_pmos ad=2.04p pd=12.68u as=0 ps=0 w=6u l=1u
X942 VDD iqmod_mixer_0.iqmod_mixer_half_0.iqmod_mixer_se2diff$1_0.iqmod_mixer_se2diff_half_inv$2_0.iqmod_mixer_se2diff_inv_NF18$7_0.vin iqmod_mixer_0.iqmod_mixer_half_0.iqmod_mixer_se2diff$1_0.iqmod_mixer_se2diff_half_inv$2_0.iqmod_mixer_se2diff_inv_NF54$7_0.vin VDD sg13_lv_pmos ad=0.57p pd=3.38u as=0.57p ps=3.38u w=3u l=0.13u
X943 VSS VSS VSS VSS sg13_lv_nmos ad=0.34p pd=2.68u as=0 ps=0 w=1u l=1u
X944 iqmod_mfb_lpf_0.iqmod_mfb_lpf_half_0.iqmod_mfb_lpf_ota_core_hybrid_bm_half$1_0.iqmod_mfb_lpf_ota_core_inv_NF20$2_0.vout di_analog_en iqmod_mfb_lpf_0.iqmod_mfb_lpf_half_0.iqmod_mfb_lpf_ota_core_hybrid_bm_half$1_0.iqmod_mfb_lpf_ota_core_inv_NF6$2_1.vout VSS sg13_lv_nmos ad=0.19p pd=1.38u as=0.19p ps=1.38u w=1u l=0.13u
X945 iqmod_mixer_0.vinp_IF iqmod_mixer_0.iqmod_mixer_half_1.iqmod_mixer_tg$1_0.di_tg_ctrl_n voutp_I_RF VDD sg13_lv_pmos ad=1.71p pd=9.38u as=1.71p ps=9.38u w=9u l=0.13u
X946 iqmod_mixer_0.iqmod_mixer_half_1.iqmod_mixer_se2diff$1_0.iqmod_mixer_se2diff_half_inv$2_0.iqmod_mixer_se2diff_inv_NF54$7_0.vin iqmod_mixer_0.iqmod_mixer_half_1.iqmod_mixer_se2diff$1_0.iqmod_mixer_se2diff_half_inv$2_0.iqmod_mixer_se2diff_inv_NF18$7_0.vin VSS VSS sg13_lv_nmos ad=0.19p pd=1.38u as=0.19p ps=1.38u w=1u l=0.13u
X947 iqmod_mixer_0.vinn_IF iqmod_mixer_0.iqmod_mixer_half_0.iqmod_mixer_tg$1_0.di_tg_ctrl_n voutn_I_RF VDD sg13_lv_pmos ad=1.71p pd=9.38u as=1.71p ps=9.38u w=9u l=0.13u
X948 VSS iqmod_mixer_0.iqmod_mixer_half_0.iqmod_mixer_se2diff$1_0.iqmod_mixer_se2diff_half_inv$2_0.iqmod_mixer_se2diff_inv_NF54$7_0.vin iqmod_mixer_0.iqmod_mixer_half_0.iqmod_mixer_tg$1_0.di_tg_ctrl VSS sg13_lv_nmos ad=0.19p pd=1.38u as=0.19p ps=1.38u w=1u l=0.13u
X949 voutn_I_RF iqmod_mixer_0.iqmod_mixer_half_0.iqmod_mixer_tg$1_0.di_tg_ctrl iqmod_mixer_0.vinn_IF VSS sg13_lv_nmos ad=0.57p pd=3.38u as=0.57p ps=3.38u w=3u l=0.13u
X950 VDD iqmod_mixer_0.iqmod_mixer_half_0.iqmod_mixer_se2diff$1_0.iqmod_mixer_se2diff_half_tg$2_0.iqmod_mixer_se2diff_inv_NF54$6_0.vin iqmod_mixer_0.iqmod_mixer_half_0.iqmod_mixer_tg$1_0.di_tg_ctrl_n VDD sg13_lv_pmos ad=0.57p pd=3.38u as=0.57p ps=3.38u w=3u l=0.13u
X951 iqmod_mfb_lpf_0.iqmod_mfb_lpf_half_0.iqmod_mfb_lpf_ota_core_hybrid_bm_half$1_0.iqmod_mfb_lpf_ota_core_tg$2_0.v_a iqmod_mfb_lpf_0.iqmod_mfb_lpf_half_0.iqmod_mfb_lpf_ota_core_hybrid_bm_half$1_0.iqmod_mfb_lpf_ota_core_inv_NF20$2_1.vin VSS VSS sg13_lv_nmos ad=0.19p pd=1.38u as=0.19p ps=1.38u w=1u l=1u
X952 iqmod_mixer_0.iqmod_mixer_half_1.iqmod_mixer_tg$1_0.di_tg_ctrl_n iqmod_mixer_0.iqmod_mixer_half_1.iqmod_mixer_se2diff$1_0.iqmod_mixer_se2diff_half_tg$2_0.iqmod_mixer_se2diff_inv_NF54$6_0.vin VSS VSS sg13_lv_nmos ad=0.19p pd=1.38u as=0.19p ps=1.38u w=1u l=0.13u
X953 iqmod_mixer_0.iqmod_mixer_half_1.iqmod_mixer_tg$1_0.di_tg_ctrl_n iqmod_mixer_0.iqmod_mixer_half_1.iqmod_mixer_se2diff$1_0.iqmod_mixer_se2diff_half_tg$2_0.iqmod_mixer_se2diff_inv_NF54$6_0.vin VDD VDD sg13_lv_pmos ad=0.57p pd=3.38u as=0.57p ps=3.38u w=3u l=0.13u
X954 VDD iqmod_mixer_0.iqmod_mixer_half_1.iqmod_mixer_se2diff$1_0.iqmod_mixer_se2diff_half_inv$2_0.iqmod_mixer_se2diff_inv_NF54$7_0.vin iqmod_mixer_0.iqmod_mixer_half_1.iqmod_mixer_tg$1_0.di_tg_ctrl VDD sg13_lv_pmos ad=0.57p pd=3.38u as=0.57p ps=3.38u w=3u l=0.13u
X955 iqmod_mixer_0.iqmod_mixer_half_0.iqmod_mixer_se2diff$1_0.iqmod_mixer_se2diff_half_inv$2_0.iqmod_mixer_se2diff_inv_NF54$7_0.vin iqmod_mixer_0.iqmod_mixer_half_0.iqmod_mixer_se2diff$1_0.iqmod_mixer_se2diff_half_inv$2_0.iqmod_mixer_se2diff_inv_NF18$7_0.vin VDD VDD sg13_lv_pmos ad=0.57p pd=3.38u as=0.57p ps=3.38u w=3u l=0.13u
X956 iqmod_mixer_0.vinp_IF iqmod_mfb_lpf_0.iqmod_mfb_lpf_half_1.iqmod_mfb_lpf_ota_core_hybrid_bm_half$1_0.iqmod_mfb_lpf_ota_core_inv_NF20$2_1.vin VDD VDD sg13_lv_pmos ad=1.14p pd=6.38u as=1.14p ps=6.38u w=6u l=1u
X957 voutp_I_RF iqmod_mixer_0.iqmod_mixer_half_1.iqmod_mixer_tg$1_0.di_tg_ctrl_n iqmod_mixer_0.vinp_IF VDD sg13_lv_pmos ad=1.71p pd=9.38u as=1.71p ps=9.38u w=9u l=0.13u
X958 VSS VSS VSS rhigh l=31u w=0.5u
X959 iqmod_mixer_0.vinn_IF iqmod_mixer_0.iqmod_mixer_half_0.iqmod_mixer_tg$1_0.di_tg_ctrl voutn_I_RF VSS sg13_lv_nmos ad=0.57p pd=3.38u as=0.57p ps=3.38u w=3u l=0.13u
X960 voutp_I_RF iqmod_mixer_0.iqmod_mixer_half_1.iqmod_mixer_tg$1_0.di_tg_ctrl_n voutp_I_RF VSS sg13_lv_nmos ad=0.57p pd=3.38u as=0 ps=0 w=3u l=0.13u
X961 iqmod_mixer_0.iqmod_mixer_half_0.iqmod_mixer_tg$1_0.di_tg_ctrl_n iqmod_mixer_0.iqmod_mixer_half_0.iqmod_mixer_se2diff$1_0.iqmod_mixer_se2diff_half_tg$2_0.iqmod_mixer_se2diff_inv_NF54$6_0.vin VDD VDD sg13_lv_pmos ad=0.57p pd=3.38u as=0.57p ps=3.38u w=3u l=0.13u
X962 iqmod_mfb_lpf_0.iqmod_mfb_lpf_half_0.iqmod_mfb_lpf_ota_core_hybrid_bm_half$1_0.iqmod_mfb_lpf_ota_core_inv_NF20$2_0.vout iqmod_mixer_0.vinn_IF VDD VDD sg13_lv_pmos ad=1.14p pd=6.38u as=1.14p ps=6.38u w=6u l=1u
X963 VSS VSS VSS VSS sg13_lv_nmos ad=0.19p pd=1.38u as=0 ps=0 w=1u l=0.13u
X964 VSS iqmod_mixer_0.iqmod_mixer_half_0.iqmod_mixer_se2diff$1_0.iqmod_mixer_se2diff_half_inv$2_0.iqmod_mixer_se2diff_inv_NF54$7_0.vin iqmod_mixer_0.iqmod_mixer_half_0.iqmod_mixer_tg$1_0.di_tg_ctrl VSS sg13_lv_nmos ad=0.19p pd=1.38u as=0.19p ps=1.38u w=1u l=0.13u
X965 iqmod_mfb_lpf_0.iqmod_mfb_lpf_half_0.iqmod_mfb_lpf_ota_core_hybrid_bm_half$1_0.iqmod_mfb_lpf_ota_core_inv_NF20$2_0.vout iqmod_mixer_0.vinn_IF VSS VSS sg13_lv_nmos ad=0.19p pd=1.38u as=0.19p ps=1.38u w=1u l=1u
X966 iqmod_mfb_lpf_0.iqmod_mfb_lpf_half_0.iqmod_mfb_lpf_ota_core_hybrid_bm_half$1_0.iqmod_mfb_lpf_ota_core_tg$2_0.v_b di_analog_en iqmod_mfb_lpf_0.iqmod_mfb_lpf_half_0.iqmod_mfb_lpf_ota_core_hybrid_bm_half$1_0.iqmod_mfb_lpf_ota_core_tg$2_0.v_a VSS sg13_lv_nmos ad=0.19p pd=1.38u as=0.19p ps=1.38u w=1u l=0.13u
X967 VDD iqmod_mixer_0.iqmod_mixer_half_1.iqmod_mixer_se2diff$1_0.iqmod_mixer_se2diff_half_inv$2_0.iqmod_mixer_se2diff_inv_NF54$7_0.vin iqmod_mixer_0.iqmod_mixer_half_1.iqmod_mixer_tg$1_0.di_tg_ctrl VDD sg13_lv_pmos ad=0.57p pd=3.38u as=0.57p ps=3.38u w=3u l=0.13u
X968 VSS VSS VSS VSS sg13_lv_nmos ad=0.34p pd=2.68u as=0 ps=0 w=1u l=0.13u
X969 VSS iqmod_mfb_lpf_0.iqmod_mfb_lpf_half_0.iqmod_mfb_lpf_ota_core_hybrid_bm_half$1_0.iqmod_mfb_lpf_ota_core_inv_NF20$2_1.vin iqmod_mfb_lpf_0.iqmod_mfb_lpf_half_0.iqmod_mfb_lpf_ota_core_hybrid_bm_half$1_0.iqmod_mfb_lpf_ota_core_tg$2_0.v_a VSS sg13_lv_nmos ad=0.19p pd=1.38u as=0.19p ps=1.38u w=1u l=1u
X970 iqmod_mixer_0.iqmod_mixer_half_0.iqmod_mixer_se2diff$1_0.iqmod_mixer_se2diff_half_tg$2_0.iqmod_mixer_se2diff_inv_NF54$6_0.vin iqmod_mixer_0.iqmod_mixer_half_0.iqmod_mixer_se2diff$1_0.iqmod_mixer_se2diff_half_tg$2_0.iqmod_mixer_se2diff_inv_NF18$6_0.vin VSS VSS sg13_lv_nmos ad=0.19p pd=1.38u as=0.19p ps=1.38u w=1u l=0.13u
X971 iqmod_mixer_0.iqmod_mixer_half_0.iqmod_mixer_tg$1_0.di_tg_ctrl iqmod_mixer_0.iqmod_mixer_half_0.iqmod_mixer_se2diff$1_0.iqmod_mixer_se2diff_half_inv$2_0.iqmod_mixer_se2diff_inv_NF54$7_0.vin VSS VSS sg13_lv_nmos ad=0.19p pd=1.38u as=0.19p ps=1.38u w=1u l=0.13u
X972 VDD iqmod_mfb_lpf_0.iqmod_mfb_lpf_half_1.iqmod_mfb_lpf_ota_core_hybrid_bm_half$1_0.iqmod_mfb_lpf_ota_core_inv_NF20$2_1.vin iqmod_mixer_0.vinp_IF VDD sg13_lv_pmos ad=1.14p pd=6.38u as=1.14p ps=6.38u w=6u l=1u
X973 iqmod_mixer_0.iqmod_mixer_half_1.iqmod_mixer_tg$1_0.di_tg_ctrl iqmod_mixer_0.iqmod_mixer_half_1.iqmod_mixer_se2diff$1_0.iqmod_mixer_se2diff_half_inv$2_0.iqmod_mixer_se2diff_inv_NF54$7_0.vin VSS VSS sg13_lv_nmos ad=0.19p pd=1.38u as=0.19p ps=1.38u w=1u l=0.13u
X974 iqmod_mfb_lpf_0.iqmod_mfb_lpf_half_0.iqmod_mfb_lpf_ota_core_hybrid_bm_half$1_0.iqmod_mfb_lpf_ota_core_inv_NF20$2_0.vout iqmod_mixer_0.vinp_IF VSS VSS sg13_lv_nmos ad=0.19p pd=1.38u as=0.19p ps=1.38u w=1u l=1u
X975 VSS iqmod_mixer_0.iqmod_mixer_half_0.iqmod_mixer_se2diff$1_0.iqmod_mixer_se2diff_half_tg$2_0.iqmod_mixer_se2diff_inv_NF18$6_0.vin iqmod_mixer_0.iqmod_mixer_half_0.iqmod_mixer_se2diff$1_0.iqmod_mixer_se2diff_half_tg$2_0.iqmod_mixer_se2diff_inv_NF54$6_0.vin VSS sg13_lv_nmos ad=0.19p pd=1.38u as=0.19p ps=1.38u w=1u l=0.13u
X976 VSS iqmod_mixer_0.iqmod_mixer_half_0.iqmod_mixer_se2diff$1_0.iqmod_mixer_se2diff_half_inv$2_0.iqmod_mixer_se2diff_inv_NF54$7_0.vin iqmod_mixer_0.iqmod_mixer_half_0.iqmod_mixer_tg$1_0.di_tg_ctrl VSS sg13_lv_nmos ad=0.19p pd=1.38u as=0.19p ps=1.38u w=1u l=0.13u
X977 iqmod_mixer_0.iqmod_mixer_half_0.iqmod_mixer_tg$1_0.di_tg_ctrl iqmod_mixer_0.iqmod_mixer_half_0.iqmod_mixer_se2diff$1_0.iqmod_mixer_se2diff_half_inv$2_0.iqmod_mixer_se2diff_inv_NF54$7_0.vin VDD VDD sg13_lv_pmos ad=0.57p pd=3.38u as=0.57p ps=3.38u w=3u l=0.13u
X978 VSS iqmod_mfb_lpf_0.iqmod_mfb_lpf_half_0.iqmod_mfb_lpf_ota_core_hybrid_bm_half$1_0.iqmod_mfb_lpf_ota_core_inv_NF20$2_0.vout iqmod_mfb_lpf_0.iqmod_mfb_lpf_half_0.iqmod_mfb_lpf_ota_core_hybrid_bm_half$1_0.iqmod_mfb_lpf_ota_core_inv_NF6$2_1.vout VSS sg13_lv_nmos ad=0.19p pd=1.38u as=0.19p ps=1.38u w=1u l=1u
X979 VDD iqmod_mixer_0.iqmod_mixer_half_0.iqmod_mixer_se2diff$1_0.iqmod_mixer_se2diff_half_tg$2_0.iqmod_mixer_se2diff_inv_NF54$6_0.vin iqmod_mixer_0.iqmod_mixer_half_0.iqmod_mixer_tg$1_0.di_tg_ctrl_n VDD sg13_lv_pmos ad=0.57p pd=3.38u as=0.57p ps=3.38u w=3u l=0.13u
X980 iqmod_mixer_0.vinn_IF iqmod_mixer_0.iqmod_mixer_half_0.iqmod_mixer_tg$1_0.di_tg_ctrl_n voutn_I_RF VDD sg13_lv_pmos ad=1.71p pd=9.38u as=1.71p ps=9.38u w=9u l=0.13u
X981 iqmod_mixer_0.iqmod_mixer_half_0.iqmod_mixer_se2diff$1_0.iqmod_mixer_se2diff_half_tg$2_0.iqmod_mixer_se2diff_inv_NF54$6_0.vin iqmod_mixer_0.iqmod_mixer_half_0.iqmod_mixer_se2diff$1_0.iqmod_mixer_se2diff_half_tg$2_0.iqmod_mixer_se2diff_inv_NF18$6_0.vin VSS VSS sg13_lv_nmos ad=0.19p pd=1.38u as=0.19p ps=1.38u w=1u l=0.13u
X982 VDD VDD VDD VDD sg13_lv_pmos ad=1.14p pd=6.38u as=0 ps=0 w=6u l=1u
X983 VSS iqmod_mixer_0.iqmod_mixer_half_1.iqmod_mixer_se2diff$1_0.iqmod_mixer_se2diff_half_tg$2_0.iqmod_mixer_se2diff_inv_NF18$6_0.vin iqmod_mixer_0.iqmod_mixer_half_1.iqmod_mixer_se2diff$1_0.iqmod_mixer_se2diff_half_tg$2_0.iqmod_mixer_se2diff_inv_NF54$6_0.vin VSS sg13_lv_nmos ad=0.19p pd=1.38u as=0.19p ps=1.38u w=1u l=0.13u
X984 VSS VSS VSS VSS sg13_lv_nmos ad=0.19p pd=1.38u as=0 ps=0 w=1u l=0.13u
X985 VSS iqmod_spdt_switch_0.spdt_switch_inv_0.vin iqmod_spdt_switch_0.spdt_switch_inv_0.vout VSS sg13_lv_nmos ad=0.19p pd=1.38u as=0.19p ps=1.38u w=1u l=0.13u
X986 VDD VDD VDD VDD sg13_lv_pmos ad=1.02p pd=6.68u as=0 ps=0 w=3u l=0.13u
X987 iqmod_mixer_0.vinn_IF iqmod_mixer_0.iqmod_mixer_half_0.iqmod_mixer_tg$1_0.di_tg_ctrl voutn_I_RF VSS sg13_lv_nmos ad=0.57p pd=3.38u as=0.57p ps=3.38u w=3u l=0.13u
X988 VSS iqmod_mixer_0.vinp_IF iqmod_mfb_lpf_0.iqmod_mfb_lpf_half_0.iqmod_mfb_lpf_ota_core_hybrid_bm_half$1_0.iqmod_mfb_lpf_ota_core_inv_NF20$2_0.vout VSS sg13_lv_nmos ad=0.19p pd=1.38u as=0.19p ps=1.38u w=1u l=1u
X989 VDD iqmod_mixer_0.iqmod_mixer_half_1.iqmod_mixer_se2diff$1_0.iqmod_mixer_se2diff_half_tg$2_0.iqmod_mixer_se2diff_inv_NF54$6_0.vin iqmod_mixer_0.iqmod_mixer_half_1.iqmod_mixer_tg$1_0.di_tg_ctrl_n VDD sg13_lv_pmos ad=0.57p pd=3.38u as=0.57p ps=3.38u w=3u l=0.13u
X990 VSS VSS VSS VSS sg13_lv_nmos ad=0.19p pd=1.38u as=0 ps=0 w=1u l=1u
X991 voutp_I_RF iqmod_mixer_0.iqmod_mixer_half_1.iqmod_mixer_tg$1_0.di_tg_ctrl iqmod_mixer_0.vinp_IF VSS sg13_lv_nmos ad=0.57p pd=3.38u as=0.57p ps=3.38u w=3u l=0.13u
X992 voutp_I_RF iqmod_mixer_0.iqmod_mixer_half_1.iqmod_mixer_tg$1_0.di_tg_ctrl_n voutp_I_RF VSS sg13_lv_nmos ad=0.57p pd=3.38u as=0 ps=0 w=3u l=0.13u
X993 VSS iqmod_mixer_0.iqmod_mixer_half_0.iqmod_mixer_se2diff$1_0.iqmod_mixer_se2diff_half_tg$2_0.iqmod_mixer_se2diff_inv_NF54$6_0.vin iqmod_mixer_0.iqmod_mixer_half_0.iqmod_mixer_tg$1_0.di_tg_ctrl_n VSS sg13_lv_nmos ad=0.19p pd=1.38u as=0.19p ps=1.38u w=1u l=0.13u
X994 iqmod_mfb_lpf_0.iqmod_mfb_lpf_half_0.iqmod_mfb_lpf_ota_core_hybrid_bm_half$1_0.iqmod_mfb_lpf_ota_core_inv_NF20$2_0.vout iqmod_mixer_0.vinp_IF VSS VSS sg13_lv_nmos ad=0.19p pd=1.38u as=0.19p ps=1.38u w=1u l=1u
X995 iqmod_mixer_0.vinn_IF iqmod_mfb_lpf_0.iqmod_mfb_lpf_half_0.iqmod_mfb_lpf_ota_core_hybrid_bm_half$1_0.iqmod_mfb_lpf_ota_core_tg$2_0.v_b VSS VSS sg13_lv_nmos ad=0.19p pd=1.38u as=0.19p ps=1.38u w=1u l=1u
X996 VSS VSS VSS VSS sg13_lv_nmos ad=0.19p pd=1.38u as=0 ps=0 w=1u l=0.13u
X997 VSS VSS VSS VSS sg13_lv_nmos ad=0.34p pd=2.68u as=0 ps=0 w=1u l=0.13u
X998 VSS iqmod_mixer_0.iqmod_mixer_half_0.iqmod_mixer_se2diff$1_0.iqmod_mixer_se2diff_half_inv$2_0.iqmod_mixer_se2diff_inv_NF18$7_0.vin iqmod_mixer_0.iqmod_mixer_half_0.iqmod_mixer_se2diff$1_0.iqmod_mixer_se2diff_half_inv$2_0.iqmod_mixer_se2diff_inv_NF54$7_0.vin VSS sg13_lv_nmos ad=0.19p pd=1.38u as=0.19p ps=1.38u w=1u l=0.13u
X999 VDD iqmod_mfb_lpf_0.iqmod_mfb_lpf_half_0.iqmod_mfb_lpf_ota_core_hybrid_bm_half$1_0.iqmod_mfb_lpf_ota_core_tg$2_0.v_a iqmod_mfb_lpf_0.iqmod_mfb_lpf_half_0.iqmod_mfb_lpf_ota_core_hybrid_bm_half$1_0.iqmod_mfb_lpf_ota_core_tg$2_0.v_b VDD sg13_lv_pmos ad=1.14p pd=6.38u as=1.14p ps=6.38u w=6u l=1u
X1000 iqmod_mixer_0.iqmod_mixer_half_1.iqmod_mixer_se2diff$1_0.iqmod_mixer_se2diff_half_inv$2_0.iqmod_mixer_se2diff_inv_NF2$7_1.vout iqmod_mixer_0.iqmod_mixer_half_1.iqmod_mixer_se2diff$1_0.iqmod_mixer_se2diff_half_tg$2_0.iqmod_mixer_se2diff_tg_NF6$3_0.v_b VSS VSS sg13_lv_nmos ad=0.19p pd=1.38u as=0.19p ps=1.38u w=1u l=0.13u
X1001 iqmod_mixer_0.iqmod_mixer_half_0.iqmod_mixer_tg$1_0.di_tg_ctrl_n iqmod_mixer_0.iqmod_mixer_half_0.iqmod_mixer_se2diff$1_0.iqmod_mixer_se2diff_half_tg$2_0.iqmod_mixer_se2diff_inv_NF54$6_0.vin VSS VSS sg13_lv_nmos ad=0.19p pd=1.38u as=0.19p ps=1.38u w=1u l=0.13u
X1002 VSS iqmod_mixer_0.iqmod_mixer_half_1.iqmod_mixer_se2diff$1_0.iqmod_mixer_se2diff_half_inv$2_0.iqmod_mixer_se2diff_inv_NF54$7_0.vin iqmod_mixer_0.iqmod_mixer_half_1.iqmod_mixer_tg$1_0.di_tg_ctrl VSS sg13_lv_nmos ad=0.19p pd=1.38u as=0.19p ps=1.38u w=1u l=0.13u
X1003 VDD VDD VDD VDD sg13_lv_pmos ad=1.02p pd=6.68u as=0 ps=0 w=3u l=0.13u
X1004 iqmod_mfb_lpf_0.iqmod_mfb_lpf_half_1.iqmod_mfb_lpf_ota_core_hybrid_bm_half$1_0.iqmod_mfb_lpf_ota_core_inv_NF20$2_1.vin iqmod_mfb_lpf_0.iqmod_mfb_lpf_half_1.iqmod_mfb_lpf_ota_core_hybrid_bm_half$1_0.iqmod_mfb_lpf_ota_core_tg$2_0.di_tg_ctrl_n iqmod_spdt_switch_0.v_c VDD sg13_lv_pmos ad=1.14p pd=6.38u as=1.14p ps=6.38u w=6u l=0.13u
X1005 iqmod_spdt_switch_1.v_c iqmod_spdt_switch_1.spdt_switch_inv_0.vin di_ds_I_p VSS sg13_lv_nmos ad=0.19p pd=1.38u as=0.19p ps=1.38u w=1u l=0.13u
X1006 VDD VDD VDD VDD sg13_lv_pmos ad=0.57p pd=3.38u as=0 ps=0 w=3u l=0.13u
X1007 iqmod_mixer_0.iqmod_mixer_half_0.iqmod_mixer_se2diff$1_0.iqmod_mixer_se2diff_half_inv$2_0.iqmod_mixer_se2diff_inv_NF54$7_0.vin iqmod_mixer_0.iqmod_mixer_half_0.iqmod_mixer_se2diff$1_0.iqmod_mixer_se2diff_half_inv$2_0.iqmod_mixer_se2diff_inv_NF18$7_0.vin VSS VSS sg13_lv_nmos ad=0.19p pd=1.38u as=0.19p ps=1.38u w=1u l=0.13u
X1008 VSS iqmod_mixer_0.iqmod_mixer_half_1.iqmod_mixer_se2diff$1_0.iqmod_mixer_se2diff_half_tg$2_0.iqmod_mixer_se2diff_tg_NF6$3_0.v_b iqmod_mixer_0.iqmod_mixer_half_1.iqmod_mixer_se2diff$1_0.iqmod_mixer_se2diff_half_inv$2_0.iqmod_mixer_se2diff_inv_NF2$7_1.vout VSS sg13_lv_nmos ad=0.19p pd=1.38u as=0.19p ps=1.38u w=1u l=0.13u
X1009 VDD iqmod_mfb_lpf_0.iqmod_mfb_lpf_half_0.iqmod_mfb_lpf_ota_core_hybrid_bm_half$1_0.iqmod_mfb_lpf_ota_core_tg$2_0.v_b iqmod_mixer_0.vinn_IF VDD sg13_lv_pmos ad=1.14p pd=6.38u as=1.14p ps=6.38u w=6u l=1u
X1010 VDD iqmod_mixer_0.iqmod_mixer_half_0.iqmod_mixer_se2diff$1_0.iqmod_mixer_se2diff_half_inv$2_0.iqmod_mixer_se2diff_inv_NF54$7_0.vin iqmod_mixer_0.iqmod_mixer_half_0.iqmod_mixer_tg$1_0.di_tg_ctrl VDD sg13_lv_pmos ad=0.57p pd=3.38u as=0.57p ps=3.38u w=3u l=0.13u
X1011 VDD VDD VDD VDD sg13_lv_pmos ad=1.02p pd=6.68u as=0 ps=0 w=3u l=0.13u
X1012 iqmod_mixer_0.iqmod_mixer_half_0.iqmod_mixer_se2diff$1_0.iqmod_mixer_se2diff_half_tg$2_0.iqmod_mixer_se2diff_inv_NF54$6_0.vin iqmod_mixer_0.iqmod_mixer_half_0.iqmod_mixer_se2diff$1_0.iqmod_mixer_se2diff_half_tg$2_0.iqmod_mixer_se2diff_inv_NF18$6_0.vin VDD VDD sg13_lv_pmos ad=0.57p pd=3.38u as=0.57p ps=3.38u w=3u l=0.13u
X1013 iqmod_spdt_switch_0.v_c a_36355_1946# VSS rhigh l=59u w=0.5u
X1014 iqmod_mfb_lpf_0.iqmod_mfb_lpf_half_0.iqmod_mfb_lpf_ota_core_hybrid_bm_half$1_0.iqmod_mfb_lpf_ota_core_tg$2_0.v_b iqmod_mfb_lpf_0.iqmod_mfb_lpf_half_0.iqmod_mfb_lpf_ota_core_hybrid_bm_half$1_0.iqmod_mfb_lpf_ota_core_tg$2_0.v_a VDD VDD sg13_lv_pmos ad=1.14p pd=6.38u as=1.14p ps=6.38u w=6u l=1u
X1015 VDD VDD VDD VDD sg13_lv_pmos ad=1.02p pd=6.68u as=0 ps=0 w=3u l=0.13u
X1016 VDD iqmod_mfb_lpf_0.iqmod_mfb_lpf_half_0.iqmod_mfb_lpf_ota_core_hybrid_bm_half$1_0.iqmod_mfb_lpf_ota_core_spdt_switch$2_0.iqmod_mfb_lpf_ota_core_spdt_switch_inv$3_0.vout iqmod_mfb_lpf_0.iqmod_mfb_lpf_half_0.iqmod_mfb_lpf_ota_core_hybrid_bm_half$1_0.iqmod_mfb_lpf_ota_core_inv_NF20$2_1.vin VDD sg13_lv_pmos ad=2.04p pd=12.68u as=1.14p ps=6.38u w=6u l=0.13u
X1017 VSS VSS VSS VSS sg13_lv_nmos ad=0.19p pd=1.38u as=0 ps=0 w=1u l=0.13u
X1018 iqmod_spdt_switch_0.v_c iqmod_spdt_switch_0.spdt_switch_inv_0.vin vinn_I VDD sg13_lv_pmos ad=1.14p pd=6.38u as=1.14p ps=6.38u w=6u l=0.13u
X1019 VDD VDD VDD VDD sg13_lv_pmos ad=1.14p pd=6.38u as=0 ps=0 w=6u l=1u
X1020 iqmod_mixer_0.vinn_IF iqmod_mfb_lpf_0.iqmod_mfb_lpf_half_0.iqmod_mfb_lpf_ota_core_hybrid_bm_half$1_0.iqmod_mfb_lpf_ota_core_inv_NF20$2_1.vin VSS VSS sg13_lv_nmos ad=0.19p pd=1.38u as=0.19p ps=1.38u w=1u l=1u
X1021 VSS VSS VSS VSS sg13_lv_nmos ad=0.34p pd=2.68u as=0 ps=0 w=1u l=0.13u
X1022 VSS iqmod_mixer_0.iqmod_mixer_half_0.iqmod_mixer_se2diff$1_0.iqmod_mixer_se2diff_half_inv$2_0.iqmod_mixer_se2diff_inv_NF6$7_0.vout iqmod_mixer_0.iqmod_mixer_half_0.iqmod_mixer_se2diff$1_0.iqmod_mixer_se2diff_half_inv$2_0.iqmod_mixer_se2diff_inv_NF6$7_1.vin VSS sg13_lv_nmos ad=0.19p pd=1.38u as=0.19p ps=1.38u w=1u l=0.13u
X1023 VSS VSS VSS VSS sg13_lv_nmos ad=0.34p pd=2.68u as=0 ps=0 w=1u l=1u
X1024 iqmod_mfb_lpf_0.iqmod_mfb_lpf_half_0.iqmod_mfb_lpf_ota_core_hybrid_bm_half$1_0.iqmod_mfb_lpf_ota_core_inv_NF20$2_1.vin iqmod_mfb_lpf_0.iqmod_mfb_lpf_half_0.iqmod_mfb_lpf_ota_core_hybrid_bm_half$1_0.iqmod_mfb_lpf_ota_core_spdt_switch$2_0.iqmod_mfb_lpf_ota_core_spdt_switch_inv$3_0.vout VDD VDD sg13_lv_pmos ad=1.14p pd=6.38u as=1.14p ps=6.38u w=6u l=0.13u
X1025 iqmod_mixer_0.iqmod_mixer_half_0.iqmod_mixer_tg$1_0.di_tg_ctrl_n iqmod_mixer_0.iqmod_mixer_half_0.iqmod_mixer_se2diff$1_0.iqmod_mixer_se2diff_half_tg$2_0.iqmod_mixer_se2diff_inv_NF54$6_0.vin VSS VSS sg13_lv_nmos ad=0.19p pd=1.38u as=0.19p ps=1.38u w=1u l=0.13u
X1026 iqmod_mixer_0.iqmod_mixer_half_0.iqmod_mixer_tg$1_0.di_tg_ctrl iqmod_mixer_0.iqmod_mixer_half_0.iqmod_mixer_se2diff$1_0.iqmod_mixer_se2diff_half_inv$2_0.iqmod_mixer_se2diff_inv_NF54$7_0.vin VSS VSS sg13_lv_nmos ad=0.19p pd=1.38u as=0.19p ps=1.38u w=1u l=0.13u
X1027 iqmod_mixer_0.iqmod_mixer_half_1.iqmod_mixer_tg$1_0.di_tg_ctrl iqmod_mixer_0.iqmod_mixer_half_1.iqmod_mixer_se2diff$1_0.iqmod_mixer_se2diff_half_inv$2_0.iqmod_mixer_se2diff_inv_NF54$7_0.vin VDD VDD sg13_lv_pmos ad=0.57p pd=3.38u as=0.57p ps=3.38u w=3u l=0.13u
X1028 VSS iqmod_mixer_0.iqmod_mixer_half_1.iqmod_mixer_se2diff$1_0.iqmod_mixer_se2diff_half_tg$2_0.iqmod_mixer_se2diff_inv_NF54$6_0.vin iqmod_mixer_0.iqmod_mixer_half_1.iqmod_mixer_tg$1_0.di_tg_ctrl_n VSS sg13_lv_nmos ad=0.19p pd=1.38u as=0.19p ps=1.38u w=1u l=0.13u
X1029 VDD VDD VDD VDD sg13_lv_pmos ad=1.02p pd=6.68u as=0 ps=0 w=3u l=0.13u
X1030 vinn_I iqmod_spdt_switch_0.spdt_switch_inv_0.vin iqmod_spdt_switch_0.v_c VDD sg13_lv_pmos ad=1.14p pd=6.38u as=1.14p ps=6.38u w=6u l=0.13u
X1031 iqmod_mixer_0.iqmod_mixer_half_0.iqmod_mixer_se2diff$1_0.iqmod_mixer_se2diff_half_inv$2_0.iqmod_mixer_se2diff_inv_NF6$7_1.vin iqmod_mixer_0.iqmod_mixer_half_0.iqmod_mixer_se2diff$1_0.iqmod_mixer_se2diff_half_inv$2_0.iqmod_mixer_se2diff_inv_NF6$7_0.vout VSS VSS sg13_lv_nmos ad=0.19p pd=1.38u as=0.19p ps=1.38u w=1u l=0.13u
X1032 VDD VDD VDD VDD sg13_lv_pmos ad=1.02p pd=6.68u as=0 ps=0 w=3u l=0.13u
X1033 VDD VDD VDD VDD sg13_lv_pmos ad=2.04p pd=12.68u as=0 ps=0 w=6u l=1u
X1034 iqmod_mixer_0.iqmod_mixer_half_1.iqmod_mixer_se2diff$1_0.iqmod_mixer_se2diff_half_tg$2_0.iqmod_mixer_se2diff_inv_NF54$6_0.vin iqmod_mixer_0.iqmod_mixer_half_1.iqmod_mixer_se2diff$1_0.iqmod_mixer_se2diff_half_tg$2_0.iqmod_mixer_se2diff_inv_NF18$6_0.vin VDD VDD sg13_lv_pmos ad=0.57p pd=3.38u as=0.57p ps=3.38u w=3u l=0.13u
X1035 VDD iqmod_mixer_0.iqmod_mixer_half_0.iqmod_mixer_se2diff$1_0.iqmod_mixer_se2diff_half_tg$2_0.iqmod_mixer_se2diff_inv_NF54$6_0.vin iqmod_mixer_0.iqmod_mixer_half_0.iqmod_mixer_tg$1_0.di_tg_ctrl_n VDD sg13_lv_pmos ad=0.57p pd=3.38u as=0.57p ps=3.38u w=3u l=0.13u
X1036 iqmod_mixer_0.vinn_IF iqmod_mixer_0.iqmod_mixer_half_0.iqmod_mixer_tg$1_0.di_tg_ctrl_n voutn_I_RF VDD sg13_lv_pmos ad=1.71p pd=9.38u as=1.71p ps=9.38u w=9u l=0.13u
X1037 iqmod_mixer_0.iqmod_mixer_half_1.iqmod_mixer_tg$1_0.di_tg_ctrl_n iqmod_mixer_0.iqmod_mixer_half_1.iqmod_mixer_se2diff$1_0.iqmod_mixer_se2diff_half_tg$2_0.iqmod_mixer_se2diff_inv_NF54$6_0.vin VSS VSS sg13_lv_nmos ad=0.19p pd=1.38u as=0.19p ps=1.38u w=1u l=0.13u
X1038 iqmod_mixer_0.vinn_IF iqmod_mfb_lpf_0.iqmod_mfb_lpf_half_0.iqmod_mfb_lpf_ota_core_hybrid_bm_half$1_0.iqmod_mfb_lpf_ota_core_inv_NF20$2_1.vin VDD VDD sg13_lv_pmos ad=1.14p pd=6.38u as=1.14p ps=6.38u w=6u l=1u
X1039 VDD VDD VDD VDD sg13_lv_pmos ad=2.04p pd=12.68u as=0 ps=0 w=6u l=0.13u
X1040 VSS iqmod_mfb_lpf_0.iqmod_mfb_lpf_half_0.iqmod_mfb_lpf_ota_core_hybrid_bm_half$1_0.iqmod_mfb_lpf_ota_core_inv_NF20$2_1.vin iqmod_mixer_0.vinn_IF VSS sg13_lv_nmos ad=0.19p pd=1.38u as=0.19p ps=1.38u w=1u l=1u
X1041 iqmod_mfb_lpf_0.iqmod_mfb_lpf_half_0.iqmod_mfb_lpf_ota_core_hybrid_bm_half$1_0.iqmod_mfb_lpf_ota_core_tg$2_0.v_b iqmod_mfb_lpf_0.iqmod_mfb_lpf_half_0.iqmod_mfb_lpf_ota_core_hybrid_bm_half$1_0.iqmod_mfb_lpf_ota_core_inv_NF6$2_1.vout VSS VSS sg13_lv_nmos ad=0.19p pd=1.38u as=0.19p ps=1.38u w=1u l=1u
X1042 iqmod_mixer_0.iqmod_mixer_half_1.iqmod_mixer_tg$1_0.di_tg_ctrl iqmod_mixer_0.iqmod_mixer_half_1.iqmod_mixer_se2diff$1_0.iqmod_mixer_se2diff_half_inv$2_0.iqmod_mixer_se2diff_inv_NF54$7_0.vin VDD VDD sg13_lv_pmos ad=0.57p pd=3.38u as=0.57p ps=3.38u w=3u l=0.13u
X1043 VSS VSS VSS VSS sg13_lv_nmos ad=0.34p pd=2.68u as=0 ps=0 w=1u l=1u
X1044 VDD iqmod_mfb_lpf_0.iqmod_mfb_lpf_half_0.iqmod_mfb_lpf_ota_core_hybrid_bm_half$1_0.iqmod_mfb_lpf_ota_core_inv_NF6$2_1.vout iqmod_mfb_lpf_0.iqmod_mfb_lpf_half_0.iqmod_mfb_lpf_ota_core_hybrid_bm_half$1_0.iqmod_mfb_lpf_ota_core_tg$2_0.v_b VDD sg13_lv_pmos ad=1.14p pd=6.38u as=1.14p ps=6.38u w=6u l=1u
X1045 VDD VDD VDD VDD sg13_lv_pmos ad=1.02p pd=6.68u as=0 ps=0 w=3u l=0.13u
X1046 VDD iqmod_mixer_0.iqmod_mixer_half_1.iqmod_mixer_se2diff$1_0.iqmod_mixer_se2diff_half_inv$2_0.iqmod_mixer_se2diff_inv_NF18$7_0.vin iqmod_mixer_0.iqmod_mixer_half_1.iqmod_mixer_se2diff$1_0.iqmod_mixer_se2diff_half_inv$2_0.iqmod_mixer_se2diff_inv_NF54$7_0.vin VDD sg13_lv_pmos ad=0.57p pd=3.38u as=0.57p ps=3.38u w=3u l=0.13u
X1047 VDD iqmod_mixer_0.iqmod_mixer_half_1.iqmod_mixer_se2diff$1_0.iqmod_mixer_se2diff_half_inv$2_0.iqmod_mixer_se2diff_inv_NF18$7_0.vin iqmod_mixer_0.iqmod_mixer_half_1.iqmod_mixer_se2diff$1_0.iqmod_mixer_se2diff_half_inv$2_0.iqmod_mixer_se2diff_inv_NF54$7_0.vin VDD sg13_lv_pmos ad=0.57p pd=3.38u as=0.57p ps=3.38u w=3u l=0.13u
X1048 voutp_I_RF iqmod_mixer_0.iqmod_mixer_half_1.iqmod_mixer_tg$1_0.di_tg_ctrl_n iqmod_mixer_0.vinp_IF VDD sg13_lv_pmos ad=1.71p pd=9.38u as=1.71p ps=9.38u w=9u l=0.13u
X1049 iqmod_mixer_0.iqmod_mixer_half_0.iqmod_mixer_tg$1_0.di_tg_ctrl_n iqmod_mixer_0.iqmod_mixer_half_0.iqmod_mixer_se2diff$1_0.iqmod_mixer_se2diff_half_tg$2_0.iqmod_mixer_se2diff_inv_NF54$6_0.vin VDD VDD sg13_lv_pmos ad=0.57p pd=3.38u as=0.57p ps=3.38u w=3u l=0.13u
X1050 iqmod_spdt_switch_1.v_c iqmod_spdt_switch_1.spdt_switch_inv_0.vout vinp_I VSS sg13_lv_nmos ad=0.19p pd=1.38u as=0.34p ps=2.68u w=1u l=0.13u
X1051 iqmod_spdt_switch_1.spdt_switch_inv_0.vout iqmod_spdt_switch_1.spdt_switch_inv_0.vin VSS VSS sg13_lv_nmos ad=0.19p pd=1.38u as=0.19p ps=1.38u w=1u l=0.13u
X1052 iqmod_mixer_0.iqmod_mixer_half_1.iqmod_mixer_se2diff$1_0.iqmod_mixer_se2diff_half_inv$2_0.iqmod_mixer_se2diff_inv_NF18$7_0.vin iqmod_mixer_0.iqmod_mixer_half_1.iqmod_mixer_se2diff$1_0.iqmod_mixer_se2diff_half_inv$2_0.iqmod_mixer_se2diff_inv_NF6$7_1.vin VDD VDD sg13_lv_pmos ad=0.57p pd=3.38u as=0.57p ps=3.38u w=3u l=0.13u
X1053 voutn_I_RF iqmod_mixer_0.iqmod_mixer_half_0.iqmod_mixer_tg$1_0.di_tg_ctrl_n iqmod_mixer_0.vinn_IF VDD sg13_lv_pmos ad=1.71p pd=9.38u as=1.71p ps=9.38u w=9u l=0.13u
X1054 VSS iqmod_mixer_0.iqmod_mixer_half_1.iqmod_mixer_se2diff$1_0.iqmod_mixer_se2diff_half_tg$2_0.iqmod_mixer_se2diff_inv_NF54$6_0.vin iqmod_mixer_0.iqmod_mixer_half_1.iqmod_mixer_tg$1_0.di_tg_ctrl_n VSS sg13_lv_nmos ad=0.19p pd=1.38u as=0.19p ps=1.38u w=1u l=0.13u
X1055 VDD iqmod_mixer_0.iqmod_mixer_half_1.iqmod_mixer_se2diff$1_0.iqmod_mixer_se2diff_half_inv$2_0.iqmod_mixer_se2diff_inv_NF6$7_1.vin iqmod_mixer_0.iqmod_mixer_half_1.iqmod_mixer_se2diff$1_0.iqmod_mixer_se2diff_half_inv$2_0.iqmod_mixer_se2diff_inv_NF2$7_1.vout VDD sg13_lv_pmos ad=0.57p pd=3.38u as=0.57p ps=3.38u w=3u l=0.13u
X1056 iqmod_mixer_0.vinn_IF iqmod_mixer_0.iqmod_mixer_half_0.iqmod_mixer_tg$1_0.di_tg_ctrl voutn_I_RF VSS sg13_lv_nmos ad=0.57p pd=3.38u as=0.57p ps=3.38u w=3u l=0.13u
X1057 iqmod_mfb_lpf_0.iqmod_mfb_lpf_half_0.iqmod_mfb_lpf_ota_core_hybrid_bm_half$1_0.iqmod_mfb_lpf_ota_core_inv_NF20$2_0.vout iqmod_mixer_0.vinp_IF VDD VDD sg13_lv_pmos ad=1.14p pd=6.38u as=1.14p ps=6.38u w=6u l=1u
X1058 voutp_I_RF iqmod_mixer_0.iqmod_mixer_half_1.iqmod_mixer_tg$1_0.di_tg_ctrl voutp_I_RF VDD sg13_lv_pmos ad=1.71p pd=9.38u as=0 ps=0 w=9u l=0.13u
X1059 iqmod_mixer_0.vinp_IF iqmod_mixer_0.iqmod_mixer_half_1.iqmod_mixer_tg$1_0.di_tg_ctrl_n voutp_I_RF VDD sg13_lv_pmos ad=1.71p pd=9.38u as=1.71p ps=9.38u w=9u l=0.13u
X1060 VSS VSS VSS VSS sg13_lv_nmos ad=0.34p pd=2.68u as=0 ps=0 w=1u l=0.13u
X1061 VDD iqmod_mfb_lpf_0.iqmod_mfb_lpf_half_0.iqmod_mfb_lpf_ota_core_hybrid_bm_half$1_0.iqmod_mfb_lpf_ota_core_inv_NF20$2_1.vin iqmod_mixer_0.vinn_IF VDD sg13_lv_pmos ad=1.14p pd=6.38u as=1.14p ps=6.38u w=6u l=1u
X1062 VSS iqmod_mixer_0.vinn_IF iqmod_mfb_lpf_0.iqmod_mfb_lpf_half_0.iqmod_mfb_lpf_ota_core_hybrid_bm_half$1_0.iqmod_mfb_lpf_ota_core_inv_NF20$2_0.vout VSS sg13_lv_nmos ad=0.19p pd=1.38u as=0.19p ps=1.38u w=1u l=1u
X1063 iqmod_mixer_0.iqmod_mixer_half_1.iqmod_mixer_se2diff$1_0.iqmod_mixer_se2diff_half_inv$2_0.iqmod_mixer_se2diff_inv_NF54$7_0.vin iqmod_mixer_0.iqmod_mixer_half_1.iqmod_mixer_se2diff$1_0.iqmod_mixer_se2diff_half_inv$2_0.iqmod_mixer_se2diff_inv_NF18$7_0.vin VSS VSS sg13_lv_nmos ad=0.19p pd=1.38u as=0.19p ps=1.38u w=1u l=0.13u
X1064 iqmod_mixer_0.iqmod_mixer_half_1.iqmod_mixer_tg$1_0.di_tg_ctrl_n iqmod_mixer_0.iqmod_mixer_half_1.iqmod_mixer_se2diff$1_0.iqmod_mixer_se2diff_half_tg$2_0.iqmod_mixer_se2diff_inv_NF54$6_0.vin VDD VDD sg13_lv_pmos ad=0.57p pd=3.38u as=0.57p ps=3.38u w=3u l=0.13u
X1065 iqmod_mixer_0.vinn_IF iqmod_mfb_lpf_0.iqmod_mfb_lpf_half_0.iqmod_mfb_lpf_ota_core_hybrid_bm_half$1_0.iqmod_mfb_lpf_ota_core_inv_NF20$2_1.vin VSS VSS sg13_lv_nmos ad=0.19p pd=1.38u as=0.19p ps=1.38u w=1u l=1u
X1066 voutn_I_RF iqmod_mixer_0.iqmod_mixer_half_0.iqmod_mixer_tg$1_0.di_tg_ctrl iqmod_mixer_0.vinn_IF VSS sg13_lv_nmos ad=0.57p pd=3.38u as=0.57p ps=3.38u w=3u l=0.13u
X1067 VSS iqmod_mfb_lpf_0.iqmod_mfb_lpf_half_0.iqmod_mfb_lpf_ota_core_hybrid_bm_half$1_0.iqmod_mfb_lpf_ota_core_inv_NF6$2_1.vout iqmod_mfb_lpf_0.iqmod_mfb_lpf_half_0.iqmod_mfb_lpf_ota_core_hybrid_bm_half$1_0.iqmod_mfb_lpf_ota_core_tg$2_0.v_b VSS sg13_lv_nmos ad=0.19p pd=1.38u as=0.19p ps=1.38u w=1u l=1u
X1068 VDD VDD VDD VDD sg13_lv_pmos ad=0.57p pd=3.38u as=0 ps=0 w=3u l=0.13u
X1069 iqmod_mfb_lpf_0.iqmod_mfb_lpf_half_0.iqmod_mfb_lpf_ota_core_hybrid_bm_half$1_0.iqmod_mfb_lpf_ota_core_tg$2_0.v_a iqmod_mfb_lpf_0.iqmod_mfb_lpf_half_1.iqmod_mfb_lpf_ota_core_hybrid_bm_half$1_0.iqmod_mfb_lpf_ota_core_inv_NF20$2_1.vin VSS VSS sg13_lv_nmos ad=0.19p pd=1.38u as=0.19p ps=1.38u w=1u l=1u
X1070 VDD VDD VDD VDD sg13_lv_pmos ad=1.02p pd=6.68u as=0 ps=0 w=3u l=0.13u
X1071 VDD di_spdt_ctrl_I iqmod_spdt_switch_1.spdt_switch_inv_0.vin VDD sg13_lv_pmos ad=1.14p pd=6.38u as=1.14p ps=6.38u w=6u l=0.13u
X1072 VDD VDD VDD VDD sg13_lv_pmos ad=1.02p pd=6.68u as=0 ps=0 w=3u l=0.13u
X1073 iqmod_mixer_0.iqmod_mixer_half_0.iqmod_mixer_se2diff$1_0.iqmod_mixer_se2diff_half_inv$2_0.iqmod_mixer_se2diff_inv_NF54$7_0.vin iqmod_mixer_0.iqmod_mixer_half_0.iqmod_mixer_se2diff$1_0.iqmod_mixer_se2diff_half_inv$2_0.iqmod_mixer_se2diff_inv_NF18$7_0.vin VDD VDD sg13_lv_pmos ad=0.57p pd=3.38u as=0.57p ps=3.38u w=3u l=0.13u
X1074 iqmod_mixer_0.vinp_IF iqmod_mixer_0.iqmod_mixer_half_1.iqmod_mixer_tg$1_0.di_tg_ctrl voutp_I_RF VSS sg13_lv_nmos ad=0.57p pd=3.38u as=0.57p ps=3.38u w=3u l=0.13u
X1075 iqmod_mixer_0.iqmod_mixer_half_1.iqmod_mixer_se2diff$1_0.iqmod_mixer_se2diff_half_inv$2_0.iqmod_mixer_se2diff_inv_NF18$7_0.vin iqmod_mixer_0.iqmod_mixer_half_1.iqmod_mixer_se2diff$1_0.iqmod_mixer_se2diff_half_inv$2_0.iqmod_mixer_se2diff_inv_NF6$7_1.vin VDD VDD sg13_lv_pmos ad=0.57p pd=3.38u as=0.57p ps=3.38u w=3u l=0.13u
X1076 voutp_I_RF iqmod_mixer_0.iqmod_mixer_half_1.iqmod_mixer_tg$1_0.di_tg_ctrl_n iqmod_mixer_0.vinp_IF VDD sg13_lv_pmos ad=1.71p pd=9.38u as=1.71p ps=9.38u w=9u l=0.13u
X1077 VSS iqmod_mixer_0.iqmod_mixer_half_0.iqmod_mixer_se2diff$1_0.iqmod_mixer_se2diff_half_inv$2_0.iqmod_mixer_se2diff_inv_NF54$7_0.vin iqmod_mixer_0.iqmod_mixer_half_0.iqmod_mixer_tg$1_0.di_tg_ctrl VSS sg13_lv_nmos ad=0.19p pd=1.38u as=0.19p ps=1.38u w=1u l=0.13u
X1078 voutn_I_RF iqmod_mixer_0.iqmod_mixer_half_0.iqmod_mixer_tg$1_0.di_tg_ctrl_n voutn_I_RF VSS sg13_lv_nmos ad=0.57p pd=3.38u as=0 ps=0 w=3u l=0.13u
X1079 VSS iqmod_mfb_lpf_0.iqmod_mfb_lpf_half_0.iqmod_mfb_lpf_ota_core_hybrid_bm_half$1_0.iqmod_mfb_lpf_ota_core_inv_NF20$2_1.vin iqmod_mixer_0.vinn_IF VSS sg13_lv_nmos ad=0.19p pd=1.38u as=0.19p ps=1.38u w=1u l=1u
X1080 iqmod_spdt_switch_0.v_c iqmod_mfb_lpf_0.iqmod_mfb_lpf_half_1.iqmod_mfb_lpf_ota_core_hybrid_bm_half$1_0.iqmod_mfb_lpf_ota_core_spdt_switch$2_0.iqmod_mfb_lpf_ota_core_spdt_switch_inv$3_0.vout iqmod_mfb_lpf_0.iqmod_mfb_lpf_half_1.iqmod_mfb_lpf_ota_core_hybrid_bm_half$1_0.iqmod_mfb_lpf_ota_core_inv_NF20$2_1.vin VSS sg13_lv_nmos ad=0.34p pd=2.68u as=0.19p ps=1.38u w=1u l=0.13u
X1081 iqmod_mixer_0.iqmod_mixer_half_1.iqmod_mixer_tg$1_0.di_tg_ctrl iqmod_mixer_0.iqmod_mixer_half_1.iqmod_mixer_se2diff$1_0.iqmod_mixer_se2diff_half_inv$2_0.iqmod_mixer_se2diff_inv_NF54$7_0.vin VSS VSS sg13_lv_nmos ad=0.19p pd=1.38u as=0.19p ps=1.38u w=1u l=0.13u
X1082 VSS VSS VSS VSS sg13_lv_nmos ad=0.19p pd=1.38u as=0 ps=0 w=1u l=0.13u
X1083 VSS iqmod_mixer_0.iqmod_mixer_half_1.iqmod_mixer_se2diff$1_0.iqmod_mixer_se2diff_half_tg$2_0.iqmod_mixer_se2diff_inv_NF18$6_0.vin iqmod_mixer_0.iqmod_mixer_half_1.iqmod_mixer_se2diff$1_0.iqmod_mixer_se2diff_half_tg$2_0.iqmod_mixer_se2diff_inv_NF54$6_0.vin VSS sg13_lv_nmos ad=0.19p pd=1.38u as=0.19p ps=1.38u w=1u l=0.13u
X1084 iqmod_mixer_0.iqmod_mixer_half_0.iqmod_mixer_tg$1_0.di_tg_ctrl_n iqmod_mixer_0.iqmod_mixer_half_0.iqmod_mixer_se2diff$1_0.iqmod_mixer_se2diff_half_tg$2_0.iqmod_mixer_se2diff_inv_NF54$6_0.vin VDD VDD sg13_lv_pmos ad=0.57p pd=3.38u as=0.57p ps=3.38u w=3u l=0.13u
X1085 VSS VSS VSS VSS sg13_lv_nmos ad=0.19p pd=1.38u as=0 ps=0 w=1u l=0.13u
X1086 iqmod_mixer_0.iqmod_mixer_half_0.iqmod_mixer_tg$1_0.di_tg_ctrl iqmod_mixer_0.iqmod_mixer_half_0.iqmod_mixer_se2diff$1_0.iqmod_mixer_se2diff_half_inv$2_0.iqmod_mixer_se2diff_inv_NF54$7_0.vin VDD VDD sg13_lv_pmos ad=0.57p pd=3.38u as=0.57p ps=3.38u w=3u l=0.13u
X1087 iqmod_mixer_0.vinp_IF iqmod_mfb_lpf_0.iqmod_mfb_lpf_half_0.iqmod_mfb_lpf_ota_core_hybrid_bm_half$1_0.iqmod_mfb_lpf_ota_core_tg$2_0.v_b VSS VSS sg13_lv_nmos ad=0.19p pd=1.38u as=0.19p ps=1.38u w=1u l=1u
X1088 VDD VDD VDD VDD sg13_lv_pmos ad=2.04p pd=12.68u as=0 ps=0 w=6u l=1u
X1089 voutp_I_RF iqmod_mixer_0.iqmod_mixer_half_1.iqmod_mixer_tg$1_0.di_tg_ctrl voutp_I_RF VDD sg13_lv_pmos ad=1.71p pd=9.38u as=0 ps=0 w=9u l=0.13u
X1090 VDD VDD VDD VDD sg13_lv_pmos ad=0.57p pd=3.38u as=0 ps=0 w=3u l=0.13u
X1091 VSS iqmod_mixer_0.iqmod_mixer_half_0.iqmod_mixer_se2diff$1_0.iqmod_mixer_se2diff_half_tg$2_0.iqmod_mixer_se2diff_inv_NF18$6_0.vin iqmod_mixer_0.iqmod_mixer_half_0.iqmod_mixer_se2diff$1_0.iqmod_mixer_se2diff_half_tg$2_0.iqmod_mixer_se2diff_inv_NF54$6_0.vin VSS sg13_lv_nmos ad=0.19p pd=1.38u as=0.19p ps=1.38u w=1u l=0.13u
X1092 iqmod_mixer_0.iqmod_mixer_half_1.iqmod_mixer_se2diff$1_0.iqmod_mixer_se2diff_half_tg$2_0.iqmod_mixer_se2diff_inv_NF54$6_0.vin iqmod_mixer_0.iqmod_mixer_half_1.iqmod_mixer_se2diff$1_0.iqmod_mixer_se2diff_half_tg$2_0.iqmod_mixer_se2diff_inv_NF18$6_0.vin VSS VSS sg13_lv_nmos ad=0.19p pd=1.38u as=0.19p ps=1.38u w=1u l=0.13u
X1093 voutn_I_RF iqmod_mixer_0.iqmod_mixer_half_0.iqmod_mixer_tg$1_0.di_tg_ctrl_n voutn_I_RF VSS sg13_lv_nmos ad=0.57p pd=3.38u as=0 ps=0 w=3u l=0.13u
X1094 iqmod_mixer_0.iqmod_mixer_half_1.iqmod_mixer_tg$1_0.di_tg_ctrl_n iqmod_mixer_0.iqmod_mixer_half_1.iqmod_mixer_se2diff$1_0.iqmod_mixer_se2diff_half_tg$2_0.iqmod_mixer_se2diff_inv_NF54$6_0.vin VDD VDD sg13_lv_pmos ad=0.57p pd=3.38u as=0.57p ps=3.38u w=3u l=0.13u
X1095 VDD iqmod_mfb_lpf_0.iqmod_mfb_lpf_half_0.iqmod_mfb_lpf_ota_core_hybrid_bm_half$1_0.iqmod_mfb_lpf_ota_core_tg$2_0.v_a iqmod_mfb_lpf_0.iqmod_mfb_lpf_half_0.iqmod_mfb_lpf_ota_core_hybrid_bm_half$1_0.iqmod_mfb_lpf_ota_core_tg$2_0.v_b VDD sg13_lv_pmos ad=1.14p pd=6.38u as=1.14p ps=6.38u w=6u l=1u
X1096 iqmod_mixer_0.iqmod_mixer_half_1.iqmod_mixer_se2diff$1_0.iqmod_mixer_se2diff_half_tg$2_0.iqmod_mixer_se2diff_inv_NF18$6_0.vin iqmod_mixer_0.iqmod_mixer_half_1.iqmod_mixer_se2diff$1_0.iqmod_mixer_se2diff_half_inv$2_0.iqmod_mixer_se2diff_inv_NF2$7_1.vout VDD VDD sg13_lv_pmos ad=0.57p pd=3.38u as=0.57p ps=3.38u w=3u l=0.13u
X1097 VDD iqmod_mixer_0.iqmod_mixer_half_1.iqmod_mixer_se2diff$1_0.iqmod_mixer_se2diff_half_tg$2_0.iqmod_mixer_se2diff_inv_NF54$6_0.vin iqmod_mixer_0.iqmod_mixer_half_1.iqmod_mixer_tg$1_0.di_tg_ctrl_n VDD sg13_lv_pmos ad=0.57p pd=3.38u as=0.57p ps=3.38u w=3u l=0.13u
X1098 iqmod_mfb_lpf_0.iqmod_mfb_lpf_half_0.iqmod_mfb_lpf_R1$1_0.v_b iqmod_mfb_lpf_0.iqmod_mfb_lpf_half_0.C1_half cap_cmim l=8u w=8u
X1099 VSS iqmod_mfb_lpf_0.iqmod_mfb_lpf_half_0.iqmod_mfb_lpf_ota_core_hybrid_bm_half$1_0.iqmod_mfb_lpf_ota_core_tg$2_0.v_b iqmod_mixer_0.vinp_IF VSS sg13_lv_nmos ad=0.19p pd=1.38u as=0.19p ps=1.38u w=1u l=1u
X1100 iqmod_mfb_lpf_0.iqmod_mfb_lpf_half_0.iqmod_mfb_lpf_ota_core_hybrid_bm_half$1_0.iqmod_mfb_lpf_ota_core_inv_NF20$2_0.vout iqmod_mfb_lpf_0.iqmod_mfb_lpf_half_0.iqmod_mfb_lpf_ota_core_hybrid_bm_half$1_0.iqmod_mfb_lpf_ota_core_tg$2_0.di_tg_ctrl_n iqmod_mfb_lpf_0.iqmod_mfb_lpf_half_0.iqmod_mfb_lpf_ota_core_hybrid_bm_half$1_0.iqmod_mfb_lpf_ota_core_inv_NF6$2_1.vout VDD sg13_lv_pmos ad=2.04p pd=12.68u as=1.14p ps=6.38u w=6u l=0.13u
X1101 voutp_I_RF iqmod_mixer_0.iqmod_mixer_half_1.iqmod_mixer_tg$1_0.di_tg_ctrl iqmod_mixer_0.vinp_IF VSS sg13_lv_nmos ad=0.57p pd=3.38u as=0.57p ps=3.38u w=3u l=0.13u
X1102 VDD iqmod_mixer_0.iqmod_mixer_half_1.iqmod_mixer_se2diff$1_0.iqmod_mixer_se2diff_half_inv$2_0.iqmod_mixer_se2diff_inv_NF2$7_1.vout iqmod_mixer_0.iqmod_mixer_half_1.iqmod_mixer_se2diff$1_0.iqmod_mixer_se2diff_half_tg$2_0.iqmod_mixer_se2diff_inv_NF18$6_0.vin VDD sg13_lv_pmos ad=0.57p pd=3.38u as=0.57p ps=3.38u w=3u l=0.13u
X1103 iqmod_mixer_0.iqmod_mixer_half_1.iqmod_mixer_se2diff$1_0.iqmod_mixer_se2diff_half_inv$2_0.iqmod_mixer_se2diff_inv_NF6$7_1.vin iqmod_mixer_0.iqmod_mixer_half_1.iqmod_mixer_se2diff$1_0.iqmod_mixer_se2diff_half_inv$2_0.iqmod_mixer_se2diff_inv_NF6$7_0.vout VDD VDD sg13_lv_pmos ad=0.57p pd=3.38u as=0.57p ps=3.38u w=3u l=0.13u
X1104 VDD iqmod_mixer_0.iqmod_mixer_half_1.iqmod_mixer_se2diff$1_0.iqmod_mixer_se2diff_half_inv$2_0.iqmod_mixer_se2diff_inv_NF54$7_0.vin iqmod_mixer_0.iqmod_mixer_half_1.iqmod_mixer_tg$1_0.di_tg_ctrl VDD sg13_lv_pmos ad=0.57p pd=3.38u as=0.57p ps=3.38u w=3u l=0.13u
X1105 VSS iqmod_mixer_0.iqmod_mixer_half_0.iqmod_mixer_se2diff$1_0.iqmod_mixer_se2diff_half_tg$2_0.iqmod_mixer_se2diff_inv_NF54$6_0.vin iqmod_mixer_0.iqmod_mixer_half_0.iqmod_mixer_tg$1_0.di_tg_ctrl_n VSS sg13_lv_nmos ad=0.19p pd=1.38u as=0.19p ps=1.38u w=1u l=0.13u
X1106 VDD iqmod_mixer_0.iqmod_mixer_half_1.iqmod_mixer_se2diff$1_0.iqmod_mixer_se2diff_half_inv$2_0.iqmod_mixer_se2diff_inv_NF6$7_0.vin iqmod_mixer_0.iqmod_mixer_half_1.iqmod_mixer_se2diff$1_0.iqmod_mixer_se2diff_half_inv$2_0.iqmod_mixer_se2diff_inv_NF6$7_0.vout VDD sg13_lv_pmos ad=0.57p pd=3.38u as=0.57p ps=3.38u w=3u l=0.13u
X1107 VDD iqmod_mfb_lpf_0.iqmod_mfb_lpf_half_0.iqmod_mfb_lpf_ota_core_hybrid_bm_half$1_0.iqmod_mfb_lpf_ota_core_tg$2_0.v_b iqmod_mixer_0.vinp_IF VDD sg13_lv_pmos ad=1.14p pd=6.38u as=1.14p ps=6.38u w=6u l=1u
X1108 VDD VDD VDD VDD sg13_lv_pmos ad=0.57p pd=3.38u as=0 ps=0 w=3u l=0.13u
X1109 iqmod_mixer_0.iqmod_mixer_half_0.iqmod_mixer_se2diff$1_0.iqmod_mixer_se2diff_half_inv$2_0.iqmod_mixer_se2diff_inv_NF54$7_0.vin iqmod_mixer_0.iqmod_mixer_half_0.iqmod_mixer_se2diff$1_0.iqmod_mixer_se2diff_half_inv$2_0.iqmod_mixer_se2diff_inv_NF18$7_0.vin VSS VSS sg13_lv_nmos ad=0.19p pd=1.38u as=0.19p ps=1.38u w=1u l=0.13u
X1110 iqmod_mfb_lpf_0.iqmod_mfb_lpf_half_0.iqmod_mfb_lpf_ota_core_hybrid_bm_half$1_0.iqmod_mfb_lpf_ota_core_inv_NF6$2_1.vout iqmod_mfb_lpf_0.iqmod_mfb_lpf_half_0.iqmod_mfb_lpf_ota_core_hybrid_bm_half$1_0.iqmod_mfb_lpf_ota_core_tg$2_0.di_tg_ctrl_n iqmod_mfb_lpf_0.iqmod_mfb_lpf_half_0.iqmod_mfb_lpf_ota_core_hybrid_bm_half$1_0.iqmod_mfb_lpf_ota_core_inv_NF20$2_0.vout VDD sg13_lv_pmos ad=1.14p pd=6.38u as=1.14p ps=6.38u w=6u l=0.13u
X1111 VSS iqmod_mixer_0.iqmod_mixer_half_0.iqmod_mixer_se2diff$1_0.iqmod_mixer_se2diff_half_tg$2_0.iqmod_mixer_se2diff_inv_NF54$6_0.vin iqmod_mixer_0.iqmod_mixer_half_0.iqmod_mixer_tg$1_0.di_tg_ctrl_n VSS sg13_lv_nmos ad=0.19p pd=1.38u as=0.19p ps=1.38u w=1u l=0.13u
X1112 VSS VSS VSS VSS sg13_lv_nmos ad=0.34p pd=2.68u as=0 ps=0 w=1u l=1u
X1113 iqmod_mixer_0.iqmod_mixer_half_1.iqmod_mixer_tg$1_0.di_tg_ctrl_n iqmod_mixer_0.iqmod_mixer_half_1.iqmod_mixer_se2diff$1_0.iqmod_mixer_se2diff_half_tg$2_0.iqmod_mixer_se2diff_inv_NF54$6_0.vin VSS VSS sg13_lv_nmos ad=0.19p pd=1.38u as=0.19p ps=1.38u w=1u l=0.13u
X1114 iqmod_mixer_0.iqmod_mixer_half_1.iqmod_mixer_tg$1_0.di_tg_ctrl iqmod_mixer_0.iqmod_mixer_half_1.iqmod_mixer_se2diff$1_0.iqmod_mixer_se2diff_half_inv$2_0.iqmod_mixer_se2diff_inv_NF54$7_0.vin VSS VSS sg13_lv_nmos ad=0.19p pd=1.38u as=0.19p ps=1.38u w=1u l=0.13u
X1115 iqmod_mixer_0.vinp_IF iqmod_mfb_lpf_0.iqmod_mfb_lpf_half_0.iqmod_mfb_lpf_ota_core_hybrid_bm_half$1_0.iqmod_mfb_lpf_ota_core_tg$2_0.v_b VSS VSS sg13_lv_nmos ad=0.19p pd=1.38u as=0.19p ps=1.38u w=1u l=1u
X1116 iqmod_mixer_0.iqmod_mixer_half_0.iqmod_mixer_tg$1_0.di_tg_ctrl_n iqmod_mixer_0.iqmod_mixer_half_0.iqmod_mixer_se2diff$1_0.iqmod_mixer_se2diff_half_tg$2_0.iqmod_mixer_se2diff_inv_NF54$6_0.vin VSS VSS sg13_lv_nmos ad=0.19p pd=1.38u as=0.19p ps=1.38u w=1u l=0.13u
X1117 VSS VSS VSS VSS sg13_lv_nmos ad=0.19p pd=1.38u as=0 ps=0 w=1u l=1u
X1118 iqmod_mixer_0.iqmod_mixer_half_1.iqmod_mixer_se2diff$1_0.iqmod_mixer_se2diff_half_inv$2_0.iqmod_mixer_se2diff_inv_NF18$7_0.vin iqmod_mixer_0.iqmod_mixer_half_1.iqmod_mixer_se2diff$1_0.iqmod_mixer_se2diff_half_inv$2_0.iqmod_mixer_se2diff_inv_NF6$7_1.vin VSS VSS sg13_lv_nmos ad=0.19p pd=1.38u as=0.19p ps=1.38u w=1u l=0.13u
X1119 VSS iqmod_mixer_0.iqmod_mixer_half_1.iqmod_mixer_se2diff$1_0.iqmod_mixer_se2diff_half_inv$2_0.iqmod_mixer_se2diff_inv_NF54$7_0.vin iqmod_mixer_0.iqmod_mixer_half_1.iqmod_mixer_tg$1_0.di_tg_ctrl VSS sg13_lv_nmos ad=0.19p pd=1.38u as=0.19p ps=1.38u w=1u l=0.13u
X1120 VSS iqmod_mixer_0.iqmod_mixer_half_0.iqmod_mixer_se2diff$1_0.iqmod_mixer_se2diff_half_inv$2_0.iqmod_mixer_se2diff_inv_NF18$7_0.vin iqmod_mixer_0.iqmod_mixer_half_0.iqmod_mixer_se2diff$1_0.iqmod_mixer_se2diff_half_inv$2_0.iqmod_mixer_se2diff_inv_NF54$7_0.vin VSS sg13_lv_nmos ad=0.19p pd=1.38u as=0.19p ps=1.38u w=1u l=0.13u
X1121 iqmod_mixer_0.iqmod_mixer_half_0.iqmod_mixer_tg$1_0.di_tg_ctrl iqmod_mixer_0.iqmod_mixer_half_0.iqmod_mixer_se2diff$1_0.iqmod_mixer_se2diff_half_inv$2_0.iqmod_mixer_se2diff_inv_NF54$7_0.vin VDD VDD sg13_lv_pmos ad=0.57p pd=3.38u as=0.57p ps=3.38u w=3u l=0.13u
X1122 iqmod_mixer_0.iqmod_mixer_half_1.iqmod_mixer_se2diff$1_0.iqmod_mixer_se2diff_half_inv$2_0.iqmod_mixer_se2diff_inv_NF6$7_1.vin iqmod_mixer_0.iqmod_mixer_half_1.iqmod_mixer_se2diff$1_0.iqmod_mixer_se2diff_half_inv$2_0.iqmod_mixer_se2diff_inv_NF6$7_0.vout VDD VDD sg13_lv_pmos ad=0.57p pd=3.38u as=0.57p ps=3.38u w=3u l=0.13u
X1123 VDD iqmod_mixer_0.iqmod_mixer_half_1.iqmod_mixer_se2diff$1_0.iqmod_mixer_se2diff_half_inv$2_0.iqmod_mixer_se2diff_inv_NF54$7_0.vin iqmod_mixer_0.iqmod_mixer_half_1.iqmod_mixer_tg$1_0.di_tg_ctrl VDD sg13_lv_pmos ad=0.57p pd=3.38u as=0.57p ps=3.38u w=3u l=0.13u
X1124 VDD iqmod_mixer_0.iqmod_mixer_half_1.iqmod_mixer_se2diff$1_0.iqmod_mixer_se2diff_half_inv$2_0.iqmod_mixer_se2diff_inv_NF6$7_0.vin iqmod_mixer_0.iqmod_mixer_half_1.iqmod_mixer_se2diff$1_0.iqmod_mixer_se2diff_half_inv$2_0.iqmod_mixer_se2diff_inv_NF6$7_0.vout VDD sg13_lv_pmos ad=0.57p pd=3.38u as=0.57p ps=3.38u w=3u l=0.13u
X1125 iqmod_mixer_0.iqmod_mixer_half_0.iqmod_mixer_se2diff$1_0.iqmod_mixer_se2diff_half_inv$2_0.iqmod_mixer_se2diff_inv_NF18$7_0.vin iqmod_mixer_0.iqmod_mixer_half_0.iqmod_mixer_se2diff$1_0.iqmod_mixer_se2diff_half_inv$2_0.iqmod_mixer_se2diff_inv_NF6$7_1.vin VDD VDD sg13_lv_pmos ad=0.57p pd=3.38u as=0.57p ps=3.38u w=3u l=0.13u
X1126 VDD iqmod_mixer_0.iqmod_mixer_half_0.iqmod_mixer_se2diff$1_0.iqmod_mixer_se2diff_half_inv$2_0.iqmod_mixer_se2diff_inv_NF54$7_0.vin iqmod_mixer_0.iqmod_mixer_half_0.iqmod_mixer_tg$1_0.di_tg_ctrl VDD sg13_lv_pmos ad=0.57p pd=3.38u as=0.57p ps=3.38u w=3u l=0.13u
X1127 VDD iqmod_mfb_lpf_0.iqmod_mfb_lpf_half_1.iqmod_mfb_lpf_ota_core_hybrid_bm_half$1_0.iqmod_mfb_lpf_ota_core_spdt_switch$2_0.iqmod_mfb_lpf_ota_core_spdt_switch_inv$3_0.vout iqmod_mfb_lpf_0.iqmod_mfb_lpf_half_1.iqmod_mfb_lpf_ota_core_hybrid_bm_half$1_0.iqmod_mfb_lpf_ota_core_inv_NF20$2_1.vin VDD sg13_lv_pmos ad=2.04p pd=12.68u as=1.14p ps=6.38u w=6u l=0.13u
X1128 VSS iqmod_mixer_0.iqmod_mixer_half_1.iqmod_mixer_se2diff$1_0.iqmod_mixer_se2diff_half_inv$2_0.iqmod_mixer_se2diff_inv_NF6$7_1.vin iqmod_mixer_0.iqmod_mixer_half_1.iqmod_mixer_se2diff$1_0.iqmod_mixer_se2diff_half_inv$2_0.iqmod_mixer_se2diff_inv_NF18$7_0.vin VSS sg13_lv_nmos ad=0.19p pd=1.38u as=0.19p ps=1.38u w=1u l=0.13u
X1129 iqmod_mfb_lpf_0.iqmod_mfb_lpf_half_0.iqmod_mfb_lpf_ota_core_hybrid_bm_half$1_0.iqmod_mfb_lpf_ota_core_tg$2_0.v_a iqmod_mfb_lpf_0.iqmod_mfb_lpf_half_0.iqmod_mfb_lpf_ota_core_hybrid_bm_half$1_0.iqmod_mfb_lpf_ota_core_tg$2_0.di_tg_ctrl_n iqmod_mfb_lpf_0.iqmod_mfb_lpf_half_0.iqmod_mfb_lpf_ota_core_hybrid_bm_half$1_0.iqmod_mfb_lpf_ota_core_tg$2_0.v_b VDD sg13_lv_pmos ad=1.14p pd=6.38u as=1.14p ps=6.38u w=6u l=0.13u
X1130 iqmod_mixer_0.iqmod_mixer_half_0.iqmod_mixer_se2diff$1_0.iqmod_mixer_se2diff_half_inv$2_0.iqmod_mixer_se2diff_inv_NF54$7_0.vin iqmod_mixer_0.iqmod_mixer_half_0.iqmod_mixer_se2diff$1_0.iqmod_mixer_se2diff_half_inv$2_0.iqmod_mixer_se2diff_inv_NF18$7_0.vin VSS VSS sg13_lv_nmos ad=0.19p pd=1.38u as=0.19p ps=1.38u w=1u l=0.13u
X1131 iqmod_mixer_0.iqmod_mixer_half_1.iqmod_mixer_se2diff$1_0.iqmod_mixer_se2diff_half_tg$2_0.iqmod_mixer_se2diff_tg_NF6$3_0.v_b VSS iqmod_mixer_0.iqmod_mixer_half_1.iqmod_mixer_se2diff$1_0.iqmod_mixer_se2diff_half_inv$2_0.iqmod_mixer_se2diff_inv_NF6$7_0.vin VDD sg13_lv_pmos ad=0.57p pd=3.38u as=0.57p ps=3.38u w=3u l=0.13u
X1132 voutp_I_RF iqmod_mixer_0.iqmod_mixer_half_1.iqmod_mixer_tg$1_0.di_tg_ctrl voutp_I_RF VDD sg13_lv_pmos ad=1.71p pd=9.38u as=0 ps=0 w=9u l=0.13u
X1133 iqmod_mixer_0.iqmod_mixer_half_0.iqmod_mixer_se2diff$1_0.iqmod_mixer_se2diff_half_tg$2_0.iqmod_mixer_se2diff_inv_NF54$6_0.vin iqmod_mixer_0.iqmod_mixer_half_0.iqmod_mixer_se2diff$1_0.iqmod_mixer_se2diff_half_tg$2_0.iqmod_mixer_se2diff_inv_NF18$6_0.vin VDD VDD sg13_lv_pmos ad=0.57p pd=3.38u as=0.57p ps=3.38u w=3u l=0.13u
X1134 VDD iqmod_mixer_0.iqmod_mixer_half_0.iqmod_mixer_se2diff$1_0.iqmod_mixer_se2diff_half_inv$2_0.iqmod_mixer_se2diff_inv_NF6$7_1.vin iqmod_mixer_0.iqmod_mixer_half_0.iqmod_mixer_se2diff$1_0.iqmod_mixer_se2diff_half_inv$2_0.iqmod_mixer_se2diff_inv_NF18$7_0.vin VDD sg13_lv_pmos ad=0.57p pd=3.38u as=0.57p ps=3.38u w=3u l=0.13u
X1135 VDD iqmod_mixer_0.vinn_IF iqmod_mfb_lpf_0.iqmod_mfb_lpf_half_0.iqmod_mfb_lpf_ota_core_hybrid_bm_half$1_0.iqmod_mfb_lpf_ota_core_inv_NF20$2_0.vout VDD sg13_lv_pmos ad=1.14p pd=6.38u as=1.14p ps=6.38u w=6u l=1u
X1136 VSS VSS VSS rhigh l=59u w=0.5u
X1137 iqmod_mfb_lpf_0.iqmod_mfb_lpf_half_1.iqmod_mfb_lpf_ota_core_hybrid_bm_half$1_0.iqmod_mfb_lpf_ota_core_inv_NF20$2_1.vin iqmod_mfb_lpf_0.iqmod_mfb_lpf_half_1.iqmod_mfb_lpf_ota_core_hybrid_bm_half$1_0.iqmod_mfb_lpf_ota_core_spdt_switch$2_0.iqmod_mfb_lpf_ota_core_spdt_switch_inv$3_0.vout VDD VDD sg13_lv_pmos ad=1.14p pd=6.38u as=1.14p ps=6.38u w=6u l=0.13u
X1138 iqmod_mfb_lpf_0.iqmod_mfb_lpf_half_0.iqmod_mfb_lpf_ota_core_hybrid_bm_half$1_0.iqmod_mfb_lpf_ota_core_tg$2_0.v_b iqmod_mfb_lpf_0.iqmod_mfb_lpf_half_0.iqmod_mfb_lpf_ota_core_hybrid_bm_half$1_0.iqmod_mfb_lpf_ota_core_tg$2_0.di_tg_ctrl_n iqmod_mfb_lpf_0.iqmod_mfb_lpf_half_0.iqmod_mfb_lpf_ota_core_hybrid_bm_half$1_0.iqmod_mfb_lpf_ota_core_tg$2_0.v_a VDD sg13_lv_pmos ad=1.14p pd=6.38u as=2.04p ps=12.68u w=6u l=0.13u
X1139 VDD iqmod_mixer_0.iqmod_mixer_half_1.iqmod_mixer_se2diff$1_0.iqmod_mixer_se2diff_half_inv$2_0.iqmod_mixer_se2diff_inv_NF54$7_0.vin iqmod_mixer_0.iqmod_mixer_half_1.iqmod_mixer_tg$1_0.di_tg_ctrl VDD sg13_lv_pmos ad=0.57p pd=3.38u as=0.57p ps=3.38u w=3u l=0.13u
X1140 VDD iqmod_mixer_0.iqmod_mixer_half_1.iqmod_mixer_se2diff$1_0.iqmod_mixer_se2diff_half_inv$2_0.iqmod_mixer_se2diff_inv_NF54$7_0.vin iqmod_mixer_0.iqmod_mixer_half_1.iqmod_mixer_tg$1_0.di_tg_ctrl VDD sg13_lv_pmos ad=0.57p pd=3.38u as=0.57p ps=3.38u w=3u l=0.13u
X1141 iqmod_mfb_lpf_0.iqmod_mfb_lpf_half_0.iqmod_mfb_lpf_R3$1_0.v_a iqmod_mfb_lpf_0.iqmod_mfb_lpf_half_0.C2_half cap_cmim l=8u w=8u
X1142 iqmod_mixer_0.iqmod_mixer_half_1.iqmod_mixer_se2diff$1_0.iqmod_mixer_se2diff_half_inv$2_0.iqmod_mixer_se2diff_inv_NF6$7_0.vin VSS iqmod_mixer_0.iqmod_mixer_half_1.iqmod_mixer_se2diff$1_0.iqmod_mixer_se2diff_half_tg$2_0.iqmod_mixer_se2diff_tg_NF6$3_0.v_b VDD sg13_lv_pmos ad=0.57p pd=3.38u as=0.57p ps=3.38u w=3u l=0.13u
X1143 VDD iqmod_mixer_0.iqmod_mixer_half_0.iqmod_mixer_se2diff$1_0.iqmod_mixer_se2diff_half_tg$2_0.iqmod_mixer_se2diff_inv_NF18$6_0.vin iqmod_mixer_0.iqmod_mixer_half_0.iqmod_mixer_se2diff$1_0.iqmod_mixer_se2diff_half_tg$2_0.iqmod_mixer_se2diff_inv_NF54$6_0.vin VDD sg13_lv_pmos ad=0.57p pd=3.38u as=0.57p ps=3.38u w=3u l=0.13u
X1144 VDD iqmod_mfb_lpf_0.iqmod_mfb_lpf_half_0.iqmod_mfb_lpf_ota_core_hybrid_bm_half$1_0.iqmod_mfb_lpf_ota_core_inv_NF20$2_1.vin iqmod_mfb_lpf_0.iqmod_mfb_lpf_half_0.iqmod_mfb_lpf_ota_core_hybrid_bm_half$1_0.iqmod_mfb_lpf_ota_core_tg$2_0.v_a VDD sg13_lv_pmos ad=1.14p pd=6.38u as=1.14p ps=6.38u w=6u l=1u
X1145 iqmod_mfb_lpf_0.iqmod_mfb_lpf_half_0.iqmod_mfb_lpf_ota_core_hybrid_bm_half$1_0.iqmod_mfb_lpf_ota_core_tg$2_0.v_b iqmod_mfb_lpf_0.iqmod_mfb_lpf_half_0.iqmod_mfb_lpf_ota_core_hybrid_bm_half$1_0.iqmod_mfb_lpf_ota_core_tg$2_0.v_a VDD VDD sg13_lv_pmos ad=1.14p pd=6.38u as=1.14p ps=6.38u w=6u l=1u
X1146 VSS iqmod_mixer_0.iqmod_mixer_half_0.iqmod_mixer_se2diff$1_0.iqmod_mixer_se2diff_half_inv$2_0.iqmod_mixer_se2diff_inv_NF54$7_0.vin iqmod_mixer_0.iqmod_mixer_half_0.iqmod_mixer_tg$1_0.di_tg_ctrl VSS sg13_lv_nmos ad=0.19p pd=1.38u as=0.19p ps=1.38u w=1u l=0.13u
X1147 iqmod_mixer_0.vinp_IF iqmod_mfb_lpf_0.iqmod_mfb_lpf_half_1.iqmod_mfb_lpf_ota_core_hybrid_bm_half$1_0.iqmod_mfb_lpf_ota_core_inv_NF20$2_1.vin VDD VDD sg13_lv_pmos ad=1.14p pd=6.38u as=1.14p ps=6.38u w=6u l=1u
X1148 VDD VDD VDD VDD sg13_lv_pmos ad=2.04p pd=12.68u as=0 ps=0 w=6u l=0.13u
X1149 iqmod_mfb_lpf_0.iqmod_mfb_lpf_half_0.iqmod_mfb_lpf_ota_core_hybrid_bm_half$1_0.iqmod_mfb_lpf_ota_core_inv_NF6$2_1.vout iqmod_mfb_lpf_0.iqmod_mfb_lpf_half_0.iqmod_mfb_lpf_ota_core_hybrid_bm_half$1_0.iqmod_mfb_lpf_ota_core_inv_NF20$2_0.vout VSS VSS sg13_lv_nmos ad=0.19p pd=1.38u as=0.19p ps=1.38u w=1u l=1u
X1150 VSS iqmod_mixer_0.vinp_IF iqmod_mfb_lpf_0.iqmod_mfb_lpf_half_0.iqmod_mfb_lpf_ota_core_hybrid_bm_half$1_0.iqmod_mfb_lpf_ota_core_inv_NF20$2_0.vout VSS sg13_lv_nmos ad=0.19p pd=1.38u as=0.19p ps=1.38u w=1u l=1u
X1151 iqmod_mixer_0.vinp_IF iqmod_mfb_lpf_0.iqmod_mfb_lpf_half_0.iqmod_mfb_lpf_ota_core_hybrid_bm_half$1_0.iqmod_mfb_lpf_ota_core_tg$2_0.v_b VSS VSS sg13_lv_nmos ad=0.19p pd=1.38u as=0.19p ps=1.38u w=1u l=1u
X1152 di_ds_I_p iqmod_spdt_switch_1.spdt_switch_inv_0.vout iqmod_spdt_switch_1.v_c VDD sg13_lv_pmos ad=2.04p pd=12.68u as=1.14p ps=6.38u w=6u l=0.13u
X1153 VSS VSS VSS VSS sg13_lv_nmos ad=0.19p pd=1.38u as=0 ps=0 w=1u l=0.13u
X1154 VSS iqmod_mixer_0.iqmod_mixer_half_0.iqmod_mixer_se2diff$1_0.iqmod_mixer_se2diff_half_inv$2_0.iqmod_mixer_se2diff_inv_NF2$7_1.vout iqmod_mixer_0.iqmod_mixer_half_0.iqmod_mixer_se2diff$1_0.iqmod_mixer_se2diff_half_tg$2_0.iqmod_mixer_se2diff_inv_NF18$6_0.vin VSS sg13_lv_nmos ad=0.19p pd=1.38u as=0.19p ps=1.38u w=1u l=0.13u
X1155 iqmod_mfb_lpf_0.iqmod_mfb_lpf_half_0.iqmod_mfb_lpf_ota_core_hybrid_bm_half$1_0.iqmod_mfb_lpf_ota_core_inv_NF20$2_1.vin iqmod_mfb_lpf_0.iqmod_mfb_lpf_half_0.iqmod_mfb_lpf_ota_core_hybrid_bm_half$1_0.iqmod_mfb_lpf_ota_core_spdt_switch$2_0.iqmod_mfb_lpf_ota_core_spdt_switch_inv$3_0.vout iqmod_spdt_switch_1.v_c VSS sg13_lv_nmos ad=0.19p pd=1.38u as=0.19p ps=1.38u w=1u l=0.13u
X1156 iqmod_mixer_0.iqmod_mixer_half_1.iqmod_mixer_se2diff$1_0.iqmod_mixer_se2diff_half_inv$2_0.iqmod_mixer_se2diff_inv_NF6$7_0.vout iqmod_mixer_0.iqmod_mixer_half_1.iqmod_mixer_se2diff$1_0.iqmod_mixer_se2diff_half_inv$2_0.iqmod_mixer_se2diff_inv_NF6$7_0.vin VSS VSS sg13_lv_nmos ad=0.19p pd=1.38u as=0.19p ps=1.38u w=1u l=0.13u
X1157 iqmod_mfb_lpf_0.iqmod_mfb_lpf_half_0.iqmod_mfb_lpf_ota_core_hybrid_bm_half$1_0.iqmod_mfb_lpf_ota_core_inv_NF20$2_0.vout iqmod_mixer_0.vinn_IF VDD VDD sg13_lv_pmos ad=1.14p pd=6.38u as=1.14p ps=6.38u w=6u l=1u
X1158 iqmod_mixer_0.iqmod_mixer_half_0.iqmod_mixer_tg$1_0.di_tg_ctrl_n iqmod_mixer_0.iqmod_mixer_half_0.iqmod_mixer_se2diff$1_0.iqmod_mixer_se2diff_half_tg$2_0.iqmod_mixer_se2diff_inv_NF54$6_0.vin VSS VSS sg13_lv_nmos ad=0.19p pd=1.38u as=0.19p ps=1.38u w=1u l=0.13u
X1159 VDD iqmod_mfb_lpf_0.iqmod_mfb_lpf_half_0.iqmod_mfb_lpf_ota_core_hybrid_bm_half$1_0.iqmod_mfb_lpf_ota_core_inv_NF6$2_1.vout iqmod_mfb_lpf_0.iqmod_mfb_lpf_half_0.iqmod_mfb_lpf_ota_core_hybrid_bm_half$1_0.iqmod_mfb_lpf_ota_core_tg$2_0.v_b VDD sg13_lv_pmos ad=1.14p pd=6.38u as=1.14p ps=6.38u w=6u l=1u
X1160 iqmod_mixer_0.vinp_IF iqmod_mfb_lpf_0.iqmod_mfb_lpf_half_1.iqmod_mfb_lpf_ota_core_hybrid_bm_half$1_0.iqmod_mfb_lpf_ota_core_inv_NF20$2_1.vin VSS VSS sg13_lv_nmos ad=0.19p pd=1.38u as=0.19p ps=1.38u w=1u l=1u
X1161 iqmod_mixer_0.iqmod_mixer_half_1.iqmod_mixer_tg$1_0.di_tg_ctrl_n iqmod_mixer_0.iqmod_mixer_half_1.iqmod_mixer_se2diff$1_0.iqmod_mixer_se2diff_half_tg$2_0.iqmod_mixer_se2diff_inv_NF54$6_0.vin VDD VDD sg13_lv_pmos ad=0.57p pd=3.38u as=0.57p ps=3.38u w=3u l=0.13u
X1162 VSS iqmod_mixer_0.vinn_IF iqmod_mfb_lpf_0.iqmod_mfb_lpf_half_0.iqmod_mfb_lpf_ota_core_hybrid_bm_half$1_0.iqmod_mfb_lpf_ota_core_inv_NF20$2_0.vout VSS sg13_lv_nmos ad=0.19p pd=1.38u as=0.19p ps=1.38u w=1u l=1u
X1163 VSS VSS VSS VSS sg13_lv_nmos ad=0.34p pd=2.68u as=0 ps=0 w=1u l=0.13u
X1164 VDD iqmod_mixer_0.iqmod_mixer_half_1.iqmod_mixer_se2diff$1_0.iqmod_mixer_se2diff_half_inv$2_0.iqmod_mixer_se2diff_inv_NF54$7_0.vin iqmod_mixer_0.iqmod_mixer_half_1.iqmod_mixer_tg$1_0.di_tg_ctrl VDD sg13_lv_pmos ad=0.57p pd=3.38u as=0.57p ps=3.38u w=3u l=0.13u
X1165 iqmod_mixer_0.iqmod_mixer_half_0.iqmod_mixer_tg$1_0.di_tg_ctrl iqmod_mixer_0.iqmod_mixer_half_0.iqmod_mixer_se2diff$1_0.iqmod_mixer_se2diff_half_inv$2_0.iqmod_mixer_se2diff_inv_NF54$7_0.vin VSS VSS sg13_lv_nmos ad=0.19p pd=1.38u as=0.19p ps=1.38u w=1u l=0.13u
X1166 iqmod_mfb_lpf_0.iqmod_mfb_lpf_half_0.iqmod_mfb_lpf_ota_core_hybrid_bm_half$1_0.iqmod_mfb_lpf_ota_core_inv_NF6$2_1.vout iqmod_mfb_lpf_0.iqmod_mfb_lpf_half_0.iqmod_mfb_lpf_ota_core_hybrid_bm_half$1_0.iqmod_mfb_lpf_ota_core_inv_NF20$2_0.vout VSS VSS sg13_lv_nmos ad=0.19p pd=1.38u as=0.19p ps=1.38u w=1u l=1u
X1167 iqmod_mixer_0.iqmod_mixer_half_0.iqmod_mixer_tg$1_0.di_tg_ctrl_n iqmod_mixer_0.iqmod_mixer_half_0.iqmod_mixer_se2diff$1_0.iqmod_mixer_se2diff_half_tg$2_0.iqmod_mixer_se2diff_inv_NF54$6_0.vin VDD VDD sg13_lv_pmos ad=0.57p pd=3.38u as=0.57p ps=3.38u w=3u l=0.13u
X1168 voutn_I_RF iqmod_mixer_0.iqmod_mixer_half_0.iqmod_mixer_tg$1_0.di_tg_ctrl_n iqmod_mixer_0.vinn_IF VDD sg13_lv_pmos ad=1.71p pd=9.38u as=1.71p ps=9.38u w=9u l=0.13u
X1169 VSS iqmod_mixer_0.iqmod_mixer_half_1.iqmod_mixer_se2diff$1_0.iqmod_mixer_se2diff_half_tg$2_0.iqmod_mixer_se2diff_inv_NF54$6_0.vin iqmod_mixer_0.iqmod_mixer_half_1.iqmod_mixer_tg$1_0.di_tg_ctrl_n VSS sg13_lv_nmos ad=0.19p pd=1.38u as=0.19p ps=1.38u w=1u l=0.13u
X1170 iqmod_mixer_0.iqmod_mixer_half_0.iqmod_mixer_se2diff$1_0.iqmod_mixer_se2diff_half_inv$2_0.iqmod_mixer_se2diff_inv_NF6$7_0.vout iqmod_mixer_0.iqmod_mixer_half_0.iqmod_mixer_se2diff$1_0.iqmod_mixer_se2diff_half_inv$2_0.iqmod_mixer_se2diff_inv_NF6$7_0.vin VDD VDD sg13_lv_pmos ad=0.57p pd=3.38u as=0.57p ps=3.38u w=3u l=0.13u
X1171 VSS iqmod_mixer_0.iqmod_mixer_half_1.iqmod_mixer_se2diff$1_0.iqmod_mixer_se2diff_half_inv$2_0.iqmod_mixer_se2diff_inv_NF6$7_0.vin iqmod_mixer_0.iqmod_mixer_half_1.iqmod_mixer_se2diff$1_0.iqmod_mixer_se2diff_half_inv$2_0.iqmod_mixer_se2diff_inv_NF6$7_0.vout VSS sg13_lv_nmos ad=0.19p pd=1.38u as=0.19p ps=1.38u w=1u l=0.13u
X1172 iqmod_mixer_0.iqmod_mixer_half_0.iqmod_mixer_se2diff$1_0.iqmod_mixer_se2diff_half_tg$2_0.iqmod_mixer_se2diff_inv_NF18$6_0.vin iqmod_mixer_0.iqmod_mixer_half_0.iqmod_mixer_se2diff$1_0.iqmod_mixer_se2diff_half_inv$2_0.iqmod_mixer_se2diff_inv_NF2$7_1.vout VSS VSS sg13_lv_nmos ad=0.19p pd=1.38u as=0.19p ps=1.38u w=1u l=0.13u
X1173 VSS iqmod_mfb_lpf_0.iqmod_mfb_lpf_half_0.iqmod_mfb_lpf_ota_core_hybrid_bm_half$1_0.iqmod_mfb_lpf_ota_core_inv_NF20$2_1.vin iqmod_mfb_lpf_0.iqmod_mfb_lpf_half_0.iqmod_mfb_lpf_ota_core_hybrid_bm_half$1_0.iqmod_mfb_lpf_ota_core_tg$2_0.v_a VSS sg13_lv_nmos ad=0.19p pd=1.38u as=0.19p ps=1.38u w=1u l=1u
X1174 iqmod_spdt_switch_1.v_c iqmod_mfb_lpf_0.iqmod_mfb_lpf_half_0.iqmod_mfb_lpf_ota_core_hybrid_bm_half$1_0.iqmod_mfb_lpf_ota_core_spdt_switch$2_0.iqmod_mfb_lpf_ota_core_spdt_switch_inv$3_0.vout iqmod_mfb_lpf_0.iqmod_mfb_lpf_half_0.iqmod_mfb_lpf_ota_core_hybrid_bm_half$1_0.iqmod_mfb_lpf_ota_core_inv_NF20$2_1.vin VSS sg13_lv_nmos ad=0.19p pd=1.38u as=0.19p ps=1.38u w=1u l=0.13u
X1175 VDD iqmod_mixer_0.iqmod_mixer_half_0.iqmod_mixer_se2diff$1_0.iqmod_mixer_se2diff_half_inv$2_0.iqmod_mixer_se2diff_inv_NF2$7_1.vout iqmod_mixer_0.iqmod_mixer_half_0.iqmod_mixer_se2diff$1_0.iqmod_mixer_se2diff_half_inv$2_0.iqmod_mixer_se2diff_inv_NF6$7_1.vin VDD sg13_lv_pmos ad=0.57p pd=3.38u as=0.57p ps=3.38u w=3u l=0.13u
X1176 VSS VSS VSS VSS sg13_lv_nmos ad=0.19p pd=1.38u as=0 ps=0 w=1u l=1u
X1177 VDD iqmod_mfb_lpf_0.iqmod_mfb_lpf_half_1.iqmod_mfb_lpf_ota_core_hybrid_bm_half$1_0.iqmod_mfb_lpf_ota_core_inv_NF20$2_1.vin iqmod_mixer_0.vinp_IF VDD sg13_lv_pmos ad=1.14p pd=6.38u as=1.14p ps=6.38u w=6u l=1u
X1178 voutn_I_RF iqmod_mixer_0.iqmod_mixer_half_0.iqmod_mixer_tg$1_0.di_tg_ctrl voutn_I_RF VDD sg13_lv_pmos ad=1.71p pd=9.38u as=0 ps=0 w=9u l=0.13u
X1179 VDD iqmod_mixer_0.iqmod_mixer_half_0.iqmod_mixer_se2diff$1_0.iqmod_mixer_se2diff_half_tg$2_0.iqmod_mixer_se2diff_inv_NF54$6_0.vin iqmod_mixer_0.iqmod_mixer_half_0.iqmod_mixer_tg$1_0.di_tg_ctrl_n VDD sg13_lv_pmos ad=0.57p pd=3.38u as=0.57p ps=3.38u w=3u l=0.13u
X1180 VDD iqmod_mixer_0.iqmod_mixer_half_0.iqmod_mixer_se2diff$1_0.iqmod_mixer_se2diff_half_inv$2_0.iqmod_mixer_se2diff_inv_NF6$7_0.vin iqmod_mixer_0.iqmod_mixer_half_0.iqmod_mixer_se2diff$1_0.iqmod_mixer_se2diff_half_inv$2_0.iqmod_mixer_se2diff_inv_NF6$7_0.vout VDD sg13_lv_pmos ad=0.57p pd=3.38u as=0.57p ps=3.38u w=3u l=0.13u
X1181 iqmod_mixer_0.vinn_IF iqmod_mixer_0.iqmod_mixer_half_0.iqmod_mixer_tg$1_0.di_tg_ctrl_n voutn_I_RF VDD sg13_lv_pmos ad=1.71p pd=9.38u as=1.71p ps=9.38u w=9u l=0.13u
X1182 voutn_I_RF iqmod_mixer_0.iqmod_mixer_half_0.iqmod_mixer_tg$1_0.di_tg_ctrl_n voutn_I_RF VSS sg13_lv_nmos ad=0.57p pd=3.38u as=0 ps=0 w=3u l=0.13u
X1183 iqmod_mfb_lpf_0.iqmod_mfb_lpf_half_0.iqmod_mfb_lpf_ota_core_hybrid_bm_half$1_0.iqmod_mfb_lpf_ota_core_inv_NF20$2_0.vout iqmod_mixer_0.vinp_IF VSS VSS sg13_lv_nmos ad=0.19p pd=1.38u as=0.19p ps=1.38u w=1u l=1u
X1184 VSS iqmod_mfb_lpf_0.iqmod_mfb_lpf_half_1.iqmod_mfb_lpf_ota_core_hybrid_bm_half$1_0.iqmod_mfb_lpf_ota_core_inv_NF20$2_1.vin iqmod_mixer_0.vinp_IF VSS sg13_lv_nmos ad=0.19p pd=1.38u as=0.19p ps=1.38u w=1u l=1u
X1185 VDD iqmod_mixer_0.vinn_IF iqmod_mfb_lpf_0.iqmod_mfb_lpf_half_0.iqmod_mfb_lpf_ota_core_hybrid_bm_half$1_0.iqmod_mfb_lpf_ota_core_inv_NF20$2_0.vout VDD sg13_lv_pmos ad=1.14p pd=6.38u as=1.14p ps=6.38u w=6u l=1u
X1186 VDD iqmod_mixer_0.iqmod_mixer_half_1.iqmod_mixer_se2diff$1_0.iqmod_mixer_se2diff_half_inv$2_0.iqmod_mixer_se2diff_inv_NF54$7_0.vin iqmod_mixer_0.iqmod_mixer_half_1.iqmod_mixer_tg$1_0.di_tg_ctrl VDD sg13_lv_pmos ad=0.57p pd=3.38u as=0.57p ps=3.38u w=3u l=0.13u
X1187 voutp_I_RF iqmod_mixer_0.iqmod_mixer_half_1.iqmod_mixer_tg$1_0.di_tg_ctrl_n iqmod_mixer_0.vinp_IF VDD sg13_lv_pmos ad=1.71p pd=9.38u as=1.71p ps=9.38u w=9u l=0.13u
X1188 VDD di_spdt_ctrl_I iqmod_spdt_switch_0.spdt_switch_inv_0.vin VDD sg13_lv_pmos ad=1.14p pd=6.38u as=1.14p ps=6.38u w=6u l=0.13u
X1189 iqmod_mixer_0.vinn_IF iqmod_mixer_0.iqmod_mixer_half_0.iqmod_mixer_tg$1_0.di_tg_ctrl voutn_I_RF VSS sg13_lv_nmos ad=0.57p pd=3.38u as=0.57p ps=3.38u w=3u l=0.13u
X1190 voutp_I_RF iqmod_mixer_0.iqmod_mixer_half_1.iqmod_mixer_tg$1_0.di_tg_ctrl voutp_I_RF VDD sg13_lv_pmos ad=1.71p pd=9.38u as=0 ps=0 w=9u l=0.13u
X1191 iqmod_mixer_0.iqmod_mixer_half_1.iqmod_mixer_tg$1_0.di_tg_ctrl iqmod_mixer_0.iqmod_mixer_half_1.iqmod_mixer_se2diff$1_0.iqmod_mixer_se2diff_half_inv$2_0.iqmod_mixer_se2diff_inv_NF54$7_0.vin VSS VSS sg13_lv_nmos ad=0.19p pd=1.38u as=0.19p ps=1.38u w=1u l=0.13u
X1192 VDD iqmod_mfb_lpf_0.iqmod_mfb_lpf_half_0.iqmod_mfb_lpf_ota_core_hybrid_bm_half$1_0.iqmod_mfb_lpf_ota_core_tg$2_0.di_tg_ctrl_n iqmod_mfb_lpf_0.iqmod_mfb_lpf_half_0.iqmod_mfb_lpf_ota_core_hybrid_bm_half$1_0.iqmod_mfb_lpf_ota_core_spdt_switch$2_0.iqmod_mfb_lpf_ota_core_spdt_switch_inv$3_0.vout VDD sg13_lv_pmos ad=1.14p pd=6.38u as=1.14p ps=6.38u w=6u l=0.13u
X1193 voutn_I_RF iqmod_mixer_0.iqmod_mixer_half_0.iqmod_mixer_tg$1_0.di_tg_ctrl_n iqmod_mixer_0.vinn_IF VDD sg13_lv_pmos ad=1.71p pd=9.38u as=1.71p ps=9.38u w=9u l=0.13u
X1194 VDD iqmod_mixer_0.iqmod_mixer_half_1.iqmod_mixer_se2diff$1_0.iqmod_mixer_se2diff_half_tg$2_0.iqmod_mixer_se2diff_inv_NF54$6_0.vin iqmod_mixer_0.iqmod_mixer_half_1.iqmod_mixer_tg$1_0.di_tg_ctrl_n VDD sg13_lv_pmos ad=0.57p pd=3.38u as=0.57p ps=3.38u w=3u l=0.13u
X1195 voutn_I_RF iqmod_mixer_0.iqmod_mixer_half_0.iqmod_mixer_tg$1_0.di_tg_ctrl_n voutn_I_RF VSS sg13_lv_nmos ad=0.57p pd=3.38u as=0 ps=0 w=3u l=0.13u
X1196 iqmod_mixer_0.iqmod_mixer_half_0.iqmod_mixer_tg$1_0.di_tg_ctrl iqmod_mixer_0.iqmod_mixer_half_0.iqmod_mixer_se2diff$1_0.iqmod_mixer_se2diff_half_inv$2_0.iqmod_mixer_se2diff_inv_NF54$7_0.vin VDD VDD sg13_lv_pmos ad=0.57p pd=3.38u as=0.57p ps=3.38u w=3u l=0.13u
X1197 VDD iqmod_mfb_lpf_0.iqmod_mfb_lpf_half_0.iqmod_mfb_lpf_ota_core_hybrid_bm_half$1_0.iqmod_mfb_lpf_ota_core_tg$2_0.v_b iqmod_mixer_0.vinn_IF VDD sg13_lv_pmos ad=1.14p pd=6.38u as=1.14p ps=6.38u w=6u l=1u
X1198 voutp_I_RF iqmod_mixer_0.iqmod_mixer_half_1.iqmod_mixer_tg$1_0.di_tg_ctrl iqmod_mixer_0.vinp_IF VSS sg13_lv_nmos ad=0.57p pd=3.38u as=0.57p ps=3.38u w=3u l=0.13u
X1199 iqmod_spdt_switch_1.v_c iqmod_spdt_switch_1.spdt_switch_inv_0.vin di_ds_I_p VSS sg13_lv_nmos ad=0.19p pd=1.38u as=0.34p ps=2.68u w=1u l=0.13u
X1200 vinp_I iqmod_spdt_switch_1.spdt_switch_inv_0.vout iqmod_spdt_switch_1.v_c VSS sg13_lv_nmos ad=0.19p pd=1.38u as=0.19p ps=1.38u w=1u l=0.13u
X1201 VSS VSS VSS VSS sg13_lv_nmos ad=0.19p pd=1.38u as=0 ps=0 w=1u l=0.13u
X1202 iqmod_mixer_0.iqmod_mixer_half_0.iqmod_mixer_se2diff$1_0.iqmod_mixer_se2diff_half_inv$2_0.iqmod_mixer_se2diff_inv_NF6$7_0.vin VDD iqmod_mixer_0.iqmod_mixer_half_0.iqmod_mixer_se2diff$1_0.iqmod_mixer_se2diff_half_tg$2_0.iqmod_mixer_se2diff_tg_NF6$3_0.v_b VSS sg13_lv_nmos ad=0.19p pd=1.38u as=0.19p ps=1.38u w=1u l=0.13u
X1203 VSS iqmod_mixer_0.vinp_IF iqmod_mfb_lpf_0.iqmod_mfb_lpf_half_0.iqmod_mfb_lpf_ota_core_hybrid_bm_half$1_0.iqmod_mfb_lpf_ota_core_inv_NF20$2_0.vout VSS sg13_lv_nmos ad=0.19p pd=1.38u as=0.19p ps=1.38u w=1u l=1u
X1204 iqmod_mixer_0.iqmod_mixer_half_1.iqmod_mixer_tg$1_0.di_tg_ctrl_n iqmod_mixer_0.iqmod_mixer_half_1.iqmod_mixer_se2diff$1_0.iqmod_mixer_se2diff_half_tg$2_0.iqmod_mixer_se2diff_inv_NF54$6_0.vin VDD VDD sg13_lv_pmos ad=0.57p pd=3.38u as=0.57p ps=3.38u w=3u l=0.13u
X1205 di_ds_I_p iqmod_spdt_switch_1.spdt_switch_inv_0.vout iqmod_spdt_switch_1.v_c VDD sg13_lv_pmos ad=1.14p pd=6.38u as=1.14p ps=6.38u w=6u l=0.13u
X1206 voutn_I_RF iqmod_mixer_0.iqmod_mixer_half_0.iqmod_mixer_tg$1_0.di_tg_ctrl_n voutn_I_RF VSS sg13_lv_nmos ad=0.57p pd=3.38u as=0 ps=0 w=3u l=0.13u
X1207 iqmod_mixer_0.vinp_IF iqmod_mfb_lpf_0.iqmod_mfb_lpf_half_1.iqmod_mfb_lpf_ota_core_hybrid_bm_half$1_0.iqmod_mfb_lpf_ota_core_inv_NF20$2_1.vin VSS VSS sg13_lv_nmos ad=0.19p pd=1.38u as=0.19p ps=1.38u w=1u l=1u
X1208 VSS VSS VSS VSS sg13_lv_nmos ad=0.34p pd=2.68u as=0 ps=0 w=1u l=0.13u
X1209 VDD iqmod_mfb_lpf_0.iqmod_mfb_lpf_half_0.iqmod_mfb_lpf_ota_core_hybrid_bm_half$1_0.iqmod_mfb_lpf_ota_core_inv_NF20$2_0.vout iqmod_mfb_lpf_0.iqmod_mfb_lpf_half_0.iqmod_mfb_lpf_ota_core_hybrid_bm_half$1_0.iqmod_mfb_lpf_ota_core_inv_NF6$2_1.vout VDD sg13_lv_pmos ad=1.14p pd=6.38u as=1.14p ps=6.38u w=6u l=1u
X1210 iqmod_mixer_0.iqmod_mixer_half_0.iqmod_mixer_tg$1_0.di_tg_ctrl iqmod_mixer_0.iqmod_mixer_half_0.iqmod_mixer_se2diff$1_0.iqmod_mixer_se2diff_half_inv$2_0.iqmod_mixer_se2diff_inv_NF54$7_0.vin VSS VSS sg13_lv_nmos ad=0.19p pd=1.38u as=0.19p ps=1.38u w=1u l=0.13u
X1211 iqmod_mixer_0.vinp_IF iqmod_mixer_0.iqmod_mixer_half_1.iqmod_mixer_tg$1_0.di_tg_ctrl voutp_I_RF VSS sg13_lv_nmos ad=0.57p pd=3.38u as=0.57p ps=3.38u w=3u l=0.13u
X1212 iqmod_mixer_0.vinn_IF iqmod_mixer_0.iqmod_mixer_half_0.iqmod_mixer_tg$1_0.di_tg_ctrl voutn_I_RF VSS sg13_lv_nmos ad=0.57p pd=3.38u as=1.02p ps=6.68u w=3u l=0.13u
X1213 iqmod_mixer_0.iqmod_mixer_half_0.iqmod_mixer_se2diff$1_0.iqmod_mixer_se2diff_half_tg$2_0.iqmod_mixer_se2diff_tg_NF6$3_0.v_b VDD iqmod_mixer_0.iqmod_mixer_half_0.iqmod_mixer_se2diff$1_0.iqmod_mixer_se2diff_half_inv$2_0.iqmod_mixer_se2diff_inv_NF6$7_0.vin VSS sg13_lv_nmos ad=0.19p pd=1.38u as=0.34p ps=2.68u w=1u l=0.13u
X1214 VDD di_lo_Ix iqmod_mixer_0.iqmod_mixer_half_0.iqmod_mixer_se2diff$1_0.iqmod_mixer_se2diff_half_inv$2_0.iqmod_mixer_se2diff_inv_NF6$7_0.vin VDD sg13_lv_pmos ad=0.57p pd=3.38u as=0.57p ps=3.38u w=3u l=0.13u
X1215 VDD VDD VDD VDD sg13_lv_pmos ad=2.04p pd=12.68u as=0 ps=0 w=6u l=1u
X1216 VDD iqmod_mixer_0.iqmod_mixer_half_1.iqmod_mixer_se2diff$1_0.iqmod_mixer_se2diff_half_tg$2_0.iqmod_mixer_se2diff_inv_NF54$6_0.vin iqmod_mixer_0.iqmod_mixer_half_1.iqmod_mixer_tg$1_0.di_tg_ctrl_n VDD sg13_lv_pmos ad=0.57p pd=3.38u as=0.57p ps=3.38u w=3u l=0.13u
X1217 VSS iqmod_mixer_0.iqmod_mixer_half_1.iqmod_mixer_se2diff$1_0.iqmod_mixer_se2diff_half_inv$2_0.iqmod_mixer_se2diff_inv_NF54$7_0.vin iqmod_mixer_0.iqmod_mixer_half_1.iqmod_mixer_tg$1_0.di_tg_ctrl VSS sg13_lv_nmos ad=0.19p pd=1.38u as=0.19p ps=1.38u w=1u l=0.13u
X1218 voutn_I_RF iqmod_mixer_0.iqmod_mixer_half_0.iqmod_mixer_tg$1_0.di_tg_ctrl voutn_I_RF VDD sg13_lv_pmos ad=1.71p pd=9.38u as=0 ps=0 w=9u l=0.13u
X1219 VDD iqmod_mixer_0.iqmod_mixer_half_0.iqmod_mixer_se2diff$1_0.iqmod_mixer_se2diff_half_inv$2_0.iqmod_mixer_se2diff_inv_NF54$7_0.vin iqmod_mixer_0.iqmod_mixer_half_0.iqmod_mixer_tg$1_0.di_tg_ctrl VDD sg13_lv_pmos ad=0.57p pd=3.38u as=0.57p ps=3.38u w=3u l=0.13u
X1220 VDD iqmod_mfb_lpf_0.iqmod_mfb_lpf_half_0.iqmod_mfb_lpf_ota_core_hybrid_bm_half$1_0.iqmod_mfb_lpf_ota_core_tg$2_0.v_a iqmod_mfb_lpf_0.iqmod_mfb_lpf_half_0.iqmod_mfb_lpf_ota_core_hybrid_bm_half$1_0.iqmod_mfb_lpf_ota_core_tg$2_0.v_b VDD sg13_lv_pmos ad=1.14p pd=6.38u as=1.14p ps=6.38u w=6u l=1u
X1221 iqmod_mixer_0.iqmod_mixer_half_1.iqmod_mixer_tg$1_0.di_tg_ctrl iqmod_mixer_0.iqmod_mixer_half_1.iqmod_mixer_se2diff$1_0.iqmod_mixer_se2diff_half_inv$2_0.iqmod_mixer_se2diff_inv_NF54$7_0.vin VSS VSS sg13_lv_nmos ad=0.19p pd=1.38u as=0.19p ps=1.38u w=1u l=0.13u
X1222 VSS iqmod_mixer_0.iqmod_mixer_half_0.iqmod_mixer_se2diff$1_0.iqmod_mixer_se2diff_half_tg$2_0.iqmod_mixer_se2diff_inv_NF54$6_0.vin iqmod_mixer_0.iqmod_mixer_half_0.iqmod_mixer_tg$1_0.di_tg_ctrl_n VSS sg13_lv_nmos ad=0.19p pd=1.38u as=0.19p ps=1.38u w=1u l=0.13u
X1223 iqmod_mixer_0.iqmod_mixer_half_0.iqmod_mixer_tg$1_0.di_tg_ctrl iqmod_mixer_0.iqmod_mixer_half_0.iqmod_mixer_se2diff$1_0.iqmod_mixer_se2diff_half_inv$2_0.iqmod_mixer_se2diff_inv_NF54$7_0.vin VDD VDD sg13_lv_pmos ad=0.57p pd=3.38u as=0.57p ps=3.38u w=3u l=0.13u
X1224 iqmod_mfb_lpf_0.iqmod_mfb_lpf_half_0.iqmod_mfb_lpf_ota_core_hybrid_bm_half$1_0.iqmod_mfb_lpf_ota_core_inv_NF20$2_0.vout iqmod_mfb_lpf_0.iqmod_mfb_lpf_half_1.iqmod_mfb_lpf_ota_core_hybrid_bm_half$1_0.iqmod_mfb_lpf_ota_core_tg$2_0.di_tg_ctrl_n iqmod_mfb_lpf_0.iqmod_mfb_lpf_half_0.iqmod_mfb_lpf_ota_core_hybrid_bm_half$1_0.iqmod_mfb_lpf_ota_core_inv_NF6$2_1.vout VDD sg13_lv_pmos ad=2.04p pd=12.68u as=1.14p ps=6.38u w=6u l=0.13u
X1225 VDD iqmod_mfb_lpf_0.iqmod_mfb_lpf_half_0.iqmod_mfb_lpf_ota_core_hybrid_bm_half$1_0.iqmod_mfb_lpf_ota_core_tg$2_0.v_b iqmod_mixer_0.vinn_IF VDD sg13_lv_pmos ad=1.14p pd=6.38u as=1.14p ps=6.38u w=6u l=1u
X1226 iqmod_mixer_0.iqmod_mixer_half_0.iqmod_mixer_tg$1_0.di_tg_ctrl_n iqmod_mixer_0.iqmod_mixer_half_0.iqmod_mixer_se2diff$1_0.iqmod_mixer_se2diff_half_tg$2_0.iqmod_mixer_se2diff_inv_NF54$6_0.vin VSS VSS sg13_lv_nmos ad=0.19p pd=1.38u as=0.19p ps=1.38u w=1u l=0.13u
X1227 VSS VSS VSS VSS sg13_lv_nmos ad=0.34p pd=2.68u as=0 ps=0 w=1u l=0.13u
X1228 iqmod_mixer_0.iqmod_mixer_half_1.iqmod_mixer_se2diff$1_0.iqmod_mixer_se2diff_half_tg$2_0.iqmod_mixer_se2diff_inv_NF54$6_0.vin iqmod_mixer_0.iqmod_mixer_half_1.iqmod_mixer_se2diff$1_0.iqmod_mixer_se2diff_half_tg$2_0.iqmod_mixer_se2diff_inv_NF18$6_0.vin VSS VSS sg13_lv_nmos ad=0.19p pd=1.38u as=0.19p ps=1.38u w=1u l=0.13u
X1229 VSS iqmod_mixer_0.iqmod_mixer_half_1.iqmod_mixer_se2diff$1_0.iqmod_mixer_se2diff_half_inv$2_0.iqmod_mixer_se2diff_inv_NF54$7_0.vin iqmod_mixer_0.iqmod_mixer_half_1.iqmod_mixer_tg$1_0.di_tg_ctrl VSS sg13_lv_nmos ad=0.19p pd=1.38u as=0.19p ps=1.38u w=1u l=0.13u
X1230 iqmod_mixer_0.iqmod_mixer_half_1.iqmod_mixer_tg$1_0.di_tg_ctrl_n iqmod_mixer_0.iqmod_mixer_half_1.iqmod_mixer_se2diff$1_0.iqmod_mixer_se2diff_half_tg$2_0.iqmod_mixer_se2diff_inv_NF54$6_0.vin VDD VDD sg13_lv_pmos ad=0.57p pd=3.38u as=0.57p ps=3.38u w=3u l=0.13u
X1231 iqmod_mfb_lpf_0.iqmod_mfb_lpf_half_0.iqmod_mfb_lpf_ota_core_hybrid_bm_half$1_0.iqmod_mfb_lpf_ota_core_inv_NF6$2_1.vout iqmod_mfb_lpf_0.iqmod_mfb_lpf_half_1.iqmod_mfb_lpf_ota_core_hybrid_bm_half$1_0.iqmod_mfb_lpf_ota_core_tg$2_0.di_tg_ctrl_n iqmod_mfb_lpf_0.iqmod_mfb_lpf_half_0.iqmod_mfb_lpf_ota_core_hybrid_bm_half$1_0.iqmod_mfb_lpf_ota_core_inv_NF20$2_0.vout VDD sg13_lv_pmos ad=1.14p pd=6.38u as=1.14p ps=6.38u w=6u l=0.13u
X1232 VDD iqmod_mixer_0.iqmod_mixer_half_0.iqmod_mixer_se2diff$1_0.iqmod_mixer_se2diff_half_inv$2_0.iqmod_mixer_se2diff_inv_NF54$7_0.vin iqmod_mixer_0.iqmod_mixer_half_0.iqmod_mixer_tg$1_0.di_tg_ctrl VDD sg13_lv_pmos ad=0.57p pd=3.38u as=0.57p ps=3.38u w=3u l=0.13u
X1233 iqmod_mixer_0.vinp_IF iqmod_mixer_0.iqmod_mixer_half_1.iqmod_mixer_tg$1_0.di_tg_ctrl voutp_I_RF VSS sg13_lv_nmos ad=0.57p pd=3.38u as=0.57p ps=3.38u w=3u l=0.13u
X1234 VSS VSS VSS VSS sg13_lv_nmos ad=0.19p pd=1.38u as=0 ps=0 w=1u l=0.13u
X1235 iqmod_mixer_0.iqmod_mixer_half_0.iqmod_mixer_tg$1_0.di_tg_ctrl_n iqmod_mixer_0.iqmod_mixer_half_0.iqmod_mixer_se2diff$1_0.iqmod_mixer_se2diff_half_tg$2_0.iqmod_mixer_se2diff_inv_NF54$6_0.vin VSS VSS sg13_lv_nmos ad=0.19p pd=1.38u as=0.19p ps=1.38u w=1u l=0.13u
X1236 iqmod_mixer_0.vinn_IF iqmod_mfb_lpf_0.iqmod_mfb_lpf_half_0.iqmod_mfb_lpf_ota_core_hybrid_bm_half$1_0.iqmod_mfb_lpf_ota_core_tg$2_0.v_b VDD VDD sg13_lv_pmos ad=1.14p pd=6.38u as=1.14p ps=6.38u w=6u l=1u
X1237 VDD VDD VDD VDD sg13_lv_pmos ad=2.04p pd=12.68u as=0 ps=0 w=6u l=0.13u
X1238 a_24469_2246# a_36355_1946# VSS rhigh l=59u w=0.5u
X1239 VDD VDD VDD VDD sg13_lv_pmos ad=1.02p pd=6.68u as=0 ps=0 w=3u l=0.13u
X1240 VSS iqmod_mixer_0.iqmod_mixer_half_0.iqmod_mixer_se2diff$1_0.iqmod_mixer_se2diff_half_tg$2_0.iqmod_mixer_se2diff_inv_NF54$6_0.vin iqmod_mixer_0.iqmod_mixer_half_0.iqmod_mixer_tg$1_0.di_tg_ctrl_n VSS sg13_lv_nmos ad=0.19p pd=1.38u as=0.19p ps=1.38u w=1u l=0.13u
X1241 iqmod_mfb_lpf_0.iqmod_mfb_lpf_half_0.iqmod_mfb_lpf_ota_core_hybrid_bm_half$1_0.iqmod_mfb_lpf_ota_core_inv_NF20$2_0.vout di_analog_en iqmod_mfb_lpf_0.iqmod_mfb_lpf_half_0.iqmod_mfb_lpf_ota_core_hybrid_bm_half$1_0.iqmod_mfb_lpf_ota_core_inv_NF6$2_1.vout VSS sg13_lv_nmos ad=0.19p pd=1.38u as=0.19p ps=1.38u w=1u l=0.13u
X1242 iqmod_mfb_lpf_0.iqmod_mfb_lpf_half_1.iqmod_mfb_lpf_ota_core_hybrid_bm_half$1_0.iqmod_mfb_lpf_ota_core_inv_NF20$2_1.vin iqmod_mfb_lpf_0.iqmod_mfb_lpf_half_1.iqmod_mfb_lpf_ota_core_hybrid_bm_half$1_0.iqmod_mfb_lpf_ota_core_tg$2_0.di_tg_ctrl_n VDD VSS sg13_lv_nmos ad=0.19p pd=1.38u as=0.19p ps=1.38u w=1u l=0.13u
X1243 iqmod_mfb_lpf_0.iqmod_mfb_lpf_half_0.iqmod_mfb_lpf_ota_core_hybrid_bm_half$1_0.iqmod_mfb_lpf_ota_core_tg$2_0.v_a iqmod_mfb_lpf_0.iqmod_mfb_lpf_half_1.iqmod_mfb_lpf_ota_core_hybrid_bm_half$1_0.iqmod_mfb_lpf_ota_core_tg$2_0.di_tg_ctrl_n iqmod_mfb_lpf_0.iqmod_mfb_lpf_half_0.iqmod_mfb_lpf_ota_core_hybrid_bm_half$1_0.iqmod_mfb_lpf_ota_core_tg$2_0.v_b VDD sg13_lv_pmos ad=1.14p pd=6.38u as=1.14p ps=6.38u w=6u l=0.13u
X1244 iqmod_mixer_0.iqmod_mixer_half_1.iqmod_mixer_tg$1_0.di_tg_ctrl_n iqmod_mixer_0.iqmod_mixer_half_1.iqmod_mixer_se2diff$1_0.iqmod_mixer_se2diff_half_tg$2_0.iqmod_mixer_se2diff_inv_NF54$6_0.vin VSS VSS sg13_lv_nmos ad=0.19p pd=1.38u as=0.19p ps=1.38u w=1u l=0.13u
X1245 iqmod_mixer_0.iqmod_mixer_half_1.iqmod_mixer_tg$1_0.di_tg_ctrl iqmod_mixer_0.iqmod_mixer_half_1.iqmod_mixer_se2diff$1_0.iqmod_mixer_se2diff_half_inv$2_0.iqmod_mixer_se2diff_inv_NF54$7_0.vin VSS VSS sg13_lv_nmos ad=0.19p pd=1.38u as=0.19p ps=1.38u w=1u l=0.13u
X1246 VSS VSS VSS VSS sg13_lv_nmos ad=0.19p pd=1.38u as=0 ps=0 w=1u l=0.13u
X1247 voutn_I_RF iqmod_mixer_0.iqmod_mixer_half_0.iqmod_mixer_tg$1_0.di_tg_ctrl voutn_I_RF VDD sg13_lv_pmos ad=1.71p pd=9.38u as=0 ps=0 w=9u l=0.13u
X1248 VSS VSS VSS VSS sg13_lv_nmos ad=0.19p pd=1.38u as=0 ps=0 w=1u l=0.13u
X1249 VDD iqmod_mixer_0.vinp_IF iqmod_mfb_lpf_0.iqmod_mfb_lpf_half_0.iqmod_mfb_lpf_ota_core_hybrid_bm_half$1_0.iqmod_mfb_lpf_ota_core_inv_NF20$2_0.vout VDD sg13_lv_pmos ad=1.14p pd=6.38u as=1.14p ps=6.38u w=6u l=1u
X1250 iqmod_mixer_0.iqmod_mixer_half_0.iqmod_mixer_tg$1_0.di_tg_ctrl iqmod_mixer_0.iqmod_mixer_half_0.iqmod_mixer_se2diff$1_0.iqmod_mixer_se2diff_half_inv$2_0.iqmod_mixer_se2diff_inv_NF54$7_0.vin VDD VDD sg13_lv_pmos ad=0.57p pd=3.38u as=0.57p ps=3.38u w=3u l=0.13u
X1251 iqmod_mixer_0.vinp_IF iqmod_mfb_lpf_0.iqmod_mfb_lpf_half_0.iqmod_mfb_lpf_ota_core_hybrid_bm_half$1_0.iqmod_mfb_lpf_ota_core_tg$2_0.v_b VSS VSS sg13_lv_nmos ad=0.19p pd=1.38u as=0.19p ps=1.38u w=1u l=1u
X1252 VDD iqmod_mfb_lpf_0.iqmod_mfb_lpf_half_1.iqmod_mfb_lpf_ota_core_hybrid_bm_half$1_0.iqmod_mfb_lpf_ota_core_tg$2_0.di_tg_ctrl_n iqmod_mfb_lpf_0.iqmod_mfb_lpf_half_1.iqmod_mfb_lpf_ota_core_hybrid_bm_half$1_0.iqmod_mfb_lpf_ota_core_inv_NF20$2_1.vin VSS sg13_lv_nmos ad=0.19p pd=1.38u as=0.19p ps=1.38u w=1u l=0.13u
X1253 iqmod_mixer_0.iqmod_mixer_half_1.iqmod_mixer_tg$1_0.di_tg_ctrl iqmod_mixer_0.iqmod_mixer_half_1.iqmod_mixer_se2diff$1_0.iqmod_mixer_se2diff_half_inv$2_0.iqmod_mixer_se2diff_inv_NF54$7_0.vin VDD VDD sg13_lv_pmos ad=0.57p pd=3.38u as=0.57p ps=3.38u w=3u l=0.13u
X1254 iqmod_mfb_lpf_0.iqmod_mfb_lpf_half_0.iqmod_mfb_lpf_ota_core_hybrid_bm_half$1_0.iqmod_mfb_lpf_ota_core_tg$2_0.v_b iqmod_mfb_lpf_0.iqmod_mfb_lpf_half_1.iqmod_mfb_lpf_ota_core_hybrid_bm_half$1_0.iqmod_mfb_lpf_ota_core_tg$2_0.di_tg_ctrl_n iqmod_mfb_lpf_0.iqmod_mfb_lpf_half_0.iqmod_mfb_lpf_ota_core_hybrid_bm_half$1_0.iqmod_mfb_lpf_ota_core_tg$2_0.v_a VDD sg13_lv_pmos ad=1.14p pd=6.38u as=2.04p ps=12.68u w=6u l=0.13u
X1255 VSS iqmod_mixer_0.iqmod_mixer_half_0.iqmod_mixer_se2diff$1_0.iqmod_mixer_se2diff_half_inv$2_0.iqmod_mixer_se2diff_inv_NF18$7_0.vin iqmod_mixer_0.iqmod_mixer_half_0.iqmod_mixer_se2diff$1_0.iqmod_mixer_se2diff_half_inv$2_0.iqmod_mixer_se2diff_inv_NF54$7_0.vin VSS sg13_lv_nmos ad=0.19p pd=1.38u as=0.19p ps=1.38u w=1u l=0.13u
X1256 iqmod_mixer_0.iqmod_mixer_half_0.iqmod_mixer_tg$1_0.di_tg_ctrl_n iqmod_mixer_0.iqmod_mixer_half_0.iqmod_mixer_se2diff$1_0.iqmod_mixer_se2diff_half_tg$2_0.iqmod_mixer_se2diff_inv_NF54$6_0.vin VSS VSS sg13_lv_nmos ad=0.19p pd=1.38u as=0.19p ps=1.38u w=1u l=0.13u
X1257 VDD iqmod_mixer_0.iqmod_mixer_half_0.iqmod_mixer_se2diff$1_0.iqmod_mixer_se2diff_half_tg$2_0.iqmod_mixer_se2diff_inv_NF18$6_0.vin iqmod_mixer_0.iqmod_mixer_half_0.iqmod_mixer_se2diff$1_0.iqmod_mixer_se2diff_half_tg$2_0.iqmod_mixer_se2diff_inv_NF54$6_0.vin VDD sg13_lv_pmos ad=0.57p pd=3.38u as=0.57p ps=3.38u w=3u l=0.13u
X1258 VDD iqmod_mfb_lpf_0.iqmod_mfb_lpf_half_1.iqmod_mfb_lpf_ota_core_hybrid_bm_half$1_0.iqmod_mfb_lpf_ota_core_inv_NF20$2_1.vin iqmod_mfb_lpf_0.iqmod_mfb_lpf_half_0.iqmod_mfb_lpf_ota_core_hybrid_bm_half$1_0.iqmod_mfb_lpf_ota_core_tg$2_0.v_a VDD sg13_lv_pmos ad=1.14p pd=6.38u as=1.14p ps=6.38u w=6u l=1u
X1259 iqmod_mixer_0.vinp_IF iqmod_mixer_0.iqmod_mixer_half_1.iqmod_mixer_tg$1_0.di_tg_ctrl_n voutp_I_RF VDD sg13_lv_pmos ad=1.71p pd=9.38u as=1.71p ps=9.38u w=9u l=0.13u
X1260 iqmod_mfb_lpf_0.iqmod_mfb_lpf_half_0.iqmod_mfb_lpf_ota_core_hybrid_bm_half$1_0.iqmod_mfb_lpf_ota_core_tg$2_0.v_b iqmod_mfb_lpf_0.iqmod_mfb_lpf_half_0.iqmod_mfb_lpf_ota_core_hybrid_bm_half$1_0.iqmod_mfb_lpf_ota_core_tg$2_0.v_a VDD VDD sg13_lv_pmos ad=1.14p pd=6.38u as=1.14p ps=6.38u w=6u l=1u
X1261 VDD iqmod_mixer_0.iqmod_mixer_half_1.iqmod_mixer_se2diff$1_0.iqmod_mixer_se2diff_half_tg$2_0.iqmod_mixer_se2diff_tg_NF6$3_0.v_b iqmod_mixer_0.iqmod_mixer_half_1.iqmod_mixer_se2diff$1_0.iqmod_mixer_se2diff_half_inv$2_0.iqmod_mixer_se2diff_inv_NF2$7_1.vout VDD sg13_lv_pmos ad=0.57p pd=3.38u as=0.57p ps=3.38u w=3u l=0.13u
X1262 iqmod_mixer_0.iqmod_mixer_half_0.iqmod_mixer_se2diff$1_0.iqmod_mixer_se2diff_half_tg$2_0.iqmod_mixer_se2diff_inv_NF54$6_0.vin iqmod_mixer_0.iqmod_mixer_half_0.iqmod_mixer_se2diff$1_0.iqmod_mixer_se2diff_half_tg$2_0.iqmod_mixer_se2diff_inv_NF18$6_0.vin VDD VDD sg13_lv_pmos ad=0.57p pd=3.38u as=0.57p ps=3.38u w=3u l=0.13u
X1263 iqmod_mfb_lpf_0.iqmod_mfb_lpf_half_0.iqmod_mfb_lpf_ota_core_hybrid_bm_half$1_0.iqmod_mfb_lpf_ota_core_inv_NF20$2_0.vout iqmod_mixer_0.vinp_IF VDD VDD sg13_lv_pmos ad=1.14p pd=6.38u as=1.14p ps=6.38u w=6u l=1u
X1264 di_ds_I_n iqmod_spdt_switch_0.spdt_switch_inv_0.vout iqmod_spdt_switch_0.v_c VDD sg13_lv_pmos ad=2.04p pd=12.68u as=1.14p ps=6.38u w=6u l=0.13u
X1265 VSS iqmod_mfb_lpf_0.iqmod_mfb_lpf_half_0.iqmod_mfb_lpf_ota_core_hybrid_bm_half$1_0.iqmod_mfb_lpf_ota_core_tg$2_0.v_b iqmod_mixer_0.vinp_IF VSS sg13_lv_nmos ad=0.19p pd=1.38u as=0.19p ps=1.38u w=1u l=1u
X1266 iqmod_mfb_lpf_0.iqmod_mfb_lpf_half_0.iqmod_mfb_lpf_ota_core_hybrid_bm_half$1_0.iqmod_mfb_lpf_ota_core_inv_NF20$2_0.vout iqmod_mixer_0.vinn_IF VSS VSS sg13_lv_nmos ad=0.19p pd=1.38u as=0.19p ps=1.38u w=1u l=1u
X1267 VDD iqmod_mixer_0.iqmod_mixer_half_1.iqmod_mixer_se2diff$1_0.iqmod_mixer_se2diff_half_inv$2_0.iqmod_mixer_se2diff_inv_NF18$7_0.vin iqmod_mixer_0.iqmod_mixer_half_1.iqmod_mixer_se2diff$1_0.iqmod_mixer_se2diff_half_inv$2_0.iqmod_mixer_se2diff_inv_NF54$7_0.vin VDD sg13_lv_pmos ad=0.57p pd=3.38u as=0.57p ps=3.38u w=3u l=0.13u
X1268 VDD iqmod_mfb_lpf_0.iqmod_mfb_lpf_half_0.iqmod_mfb_lpf_ota_core_hybrid_bm_half$1_0.iqmod_mfb_lpf_ota_core_inv_NF20$2_1.vin iqmod_mixer_0.vinn_IF VDD sg13_lv_pmos ad=1.14p pd=6.38u as=1.14p ps=6.38u w=6u l=1u
X1269 iqmod_mixer_0.iqmod_mixer_half_1.iqmod_mixer_se2diff$1_0.iqmod_mixer_se2diff_half_inv$2_0.iqmod_mixer_se2diff_inv_NF2$7_1.vout iqmod_mixer_0.iqmod_mixer_half_1.iqmod_mixer_se2diff$1_0.iqmod_mixer_se2diff_half_tg$2_0.iqmod_mixer_se2diff_tg_NF6$3_0.v_b VDD VDD sg13_lv_pmos ad=0.57p pd=3.38u as=0.57p ps=3.38u w=3u l=0.13u
X1270 VSS iqmod_mixer_0.iqmod_mixer_half_0.iqmod_mixer_se2diff$1_0.iqmod_mixer_se2diff_half_inv$2_0.iqmod_mixer_se2diff_inv_NF54$7_0.vin iqmod_mixer_0.iqmod_mixer_half_0.iqmod_mixer_tg$1_0.di_tg_ctrl VSS sg13_lv_nmos ad=0.19p pd=1.38u as=0.19p ps=1.38u w=1u l=0.13u
X1271 a_24469_10452# iqmod_mfb_lpf_0.iqmod_mfb_lpf_half_0.iqmod_mfb_lpf_R3$1_0.v_a VSS rhigh l=59u w=0.5u
X1272 VSS iqmod_mixer_0.iqmod_mixer_half_0.iqmod_mixer_se2diff$1_0.iqmod_mixer_se2diff_half_inv$2_0.iqmod_mixer_se2diff_inv_NF54$7_0.vin iqmod_mixer_0.iqmod_mixer_half_0.iqmod_mixer_tg$1_0.di_tg_ctrl VSS sg13_lv_nmos ad=0.19p pd=1.38u as=0.19p ps=1.38u w=1u l=0.13u
X1273 iqmod_mixer_0.iqmod_mixer_half_1.iqmod_mixer_tg$1_0.di_tg_ctrl_n iqmod_mixer_0.iqmod_mixer_half_1.iqmod_mixer_se2diff$1_0.iqmod_mixer_se2diff_half_tg$2_0.iqmod_mixer_se2diff_inv_NF54$6_0.vin VSS VSS sg13_lv_nmos ad=0.19p pd=1.38u as=0.19p ps=1.38u w=1u l=0.13u
X1274 VDD iqmod_mixer_0.vinp_IF iqmod_mfb_lpf_0.iqmod_mfb_lpf_half_0.iqmod_mfb_lpf_ota_core_hybrid_bm_half$1_0.iqmod_mfb_lpf_ota_core_inv_NF20$2_0.vout VDD sg13_lv_pmos ad=1.14p pd=6.38u as=1.14p ps=6.38u w=6u l=1u
X1275 iqmod_mixer_0.iqmod_mixer_half_1.iqmod_mixer_tg$1_0.di_tg_ctrl iqmod_mixer_0.iqmod_mixer_half_1.iqmod_mixer_se2diff$1_0.iqmod_mixer_se2diff_half_inv$2_0.iqmod_mixer_se2diff_inv_NF54$7_0.vin VDD VDD sg13_lv_pmos ad=0.57p pd=3.38u as=0.57p ps=3.38u w=3u l=0.13u
X1276 VSS iqmod_mixer_0.iqmod_mixer_half_1.iqmod_mixer_se2diff$1_0.iqmod_mixer_se2diff_half_inv$2_0.iqmod_mixer_se2diff_inv_NF6$7_0.vout iqmod_mixer_0.iqmod_mixer_half_1.iqmod_mixer_se2diff$1_0.iqmod_mixer_se2diff_half_inv$2_0.iqmod_mixer_se2diff_inv_NF6$7_1.vin VSS sg13_lv_nmos ad=0.19p pd=1.38u as=0.19p ps=1.38u w=1u l=0.13u
X1277 iqmod_mixer_0.iqmod_mixer_half_0.iqmod_mixer_tg$1_0.di_tg_ctrl iqmod_mixer_0.iqmod_mixer_half_0.iqmod_mixer_se2diff$1_0.iqmod_mixer_se2diff_half_inv$2_0.iqmod_mixer_se2diff_inv_NF54$7_0.vin VSS VSS sg13_lv_nmos ad=0.19p pd=1.38u as=0.19p ps=1.38u w=1u l=0.13u
X1278 iqmod_mixer_0.iqmod_mixer_half_1.iqmod_mixer_se2diff$1_0.iqmod_mixer_se2diff_half_tg$2_0.iqmod_mixer_se2diff_inv_NF18$6_0.vin iqmod_mixer_0.iqmod_mixer_half_1.iqmod_mixer_se2diff$1_0.iqmod_mixer_se2diff_half_inv$2_0.iqmod_mixer_se2diff_inv_NF2$7_1.vout VSS VSS sg13_lv_nmos ad=0.19p pd=1.38u as=0.19p ps=1.38u w=1u l=0.13u
X1279 voutn_I_RF iqmod_mixer_0.iqmod_mixer_half_0.iqmod_mixer_tg$1_0.di_tg_ctrl_n iqmod_mixer_0.vinn_IF VDD sg13_lv_pmos ad=1.71p pd=9.38u as=1.71p ps=9.38u w=9u l=0.13u
X1280 iqmod_mixer_0.iqmod_mixer_half_0.iqmod_mixer_tg$1_0.di_tg_ctrl_n iqmod_mixer_0.iqmod_mixer_half_0.iqmod_mixer_se2diff$1_0.iqmod_mixer_se2diff_half_tg$2_0.iqmod_mixer_se2diff_inv_NF54$6_0.vin VDD VDD sg13_lv_pmos ad=0.57p pd=3.38u as=0.57p ps=3.38u w=3u l=0.13u
X1281 iqmod_spdt_switch_0.spdt_switch_inv_0.vin di_spdt_ctrl_I VSS VSS sg13_lv_nmos ad=0.19p pd=1.38u as=0.19p ps=1.38u w=1u l=0.13u
X1282 VSS iqmod_mixer_0.iqmod_mixer_half_1.iqmod_mixer_se2diff$1_0.iqmod_mixer_se2diff_half_tg$2_0.iqmod_mixer_se2diff_inv_NF54$6_0.vin iqmod_mixer_0.iqmod_mixer_half_1.iqmod_mixer_tg$1_0.di_tg_ctrl_n VSS sg13_lv_nmos ad=0.19p pd=1.38u as=0.19p ps=1.38u w=1u l=0.13u
X1283 iqmod_mixer_0.iqmod_mixer_half_0.iqmod_mixer_tg$1_0.di_tg_ctrl_n iqmod_mixer_0.iqmod_mixer_half_0.iqmod_mixer_se2diff$1_0.iqmod_mixer_se2diff_half_tg$2_0.iqmod_mixer_se2diff_inv_NF54$6_0.vin VDD VDD sg13_lv_pmos ad=0.57p pd=3.38u as=0.57p ps=3.38u w=3u l=0.13u
X1284 VDD iqmod_mfb_lpf_0.iqmod_mfb_lpf_half_1.iqmod_mfb_lpf_ota_core_hybrid_bm_half$1_0.iqmod_mfb_lpf_ota_core_tg$2_0.di_tg_ctrl_n iqmod_mfb_lpf_0.iqmod_mfb_lpf_half_1.iqmod_mfb_lpf_ota_core_hybrid_bm_half$1_0.iqmod_mfb_lpf_ota_core_spdt_switch$2_0.iqmod_mfb_lpf_ota_core_spdt_switch_inv$3_0.vout VDD sg13_lv_pmos ad=1.14p pd=6.38u as=1.14p ps=6.38u w=6u l=0.13u
X1285 VSS iqmod_mfb_lpf_0.iqmod_mfb_lpf_half_0.iqmod_mfb_lpf_ota_core_hybrid_bm_half$1_0.iqmod_mfb_lpf_ota_core_inv_NF20$2_1.vin iqmod_mixer_0.vinn_IF VSS sg13_lv_nmos ad=0.19p pd=1.38u as=0.19p ps=1.38u w=1u l=1u
X1286 VDD iqmod_mixer_0.iqmod_mixer_half_0.iqmod_mixer_se2diff$1_0.iqmod_mixer_se2diff_half_inv$2_0.iqmod_mixer_se2diff_inv_NF6$7_0.vout iqmod_mixer_0.iqmod_mixer_half_0.iqmod_mixer_se2diff$1_0.iqmod_mixer_se2diff_half_inv$2_0.iqmod_mixer_se2diff_inv_NF6$7_1.vin VDD sg13_lv_pmos ad=0.57p pd=3.38u as=0.57p ps=3.38u w=3u l=0.13u
X1287 voutn_I_RF iqmod_mixer_0.iqmod_mixer_half_0.iqmod_mixer_tg$1_0.di_tg_ctrl voutn_I_RF VDD sg13_lv_pmos ad=1.71p pd=9.38u as=0 ps=0 w=9u l=0.13u
X1288 VSS iqmod_mixer_0.iqmod_mixer_half_0.iqmod_mixer_se2diff$1_0.iqmod_mixer_se2diff_half_tg$2_0.iqmod_mixer_se2diff_inv_NF18$6_0.vin iqmod_mixer_0.iqmod_mixer_half_0.iqmod_mixer_se2diff$1_0.iqmod_mixer_se2diff_half_tg$2_0.iqmod_mixer_se2diff_inv_NF54$6_0.vin VSS sg13_lv_nmos ad=0.19p pd=1.38u as=0.19p ps=1.38u w=1u l=0.13u
X1289 VSS VSS VSS VSS sg13_lv_nmos ad=0.19p pd=1.38u as=0 ps=0 w=1u l=0.13u
X1290 iqmod_mixer_0.iqmod_mixer_half_1.iqmod_mixer_se2diff$1_0.iqmod_mixer_se2diff_half_inv$2_0.iqmod_mixer_se2diff_inv_NF6$7_1.vin iqmod_mixer_0.iqmod_mixer_half_1.iqmod_mixer_se2diff$1_0.iqmod_mixer_se2diff_half_inv$2_0.iqmod_mixer_se2diff_inv_NF6$7_0.vout VSS VSS sg13_lv_nmos ad=0.19p pd=1.38u as=0.19p ps=1.38u w=1u l=0.13u
X1291 VSS VSS VSS rhigh l=60u w=0.5u
X1292 VDD iqmod_mfb_lpf_0.iqmod_mfb_lpf_half_0.iqmod_mfb_lpf_ota_core_hybrid_bm_half$1_0.iqmod_mfb_lpf_ota_core_tg$2_0.v_b iqmod_mixer_0.vinp_IF VDD sg13_lv_pmos ad=1.14p pd=6.38u as=1.14p ps=6.38u w=6u l=1u
X1293 VSS iqmod_mixer_0.iqmod_mixer_half_1.iqmod_mixer_se2diff$1_0.iqmod_mixer_se2diff_half_inv$2_0.iqmod_mixer_se2diff_inv_NF2$7_1.vout iqmod_mixer_0.iqmod_mixer_half_1.iqmod_mixer_se2diff$1_0.iqmod_mixer_se2diff_half_tg$2_0.iqmod_mixer_se2diff_inv_NF18$6_0.vin VSS sg13_lv_nmos ad=0.19p pd=1.38u as=0.19p ps=1.38u w=1u l=0.13u
X1294 VDD iqmod_mixer_0.iqmod_mixer_half_0.iqmod_mixer_se2diff$1_0.iqmod_mixer_se2diff_half_tg$2_0.iqmod_mixer_se2diff_inv_NF54$6_0.vin iqmod_mixer_0.iqmod_mixer_half_0.iqmod_mixer_tg$1_0.di_tg_ctrl_n VDD sg13_lv_pmos ad=0.57p pd=3.38u as=0.57p ps=3.38u w=3u l=0.13u
X1295 voutn_I_RF iqmod_mixer_0.iqmod_mixer_half_0.iqmod_mixer_tg$1_0.di_tg_ctrl iqmod_mixer_0.vinn_IF VSS sg13_lv_nmos ad=0.57p pd=3.38u as=0.57p ps=3.38u w=3u l=0.13u
X1296 VDD iqmod_mixer_0.iqmod_mixer_half_0.iqmod_mixer_se2diff$1_0.iqmod_mixer_se2diff_half_tg$2_0.iqmod_mixer_se2diff_inv_NF54$6_0.vin iqmod_mixer_0.iqmod_mixer_half_0.iqmod_mixer_tg$1_0.di_tg_ctrl_n VDD sg13_lv_pmos ad=0.57p pd=3.38u as=0.57p ps=3.38u w=3u l=0.13u
X1297 iqmod_mixer_0.iqmod_mixer_half_0.iqmod_mixer_se2diff$1_0.iqmod_mixer_se2diff_half_inv$2_0.iqmod_mixer_se2diff_inv_NF6$7_1.vin iqmod_mixer_0.iqmod_mixer_half_0.iqmod_mixer_se2diff$1_0.iqmod_mixer_se2diff_half_inv$2_0.iqmod_mixer_se2diff_inv_NF6$7_0.vout VDD VDD sg13_lv_pmos ad=0.57p pd=3.38u as=0.57p ps=3.38u w=3u l=0.13u
X1298 di_ds_I_n iqmod_spdt_switch_0.spdt_switch_inv_0.vout iqmod_spdt_switch_0.v_c VDD sg13_lv_pmos ad=1.14p pd=6.38u as=1.14p ps=6.38u w=6u l=0.13u
X1299 VSS VSS VSS VSS sg13_lv_nmos ad=0.34p pd=2.68u as=0 ps=0 w=1u l=1u
X1300 iqmod_mixer_0.iqmod_mixer_half_1.iqmod_mixer_tg$1_0.di_tg_ctrl_n iqmod_mixer_0.iqmod_mixer_half_1.iqmod_mixer_se2diff$1_0.iqmod_mixer_se2diff_half_tg$2_0.iqmod_mixer_se2diff_inv_NF54$6_0.vin VDD VDD sg13_lv_pmos ad=0.57p pd=3.38u as=0.57p ps=3.38u w=3u l=0.13u
X1301 VDD iqmod_mfb_lpf_0.iqmod_mfb_lpf_half_0.iqmod_mfb_lpf_ota_core_hybrid_bm_half$1_0.iqmod_mfb_lpf_ota_core_inv_NF20$2_0.vout iqmod_mfb_lpf_0.iqmod_mfb_lpf_half_0.iqmod_mfb_lpf_ota_core_hybrid_bm_half$1_0.iqmod_mfb_lpf_ota_core_inv_NF6$2_1.vout VDD sg13_lv_pmos ad=1.14p pd=6.38u as=1.14p ps=6.38u w=6u l=1u
X1302 voutp_I_RF iqmod_mixer_0.iqmod_mixer_half_1.iqmod_mixer_tg$1_0.di_tg_ctrl_n iqmod_mixer_0.vinp_IF VDD sg13_lv_pmos ad=1.71p pd=9.38u as=1.71p ps=9.38u w=9u l=0.13u
X1303 iqmod_mixer_0.vinn_IF iqmod_mixer_0.iqmod_mixer_half_0.iqmod_mixer_tg$1_0.di_tg_ctrl voutn_I_RF VSS sg13_lv_nmos ad=0.57p pd=3.38u as=0.57p ps=3.38u w=3u l=0.13u
X1304 iqmod_mixer_0.vinp_IF iqmod_mixer_0.iqmod_mixer_half_1.iqmod_mixer_tg$1_0.di_tg_ctrl voutp_I_RF VSS sg13_lv_nmos ad=0.57p pd=3.38u as=0.57p ps=3.38u w=3u l=0.13u
X1305 VSS di_analog_en iqmod_mfb_lpf_0.iqmod_mfb_lpf_half_0.iqmod_mfb_lpf_ota_core_hybrid_bm_half$1_0.iqmod_mfb_lpf_ota_core_tg$2_0.di_tg_ctrl_n VSS sg13_lv_nmos ad=0.19p pd=1.38u as=0.19p ps=1.38u w=1u l=0.13u
X1306 VDD iqmod_mixer_0.iqmod_mixer_half_1.iqmod_mixer_se2diff$1_0.iqmod_mixer_se2diff_half_tg$2_0.iqmod_mixer_se2diff_inv_NF54$6_0.vin iqmod_mixer_0.iqmod_mixer_half_1.iqmod_mixer_tg$1_0.di_tg_ctrl_n VDD sg13_lv_pmos ad=0.57p pd=3.38u as=0.57p ps=3.38u w=3u l=0.13u
X1307 voutp_I_RF iqmod_mixer_0.iqmod_mixer_half_1.iqmod_mixer_tg$1_0.di_tg_ctrl iqmod_mixer_0.vinp_IF VSS sg13_lv_nmos ad=0.57p pd=3.38u as=0.57p ps=3.38u w=3u l=0.13u
X1308 voutn_I_RF iqmod_mixer_0.iqmod_mixer_half_0.iqmod_mixer_tg$1_0.di_tg_ctrl iqmod_mixer_0.vinn_IF VSS sg13_lv_nmos ad=0.57p pd=3.38u as=0.57p ps=3.38u w=3u l=0.13u
X1309 iqmod_mixer_0.iqmod_mixer_half_0.iqmod_mixer_se2diff$1_0.iqmod_mixer_se2diff_half_inv$2_0.iqmod_mixer_se2diff_inv_NF2$7_1.vout iqmod_mixer_0.iqmod_mixer_half_0.iqmod_mixer_se2diff$1_0.iqmod_mixer_se2diff_half_tg$2_0.iqmod_mixer_se2diff_tg_NF6$3_0.v_b VSS VSS sg13_lv_nmos ad=0.19p pd=1.38u as=0.19p ps=1.38u w=1u l=0.13u
X1310 VSS iqmod_mixer_0.iqmod_mixer_half_0.iqmod_mixer_se2diff$1_0.iqmod_mixer_se2diff_half_inv$2_0.iqmod_mixer_se2diff_inv_NF6$7_1.vin iqmod_mixer_0.iqmod_mixer_half_0.iqmod_mixer_se2diff$1_0.iqmod_mixer_se2diff_half_inv$2_0.iqmod_mixer_se2diff_inv_NF18$7_0.vin VSS sg13_lv_nmos ad=0.19p pd=1.38u as=0.19p ps=1.38u w=1u l=0.13u
X1311 iqmod_mixer_0.iqmod_mixer_half_1.iqmod_mixer_se2diff$1_0.iqmod_mixer_se2diff_half_tg$2_0.iqmod_mixer_se2diff_tg_NF6$3_0.v_b VDD iqmod_mixer_0.iqmod_mixer_half_1.iqmod_mixer_se2diff$1_0.iqmod_mixer_se2diff_half_inv$2_0.iqmod_mixer_se2diff_inv_NF6$7_0.vin VSS sg13_lv_nmos ad=0.19p pd=1.38u as=0.19p ps=1.38u w=1u l=0.13u
X1312 iqmod_mixer_0.iqmod_mixer_half_0.iqmod_mixer_tg$1_0.di_tg_ctrl iqmod_mixer_0.iqmod_mixer_half_0.iqmod_mixer_se2diff$1_0.iqmod_mixer_se2diff_half_inv$2_0.iqmod_mixer_se2diff_inv_NF54$7_0.vin VSS VSS sg13_lv_nmos ad=0.19p pd=1.38u as=0.19p ps=1.38u w=1u l=0.13u
X1313 iqmod_mixer_0.vinp_IF iqmod_mfb_lpf_0.iqmod_mfb_lpf_half_1.iqmod_mfb_lpf_ota_core_hybrid_bm_half$1_0.iqmod_mfb_lpf_ota_core_inv_NF20$2_1.vin VSS VSS sg13_lv_nmos ad=0.19p pd=1.38u as=0.19p ps=1.38u w=1u l=1u
X1314 iqmod_mixer_0.iqmod_mixer_half_1.iqmod_mixer_tg$1_0.di_tg_ctrl iqmod_mixer_0.iqmod_mixer_half_1.iqmod_mixer_se2diff$1_0.iqmod_mixer_se2diff_half_inv$2_0.iqmod_mixer_se2diff_inv_NF54$7_0.vin VSS VSS sg13_lv_nmos ad=0.19p pd=1.38u as=0.19p ps=1.38u w=1u l=0.13u
X1315 VSS iqmod_mixer_0.iqmod_mixer_half_0.iqmod_mixer_se2diff$1_0.iqmod_mixer_se2diff_half_tg$2_0.iqmod_mixer_se2diff_tg_NF6$3_0.v_b iqmod_mixer_0.iqmod_mixer_half_0.iqmod_mixer_se2diff$1_0.iqmod_mixer_se2diff_half_inv$2_0.iqmod_mixer_se2diff_inv_NF2$7_1.vout VSS sg13_lv_nmos ad=0.19p pd=1.38u as=0.19p ps=1.38u w=1u l=0.13u
X1316 iqmod_mfb_lpf_0.iqmod_mfb_lpf_half_0.iqmod_mfb_lpf_ota_core_hybrid_bm_half$1_0.iqmod_mfb_lpf_ota_core_tg$2_0.v_b iqmod_mfb_lpf_0.iqmod_mfb_lpf_half_0.iqmod_mfb_lpf_ota_core_hybrid_bm_half$1_0.iqmod_mfb_lpf_ota_core_inv_NF6$2_1.vout VSS VSS sg13_lv_nmos ad=0.19p pd=1.38u as=0.19p ps=1.38u w=1u l=1u
X1317 iqmod_mixer_0.iqmod_mixer_half_0.iqmod_mixer_se2diff$1_0.iqmod_mixer_se2diff_half_inv$2_0.iqmod_mixer_se2diff_inv_NF18$7_0.vin iqmod_mixer_0.iqmod_mixer_half_0.iqmod_mixer_se2diff$1_0.iqmod_mixer_se2diff_half_inv$2_0.iqmod_mixer_se2diff_inv_NF6$7_1.vin VSS VSS sg13_lv_nmos ad=0.19p pd=1.38u as=0.19p ps=1.38u w=1u l=0.13u
X1318 iqmod_mixer_0.iqmod_mixer_half_1.iqmod_mixer_se2diff$1_0.iqmod_mixer_se2diff_half_inv$2_0.iqmod_mixer_se2diff_inv_NF6$7_0.vin VDD iqmod_mixer_0.iqmod_mixer_half_1.iqmod_mixer_se2diff$1_0.iqmod_mixer_se2diff_half_tg$2_0.iqmod_mixer_se2diff_tg_NF6$3_0.v_b VSS sg13_lv_nmos ad=0.19p pd=1.38u as=0.19p ps=1.38u w=1u l=0.13u
X1319 iqmod_mixer_0.iqmod_mixer_half_0.iqmod_mixer_tg$1_0.di_tg_ctrl iqmod_mixer_0.iqmod_mixer_half_0.iqmod_mixer_se2diff$1_0.iqmod_mixer_se2diff_half_inv$2_0.iqmod_mixer_se2diff_inv_NF54$7_0.vin VDD VDD sg13_lv_pmos ad=0.57p pd=3.38u as=0.57p ps=3.38u w=3u l=0.13u
X1320 voutp_I_RF iqmod_mixer_0.iqmod_mixer_half_1.iqmod_mixer_tg$1_0.di_tg_ctrl_n voutp_I_RF VSS sg13_lv_nmos ad=0.57p pd=3.38u as=0 ps=0 w=3u l=0.13u
X1321 VDD iqmod_mfb_lpf_0.iqmod_mfb_lpf_half_0.iqmod_mfb_lpf_ota_core_hybrid_bm_half$1_0.iqmod_mfb_lpf_ota_core_tg$2_0.v_b iqmod_mixer_0.vinp_IF VDD sg13_lv_pmos ad=1.14p pd=6.38u as=1.14p ps=6.38u w=6u l=1u
X1322 iqmod_mixer_0.iqmod_mixer_half_0.iqmod_mixer_se2diff$1_0.iqmod_mixer_se2diff_half_tg$2_0.iqmod_mixer_se2diff_inv_NF18$6_0.vin iqmod_mixer_0.iqmod_mixer_half_0.iqmod_mixer_se2diff$1_0.iqmod_mixer_se2diff_half_inv$2_0.iqmod_mixer_se2diff_inv_NF2$7_1.vout VDD VDD sg13_lv_pmos ad=0.57p pd=3.38u as=0.57p ps=3.38u w=3u l=0.13u
X1323 iqmod_mfb_lpf_0.iqmod_mfb_lpf_half_0.iqmod_mfb_lpf_ota_core_hybrid_bm_half$1_0.iqmod_mfb_lpf_ota_core_inv_NF6$2_1.vout di_analog_en iqmod_mfb_lpf_0.iqmod_mfb_lpf_half_0.iqmod_mfb_lpf_ota_core_hybrid_bm_half$1_0.iqmod_mfb_lpf_ota_core_inv_NF20$2_0.vout VSS sg13_lv_nmos ad=0.19p pd=1.38u as=0.19p ps=1.38u w=1u l=0.13u
X1324 VSS iqmod_mixer_0.iqmod_mixer_half_1.iqmod_mixer_se2diff$1_0.iqmod_mixer_se2diff_half_inv$2_0.iqmod_mixer_se2diff_inv_NF54$7_0.vin iqmod_mixer_0.iqmod_mixer_half_1.iqmod_mixer_tg$1_0.di_tg_ctrl VSS sg13_lv_nmos ad=0.19p pd=1.38u as=0.19p ps=1.38u w=1u l=0.13u
X1325 iqmod_mfb_lpf_0.iqmod_mfb_lpf_half_0.iqmod_mfb_lpf_ota_core_hybrid_bm_half$1_0.iqmod_mfb_lpf_ota_core_inv_NF20$2_0.vout iqmod_mixer_0.vinn_IF VDD VDD sg13_lv_pmos ad=1.14p pd=6.38u as=1.14p ps=6.38u w=6u l=1u
X1326 VDD iqmod_mixer_0.iqmod_mixer_half_0.iqmod_mixer_se2diff$1_0.iqmod_mixer_se2diff_half_inv$2_0.iqmod_mixer_se2diff_inv_NF54$7_0.vin iqmod_mixer_0.iqmod_mixer_half_0.iqmod_mixer_tg$1_0.di_tg_ctrl VDD sg13_lv_pmos ad=0.57p pd=3.38u as=0.57p ps=3.38u w=3u l=0.13u
X1327 VDD VDD VDD VDD sg13_lv_pmos ad=1.02p pd=6.68u as=0 ps=0 w=3u l=0.13u
X1328 iqmod_mixer_0.iqmod_mixer_half_1.iqmod_mixer_tg$1_0.di_tg_ctrl_n iqmod_mixer_0.iqmod_mixer_half_1.iqmod_mixer_se2diff$1_0.iqmod_mixer_se2diff_half_tg$2_0.iqmod_mixer_se2diff_inv_NF54$6_0.vin VSS VSS sg13_lv_nmos ad=0.19p pd=1.38u as=0.19p ps=1.38u w=1u l=0.13u
X1329 iqmod_spdt_switch_1.v_c iqmod_mfb_lpf_0.iqmod_mfb_lpf_half_0.iqmod_mfb_lpf_ota_core_hybrid_bm_half$1_0.iqmod_mfb_lpf_ota_core_tg$2_0.di_tg_ctrl_n iqmod_mfb_lpf_0.iqmod_mfb_lpf_half_0.iqmod_mfb_lpf_ota_core_hybrid_bm_half$1_0.iqmod_mfb_lpf_ota_core_inv_NF20$2_1.vin VDD sg13_lv_pmos ad=1.14p pd=6.38u as=1.14p ps=6.38u w=6u l=0.13u
X1330 iqmod_mfb_lpf_0.iqmod_mfb_lpf_half_0.iqmod_mfb_lpf_ota_core_hybrid_bm_half$1_0.iqmod_mfb_lpf_ota_core_inv_NF20$2_1.vin iqmod_mfb_lpf_0.iqmod_mfb_lpf_half_0.iqmod_mfb_lpf_ota_core_hybrid_bm_half$1_0.iqmod_mfb_lpf_ota_core_spdt_switch$2_0.iqmod_mfb_lpf_ota_core_spdt_switch_inv$3_0.vout VDD VDD sg13_lv_pmos ad=1.14p pd=6.38u as=2.04p ps=12.68u w=6u l=0.13u
X1331 iqmod_mixer_0.vinp_IF iqmod_mfb_lpf_0.iqmod_mfb_lpf_half_0.iqmod_mfb_lpf_ota_core_hybrid_bm_half$1_0.iqmod_mfb_lpf_ota_core_tg$2_0.v_b VDD VDD sg13_lv_pmos ad=1.14p pd=6.38u as=1.14p ps=6.38u w=6u l=1u
X1332 VDD VDD VDD VDD sg13_lv_pmos ad=2.04p pd=12.68u as=0 ps=0 w=6u l=0.13u
X1333 voutp_I_RF iqmod_mixer_0.iqmod_mixer_half_1.iqmod_mixer_tg$1_0.di_tg_ctrl_n voutp_I_RF VSS sg13_lv_nmos ad=0.57p pd=3.38u as=0 ps=0 w=3u l=0.13u
X1334 VSS iqmod_mixer_0.iqmod_mixer_half_0.iqmod_mixer_se2diff$1_0.iqmod_mixer_se2diff_half_inv$2_0.iqmod_mixer_se2diff_inv_NF6$7_0.vin iqmod_mixer_0.iqmod_mixer_half_0.iqmod_mixer_se2diff$1_0.iqmod_mixer_se2diff_half_inv$2_0.iqmod_mixer_se2diff_inv_NF6$7_0.vout VSS sg13_lv_nmos ad=0.19p pd=1.38u as=0.19p ps=1.38u w=1u l=0.13u
X1335 VSS iqmod_mixer_0.iqmod_mixer_half_0.iqmod_mixer_se2diff$1_0.iqmod_mixer_se2diff_half_tg$2_0.iqmod_mixer_se2diff_inv_NF54$6_0.vin iqmod_mixer_0.iqmod_mixer_half_0.iqmod_mixer_tg$1_0.di_tg_ctrl_n VSS sg13_lv_nmos ad=0.19p pd=1.38u as=0.19p ps=1.38u w=1u l=0.13u
X1336 VSS iqmod_mfb_lpf_0.iqmod_mfb_lpf_half_1.iqmod_mfb_lpf_ota_core_hybrid_bm_half$1_0.iqmod_mfb_lpf_ota_core_inv_NF20$2_1.vin iqmod_mixer_0.vinp_IF VSS sg13_lv_nmos ad=0.19p pd=1.38u as=0.19p ps=1.38u w=1u l=1u
X1337 VDD iqmod_mixer_0.vinn_IF iqmod_mfb_lpf_0.iqmod_mfb_lpf_half_0.iqmod_mfb_lpf_ota_core_hybrid_bm_half$1_0.iqmod_mfb_lpf_ota_core_inv_NF20$2_0.vout VDD sg13_lv_pmos ad=1.14p pd=6.38u as=1.14p ps=6.38u w=6u l=1u
X1338 iqmod_mfb_lpf_0.iqmod_mfb_lpf_half_0.iqmod_mfb_lpf_ota_core_hybrid_bm_half$1_0.iqmod_mfb_lpf_ota_core_inv_NF20$2_0.vout iqmod_mixer_0.vinn_IF VSS VSS sg13_lv_nmos ad=0.19p pd=1.38u as=0.19p ps=1.38u w=1u l=1u
X1339 iqmod_mfb_lpf_0.iqmod_mfb_lpf_half_0.iqmod_mfb_lpf_ota_core_hybrid_bm_half$1_0.iqmod_mfb_lpf_ota_core_tg$2_0.v_b di_analog_en iqmod_mfb_lpf_0.iqmod_mfb_lpf_half_0.iqmod_mfb_lpf_ota_core_hybrid_bm_half$1_0.iqmod_mfb_lpf_ota_core_tg$2_0.v_a VSS sg13_lv_nmos ad=0.19p pd=1.38u as=0.19p ps=1.38u w=1u l=0.13u
X1340 iqmod_mfb_lpf_0.iqmod_mfb_lpf_half_0.iqmod_mfb_lpf_ota_core_hybrid_bm_half$1_0.iqmod_mfb_lpf_ota_core_tg$2_0.v_a iqmod_mfb_lpf_0.iqmod_mfb_lpf_half_0.iqmod_mfb_lpf_ota_core_hybrid_bm_half$1_0.iqmod_mfb_lpf_ota_core_inv_NF20$2_1.vin VDD VDD sg13_lv_pmos ad=1.14p pd=6.38u as=1.14p ps=6.38u w=6u l=1u
X1341 iqmod_mixer_0.iqmod_mixer_half_0.iqmod_mixer_se2diff$1_0.iqmod_mixer_se2diff_half_inv$2_0.iqmod_mixer_se2diff_inv_NF6$7_0.vout iqmod_mixer_0.iqmod_mixer_half_0.iqmod_mixer_se2diff$1_0.iqmod_mixer_se2diff_half_inv$2_0.iqmod_mixer_se2diff_inv_NF6$7_0.vin VSS VSS sg13_lv_nmos ad=0.19p pd=1.38u as=0.19p ps=1.38u w=1u l=0.13u
X1342 VDD iqmod_mixer_0.iqmod_mixer_half_1.iqmod_mixer_se2diff$1_0.iqmod_mixer_se2diff_half_tg$2_0.iqmod_mixer_se2diff_inv_NF18$6_0.vin iqmod_mixer_0.iqmod_mixer_half_1.iqmod_mixer_se2diff$1_0.iqmod_mixer_se2diff_half_tg$2_0.iqmod_mixer_se2diff_inv_NF54$6_0.vin VDD sg13_lv_pmos ad=0.57p pd=3.38u as=0.57p ps=3.38u w=3u l=0.13u
X1343 iqmod_mfb_lpf_0.iqmod_mfb_lpf_half_0.iqmod_mfb_lpf_ota_core_hybrid_bm_half$1_0.iqmod_mfb_lpf_ota_core_tg$2_0.v_b iqmod_mfb_lpf_0.iqmod_mfb_lpf_half_0.iqmod_mfb_lpf_ota_core_hybrid_bm_half$1_0.iqmod_mfb_lpf_ota_core_inv_NF6$2_1.vout VSS VSS sg13_lv_nmos ad=0.19p pd=1.38u as=0.19p ps=1.38u w=1u l=1u
X1344 iqmod_mixer_0.iqmod_mixer_half_0.iqmod_mixer_tg$1_0.di_tg_ctrl_n iqmod_mixer_0.iqmod_mixer_half_0.iqmod_mixer_se2diff$1_0.iqmod_mixer_se2diff_half_tg$2_0.iqmod_mixer_se2diff_inv_NF54$6_0.vin VSS VSS sg13_lv_nmos ad=0.19p pd=1.38u as=0.19p ps=1.38u w=1u l=0.13u
X1345 VSS iqmod_mixer_0.iqmod_mixer_half_1.iqmod_mixer_se2diff$1_0.iqmod_mixer_se2diff_half_tg$2_0.iqmod_mixer_se2diff_inv_NF54$6_0.vin iqmod_mixer_0.iqmod_mixer_half_1.iqmod_mixer_tg$1_0.di_tg_ctrl_n VSS sg13_lv_nmos ad=0.19p pd=1.38u as=0.19p ps=1.38u w=1u l=0.13u
X1346 vinp_I iqmod_spdt_switch_1.spdt_switch_inv_0.vin iqmod_spdt_switch_1.v_c VDD sg13_lv_pmos ad=2.04p pd=12.68u as=1.14p ps=6.38u w=6u l=0.13u
X1347 iqmod_mixer_0.vinp_IF iqmod_mfb_lpf_0.iqmod_mfb_lpf_half_1.iqmod_mfb_lpf_ota_core_hybrid_bm_half$1_0.iqmod_mfb_lpf_ota_core_inv_NF20$2_1.vin VSS VSS sg13_lv_nmos ad=0.19p pd=1.38u as=0.19p ps=1.38u w=1u l=1u
X1348 VSS iqmod_mixer_0.iqmod_mixer_half_0.iqmod_mixer_se2diff$1_0.iqmod_mixer_se2diff_half_tg$2_0.iqmod_mixer_se2diff_inv_NF54$6_0.vin iqmod_mixer_0.iqmod_mixer_half_0.iqmod_mixer_tg$1_0.di_tg_ctrl_n VSS sg13_lv_nmos ad=0.19p pd=1.38u as=0.19p ps=1.38u w=1u l=0.13u
X1349 iqmod_mixer_0.vinn_IF iqmod_mixer_0.iqmod_mixer_half_0.iqmod_mixer_tg$1_0.di_tg_ctrl_n voutn_I_RF VDD sg13_lv_pmos ad=1.71p pd=9.38u as=1.71p ps=9.38u w=9u l=0.13u
X1350 iqmod_mixer_0.iqmod_mixer_half_1.iqmod_mixer_tg$1_0.di_tg_ctrl_n iqmod_mixer_0.iqmod_mixer_half_1.iqmod_mixer_se2diff$1_0.iqmod_mixer_se2diff_half_tg$2_0.iqmod_mixer_se2diff_inv_NF54$6_0.vin VSS VSS sg13_lv_nmos ad=0.19p pd=1.38u as=0.19p ps=1.38u w=1u l=0.13u
X1351 VSS iqmod_mixer_0.iqmod_mixer_half_0.iqmod_mixer_se2diff$1_0.iqmod_mixer_se2diff_half_inv$2_0.iqmod_mixer_se2diff_inv_NF54$7_0.vin iqmod_mixer_0.iqmod_mixer_half_0.iqmod_mixer_tg$1_0.di_tg_ctrl VSS sg13_lv_nmos ad=0.19p pd=1.38u as=0.19p ps=1.38u w=1u l=0.13u
X1352 iqmod_spdt_switch_1.v_c iqmod_spdt_switch_1.spdt_switch_inv_0.vin vinp_I VDD sg13_lv_pmos ad=1.14p pd=6.38u as=1.14p ps=6.38u w=6u l=0.13u
X1353 iqmod_mfb_lpf_0.iqmod_mfb_lpf_half_0.iqmod_mfb_lpf_ota_core_hybrid_bm_half$1_0.iqmod_mfb_lpf_ota_core_tg$2_0.v_a iqmod_mfb_lpf_0.iqmod_mfb_lpf_half_1.iqmod_mfb_lpf_ota_core_hybrid_bm_half$1_0.iqmod_mfb_lpf_ota_core_inv_NF20$2_1.vin VSS VSS sg13_lv_nmos ad=0.19p pd=1.38u as=0.19p ps=1.38u w=1u l=1u
X1354 VDD iqmod_mfb_lpf_0.iqmod_mfb_lpf_half_0.iqmod_mfb_lpf_ota_core_hybrid_bm_half$1_0.iqmod_mfb_lpf_ota_core_inv_NF20$2_1.vin iqmod_mfb_lpf_0.iqmod_mfb_lpf_half_0.iqmod_mfb_lpf_ota_core_hybrid_bm_half$1_0.iqmod_mfb_lpf_ota_core_tg$2_0.v_a VDD sg13_lv_pmos ad=1.14p pd=6.38u as=1.14p ps=6.38u w=6u l=1u
X1355 VSS iqmod_mfb_lpf_0.iqmod_mfb_lpf_half_0.iqmod_mfb_lpf_ota_core_hybrid_bm_half$1_0.iqmod_mfb_lpf_ota_core_inv_NF6$2_1.vout iqmod_mfb_lpf_0.iqmod_mfb_lpf_half_0.iqmod_mfb_lpf_ota_core_hybrid_bm_half$1_0.iqmod_mfb_lpf_ota_core_tg$2_0.v_b VSS sg13_lv_nmos ad=0.19p pd=1.38u as=0.19p ps=1.38u w=1u l=1u
X1356 a_24469_2246# iqmod_mfb_lpf_0.iqmod_mfb_lpf_half_0.C2_half VSS rhigh l=59u w=0.5u
X1357 iqmod_spdt_switch_0.v_c iqmod_spdt_switch_0.spdt_switch_inv_0.vin di_ds_I_n VSS sg13_lv_nmos ad=0.19p pd=1.38u as=0.19p ps=1.38u w=1u l=0.13u
X1358 VSS iqmod_mfb_lpf_0.iqmod_mfb_lpf_half_0.iqmod_mfb_lpf_ota_core_hybrid_bm_half$1_0.iqmod_mfb_lpf_ota_core_tg$2_0.v_a iqmod_mfb_lpf_0.iqmod_mfb_lpf_half_0.iqmod_mfb_lpf_ota_core_hybrid_bm_half$1_0.iqmod_mfb_lpf_ota_core_tg$2_0.v_b VSS sg13_lv_nmos ad=0.19p pd=1.38u as=0.19p ps=1.38u w=1u l=1u
X1359 voutp_I_RF iqmod_mixer_0.iqmod_mixer_half_1.iqmod_mixer_tg$1_0.di_tg_ctrl_n iqmod_mixer_0.vinp_IF VDD sg13_lv_pmos ad=1.71p pd=9.38u as=1.71p ps=9.38u w=9u l=0.13u
X1360 VSS iqmod_mixer_0.iqmod_mixer_half_1.iqmod_mixer_se2diff$1_0.iqmod_mixer_se2diff_half_inv$2_0.iqmod_mixer_se2diff_inv_NF18$7_0.vin iqmod_mixer_0.iqmod_mixer_half_1.iqmod_mixer_se2diff$1_0.iqmod_mixer_se2diff_half_inv$2_0.iqmod_mixer_se2diff_inv_NF54$7_0.vin VSS sg13_lv_nmos ad=0.19p pd=1.38u as=0.19p ps=1.38u w=1u l=0.13u
X1361 iqmod_mixer_0.iqmod_mixer_half_1.iqmod_mixer_se2diff$1_0.iqmod_mixer_se2diff_half_inv$2_0.iqmod_mixer_se2diff_inv_NF54$7_0.vin iqmod_mixer_0.iqmod_mixer_half_1.iqmod_mixer_se2diff$1_0.iqmod_mixer_se2diff_half_inv$2_0.iqmod_mixer_se2diff_inv_NF18$7_0.vin VDD VDD sg13_lv_pmos ad=0.57p pd=3.38u as=0.57p ps=3.38u w=3u l=0.13u
X1362 VDD iqmod_mfb_lpf_0.iqmod_mfb_lpf_half_1.iqmod_mfb_lpf_ota_core_hybrid_bm_half$1_0.iqmod_mfb_lpf_ota_core_inv_NF20$2_1.vin iqmod_mixer_0.vinp_IF VDD sg13_lv_pmos ad=1.14p pd=6.38u as=1.14p ps=6.38u w=6u l=1u
X1363 iqmod_mixer_0.vinn_IF iqmod_mixer_0.iqmod_mixer_half_0.iqmod_mixer_tg$1_0.di_tg_ctrl voutn_I_RF VSS sg13_lv_nmos ad=0.57p pd=3.38u as=0.57p ps=3.38u w=3u l=0.13u
X1364 iqmod_mixer_0.iqmod_mixer_half_0.iqmod_mixer_tg$1_0.di_tg_ctrl iqmod_mixer_0.iqmod_mixer_half_0.iqmod_mixer_se2diff$1_0.iqmod_mixer_se2diff_half_inv$2_0.iqmod_mixer_se2diff_inv_NF54$7_0.vin VSS VSS sg13_lv_nmos ad=0.19p pd=1.38u as=0.19p ps=1.38u w=1u l=0.13u
X1365 iqmod_mixer_0.iqmod_mixer_half_0.iqmod_mixer_tg$1_0.di_tg_ctrl_n iqmod_mixer_0.iqmod_mixer_half_0.iqmod_mixer_se2diff$1_0.iqmod_mixer_se2diff_half_tg$2_0.iqmod_mixer_se2diff_inv_NF54$6_0.vin VDD VDD sg13_lv_pmos ad=0.57p pd=3.38u as=0.57p ps=3.38u w=3u l=0.13u
X1366 VSS iqmod_mixer_0.iqmod_mixer_half_1.iqmod_mixer_se2diff$1_0.iqmod_mixer_se2diff_half_tg$2_0.iqmod_mixer_se2diff_inv_NF54$6_0.vin iqmod_mixer_0.iqmod_mixer_half_1.iqmod_mixer_tg$1_0.di_tg_ctrl_n VSS sg13_lv_nmos ad=0.19p pd=1.38u as=0.19p ps=1.38u w=1u l=0.13u
X1367 VDD iqmod_mixer_0.vinn_IF iqmod_mfb_lpf_0.iqmod_mfb_lpf_half_0.iqmod_mfb_lpf_ota_core_hybrid_bm_half$1_0.iqmod_mfb_lpf_ota_core_inv_NF20$2_0.vout VDD sg13_lv_pmos ad=1.14p pd=6.38u as=1.14p ps=6.38u w=6u l=1u
X1368 VDD iqmod_mixer_0.iqmod_mixer_half_0.iqmod_mixer_se2diff$1_0.iqmod_mixer_se2diff_half_inv$2_0.iqmod_mixer_se2diff_inv_NF18$7_0.vin iqmod_mixer_0.iqmod_mixer_half_0.iqmod_mixer_se2diff$1_0.iqmod_mixer_se2diff_half_inv$2_0.iqmod_mixer_se2diff_inv_NF54$7_0.vin VDD sg13_lv_pmos ad=0.57p pd=3.38u as=0.57p ps=3.38u w=3u l=0.13u
X1369 iqmod_mixer_0.vinp_IF iqmod_mixer_0.iqmod_mixer_half_1.iqmod_mixer_tg$1_0.di_tg_ctrl_n voutp_I_RF VDD sg13_lv_pmos ad=1.71p pd=9.38u as=1.71p ps=9.38u w=9u l=0.13u
X1370 VDD iqmod_mixer_0.iqmod_mixer_half_0.iqmod_mixer_se2diff$1_0.iqmod_mixer_se2diff_half_tg$2_0.iqmod_mixer_se2diff_inv_NF54$6_0.vin iqmod_mixer_0.iqmod_mixer_half_0.iqmod_mixer_tg$1_0.di_tg_ctrl_n VDD sg13_lv_pmos ad=0.57p pd=3.38u as=0.57p ps=3.38u w=3u l=0.13u
X1371 VSS VSS VSS VSS sg13_lv_nmos ad=0.19p pd=1.38u as=0 ps=0 w=1u l=1u
X1372 VDD iqmod_mixer_0.iqmod_mixer_half_1.iqmod_mixer_se2diff$1_0.iqmod_mixer_se2diff_half_tg$2_0.iqmod_mixer_se2diff_inv_NF18$6_0.vin iqmod_mixer_0.iqmod_mixer_half_1.iqmod_mixer_se2diff$1_0.iqmod_mixer_se2diff_half_tg$2_0.iqmod_mixer_se2diff_inv_NF54$6_0.vin VDD sg13_lv_pmos ad=0.57p pd=3.38u as=0.57p ps=3.38u w=3u l=0.13u
X1373 iqmod_mixer_0.iqmod_mixer_half_0.iqmod_mixer_tg$1_0.di_tg_ctrl iqmod_mixer_0.iqmod_mixer_half_0.iqmod_mixer_se2diff$1_0.iqmod_mixer_se2diff_half_inv$2_0.iqmod_mixer_se2diff_inv_NF54$7_0.vin VSS VSS sg13_lv_nmos ad=0.19p pd=1.38u as=0.19p ps=1.38u w=1u l=0.13u
X1374 iqmod_mixer_0.iqmod_mixer_half_1.iqmod_mixer_se2diff$1_0.iqmod_mixer_se2diff_half_inv$2_0.iqmod_mixer_se2diff_inv_NF54$7_0.vin iqmod_mixer_0.iqmod_mixer_half_1.iqmod_mixer_se2diff$1_0.iqmod_mixer_se2diff_half_inv$2_0.iqmod_mixer_se2diff_inv_NF18$7_0.vin VDD VDD sg13_lv_pmos ad=0.57p pd=3.38u as=0.57p ps=3.38u w=3u l=0.13u
X1375 iqmod_mfb_lpf_0.iqmod_mfb_lpf_half_0.iqmod_mfb_lpf_ota_core_hybrid_bm_half$1_0.iqmod_mfb_lpf_ota_core_tg$2_0.v_a di_analog_en iqmod_mfb_lpf_0.iqmod_mfb_lpf_half_0.iqmod_mfb_lpf_ota_core_hybrid_bm_half$1_0.iqmod_mfb_lpf_ota_core_tg$2_0.v_b VSS sg13_lv_nmos ad=0.34p pd=2.68u as=0.19p ps=1.38u w=1u l=0.13u
X1376 VDD iqmod_mfb_lpf_0.iqmod_mfb_lpf_half_0.iqmod_mfb_lpf_ota_core_hybrid_bm_half$1_0.iqmod_mfb_lpf_ota_core_tg$2_0.v_b iqmod_mixer_0.vinn_IF VDD sg13_lv_pmos ad=1.14p pd=6.38u as=1.14p ps=6.38u w=6u l=1u
X1377 iqmod_mfb_lpf_0.iqmod_mfb_lpf_half_1.iqmod_mfb_lpf_ota_core_hybrid_bm_half$1_0.iqmod_mfb_lpf_ota_core_inv_NF20$2_1.vin iqmod_mfb_lpf_0.iqmod_mfb_lpf_half_1.iqmod_mfb_lpf_ota_core_hybrid_bm_half$1_0.iqmod_mfb_lpf_ota_core_spdt_switch$2_0.iqmod_mfb_lpf_ota_core_spdt_switch_inv$3_0.vout iqmod_spdt_switch_0.v_c VSS sg13_lv_nmos ad=0.19p pd=1.38u as=0.34p ps=2.68u w=1u l=0.13u
X1378 iqmod_mfb_lpf_0.iqmod_mfb_lpf_half_1.iqmod_mfb_lpf_ota_core_hybrid_bm_half$1_0.iqmod_mfb_lpf_ota_core_spdt_switch$2_0.iqmod_mfb_lpf_ota_core_spdt_switch_inv$3_0.vout iqmod_mfb_lpf_0.iqmod_mfb_lpf_half_1.iqmod_mfb_lpf_ota_core_hybrid_bm_half$1_0.iqmod_mfb_lpf_ota_core_tg$2_0.di_tg_ctrl_n VSS VSS sg13_lv_nmos ad=0.19p pd=1.38u as=0.19p ps=1.38u w=1u l=0.13u
X1379 iqmod_mixer_0.vinp_IF iqmod_mfb_lpf_0.iqmod_mfb_lpf_half_1.iqmod_mfb_lpf_ota_core_hybrid_bm_half$1_0.iqmod_mfb_lpf_ota_core_inv_NF20$2_1.vin VSS VSS sg13_lv_nmos ad=0.19p pd=1.38u as=0.19p ps=1.38u w=1u l=1u
X1380 iqmod_mixer_0.iqmod_mixer_half_1.iqmod_mixer_se2diff$1_0.iqmod_mixer_se2diff_half_tg$2_0.iqmod_mixer_se2diff_inv_NF54$6_0.vin iqmod_mixer_0.iqmod_mixer_half_1.iqmod_mixer_se2diff$1_0.iqmod_mixer_se2diff_half_tg$2_0.iqmod_mixer_se2diff_inv_NF18$6_0.vin VDD VDD sg13_lv_pmos ad=0.57p pd=3.38u as=0.57p ps=3.38u w=3u l=0.13u
X1381 VSS iqmod_mixer_0.iqmod_mixer_half_0.iqmod_mixer_se2diff$1_0.iqmod_mixer_se2diff_half_tg$2_0.iqmod_mixer_se2diff_inv_NF18$6_0.vin iqmod_mixer_0.iqmod_mixer_half_0.iqmod_mixer_se2diff$1_0.iqmod_mixer_se2diff_half_tg$2_0.iqmod_mixer_se2diff_inv_NF54$6_0.vin VSS sg13_lv_nmos ad=0.19p pd=1.38u as=0.19p ps=1.38u w=1u l=0.13u
X1382 iqmod_mfb_lpf_0.iqmod_mfb_lpf_half_0.iqmod_mfb_lpf_ota_core_hybrid_bm_half$1_0.iqmod_mfb_lpf_ota_core_inv_NF6$2_1.vout iqmod_mfb_lpf_0.iqmod_mfb_lpf_half_0.iqmod_mfb_lpf_ota_core_hybrid_bm_half$1_0.iqmod_mfb_lpf_ota_core_inv_NF20$2_0.vout VDD VDD sg13_lv_pmos ad=1.14p pd=6.38u as=1.14p ps=6.38u w=6u l=1u
X1383 VSS iqmod_mixer_0.iqmod_mixer_half_0.iqmod_mixer_se2diff$1_0.iqmod_mixer_se2diff_half_inv$2_0.iqmod_mixer_se2diff_inv_NF54$7_0.vin iqmod_mixer_0.iqmod_mixer_half_0.iqmod_mixer_tg$1_0.di_tg_ctrl VSS sg13_lv_nmos ad=0.19p pd=1.38u as=0.19p ps=1.38u w=1u l=0.13u
X1384 VDD iqmod_mixer_0.iqmod_mixer_half_0.iqmod_mixer_se2diff$1_0.iqmod_mixer_se2diff_half_tg$2_0.iqmod_mixer_se2diff_inv_NF54$6_0.vin iqmod_mixer_0.iqmod_mixer_half_0.iqmod_mixer_tg$1_0.di_tg_ctrl_n VDD sg13_lv_pmos ad=0.57p pd=3.38u as=0.57p ps=3.38u w=3u l=0.13u
X1385 iqmod_mixer_0.iqmod_mixer_half_1.iqmod_mixer_tg$1_0.di_tg_ctrl_n iqmod_mixer_0.iqmod_mixer_half_1.iqmod_mixer_se2diff$1_0.iqmod_mixer_se2diff_half_tg$2_0.iqmod_mixer_se2diff_inv_NF54$6_0.vin VSS VSS sg13_lv_nmos ad=0.19p pd=1.38u as=0.19p ps=1.38u w=1u l=0.13u
X1386 iqmod_mixer_0.iqmod_mixer_half_1.iqmod_mixer_se2diff$1_0.iqmod_mixer_se2diff_half_inv$2_0.iqmod_mixer_se2diff_inv_NF54$7_0.vin iqmod_mixer_0.iqmod_mixer_half_1.iqmod_mixer_se2diff$1_0.iqmod_mixer_se2diff_half_inv$2_0.iqmod_mixer_se2diff_inv_NF18$7_0.vin VDD VDD sg13_lv_pmos ad=0.57p pd=3.38u as=0.57p ps=3.38u w=3u l=0.13u
X1387 iqmod_mixer_0.iqmod_mixer_half_0.iqmod_mixer_se2diff$1_0.iqmod_mixer_se2diff_half_tg$2_0.iqmod_mixer_se2diff_inv_NF54$6_0.vin iqmod_mixer_0.iqmod_mixer_half_0.iqmod_mixer_se2diff$1_0.iqmod_mixer_se2diff_half_tg$2_0.iqmod_mixer_se2diff_inv_NF18$6_0.vin VSS VSS sg13_lv_nmos ad=0.19p pd=1.38u as=0.19p ps=1.38u w=1u l=0.13u
X1388 a_24469_10452# a_36355_10752# VSS rhigh l=59u w=0.5u
X1389 iqmod_mixer_0.iqmod_mixer_half_0.iqmod_mixer_tg$1_0.di_tg_ctrl_n iqmod_mixer_0.iqmod_mixer_half_0.iqmod_mixer_se2diff$1_0.iqmod_mixer_se2diff_half_tg$2_0.iqmod_mixer_se2diff_inv_NF54$6_0.vin VDD VDD sg13_lv_pmos ad=0.57p pd=3.38u as=0.57p ps=3.38u w=3u l=0.13u
X1390 VSS iqmod_mixer_0.iqmod_mixer_half_1.iqmod_mixer_se2diff$1_0.iqmod_mixer_se2diff_half_inv$2_0.iqmod_mixer_se2diff_inv_NF18$7_0.vin iqmod_mixer_0.iqmod_mixer_half_1.iqmod_mixer_se2diff$1_0.iqmod_mixer_se2diff_half_inv$2_0.iqmod_mixer_se2diff_inv_NF54$7_0.vin VSS sg13_lv_nmos ad=0.19p pd=1.38u as=0.19p ps=1.38u w=1u l=0.13u
X1391 voutn_I_RF iqmod_mixer_0.iqmod_mixer_half_0.iqmod_mixer_tg$1_0.di_tg_ctrl_n iqmod_mixer_0.vinn_IF VDD sg13_lv_pmos ad=1.71p pd=9.38u as=1.71p ps=9.38u w=9u l=0.13u
X1392 iqmod_mixer_0.vinn_IF iqmod_mfb_lpf_0.iqmod_mfb_lpf_half_0.iqmod_mfb_lpf_ota_core_hybrid_bm_half$1_0.iqmod_mfb_lpf_ota_core_tg$2_0.v_b VDD VDD sg13_lv_pmos ad=1.14p pd=6.38u as=1.14p ps=6.38u w=6u l=1u
X1393 iqmod_mixer_0.iqmod_mixer_half_0.iqmod_mixer_tg$1_0.di_tg_ctrl iqmod_mixer_0.iqmod_mixer_half_0.iqmod_mixer_se2diff$1_0.iqmod_mixer_se2diff_half_inv$2_0.iqmod_mixer_se2diff_inv_NF54$7_0.vin VSS VSS sg13_lv_nmos ad=0.19p pd=1.38u as=0.19p ps=1.38u w=1u l=0.13u
X1394 VSS iqmod_mfb_lpf_0.iqmod_mfb_lpf_half_0.iqmod_mfb_lpf_ota_core_hybrid_bm_half$1_0.iqmod_mfb_lpf_ota_core_inv_NF20$2_0.vout iqmod_mfb_lpf_0.iqmod_mfb_lpf_half_0.iqmod_mfb_lpf_ota_core_hybrid_bm_half$1_0.iqmod_mfb_lpf_ota_core_inv_NF6$2_1.vout VSS sg13_lv_nmos ad=0.19p pd=1.38u as=0.19p ps=1.38u w=1u l=1u
X1395 VSS iqmod_mfb_lpf_0.iqmod_mfb_lpf_half_0.iqmod_mfb_lpf_ota_core_hybrid_bm_half$1_0.iqmod_mfb_lpf_ota_core_tg$2_0.v_b iqmod_mixer_0.vinn_IF VSS sg13_lv_nmos ad=0.19p pd=1.38u as=0.19p ps=1.38u w=1u l=1u
X1396 VSS iqmod_mfb_lpf_0.iqmod_mfb_lpf_half_1.iqmod_mfb_lpf_ota_core_hybrid_bm_half$1_0.iqmod_mfb_lpf_ota_core_inv_NF20$2_1.vin iqmod_mixer_0.vinp_IF VSS sg13_lv_nmos ad=0.19p pd=1.38u as=0.19p ps=1.38u w=1u l=1u
X1397 VDD iqmod_mixer_0.iqmod_mixer_half_1.iqmod_mixer_se2diff$1_0.iqmod_mixer_se2diff_half_tg$2_0.iqmod_mixer_se2diff_inv_NF54$6_0.vin iqmod_mixer_0.iqmod_mixer_half_1.iqmod_mixer_tg$1_0.di_tg_ctrl_n VDD sg13_lv_pmos ad=0.57p pd=3.38u as=0.57p ps=3.38u w=3u l=0.13u
X1398 VDD iqmod_mixer_0.iqmod_mixer_half_0.iqmod_mixer_se2diff$1_0.iqmod_mixer_se2diff_half_inv$2_0.iqmod_mixer_se2diff_inv_NF18$7_0.vin iqmod_mixer_0.iqmod_mixer_half_0.iqmod_mixer_se2diff$1_0.iqmod_mixer_se2diff_half_inv$2_0.iqmod_mixer_se2diff_inv_NF54$7_0.vin VDD sg13_lv_pmos ad=0.57p pd=3.38u as=0.57p ps=3.38u w=3u l=0.13u
X1399 iqmod_mixer_0.vinp_IF iqmod_mixer_0.iqmod_mixer_half_1.iqmod_mixer_tg$1_0.di_tg_ctrl_n voutp_I_RF VDD sg13_lv_pmos ad=1.71p pd=9.38u as=1.71p ps=9.38u w=9u l=0.13u
X1400 VDD iqmod_mixer_0.iqmod_mixer_half_0.iqmod_mixer_se2diff$1_0.iqmod_mixer_se2diff_half_tg$2_0.iqmod_mixer_se2diff_inv_NF54$6_0.vin iqmod_mixer_0.iqmod_mixer_half_0.iqmod_mixer_tg$1_0.di_tg_ctrl_n VDD sg13_lv_pmos ad=0.57p pd=3.38u as=0.57p ps=3.38u w=3u l=0.13u
X1401 iqmod_mixer_0.iqmod_mixer_half_1.iqmod_mixer_se2diff$1_0.iqmod_mixer_se2diff_half_inv$2_0.iqmod_mixer_se2diff_inv_NF54$7_0.vin iqmod_mixer_0.iqmod_mixer_half_1.iqmod_mixer_se2diff$1_0.iqmod_mixer_se2diff_half_inv$2_0.iqmod_mixer_se2diff_inv_NF18$7_0.vin VSS VSS sg13_lv_nmos ad=0.19p pd=1.38u as=0.19p ps=1.38u w=1u l=0.13u
X1402 VSS VSS VSS VSS sg13_lv_nmos ad=0.19p pd=1.38u as=0 ps=0 w=1u l=0.13u
X1403 iqmod_mixer_0.iqmod_mixer_half_1.iqmod_mixer_se2diff$1_0.iqmod_mixer_se2diff_half_inv$2_0.iqmod_mixer_se2diff_inv_NF6$7_1.vin iqmod_mixer_0.iqmod_mixer_half_1.iqmod_mixer_se2diff$1_0.iqmod_mixer_se2diff_half_inv$2_0.iqmod_mixer_se2diff_inv_NF2$7_1.vout VDD VDD sg13_lv_pmos ad=0.57p pd=3.38u as=0.57p ps=3.38u w=3u l=0.13u
X1404 voutp_I_RF iqmod_mixer_0.iqmod_mixer_half_1.iqmod_mixer_tg$1_0.di_tg_ctrl_n voutp_I_RF VSS sg13_lv_nmos ad=0.57p pd=3.38u as=0 ps=0 w=3u l=0.13u
X1405 voutn_I_RF iqmod_mixer_0.iqmod_mixer_half_0.iqmod_mixer_tg$1_0.di_tg_ctrl iqmod_mixer_0.vinn_IF VSS sg13_lv_nmos ad=0.57p pd=3.38u as=0.57p ps=3.38u w=3u l=0.13u
X1406 iqmod_mixer_0.iqmod_mixer_half_1.iqmod_mixer_tg$1_0.di_tg_ctrl_n iqmod_mixer_0.iqmod_mixer_half_1.iqmod_mixer_se2diff$1_0.iqmod_mixer_se2diff_half_tg$2_0.iqmod_mixer_se2diff_inv_NF54$6_0.vin VDD VDD sg13_lv_pmos ad=0.57p pd=3.38u as=0.57p ps=3.38u w=3u l=0.13u
X1407 iqmod_mfb_lpf_0.iqmod_mfb_lpf_half_0.iqmod_mfb_lpf_ota_core_hybrid_bm_half$1_0.iqmod_mfb_lpf_ota_core_inv_NF6$2_1.vout iqmod_mfb_lpf_0.iqmod_mfb_lpf_half_0.iqmod_mfb_lpf_ota_core_hybrid_bm_half$1_0.iqmod_mfb_lpf_ota_core_tg$2_0.di_tg_ctrl_n iqmod_mfb_lpf_0.iqmod_mfb_lpf_half_0.iqmod_mfb_lpf_ota_core_hybrid_bm_half$1_0.iqmod_mfb_lpf_ota_core_inv_NF20$2_0.vout VDD sg13_lv_pmos ad=1.14p pd=6.38u as=2.04p ps=12.68u w=6u l=0.13u
X1408 iqmod_mfb_lpf_0.iqmod_mfb_lpf_half_0.iqmod_mfb_lpf_R3$1_0.v_a a_48939_10452# VSS rhigh l=60u w=0.5u
X1409 iqmod_mixer_0.iqmod_mixer_half_0.iqmod_mixer_se2diff$1_0.iqmod_mixer_se2diff_half_inv$2_0.iqmod_mixer_se2diff_inv_NF54$7_0.vin iqmod_mixer_0.iqmod_mixer_half_0.iqmod_mixer_se2diff$1_0.iqmod_mixer_se2diff_half_inv$2_0.iqmod_mixer_se2diff_inv_NF18$7_0.vin VDD VDD sg13_lv_pmos ad=0.57p pd=3.38u as=0.57p ps=3.38u w=3u l=0.13u
X1410 iqmod_mixer_0.vinp_IF iqmod_mixer_0.iqmod_mixer_half_1.iqmod_mixer_tg$1_0.di_tg_ctrl voutp_I_RF VSS sg13_lv_nmos ad=0.57p pd=3.38u as=0.57p ps=3.38u w=3u l=0.13u
X1411 iqmod_mfb_lpf_0.iqmod_mfb_lpf_half_0.iqmod_mfb_lpf_ota_core_hybrid_bm_half$1_0.iqmod_mfb_lpf_ota_core_tg$2_0.v_a di_analog_en iqmod_mfb_lpf_0.iqmod_mfb_lpf_half_0.iqmod_mfb_lpf_ota_core_hybrid_bm_half$1_0.iqmod_mfb_lpf_ota_core_tg$2_0.v_b VSS sg13_lv_nmos ad=0.19p pd=1.38u as=0.19p ps=1.38u w=1u l=0.13u
X1412 VDD iqmod_mfb_lpf_0.iqmod_mfb_lpf_half_0.iqmod_mfb_lpf_ota_core_hybrid_bm_half$1_0.iqmod_mfb_lpf_ota_core_tg$2_0.v_b iqmod_mixer_0.vinn_IF VDD sg13_lv_pmos ad=1.14p pd=6.38u as=1.14p ps=6.38u w=6u l=1u
X1413 iqmod_mixer_0.vinn_IF iqmod_mfb_lpf_0.iqmod_mfb_lpf_half_0.iqmod_mfb_lpf_ota_core_hybrid_bm_half$1_0.iqmod_mfb_lpf_ota_core_tg$2_0.v_b VSS VSS sg13_lv_nmos ad=0.19p pd=1.38u as=0.19p ps=1.38u w=1u l=1u
X1414 voutp_I_RF iqmod_mixer_0.iqmod_mixer_half_1.iqmod_mixer_tg$1_0.di_tg_ctrl_n voutp_I_RF VSS sg13_lv_nmos ad=0.57p pd=3.38u as=0 ps=0 w=3u l=0.13u
X1415 VDD iqmod_mixer_0.iqmod_mixer_half_1.iqmod_mixer_se2diff$1_0.iqmod_mixer_se2diff_half_tg$2_0.iqmod_mixer_se2diff_inv_NF54$6_0.vin iqmod_mixer_0.iqmod_mixer_half_1.iqmod_mixer_tg$1_0.di_tg_ctrl_n VDD sg13_lv_pmos ad=0.57p pd=3.38u as=0.57p ps=3.38u w=3u l=0.13u
X1416 iqmod_mixer_0.iqmod_mixer_half_0.iqmod_mixer_tg$1_0.di_tg_ctrl_n iqmod_mixer_0.iqmod_mixer_half_0.iqmod_mixer_se2diff$1_0.iqmod_mixer_se2diff_half_tg$2_0.iqmod_mixer_se2diff_inv_NF54$6_0.vin VSS VSS sg13_lv_nmos ad=0.19p pd=1.38u as=0.19p ps=1.38u w=1u l=0.13u
X1417 VSS iqmod_mixer_0.iqmod_mixer_half_1.iqmod_mixer_se2diff$1_0.iqmod_mixer_se2diff_half_inv$2_0.iqmod_mixer_se2diff_inv_NF54$7_0.vin iqmod_mixer_0.iqmod_mixer_half_1.iqmod_mixer_tg$1_0.di_tg_ctrl VSS sg13_lv_nmos ad=0.19p pd=1.38u as=0.19p ps=1.38u w=1u l=0.13u
X1418 voutp_I_RF iqmod_mixer_0.iqmod_mixer_half_1.iqmod_mixer_tg$1_0.di_tg_ctrl_n voutp_I_RF VSS sg13_lv_nmos ad=0.57p pd=3.38u as=0 ps=0 w=3u l=0.13u
X1419 iqmod_mixer_0.iqmod_mixer_half_1.iqmod_mixer_se2diff$1_0.iqmod_mixer_se2diff_half_inv$2_0.iqmod_mixer_se2diff_inv_NF2$7_1.vout iqmod_mixer_0.iqmod_mixer_half_1.iqmod_mixer_se2diff$1_0.iqmod_mixer_se2diff_half_inv$2_0.iqmod_mixer_se2diff_inv_NF6$7_1.vin VSS VSS sg13_lv_nmos ad=0.19p pd=1.38u as=0.19p ps=1.38u w=1u l=0.13u
X1420 iqmod_mfb_lpf_0.iqmod_mfb_lpf_half_0.iqmod_mfb_lpf_ota_core_hybrid_bm_half$1_0.iqmod_mfb_lpf_ota_core_inv_NF20$2_0.vout iqmod_mixer_0.vinp_IF VDD VDD sg13_lv_pmos ad=1.14p pd=6.38u as=1.14p ps=6.38u w=6u l=1u
X1421 VSS iqmod_mixer_0.iqmod_mixer_half_1.iqmod_mixer_se2diff$1_0.iqmod_mixer_se2diff_half_tg$2_0.iqmod_mixer_se2diff_tg_NF6$3_0.v_b iqmod_mixer_0.iqmod_mixer_half_1.iqmod_mixer_se2diff$1_0.iqmod_mixer_se2diff_half_inv$2_0.iqmod_mixer_se2diff_inv_NF2$7_1.vout VSS sg13_lv_nmos ad=0.19p pd=1.38u as=0.19p ps=1.38u w=1u l=0.13u
X1422 VDD iqmod_mixer_0.iqmod_mixer_half_0.iqmod_mixer_se2diff$1_0.iqmod_mixer_se2diff_half_inv$2_0.iqmod_mixer_se2diff_inv_NF54$7_0.vin iqmod_mixer_0.iqmod_mixer_half_0.iqmod_mixer_tg$1_0.di_tg_ctrl VDD sg13_lv_pmos ad=0.57p pd=3.38u as=0.57p ps=3.38u w=3u l=0.13u
X1423 VSS iqmod_mfb_lpf_0.iqmod_mfb_lpf_half_0.iqmod_mfb_lpf_ota_core_hybrid_bm_half$1_0.iqmod_mfb_lpf_ota_core_tg$2_0.v_b iqmod_mixer_0.vinp_IF VSS sg13_lv_nmos ad=0.19p pd=1.38u as=0.19p ps=1.38u w=1u l=1u
X1424 iqmod_mixer_0.vinn_IF iqmod_mfb_lpf_0.iqmod_mfb_lpf_half_0.iqmod_mfb_lpf_ota_core_hybrid_bm_half$1_0.iqmod_mfb_lpf_ota_core_tg$2_0.v_b VDD VDD sg13_lv_pmos ad=1.14p pd=6.38u as=1.14p ps=6.38u w=6u l=1u
X1425 iqmod_mixer_0.vinp_IF iqmod_mixer_0.iqmod_mixer_half_1.iqmod_mixer_tg$1_0.di_tg_ctrl voutp_I_RF VSS sg13_lv_nmos ad=0.57p pd=3.38u as=1.02p ps=6.68u w=3u l=0.13u
X1426 iqmod_mixer_0.iqmod_mixer_half_1.iqmod_mixer_tg$1_0.di_tg_ctrl iqmod_mixer_0.iqmod_mixer_half_1.iqmod_mixer_se2diff$1_0.iqmod_mixer_se2diff_half_inv$2_0.iqmod_mixer_se2diff_inv_NF54$7_0.vin VSS VSS sg13_lv_nmos ad=0.19p pd=1.38u as=0.19p ps=1.38u w=1u l=0.13u
X1427 iqmod_mfb_lpf_0.iqmod_mfb_lpf_half_0.iqmod_mfb_lpf_ota_core_hybrid_bm_half$1_0.iqmod_mfb_lpf_ota_core_inv_NF20$2_0.vout iqmod_mixer_0.vinn_IF VSS VSS sg13_lv_nmos ad=0.19p pd=1.38u as=0.19p ps=1.38u w=1u l=1u
X1428 VSS iqmod_mfb_lpf_0.iqmod_mfb_lpf_half_0.iqmod_mfb_lpf_ota_core_hybrid_bm_half$1_0.iqmod_mfb_lpf_ota_core_tg$2_0.v_b iqmod_mixer_0.vinn_IF VSS sg13_lv_nmos ad=0.19p pd=1.38u as=0.19p ps=1.38u w=1u l=1u
X1429 iqmod_mixer_0.iqmod_mixer_half_0.iqmod_mixer_se2diff$1_0.iqmod_mixer_se2diff_half_inv$2_0.iqmod_mixer_se2diff_inv_NF2$7_1.vout iqmod_mixer_0.iqmod_mixer_half_0.iqmod_mixer_se2diff$1_0.iqmod_mixer_se2diff_half_inv$2_0.iqmod_mixer_se2diff_inv_NF6$7_1.vin VDD VDD sg13_lv_pmos ad=0.57p pd=3.38u as=0.57p ps=3.38u w=3u l=0.13u
X1430 iqmod_mfb_lpf_0.iqmod_mfb_lpf_half_1.iqmod_mfb_lpf_ota_core_hybrid_bm_half$1_0.iqmod_mfb_lpf_ota_core_inv_NF20$2_1.vin iqmod_mfb_lpf_0.iqmod_mfb_lpf_half_1.iqmod_mfb_lpf_ota_core_hybrid_bm_half$1_0.iqmod_mfb_lpf_ota_core_spdt_switch$2_0.iqmod_mfb_lpf_ota_core_spdt_switch_inv$3_0.vout VDD VDD sg13_lv_pmos ad=1.14p pd=6.38u as=2.04p ps=12.68u w=6u l=0.13u
X1431 iqmod_spdt_switch_0.v_c iqmod_mfb_lpf_0.iqmod_mfb_lpf_half_1.iqmod_mfb_lpf_ota_core_hybrid_bm_half$1_0.iqmod_mfb_lpf_ota_core_tg$2_0.di_tg_ctrl_n iqmod_mfb_lpf_0.iqmod_mfb_lpf_half_1.iqmod_mfb_lpf_ota_core_hybrid_bm_half$1_0.iqmod_mfb_lpf_ota_core_inv_NF20$2_1.vin VDD sg13_lv_pmos ad=1.14p pd=6.38u as=1.14p ps=6.38u w=6u l=0.13u
X1432 di_ds_I_p iqmod_spdt_switch_1.spdt_switch_inv_0.vin iqmod_spdt_switch_1.v_c VSS sg13_lv_nmos ad=0.19p pd=1.38u as=0.19p ps=1.38u w=1u l=0.13u
X1433 VSS iqmod_mixer_0.iqmod_mixer_half_0.iqmod_mixer_se2diff$1_0.iqmod_mixer_se2diff_half_inv$2_0.iqmod_mixer_se2diff_inv_NF18$7_0.vin iqmod_mixer_0.iqmod_mixer_half_0.iqmod_mixer_se2diff$1_0.iqmod_mixer_se2diff_half_inv$2_0.iqmod_mixer_se2diff_inv_NF54$7_0.vin VSS sg13_lv_nmos ad=0.19p pd=1.38u as=0.19p ps=1.38u w=1u l=0.13u
X1434 iqmod_mixer_0.iqmod_mixer_half_1.iqmod_mixer_se2diff$1_0.iqmod_mixer_se2diff_half_inv$2_0.iqmod_mixer_se2diff_inv_NF2$7_1.vout iqmod_mixer_0.iqmod_mixer_half_1.iqmod_mixer_se2diff$1_0.iqmod_mixer_se2diff_half_tg$2_0.iqmod_mixer_se2diff_tg_NF6$3_0.v_b VSS VSS sg13_lv_nmos ad=0.19p pd=1.38u as=0.19p ps=1.38u w=1u l=0.13u
X1435 VSS VSS VSS VSS sg13_lv_nmos ad=0.19p pd=1.38u as=0 ps=0 w=1u l=0.13u
X1436 iqmod_mixer_0.iqmod_mixer_half_0.iqmod_mixer_tg$1_0.di_tg_ctrl iqmod_mixer_0.iqmod_mixer_half_0.iqmod_mixer_se2diff$1_0.iqmod_mixer_se2diff_half_inv$2_0.iqmod_mixer_se2diff_inv_NF54$7_0.vin VDD VDD sg13_lv_pmos ad=0.57p pd=3.38u as=0.57p ps=3.38u w=3u l=0.13u
X1437 VDD iqmod_mixer_0.iqmod_mixer_half_0.iqmod_mixer_se2diff$1_0.iqmod_mixer_se2diff_half_tg$2_0.iqmod_mixer_se2diff_inv_NF18$6_0.vin iqmod_mixer_0.iqmod_mixer_half_0.iqmod_mixer_se2diff$1_0.iqmod_mixer_se2diff_half_tg$2_0.iqmod_mixer_se2diff_inv_NF54$6_0.vin VDD sg13_lv_pmos ad=0.57p pd=3.38u as=0.57p ps=3.38u w=3u l=0.13u
X1438 iqmod_mixer_0.iqmod_mixer_half_1.iqmod_mixer_se2diff$1_0.iqmod_mixer_se2diff_half_inv$2_0.iqmod_mixer_se2diff_inv_NF6$7_0.vin di_lo_I VDD VDD sg13_lv_pmos ad=0.57p pd=3.38u as=0.57p ps=3.38u w=3u l=0.13u
X1439 VSS iqmod_mixer_0.iqmod_mixer_half_1.iqmod_mixer_se2diff$1_0.iqmod_mixer_se2diff_half_inv$2_0.iqmod_mixer_se2diff_inv_NF54$7_0.vin iqmod_mixer_0.iqmod_mixer_half_1.iqmod_mixer_tg$1_0.di_tg_ctrl VSS sg13_lv_nmos ad=0.19p pd=1.38u as=0.19p ps=1.38u w=1u l=0.13u
X1440 iqmod_mixer_0.iqmod_mixer_half_1.iqmod_mixer_tg$1_0.di_tg_ctrl iqmod_mixer_0.iqmod_mixer_half_1.iqmod_mixer_se2diff$1_0.iqmod_mixer_se2diff_half_inv$2_0.iqmod_mixer_se2diff_inv_NF54$7_0.vin VDD VDD sg13_lv_pmos ad=0.57p pd=3.38u as=0.57p ps=3.38u w=3u l=0.13u
X1441 VDD iqmod_mixer_0.vinp_IF iqmod_mfb_lpf_0.iqmod_mfb_lpf_half_0.iqmod_mfb_lpf_ota_core_hybrid_bm_half$1_0.iqmod_mfb_lpf_ota_core_inv_NF20$2_0.vout VDD sg13_lv_pmos ad=1.14p pd=6.38u as=1.14p ps=6.38u w=6u l=1u
X1442 VDD iqmod_mixer_0.iqmod_mixer_half_0.iqmod_mixer_se2diff$1_0.iqmod_mixer_se2diff_half_inv$2_0.iqmod_mixer_se2diff_inv_NF54$7_0.vin iqmod_mixer_0.iqmod_mixer_half_0.iqmod_mixer_tg$1_0.di_tg_ctrl VDD sg13_lv_pmos ad=0.57p pd=3.38u as=0.57p ps=3.38u w=3u l=0.13u
X1443 iqmod_mixer_0.vinp_IF iqmod_mfb_lpf_0.iqmod_mfb_lpf_half_0.iqmod_mfb_lpf_ota_core_hybrid_bm_half$1_0.iqmod_mfb_lpf_ota_core_tg$2_0.v_b VSS VSS sg13_lv_nmos ad=0.19p pd=1.38u as=0.19p ps=1.38u w=1u l=1u
X1444 iqmod_mixer_0.iqmod_mixer_half_0.iqmod_mixer_se2diff$1_0.iqmod_mixer_se2diff_half_tg$2_0.iqmod_mixer_se2diff_inv_NF54$6_0.vin iqmod_mixer_0.iqmod_mixer_half_0.iqmod_mixer_se2diff$1_0.iqmod_mixer_se2diff_half_tg$2_0.iqmod_mixer_se2diff_inv_NF18$6_0.vin VDD VDD sg13_lv_pmos ad=0.57p pd=3.38u as=0.57p ps=3.38u w=3u l=0.13u
X1445 iqmod_mfb_lpf_0.iqmod_mfb_lpf_half_0.iqmod_mfb_lpf_ota_core_hybrid_bm_half$1_0.iqmod_mfb_lpf_ota_core_tg$2_0.v_a iqmod_mfb_lpf_0.iqmod_mfb_lpf_half_1.iqmod_mfb_lpf_ota_core_hybrid_bm_half$1_0.iqmod_mfb_lpf_ota_core_inv_NF20$2_1.vin VDD VDD sg13_lv_pmos ad=1.14p pd=6.38u as=1.14p ps=6.38u w=6u l=1u
X1446 VSS VSS VSS VSS sg13_lv_nmos ad=0.19p pd=1.38u as=0 ps=0 w=1u l=0.13u
X1447 iqmod_mixer_0.iqmod_mixer_half_1.iqmod_mixer_tg$1_0.di_tg_ctrl iqmod_mixer_0.iqmod_mixer_half_1.iqmod_mixer_se2diff$1_0.iqmod_mixer_se2diff_half_inv$2_0.iqmod_mixer_se2diff_inv_NF54$7_0.vin VDD VDD sg13_lv_pmos ad=0.57p pd=3.38u as=0.57p ps=3.38u w=3u l=0.13u
X1448 vinn_I iqmod_spdt_switch_0.spdt_switch_inv_0.vin iqmod_spdt_switch_0.v_c VDD sg13_lv_pmos ad=2.04p pd=12.68u as=1.14p ps=6.38u w=6u l=0.13u
X1449 VSS VSS VSS VSS sg13_lv_nmos ad=0.34p pd=2.68u as=0 ps=0 w=1u l=0.13u
X1450 iqmod_mixer_0.iqmod_mixer_half_1.iqmod_mixer_se2diff$1_0.iqmod_mixer_se2diff_half_inv$2_0.iqmod_mixer_se2diff_inv_NF6$7_0.vin di_lo_I VSS VSS sg13_lv_nmos ad=0.19p pd=1.38u as=0.19p ps=1.38u w=1u l=0.13u
X1451 VSS VSS VSS VSS sg13_lv_nmos ad=0.34p pd=2.68u as=0 ps=0 w=1u l=0.13u
X1452 iqmod_mixer_0.iqmod_mixer_half_0.iqmod_mixer_se2diff$1_0.iqmod_mixer_se2diff_half_inv$2_0.iqmod_mixer_se2diff_inv_NF6$7_1.vin iqmod_mixer_0.iqmod_mixer_half_0.iqmod_mixer_se2diff$1_0.iqmod_mixer_se2diff_half_inv$2_0.iqmod_mixer_se2diff_inv_NF6$7_0.vout VSS VSS sg13_lv_nmos ad=0.19p pd=1.38u as=0.19p ps=1.38u w=1u l=0.13u
X1453 VDD iqmod_mfb_lpf_0.iqmod_mfb_lpf_half_0.iqmod_mfb_lpf_ota_core_hybrid_bm_half$1_0.iqmod_mfb_lpf_ota_core_spdt_switch$2_0.iqmod_mfb_lpf_ota_core_spdt_switch_inv$3_0.vout iqmod_mfb_lpf_0.iqmod_mfb_lpf_half_0.iqmod_mfb_lpf_ota_core_hybrid_bm_half$1_0.iqmod_mfb_lpf_ota_core_inv_NF20$2_1.vin VDD sg13_lv_pmos ad=1.14p pd=6.38u as=1.14p ps=6.38u w=6u l=0.13u
X1454 VSS iqmod_mixer_0.iqmod_mixer_half_0.iqmod_mixer_se2diff$1_0.iqmod_mixer_se2diff_half_tg$2_0.iqmod_mixer_se2diff_inv_NF54$6_0.vin iqmod_mixer_0.iqmod_mixer_half_0.iqmod_mixer_tg$1_0.di_tg_ctrl_n VSS sg13_lv_nmos ad=0.19p pd=1.38u as=0.19p ps=1.38u w=1u l=0.13u
X1455 iqmod_mixer_0.iqmod_mixer_half_1.iqmod_mixer_tg$1_0.di_tg_ctrl_n iqmod_mixer_0.iqmod_mixer_half_1.iqmod_mixer_se2diff$1_0.iqmod_mixer_se2diff_half_tg$2_0.iqmod_mixer_se2diff_inv_NF54$6_0.vin VSS VSS sg13_lv_nmos ad=0.19p pd=1.38u as=0.19p ps=1.38u w=1u l=0.13u
X1456 VDD iqmod_mixer_0.vinn_IF iqmod_mfb_lpf_0.iqmod_mfb_lpf_half_0.iqmod_mfb_lpf_ota_core_hybrid_bm_half$1_0.iqmod_mfb_lpf_ota_core_inv_NF20$2_0.vout VDD sg13_lv_pmos ad=1.14p pd=6.38u as=1.14p ps=6.38u w=6u l=1u
X1457 iqmod_mixer_0.vinn_IF iqmod_mfb_lpf_0.iqmod_mfb_lpf_half_0.iqmod_mfb_lpf_ota_core_hybrid_bm_half$1_0.iqmod_mfb_lpf_ota_core_inv_NF20$2_1.vin VDD VDD sg13_lv_pmos ad=1.14p pd=6.38u as=1.14p ps=6.38u w=6u l=1u
X1458 iqmod_spdt_switch_0.v_c iqmod_spdt_switch_0.spdt_switch_inv_0.vin vinn_I VDD sg13_lv_pmos ad=1.14p pd=6.38u as=1.14p ps=6.38u w=6u l=0.13u
X1459 iqmod_mixer_0.iqmod_mixer_half_0.iqmod_mixer_se2diff$1_0.iqmod_mixer_se2diff_half_inv$2_0.iqmod_mixer_se2diff_inv_NF6$7_0.vin di_lo_Ix VDD VDD sg13_lv_pmos ad=0.57p pd=3.38u as=0.57p ps=3.38u w=3u l=0.13u
X1460 VDD iqmod_mfb_lpf_0.iqmod_mfb_lpf_half_1.iqmod_mfb_lpf_ota_core_hybrid_bm_half$1_0.iqmod_mfb_lpf_ota_core_inv_NF20$2_1.vin iqmod_mfb_lpf_0.iqmod_mfb_lpf_half_0.iqmod_mfb_lpf_ota_core_hybrid_bm_half$1_0.iqmod_mfb_lpf_ota_core_tg$2_0.v_a VDD sg13_lv_pmos ad=1.14p pd=6.38u as=1.14p ps=6.38u w=6u l=1u
X1461 iqmod_mfb_lpf_0.iqmod_mfb_lpf_half_0.iqmod_mfb_lpf_ota_core_hybrid_bm_half$1_0.iqmod_mfb_lpf_ota_core_inv_NF20$2_0.vout iqmod_mixer_0.vinn_IF VSS VSS sg13_lv_nmos ad=0.19p pd=1.38u as=0.19p ps=1.38u w=1u l=1u
X1462 VSS iqmod_mixer_0.iqmod_mixer_half_0.iqmod_mixer_se2diff$1_0.iqmod_mixer_se2diff_half_inv$2_0.iqmod_mixer_se2diff_inv_NF6$7_0.vout iqmod_mixer_0.iqmod_mixer_half_0.iqmod_mixer_se2diff$1_0.iqmod_mixer_se2diff_half_inv$2_0.iqmod_mixer_se2diff_inv_NF6$7_1.vin VSS sg13_lv_nmos ad=0.19p pd=1.38u as=0.19p ps=1.38u w=1u l=0.13u
X1463 VDD iqmod_mixer_0.iqmod_mixer_half_0.iqmod_mixer_se2diff$1_0.iqmod_mixer_se2diff_half_tg$2_0.iqmod_mixer_se2diff_tg_NF6$3_0.v_b iqmod_mixer_0.iqmod_mixer_half_0.iqmod_mixer_se2diff$1_0.iqmod_mixer_se2diff_half_inv$2_0.iqmod_mixer_se2diff_inv_NF2$7_1.vout VDD sg13_lv_pmos ad=0.57p pd=3.38u as=0.57p ps=3.38u w=3u l=0.13u
X1464 iqmod_mixer_0.iqmod_mixer_half_1.iqmod_mixer_tg$1_0.di_tg_ctrl iqmod_mixer_0.iqmod_mixer_half_1.iqmod_mixer_se2diff$1_0.iqmod_mixer_se2diff_half_inv$2_0.iqmod_mixer_se2diff_inv_NF54$7_0.vin VDD VDD sg13_lv_pmos ad=0.57p pd=3.38u as=0.57p ps=3.38u w=3u l=0.13u
X1465 iqmod_mixer_0.iqmod_mixer_half_0.iqmod_mixer_tg$1_0.di_tg_ctrl_n iqmod_mixer_0.iqmod_mixer_half_0.iqmod_mixer_se2diff$1_0.iqmod_mixer_se2diff_half_tg$2_0.iqmod_mixer_se2diff_inv_NF54$6_0.vin VDD VDD sg13_lv_pmos ad=0.57p pd=3.38u as=0.57p ps=3.38u w=3u l=0.13u
X1466 VSS iqmod_mixer_0.iqmod_mixer_half_1.iqmod_mixer_se2diff$1_0.iqmod_mixer_se2diff_half_tg$2_0.iqmod_mixer_se2diff_inv_NF54$6_0.vin iqmod_mixer_0.iqmod_mixer_half_1.iqmod_mixer_tg$1_0.di_tg_ctrl_n VSS sg13_lv_nmos ad=0.19p pd=1.38u as=0.19p ps=1.38u w=1u l=0.13u
X1467 voutn_I_RF iqmod_mixer_0.iqmod_mixer_half_0.iqmod_mixer_tg$1_0.di_tg_ctrl_n iqmod_mixer_0.vinn_IF VDD sg13_lv_pmos ad=1.71p pd=9.38u as=1.71p ps=9.38u w=9u l=0.13u
X1468 iqmod_mfb_lpf_0.iqmod_mfb_lpf_half_0.iqmod_mfb_lpf_ota_core_hybrid_bm_half$1_0.iqmod_mfb_lpf_ota_core_tg$2_0.di_tg_ctrl_n di_analog_en VDD VDD sg13_lv_pmos ad=1.14p pd=6.38u as=1.14p ps=6.38u w=6u l=0.13u
X1469 VDD iqmod_mixer_0.vinp_IF iqmod_mfb_lpf_0.iqmod_mfb_lpf_half_0.iqmod_mfb_lpf_ota_core_hybrid_bm_half$1_0.iqmod_mfb_lpf_ota_core_inv_NF20$2_0.vout VDD sg13_lv_pmos ad=1.14p pd=6.38u as=1.14p ps=6.38u w=6u l=1u
X1470 iqmod_mixer_0.iqmod_mixer_half_0.iqmod_mixer_se2diff$1_0.iqmod_mixer_se2diff_half_inv$2_0.iqmod_mixer_se2diff_inv_NF2$7_1.vout iqmod_mixer_0.iqmod_mixer_half_0.iqmod_mixer_se2diff$1_0.iqmod_mixer_se2diff_half_tg$2_0.iqmod_mixer_se2diff_tg_NF6$3_0.v_b VDD VDD sg13_lv_pmos ad=0.57p pd=3.38u as=0.57p ps=3.38u w=3u l=0.13u
X1471 iqmod_mixer_0.vinp_IF iqmod_mixer_0.iqmod_mixer_half_1.iqmod_mixer_tg$1_0.di_tg_ctrl_n voutp_I_RF VDD sg13_lv_pmos ad=1.71p pd=9.38u as=1.71p ps=9.38u w=9u l=0.13u
X1472 iqmod_mixer_0.vinp_IF iqmod_mfb_lpf_0.iqmod_mfb_lpf_half_1.iqmod_mfb_lpf_ota_core_hybrid_bm_half$1_0.iqmod_mfb_lpf_ota_core_inv_NF20$2_1.vin VSS VSS sg13_lv_nmos ad=0.19p pd=1.38u as=0.19p ps=1.38u w=1u l=1u
X1473 VSS iqmod_spdt_switch_1.spdt_switch_inv_0.vin iqmod_spdt_switch_1.spdt_switch_inv_0.vout VSS sg13_lv_nmos ad=0.19p pd=1.38u as=0.19p ps=1.38u w=1u l=0.13u
X1474 VDD VDD VDD VDD sg13_lv_pmos ad=1.14p pd=6.38u as=0 ps=0 w=6u l=1u
X1475 VDD iqmod_mfb_lpf_0.iqmod_mfb_lpf_half_0.iqmod_mfb_lpf_ota_core_hybrid_bm_half$1_0.iqmod_mfb_lpf_ota_core_inv_NF20$2_1.vin iqmod_mixer_0.vinn_IF VDD sg13_lv_pmos ad=1.14p pd=6.38u as=1.14p ps=6.38u w=6u l=1u
X1476 iqmod_mixer_0.vinn_IF iqmod_mixer_0.iqmod_mixer_half_0.iqmod_mixer_tg$1_0.di_tg_ctrl_n voutn_I_RF VDD sg13_lv_pmos ad=1.71p pd=9.38u as=1.71p ps=9.38u w=9u l=0.13u
X1477 VSS iqmod_mixer_0.vinn_IF iqmod_mfb_lpf_0.iqmod_mfb_lpf_half_0.iqmod_mfb_lpf_ota_core_hybrid_bm_half$1_0.iqmod_mfb_lpf_ota_core_inv_NF20$2_0.vout VSS sg13_lv_nmos ad=0.19p pd=1.38u as=0.19p ps=1.38u w=1u l=1u
X1478 voutn_I_RF iqmod_mixer_0.iqmod_mixer_half_0.iqmod_mixer_tg$1_0.di_tg_ctrl iqmod_mixer_0.vinn_IF VSS sg13_lv_nmos ad=0.57p pd=3.38u as=0.57p ps=3.38u w=3u l=0.13u
X1479 iqmod_mixer_0.iqmod_mixer_half_1.iqmod_mixer_tg$1_0.di_tg_ctrl iqmod_mixer_0.iqmod_mixer_half_1.iqmod_mixer_se2diff$1_0.iqmod_mixer_se2diff_half_inv$2_0.iqmod_mixer_se2diff_inv_NF54$7_0.vin VDD VDD sg13_lv_pmos ad=0.57p pd=3.38u as=0.57p ps=3.38u w=3u l=0.13u
X1480 voutp_I_RF iqmod_mixer_0.iqmod_mixer_half_1.iqmod_mixer_tg$1_0.di_tg_ctrl_n iqmod_mixer_0.vinp_IF VDD sg13_lv_pmos ad=1.71p pd=9.38u as=1.71p ps=9.38u w=9u l=0.13u
X1481 VDD iqmod_mfb_lpf_0.iqmod_mfb_lpf_half_0.iqmod_mfb_lpf_ota_core_hybrid_bm_half$1_0.iqmod_mfb_lpf_ota_core_tg$2_0.v_b iqmod_mixer_0.vinp_IF VDD sg13_lv_pmos ad=1.14p pd=6.38u as=1.14p ps=6.38u w=6u l=1u
X1482 VSS VSS VSS VSS sg13_lv_nmos ad=0.34p pd=2.68u as=0 ps=0 w=1u l=0.13u
X1483 iqmod_mixer_0.vinn_IF iqmod_mixer_0.iqmod_mixer_half_0.iqmod_mixer_tg$1_0.di_tg_ctrl voutn_I_RF VSS sg13_lv_nmos ad=0.57p pd=3.38u as=0.57p ps=3.38u w=3u l=0.13u
X1484 VSS VSS VSS rhigh l=59u w=0.5u
X1485 iqmod_mfb_lpf_0.iqmod_mfb_lpf_half_0.iqmod_mfb_lpf_ota_core_hybrid_bm_half$1_0.iqmod_mfb_lpf_ota_core_inv_NF6$2_1.vout iqmod_mfb_lpf_0.iqmod_mfb_lpf_half_0.iqmod_mfb_lpf_ota_core_hybrid_bm_half$1_0.iqmod_mfb_lpf_ota_core_inv_NF20$2_0.vout VDD VDD sg13_lv_pmos ad=1.14p pd=6.38u as=1.14p ps=6.38u w=6u l=1u
X1486 VDD VDD VDD VDD sg13_lv_pmos ad=1.14p pd=6.38u as=0 ps=0 w=6u l=0.13u
X1487 VSS iqmod_mixer_0.iqmod_mixer_half_0.iqmod_mixer_se2diff$1_0.iqmod_mixer_se2diff_half_inv$2_0.iqmod_mixer_se2diff_inv_NF54$7_0.vin iqmod_mixer_0.iqmod_mixer_half_0.iqmod_mixer_tg$1_0.di_tg_ctrl VSS sg13_lv_nmos ad=0.19p pd=1.38u as=0.19p ps=1.38u w=1u l=0.13u
X1488 VSS iqmod_mfb_lpf_0.iqmod_mfb_lpf_half_1.iqmod_mfb_lpf_ota_core_hybrid_bm_half$1_0.iqmod_mfb_lpf_ota_core_inv_NF20$2_1.vin iqmod_mixer_0.vinp_IF VSS sg13_lv_nmos ad=0.19p pd=1.38u as=0.19p ps=1.38u w=1u l=1u
X1489 iqmod_mfb_lpf_0.iqmod_mfb_lpf_half_0.iqmod_mfb_lpf_ota_core_hybrid_bm_half$1_0.iqmod_mfb_lpf_ota_core_inv_NF20$2_0.vout iqmod_mixer_0.vinn_IF VSS VSS sg13_lv_nmos ad=0.19p pd=1.38u as=0.19p ps=1.38u w=1u l=1u
X1490 iqmod_mixer_0.iqmod_mixer_half_1.iqmod_mixer_tg$1_0.di_tg_ctrl iqmod_mixer_0.iqmod_mixer_half_1.iqmod_mixer_se2diff$1_0.iqmod_mixer_se2diff_half_inv$2_0.iqmod_mixer_se2diff_inv_NF54$7_0.vin VDD VDD sg13_lv_pmos ad=0.57p pd=3.38u as=0.57p ps=3.38u w=3u l=0.13u
X1491 voutp_I_RF iqmod_mixer_0.iqmod_mixer_half_1.iqmod_mixer_tg$1_0.di_tg_ctrl voutp_I_RF VDD sg13_lv_pmos ad=1.71p pd=9.38u as=0 ps=0 w=9u l=0.13u
X1492 VDD VDD VDD VDD sg13_lv_pmos ad=2.04p pd=12.68u as=0 ps=0 w=6u l=0.13u
X1493 iqmod_mixer_0.iqmod_mixer_half_0.iqmod_mixer_tg$1_0.di_tg_ctrl iqmod_mixer_0.iqmod_mixer_half_0.iqmod_mixer_se2diff$1_0.iqmod_mixer_se2diff_half_inv$2_0.iqmod_mixer_se2diff_inv_NF54$7_0.vin VSS VSS sg13_lv_nmos ad=0.19p pd=1.38u as=0.19p ps=1.38u w=1u l=0.13u
X1494 iqmod_mixer_0.vinp_IF iqmod_mfb_lpf_0.iqmod_mfb_lpf_half_0.iqmod_mfb_lpf_ota_core_hybrid_bm_half$1_0.iqmod_mfb_lpf_ota_core_tg$2_0.v_b VDD VDD sg13_lv_pmos ad=1.14p pd=6.38u as=1.14p ps=6.38u w=6u l=1u
X1495 VSS iqmod_mixer_0.iqmod_mixer_half_0.iqmod_mixer_se2diff$1_0.iqmod_mixer_se2diff_half_inv$2_0.iqmod_mixer_se2diff_inv_NF54$7_0.vin iqmod_mixer_0.iqmod_mixer_half_0.iqmod_mixer_tg$1_0.di_tg_ctrl VSS sg13_lv_nmos ad=0.19p pd=1.38u as=0.19p ps=1.38u w=1u l=0.13u
X1496 VSS VSS VSS VSS sg13_lv_nmos ad=0.19p pd=1.38u as=0 ps=0 w=1u l=1u
X1497 VDD iqmod_mixer_0.iqmod_mixer_half_0.iqmod_mixer_se2diff$1_0.iqmod_mixer_se2diff_half_tg$2_0.iqmod_mixer_se2diff_inv_NF54$6_0.vin iqmod_mixer_0.iqmod_mixer_half_0.iqmod_mixer_tg$1_0.di_tg_ctrl_n VDD sg13_lv_pmos ad=0.57p pd=3.38u as=0.57p ps=3.38u w=3u l=0.13u
X1498 iqmod_mixer_0.vinn_IF iqmod_mixer_0.iqmod_mixer_half_0.iqmod_mixer_tg$1_0.di_tg_ctrl_n voutn_I_RF VDD sg13_lv_pmos ad=1.71p pd=9.38u as=1.71p ps=9.38u w=9u l=0.13u
X1499 iqmod_mfb_lpf_0.iqmod_mfb_lpf_half_0.iqmod_mfb_lpf_ota_core_hybrid_bm_half$1_0.iqmod_mfb_lpf_ota_core_tg$2_0.v_a iqmod_mfb_lpf_0.iqmod_mfb_lpf_half_0.iqmod_mfb_lpf_ota_core_hybrid_bm_half$1_0.iqmod_mfb_lpf_ota_core_inv_NF20$2_1.vin VDD VDD sg13_lv_pmos ad=1.14p pd=6.38u as=1.14p ps=6.38u w=6u l=1u
X1500 iqmod_mfb_lpf_0.iqmod_mfb_lpf_half_0.iqmod_mfb_lpf_ota_core_hybrid_bm_half$1_0.iqmod_mfb_lpf_ota_core_inv_NF6$2_1.vout iqmod_mfb_lpf_0.iqmod_mfb_lpf_half_1.iqmod_mfb_lpf_ota_core_hybrid_bm_half$1_0.iqmod_mfb_lpf_ota_core_tg$2_0.di_tg_ctrl_n iqmod_mfb_lpf_0.iqmod_mfb_lpf_half_0.iqmod_mfb_lpf_ota_core_hybrid_bm_half$1_0.iqmod_mfb_lpf_ota_core_inv_NF20$2_0.vout VDD sg13_lv_pmos ad=1.14p pd=6.38u as=2.04p ps=12.68u w=6u l=0.13u
X1501 VSS VSS VSS VSS sg13_lv_nmos ad=0.34p pd=2.68u as=0 ps=0 w=1u l=0.13u
X1502 iqmod_mixer_0.iqmod_mixer_half_0.iqmod_mixer_se2diff$1_0.iqmod_mixer_se2diff_half_tg$2_0.iqmod_mixer_se2diff_inv_NF54$6_0.vin iqmod_mixer_0.iqmod_mixer_half_0.iqmod_mixer_se2diff$1_0.iqmod_mixer_se2diff_half_tg$2_0.iqmod_mixer_se2diff_inv_NF18$6_0.vin VSS VSS sg13_lv_nmos ad=0.19p pd=1.38u as=0.19p ps=1.38u w=1u l=0.13u
X1503 voutp_I_RF iqmod_mixer_0.iqmod_mixer_half_1.iqmod_mixer_tg$1_0.di_tg_ctrl voutp_I_RF VDD sg13_lv_pmos ad=1.71p pd=9.38u as=0 ps=0 w=9u l=0.13u
X1504 VDD iqmod_mfb_lpf_0.iqmod_mfb_lpf_half_0.iqmod_mfb_lpf_ota_core_hybrid_bm_half$1_0.iqmod_mfb_lpf_ota_core_tg$2_0.v_b iqmod_mixer_0.vinp_IF VDD sg13_lv_pmos ad=1.14p pd=6.38u as=1.14p ps=6.38u w=6u l=1u
X1505 VSS iqmod_mixer_0.iqmod_mixer_half_1.iqmod_mixer_se2diff$1_0.iqmod_mixer_se2diff_half_tg$2_0.iqmod_mixer_se2diff_inv_NF18$6_0.vin iqmod_mixer_0.iqmod_mixer_half_1.iqmod_mixer_se2diff$1_0.iqmod_mixer_se2diff_half_tg$2_0.iqmod_mixer_se2diff_inv_NF54$6_0.vin VSS sg13_lv_nmos ad=0.19p pd=1.38u as=0.19p ps=1.38u w=1u l=0.13u
X1506 voutn_I_RF iqmod_mixer_0.iqmod_mixer_half_0.iqmod_mixer_tg$1_0.di_tg_ctrl_n voutn_I_RF VSS sg13_lv_nmos ad=0.57p pd=3.38u as=0 ps=0 w=3u l=0.13u
X1507 VDD iqmod_mixer_0.iqmod_mixer_half_1.iqmod_mixer_se2diff$1_0.iqmod_mixer_se2diff_half_tg$2_0.iqmod_mixer_se2diff_inv_NF54$6_0.vin iqmod_mixer_0.iqmod_mixer_half_1.iqmod_mixer_tg$1_0.di_tg_ctrl_n VDD sg13_lv_pmos ad=0.57p pd=3.38u as=0.57p ps=3.38u w=3u l=0.13u
X1508 iqmod_mixer_0.vinn_IF iqmod_mixer_0.iqmod_mixer_half_0.iqmod_mixer_tg$1_0.di_tg_ctrl voutn_I_RF VSS sg13_lv_nmos ad=0.57p pd=3.38u as=0.57p ps=3.38u w=3u l=0.13u
X1509 VDD iqmod_mixer_0.iqmod_mixer_half_1.iqmod_mixer_se2diff$1_0.iqmod_mixer_se2diff_half_tg$2_0.iqmod_mixer_se2diff_inv_NF54$6_0.vin iqmod_mixer_0.iqmod_mixer_half_1.iqmod_mixer_tg$1_0.di_tg_ctrl_n VDD sg13_lv_pmos ad=0.57p pd=3.38u as=0.57p ps=3.38u w=3u l=0.13u
X1510 voutp_I_RF iqmod_mixer_0.iqmod_mixer_half_1.iqmod_mixer_tg$1_0.di_tg_ctrl iqmod_mixer_0.vinp_IF VSS sg13_lv_nmos ad=0.57p pd=3.38u as=0.57p ps=3.38u w=3u l=0.13u
X1511 voutn_I_RF iqmod_mixer_0.iqmod_mixer_half_0.iqmod_mixer_tg$1_0.di_tg_ctrl_n voutn_I_RF VSS sg13_lv_nmos ad=0.57p pd=3.38u as=0 ps=0 w=3u l=0.13u
X1512 VDD iqmod_mixer_0.iqmod_mixer_half_1.iqmod_mixer_se2diff$1_0.iqmod_mixer_se2diff_half_inv$2_0.iqmod_mixer_se2diff_inv_NF2$7_1.vout iqmod_mixer_0.iqmod_mixer_half_1.iqmod_mixer_se2diff$1_0.iqmod_mixer_se2diff_half_tg$2_0.iqmod_mixer_se2diff_inv_NF18$6_0.vin VDD sg13_lv_pmos ad=0.57p pd=3.38u as=0.57p ps=3.38u w=3u l=0.13u
X1513 iqmod_mixer_0.iqmod_mixer_half_1.iqmod_mixer_tg$1_0.di_tg_ctrl_n iqmod_mixer_0.iqmod_mixer_half_1.iqmod_mixer_se2diff$1_0.iqmod_mixer_se2diff_half_tg$2_0.iqmod_mixer_se2diff_inv_NF54$6_0.vin VDD VDD sg13_lv_pmos ad=0.57p pd=3.38u as=0.57p ps=3.38u w=3u l=0.13u
X1514 VDD iqmod_mfb_lpf_0.iqmod_mfb_lpf_half_0.iqmod_mfb_lpf_ota_core_hybrid_bm_half$1_0.iqmod_mfb_lpf_ota_core_inv_NF20$2_1.vin iqmod_mfb_lpf_0.iqmod_mfb_lpf_half_0.iqmod_mfb_lpf_ota_core_hybrid_bm_half$1_0.iqmod_mfb_lpf_ota_core_tg$2_0.v_a VDD sg13_lv_pmos ad=1.14p pd=6.38u as=1.14p ps=6.38u w=6u l=1u
X1515 VSS VSS VSS VSS sg13_lv_nmos ad=0.34p pd=2.68u as=0 ps=0 w=1u l=1u
X1516 VSS iqmod_mfb_lpf_0.iqmod_mfb_lpf_half_0.iqmod_mfb_lpf_ota_core_hybrid_bm_half$1_0.iqmod_mfb_lpf_ota_core_tg$2_0.v_a iqmod_mfb_lpf_0.iqmod_mfb_lpf_half_0.iqmod_mfb_lpf_ota_core_hybrid_bm_half$1_0.iqmod_mfb_lpf_ota_core_tg$2_0.v_b VSS sg13_lv_nmos ad=0.19p pd=1.38u as=0.19p ps=1.38u w=1u l=1u
X1517 iqmod_mfb_lpf_0.iqmod_mfb_lpf_half_0.iqmod_mfb_lpf_ota_core_hybrid_bm_half$1_0.iqmod_mfb_lpf_ota_core_tg$2_0.v_b iqmod_mfb_lpf_0.iqmod_mfb_lpf_half_0.iqmod_mfb_lpf_ota_core_hybrid_bm_half$1_0.iqmod_mfb_lpf_ota_core_tg$2_0.v_a VDD VDD sg13_lv_pmos ad=1.14p pd=6.38u as=1.14p ps=6.38u w=6u l=1u
X1518 iqmod_mixer_0.vinp_IF iqmod_mfb_lpf_0.iqmod_mfb_lpf_half_0.iqmod_mfb_lpf_ota_core_hybrid_bm_half$1_0.iqmod_mfb_lpf_ota_core_tg$2_0.v_b VDD VDD sg13_lv_pmos ad=1.14p pd=6.38u as=1.14p ps=6.38u w=6u l=1u
X1519 iqmod_mixer_0.vinp_IF iqmod_mixer_0.iqmod_mixer_half_1.iqmod_mixer_tg$1_0.di_tg_ctrl voutp_I_RF VSS sg13_lv_nmos ad=0.57p pd=3.38u as=0.57p ps=3.38u w=3u l=0.13u
X1520 iqmod_mixer_0.iqmod_mixer_half_0.iqmod_mixer_tg$1_0.di_tg_ctrl_n iqmod_mixer_0.iqmod_mixer_half_0.iqmod_mixer_se2diff$1_0.iqmod_mixer_se2diff_half_tg$2_0.iqmod_mixer_se2diff_inv_NF54$6_0.vin VSS VSS sg13_lv_nmos ad=0.19p pd=1.38u as=0.19p ps=1.38u w=1u l=0.13u
X1521 iqmod_mfb_lpf_0.iqmod_mfb_lpf_half_1.iqmod_mfb_lpf_ota_core_hybrid_bm_half$1_0.iqmod_mfb_lpf_ota_core_inv_NF20$2_1.vin iqmod_mfb_lpf_0.iqmod_mfb_lpf_half_1.iqmod_mfb_lpf_ota_core_hybrid_bm_half$1_0.iqmod_mfb_lpf_ota_core_spdt_switch$2_0.iqmod_mfb_lpf_ota_core_spdt_switch_inv$3_0.vout iqmod_spdt_switch_0.v_c VSS sg13_lv_nmos ad=0.19p pd=1.38u as=0.19p ps=1.38u w=1u l=0.13u
X1522 VSS iqmod_mixer_0.iqmod_mixer_half_1.iqmod_mixer_se2diff$1_0.iqmod_mixer_se2diff_half_inv$2_0.iqmod_mixer_se2diff_inv_NF54$7_0.vin iqmod_mixer_0.iqmod_mixer_half_1.iqmod_mixer_tg$1_0.di_tg_ctrl VSS sg13_lv_nmos ad=0.19p pd=1.38u as=0.19p ps=1.38u w=1u l=0.13u
X1523 VSS iqmod_mixer_0.iqmod_mixer_half_0.iqmod_mixer_se2diff$1_0.iqmod_mixer_se2diff_half_inv$2_0.iqmod_mixer_se2diff_inv_NF18$7_0.vin iqmod_mixer_0.iqmod_mixer_half_0.iqmod_mixer_se2diff$1_0.iqmod_mixer_se2diff_half_inv$2_0.iqmod_mixer_se2diff_inv_NF54$7_0.vin VSS sg13_lv_nmos ad=0.19p pd=1.38u as=0.19p ps=1.38u w=1u l=0.13u
X1524 VDD VDD VDD VDD sg13_lv_pmos ad=2.04p pd=12.68u as=0 ps=0 w=6u l=1u
X1525 VSS VSS VSS VSS sg13_lv_nmos ad=0.19p pd=1.38u as=0 ps=0 w=1u l=0.13u
X1526 iqmod_mfb_lpf_0.iqmod_mfb_lpf_half_0.iqmod_mfb_lpf_ota_core_hybrid_bm_half$1_0.iqmod_mfb_lpf_ota_core_inv_NF20$2_0.vout iqmod_mfb_lpf_0.iqmod_mfb_lpf_half_0.iqmod_mfb_lpf_ota_core_hybrid_bm_half$1_0.iqmod_mfb_lpf_ota_core_tg$2_0.di_tg_ctrl_n iqmod_mfb_lpf_0.iqmod_mfb_lpf_half_0.iqmod_mfb_lpf_ota_core_hybrid_bm_half$1_0.iqmod_mfb_lpf_ota_core_inv_NF6$2_1.vout VDD sg13_lv_pmos ad=1.14p pd=6.38u as=1.14p ps=6.38u w=6u l=0.13u
X1527 a_36853_10752# a_48939_10452# VSS rhigh l=60u w=0.5u
X1528 voutp_I_RF iqmod_mixer_0.iqmod_mixer_half_1.iqmod_mixer_tg$1_0.di_tg_ctrl iqmod_mixer_0.vinp_IF VSS sg13_lv_nmos ad=0.57p pd=3.38u as=0.57p ps=3.38u w=3u l=0.13u
X1529 VSS iqmod_mixer_0.iqmod_mixer_half_1.iqmod_mixer_se2diff$1_0.iqmod_mixer_se2diff_half_inv$2_0.iqmod_mixer_se2diff_inv_NF54$7_0.vin iqmod_mixer_0.iqmod_mixer_half_1.iqmod_mixer_tg$1_0.di_tg_ctrl VSS sg13_lv_nmos ad=0.19p pd=1.38u as=0.19p ps=1.38u w=1u l=0.13u
X1530 iqmod_mfb_lpf_0.iqmod_mfb_lpf_half_0.iqmod_mfb_lpf_ota_core_hybrid_bm_half$1_0.iqmod_mfb_lpf_ota_core_tg$2_0.v_a iqmod_mfb_lpf_0.iqmod_mfb_lpf_half_0.iqmod_mfb_lpf_ota_core_hybrid_bm_half$1_0.iqmod_mfb_lpf_ota_core_inv_NF20$2_1.vin VDD VDD sg13_lv_pmos ad=1.14p pd=6.38u as=1.14p ps=6.38u w=6u l=1u
X1531 VDD iqmod_mixer_0.iqmod_mixer_half_0.iqmod_mixer_se2diff$1_0.iqmod_mixer_se2diff_half_inv$2_0.iqmod_mixer_se2diff_inv_NF54$7_0.vin iqmod_mixer_0.iqmod_mixer_half_0.iqmod_mixer_tg$1_0.di_tg_ctrl VDD sg13_lv_pmos ad=0.57p pd=3.38u as=0.57p ps=3.38u w=3u l=0.13u
X1532 iqmod_mfb_lpf_0.iqmod_mfb_lpf_half_0.iqmod_mfb_lpf_ota_core_hybrid_bm_half$1_0.iqmod_mfb_lpf_ota_core_tg$2_0.v_b iqmod_mfb_lpf_0.iqmod_mfb_lpf_half_0.iqmod_mfb_lpf_ota_core_hybrid_bm_half$1_0.iqmod_mfb_lpf_ota_core_inv_NF6$2_1.vout VSS VSS sg13_lv_nmos ad=0.19p pd=1.38u as=0.19p ps=1.38u w=1u l=1u
X1533 VSS VSS VSS VSS sg13_lv_nmos ad=0.34p pd=2.68u as=0 ps=0 w=1u l=1u
X1534 VSS iqmod_mixer_0.iqmod_mixer_half_1.iqmod_mixer_se2diff$1_0.iqmod_mixer_se2diff_half_inv$2_0.iqmod_mixer_se2diff_inv_NF6$7_1.vin iqmod_mixer_0.iqmod_mixer_half_1.iqmod_mixer_se2diff$1_0.iqmod_mixer_se2diff_half_inv$2_0.iqmod_mixer_se2diff_inv_NF18$7_0.vin VSS sg13_lv_nmos ad=0.19p pd=1.38u as=0.19p ps=1.38u w=1u l=0.13u
X1535 iqmod_mixer_0.iqmod_mixer_half_1.iqmod_mixer_tg$1_0.di_tg_ctrl iqmod_mixer_0.iqmod_mixer_half_1.iqmod_mixer_se2diff$1_0.iqmod_mixer_se2diff_half_inv$2_0.iqmod_mixer_se2diff_inv_NF54$7_0.vin VSS VSS sg13_lv_nmos ad=0.19p pd=1.38u as=0.19p ps=1.38u w=1u l=0.13u
X1536 iqmod_mixer_0.iqmod_mixer_half_0.iqmod_mixer_se2diff$1_0.iqmod_mixer_se2diff_half_inv$2_0.iqmod_mixer_se2diff_inv_NF54$7_0.vin iqmod_mixer_0.iqmod_mixer_half_0.iqmod_mixer_se2diff$1_0.iqmod_mixer_se2diff_half_inv$2_0.iqmod_mixer_se2diff_inv_NF18$7_0.vin VSS VSS sg13_lv_nmos ad=0.19p pd=1.38u as=0.19p ps=1.38u w=1u l=0.13u
X1537 iqmod_mfb_lpf_0.iqmod_mfb_lpf_half_0.iqmod_mfb_lpf_ota_core_hybrid_bm_half$1_0.iqmod_mfb_lpf_ota_core_tg$2_0.v_b iqmod_mfb_lpf_0.iqmod_mfb_lpf_half_0.iqmod_mfb_lpf_ota_core_hybrid_bm_half$1_0.iqmod_mfb_lpf_ota_core_tg$2_0.v_a VSS VSS sg13_lv_nmos ad=0.19p pd=1.38u as=0.19p ps=1.38u w=1u l=1u
X1538 VDD iqmod_mixer_0.iqmod_mixer_half_0.iqmod_mixer_se2diff$1_0.iqmod_mixer_se2diff_half_inv$2_0.iqmod_mixer_se2diff_inv_NF54$7_0.vin iqmod_mixer_0.iqmod_mixer_half_0.iqmod_mixer_tg$1_0.di_tg_ctrl VDD sg13_lv_pmos ad=0.57p pd=3.38u as=0.57p ps=3.38u w=3u l=0.13u
X1539 iqmod_mixer_0.iqmod_mixer_half_0.iqmod_mixer_se2diff$1_0.iqmod_mixer_se2diff_half_tg$2_0.iqmod_mixer_se2diff_inv_NF54$6_0.vin iqmod_mixer_0.iqmod_mixer_half_0.iqmod_mixer_se2diff$1_0.iqmod_mixer_se2diff_half_tg$2_0.iqmod_mixer_se2diff_inv_NF18$6_0.vin VDD VDD sg13_lv_pmos ad=0.57p pd=3.38u as=0.57p ps=3.38u w=3u l=0.13u
X1540 VSS iqmod_mixer_0.iqmod_mixer_half_1.iqmod_mixer_se2diff$1_0.iqmod_mixer_se2diff_half_tg$2_0.iqmod_mixer_se2diff_inv_NF18$6_0.vin iqmod_mixer_0.iqmod_mixer_half_1.iqmod_mixer_se2diff$1_0.iqmod_mixer_se2diff_half_tg$2_0.iqmod_mixer_se2diff_inv_NF54$6_0.vin VSS sg13_lv_nmos ad=0.19p pd=1.38u as=0.19p ps=1.38u w=1u l=0.13u
X1541 VDD iqmod_mixer_0.iqmod_mixer_half_0.iqmod_mixer_se2diff$1_0.iqmod_mixer_se2diff_half_inv$2_0.iqmod_mixer_se2diff_inv_NF6$7_1.vin iqmod_mixer_0.iqmod_mixer_half_0.iqmod_mixer_se2diff$1_0.iqmod_mixer_se2diff_half_inv$2_0.iqmod_mixer_se2diff_inv_NF18$7_0.vin VDD sg13_lv_pmos ad=0.57p pd=3.38u as=0.57p ps=3.38u w=3u l=0.13u
X1542 iqmod_mixer_0.iqmod_mixer_half_0.iqmod_mixer_tg$1_0.di_tg_ctrl iqmod_mixer_0.iqmod_mixer_half_0.iqmod_mixer_se2diff$1_0.iqmod_mixer_se2diff_half_inv$2_0.iqmod_mixer_se2diff_inv_NF54$7_0.vin VDD VDD sg13_lv_pmos ad=0.57p pd=3.38u as=0.57p ps=3.38u w=3u l=0.13u
X1543 iqmod_mfb_lpf_0.iqmod_mfb_lpf_half_0.iqmod_mfb_lpf_ota_core_hybrid_bm_half$1_0.iqmod_mfb_lpf_ota_core_inv_NF20$2_0.vout iqmod_mixer_0.vinn_IF VDD VDD sg13_lv_pmos ad=1.14p pd=6.38u as=1.14p ps=6.38u w=6u l=1u
X1544 iqmod_mfb_lpf_0.iqmod_mfb_lpf_half_0.iqmod_mfb_lpf_ota_core_hybrid_bm_half$1_0.iqmod_mfb_lpf_ota_core_tg$2_0.v_b iqmod_mfb_lpf_0.iqmod_mfb_lpf_half_0.iqmod_mfb_lpf_ota_core_hybrid_bm_half$1_0.iqmod_mfb_lpf_ota_core_tg$2_0.di_tg_ctrl_n iqmod_mfb_lpf_0.iqmod_mfb_lpf_half_0.iqmod_mfb_lpf_ota_core_hybrid_bm_half$1_0.iqmod_mfb_lpf_ota_core_tg$2_0.v_a VDD sg13_lv_pmos ad=1.14p pd=6.38u as=1.14p ps=6.38u w=6u l=0.13u
X1545 iqmod_mixer_0.iqmod_mixer_half_1.iqmod_mixer_se2diff$1_0.iqmod_mixer_se2diff_half_inv$2_0.iqmod_mixer_se2diff_inv_NF6$7_0.vin VSS iqmod_mixer_0.iqmod_mixer_half_1.iqmod_mixer_se2diff$1_0.iqmod_mixer_se2diff_half_tg$2_0.iqmod_mixer_se2diff_tg_NF6$3_0.v_b VDD sg13_lv_pmos ad=1.02p pd=6.68u as=0.57p ps=3.38u w=3u l=0.13u
X1546 VDD iqmod_mixer_0.iqmod_mixer_half_0.iqmod_mixer_se2diff$1_0.iqmod_mixer_se2diff_half_tg$2_0.iqmod_mixer_se2diff_inv_NF18$6_0.vin iqmod_mixer_0.iqmod_mixer_half_0.iqmod_mixer_se2diff$1_0.iqmod_mixer_se2diff_half_tg$2_0.iqmod_mixer_se2diff_inv_NF54$6_0.vin VDD sg13_lv_pmos ad=0.57p pd=3.38u as=0.57p ps=3.38u w=3u l=0.13u
X1547 iqmod_mixer_0.iqmod_mixer_half_1.iqmod_mixer_se2diff$1_0.iqmod_mixer_se2diff_half_tg$2_0.iqmod_mixer_se2diff_inv_NF54$6_0.vin iqmod_mixer_0.iqmod_mixer_half_1.iqmod_mixer_se2diff$1_0.iqmod_mixer_se2diff_half_tg$2_0.iqmod_mixer_se2diff_inv_NF18$6_0.vin VSS VSS sg13_lv_nmos ad=0.19p pd=1.38u as=0.19p ps=1.38u w=1u l=0.13u
X1548 iqmod_spdt_switch_0.v_c iqmod_spdt_switch_0.spdt_switch_inv_0.vout vinn_I VSS sg13_lv_nmos ad=0.19p pd=1.38u as=0.19p ps=1.38u w=1u l=0.13u
X1549 VSS VSS VSS VSS sg13_lv_nmos ad=0.19p pd=1.38u as=0 ps=0 w=1u l=1u
X1550 VDD iqmod_mfb_lpf_0.iqmod_mfb_lpf_half_0.iqmod_mfb_lpf_ota_core_hybrid_bm_half$1_0.iqmod_mfb_lpf_ota_core_inv_NF20$2_1.vin iqmod_mfb_lpf_0.iqmod_mfb_lpf_half_0.iqmod_mfb_lpf_ota_core_hybrid_bm_half$1_0.iqmod_mfb_lpf_ota_core_tg$2_0.v_a VDD sg13_lv_pmos ad=1.14p pd=6.38u as=1.14p ps=6.38u w=6u l=1u
X1551 VSS iqmod_mfb_lpf_0.iqmod_mfb_lpf_half_0.iqmod_mfb_lpf_ota_core_hybrid_bm_half$1_0.iqmod_mfb_lpf_ota_core_inv_NF6$2_1.vout iqmod_mfb_lpf_0.iqmod_mfb_lpf_half_0.iqmod_mfb_lpf_ota_core_hybrid_bm_half$1_0.iqmod_mfb_lpf_ota_core_tg$2_0.v_b VSS sg13_lv_nmos ad=0.19p pd=1.38u as=0.19p ps=1.38u w=1u l=1u
X1552 VDD iqmod_mfb_lpf_0.iqmod_mfb_lpf_half_1.iqmod_mfb_lpf_ota_core_hybrid_bm_half$1_0.iqmod_mfb_lpf_ota_core_spdt_switch$2_0.iqmod_mfb_lpf_ota_core_spdt_switch_inv$3_0.vout iqmod_mfb_lpf_0.iqmod_mfb_lpf_half_1.iqmod_mfb_lpf_ota_core_hybrid_bm_half$1_0.iqmod_mfb_lpf_ota_core_inv_NF20$2_1.vin VDD sg13_lv_pmos ad=1.14p pd=6.38u as=1.14p ps=6.38u w=6u l=0.13u
X1553 iqmod_mfb_lpf_0.iqmod_mfb_lpf_half_0.iqmod_mfb_lpf_ota_core_hybrid_bm_half$1_0.iqmod_mfb_lpf_ota_core_tg$2_0.v_a iqmod_mfb_lpf_0.iqmod_mfb_lpf_half_0.iqmod_mfb_lpf_ota_core_hybrid_bm_half$1_0.iqmod_mfb_lpf_ota_core_inv_NF20$2_1.vin VSS VSS sg13_lv_nmos ad=0.19p pd=1.38u as=0.19p ps=1.38u w=1u l=1u
X1554 VDD iqmod_mixer_0.vinp_IF iqmod_mfb_lpf_0.iqmod_mfb_lpf_half_0.iqmod_mfb_lpf_ota_core_hybrid_bm_half$1_0.iqmod_mfb_lpf_ota_core_inv_NF20$2_0.vout VDD sg13_lv_pmos ad=1.14p pd=6.38u as=1.14p ps=6.38u w=6u l=1u
X1555 iqmod_mixer_0.vinp_IF iqmod_mfb_lpf_0.iqmod_mfb_lpf_half_1.iqmod_mfb_lpf_ota_core_hybrid_bm_half$1_0.iqmod_mfb_lpf_ota_core_inv_NF20$2_1.vin VDD VDD sg13_lv_pmos ad=1.14p pd=6.38u as=1.14p ps=6.38u w=6u l=1u
X1556 iqmod_mixer_0.iqmod_mixer_half_1.iqmod_mixer_se2diff$1_0.iqmod_mixer_se2diff_half_tg$2_0.iqmod_mixer_se2diff_tg_NF6$3_0.v_b VSS iqmod_mixer_0.iqmod_mixer_half_1.iqmod_mixer_se2diff$1_0.iqmod_mixer_se2diff_half_inv$2_0.iqmod_mixer_se2diff_inv_NF6$7_0.vin VDD sg13_lv_pmos ad=0.57p pd=3.38u as=0.57p ps=3.38u w=3u l=0.13u
X1557 iqmod_mixer_0.iqmod_mixer_half_0.iqmod_mixer_se2diff$1_0.iqmod_mixer_se2diff_half_tg$2_0.iqmod_mixer_se2diff_inv_NF54$6_0.vin iqmod_mixer_0.iqmod_mixer_half_0.iqmod_mixer_se2diff$1_0.iqmod_mixer_se2diff_half_tg$2_0.iqmod_mixer_se2diff_inv_NF18$6_0.vin VDD VDD sg13_lv_pmos ad=0.57p pd=3.38u as=0.57p ps=3.38u w=3u l=0.13u
X1558 vinn_I iqmod_spdt_switch_0.spdt_switch_inv_0.vout iqmod_spdt_switch_0.v_c VSS sg13_lv_nmos ad=0.19p pd=1.38u as=0.19p ps=1.38u w=1u l=0.13u
X1559 VSS VSS VSS VSS sg13_lv_nmos ad=0.34p pd=2.68u as=0 ps=0 w=1u l=1u
X1560 VDD iqmod_mfb_lpf_0.iqmod_mfb_lpf_half_0.iqmod_mfb_lpf_ota_core_hybrid_bm_half$1_0.iqmod_mfb_lpf_ota_core_inv_NF20$2_0.vout iqmod_mfb_lpf_0.iqmod_mfb_lpf_half_0.iqmod_mfb_lpf_ota_core_hybrid_bm_half$1_0.iqmod_mfb_lpf_ota_core_inv_NF6$2_1.vout VDD sg13_lv_pmos ad=1.14p pd=6.38u as=1.14p ps=6.38u w=6u l=1u
X1561 iqmod_mixer_0.iqmod_mixer_half_0.iqmod_mixer_tg$1_0.di_tg_ctrl_n iqmod_mixer_0.iqmod_mixer_half_0.iqmod_mixer_se2diff$1_0.iqmod_mixer_se2diff_half_tg$2_0.iqmod_mixer_se2diff_inv_NF54$6_0.vin VSS VSS sg13_lv_nmos ad=0.19p pd=1.38u as=0.19p ps=1.38u w=1u l=0.13u
X1562 iqmod_mixer_0.iqmod_mixer_half_0.iqmod_mixer_tg$1_0.di_tg_ctrl iqmod_mixer_0.iqmod_mixer_half_0.iqmod_mixer_se2diff$1_0.iqmod_mixer_se2diff_half_inv$2_0.iqmod_mixer_se2diff_inv_NF54$7_0.vin VSS VSS sg13_lv_nmos ad=0.19p pd=1.38u as=0.19p ps=1.38u w=1u l=0.13u
X1563 VDD iqmod_mixer_0.iqmod_mixer_half_1.iqmod_mixer_se2diff$1_0.iqmod_mixer_se2diff_half_inv$2_0.iqmod_mixer_se2diff_inv_NF54$7_0.vin iqmod_mixer_0.iqmod_mixer_half_1.iqmod_mixer_tg$1_0.di_tg_ctrl VDD sg13_lv_pmos ad=0.57p pd=3.38u as=0.57p ps=3.38u w=3u l=0.13u
X1564 iqmod_mfb_lpf_0.iqmod_mfb_lpf_half_1.iqmod_mfb_lpf_ota_core_hybrid_bm_half$1_0.iqmod_mfb_lpf_ota_core_tg$2_0.di_tg_ctrl_n di_analog_en VDD VDD sg13_lv_pmos ad=1.14p pd=6.38u as=1.14p ps=6.38u w=6u l=0.13u
X1565 VSS iqmod_mixer_0.iqmod_mixer_half_1.iqmod_mixer_se2diff$1_0.iqmod_mixer_se2diff_half_tg$2_0.iqmod_mixer_se2diff_inv_NF54$6_0.vin iqmod_mixer_0.iqmod_mixer_half_1.iqmod_mixer_tg$1_0.di_tg_ctrl_n VSS sg13_lv_nmos ad=0.19p pd=1.38u as=0.19p ps=1.38u w=1u l=0.13u
X1566 iqmod_mixer_0.iqmod_mixer_half_0.iqmod_mixer_se2diff$1_0.iqmod_mixer_se2diff_half_tg$2_0.iqmod_mixer_se2diff_inv_NF18$6_0.vin iqmod_mixer_0.iqmod_mixer_half_0.iqmod_mixer_se2diff$1_0.iqmod_mixer_se2diff_half_inv$2_0.iqmod_mixer_se2diff_inv_NF2$7_1.vout VSS VSS sg13_lv_nmos ad=0.19p pd=1.38u as=0.19p ps=1.38u w=1u l=0.13u
X1567 VSS iqmod_mixer_0.iqmod_mixer_half_1.iqmod_mixer_se2diff$1_0.iqmod_mixer_se2diff_half_inv$2_0.iqmod_mixer_se2diff_inv_NF6$7_0.vin iqmod_mixer_0.iqmod_mixer_half_1.iqmod_mixer_se2diff$1_0.iqmod_mixer_se2diff_half_inv$2_0.iqmod_mixer_se2diff_inv_NF6$7_0.vout VSS sg13_lv_nmos ad=0.19p pd=1.38u as=0.19p ps=1.38u w=1u l=0.13u
X1568 VSS VSS VSS rhigh l=60u w=0.5u
X1569 VSS iqmod_mixer_0.iqmod_mixer_half_0.iqmod_mixer_se2diff$1_0.iqmod_mixer_se2diff_half_tg$2_0.iqmod_mixer_se2diff_inv_NF54$6_0.vin iqmod_mixer_0.iqmod_mixer_half_0.iqmod_mixer_tg$1_0.di_tg_ctrl_n VSS sg13_lv_nmos ad=0.19p pd=1.38u as=0.19p ps=1.38u w=1u l=0.13u
X1570 iqmod_spdt_switch_1.v_c iqmod_mfb_lpf_0.iqmod_mfb_lpf_half_0.iqmod_mfb_lpf_ota_core_hybrid_bm_half$1_0.iqmod_mfb_lpf_ota_core_spdt_switch$2_0.iqmod_mfb_lpf_ota_core_spdt_switch_inv$3_0.vout iqmod_mfb_lpf_0.iqmod_mfb_lpf_half_0.iqmod_mfb_lpf_ota_core_hybrid_bm_half$1_0.iqmod_mfb_lpf_ota_core_inv_NF20$2_1.vin VSS sg13_lv_nmos ad=0.34p pd=2.68u as=0.19p ps=1.38u w=1u l=0.13u
X1571 VDD iqmod_mixer_0.iqmod_mixer_half_1.iqmod_mixer_se2diff$1_0.iqmod_mixer_se2diff_half_tg$2_0.iqmod_mixer_se2diff_inv_NF54$6_0.vin iqmod_mixer_0.iqmod_mixer_half_1.iqmod_mixer_tg$1_0.di_tg_ctrl_n VDD sg13_lv_pmos ad=0.57p pd=3.38u as=0.57p ps=3.38u w=3u l=0.13u
X1572 iqmod_mixer_0.iqmod_mixer_half_1.iqmod_mixer_se2diff$1_0.iqmod_mixer_se2diff_half_inv$2_0.iqmod_mixer_se2diff_inv_NF6$7_1.vin iqmod_mixer_0.iqmod_mixer_half_1.iqmod_mixer_se2diff$1_0.iqmod_mixer_se2diff_half_inv$2_0.iqmod_mixer_se2diff_inv_NF2$7_1.vout VSS VSS sg13_lv_nmos ad=0.19p pd=1.38u as=0.19p ps=1.38u w=1u l=0.13u
X1573 VSS VSS VSS rhigh l=27u w=0.5u
X1574 VDD VDD VDD VDD sg13_lv_pmos ad=1.14p pd=6.38u as=0 ps=0 w=6u l=1u
X1575 VDD iqmod_mfb_lpf_0.iqmod_mfb_lpf_half_1.iqmod_mfb_lpf_ota_core_hybrid_bm_half$1_0.iqmod_mfb_lpf_ota_core_inv_NF20$2_1.vin iqmod_mixer_0.vinp_IF VDD sg13_lv_pmos ad=1.14p pd=6.38u as=1.14p ps=6.38u w=6u l=1u
X1576 iqmod_mixer_0.vinn_IF iqmod_mixer_0.iqmod_mixer_half_0.iqmod_mixer_tg$1_0.di_tg_ctrl_n voutn_I_RF VDD sg13_lv_pmos ad=1.71p pd=9.38u as=1.71p ps=9.38u w=9u l=0.13u
X1577 VDD iqmod_mixer_0.iqmod_mixer_half_0.iqmod_mixer_se2diff$1_0.iqmod_mixer_se2diff_half_tg$2_0.iqmod_mixer_se2diff_inv_NF54$6_0.vin iqmod_mixer_0.iqmod_mixer_half_0.iqmod_mixer_tg$1_0.di_tg_ctrl_n VDD sg13_lv_pmos ad=0.57p pd=3.38u as=0.57p ps=3.38u w=3u l=0.13u
X1578 iqmod_mixer_0.iqmod_mixer_half_1.iqmod_mixer_tg$1_0.di_tg_ctrl_n iqmod_mixer_0.iqmod_mixer_half_1.iqmod_mixer_se2diff$1_0.iqmod_mixer_se2diff_half_tg$2_0.iqmod_mixer_se2diff_inv_NF54$6_0.vin VSS VSS sg13_lv_nmos ad=0.19p pd=1.38u as=0.19p ps=1.38u w=1u l=0.13u
X1579 VDD iqmod_mixer_0.iqmod_mixer_half_0.iqmod_mixer_se2diff$1_0.iqmod_mixer_se2diff_half_inv$2_0.iqmod_mixer_se2diff_inv_NF6$7_0.vin iqmod_mixer_0.iqmod_mixer_half_0.iqmod_mixer_se2diff$1_0.iqmod_mixer_se2diff_half_inv$2_0.iqmod_mixer_se2diff_inv_NF6$7_0.vout VDD sg13_lv_pmos ad=0.57p pd=3.38u as=0.57p ps=3.38u w=3u l=0.13u
X1580 iqmod_mixer_0.vinn_IF iqmod_mfb_lpf_0.iqmod_mfb_lpf_half_0.iqmod_mfb_lpf_ota_core_hybrid_bm_half$1_0.iqmod_mfb_lpf_ota_core_tg$2_0.v_b VSS VSS sg13_lv_nmos ad=0.19p pd=1.38u as=0.19p ps=1.38u w=1u l=1u
X1581 VSS VSS VSS rhigh l=31u w=0.5u
X1582 VSS iqmod_mixer_0.iqmod_mixer_half_0.iqmod_mixer_se2diff$1_0.iqmod_mixer_se2diff_half_inv$2_0.iqmod_mixer_se2diff_inv_NF2$7_1.vout iqmod_mixer_0.iqmod_mixer_half_0.iqmod_mixer_se2diff$1_0.iqmod_mixer_se2diff_half_tg$2_0.iqmod_mixer_se2diff_inv_NF18$6_0.vin VSS sg13_lv_nmos ad=0.19p pd=1.38u as=0.19p ps=1.38u w=1u l=0.13u
X1583 iqmod_mfb_lpf_0.iqmod_mfb_lpf_half_0.iqmod_mfb_lpf_ota_core_hybrid_bm_half$1_0.iqmod_mfb_lpf_ota_core_inv_NF20$2_0.vout iqmod_mixer_0.vinp_IF VSS VSS sg13_lv_nmos ad=0.19p pd=1.38u as=0.19p ps=1.38u w=1u l=1u
X1584 iqmod_mixer_0.iqmod_mixer_half_1.iqmod_mixer_se2diff$1_0.iqmod_mixer_se2diff_half_inv$2_0.iqmod_mixer_se2diff_inv_NF6$7_0.vout iqmod_mixer_0.iqmod_mixer_half_1.iqmod_mixer_se2diff$1_0.iqmod_mixer_se2diff_half_inv$2_0.iqmod_mixer_se2diff_inv_NF6$7_0.vin VSS VSS sg13_lv_nmos ad=0.19p pd=1.38u as=0.19p ps=1.38u w=1u l=0.13u
X1585 VDD VDD VDD VDD sg13_lv_pmos ad=0.57p pd=3.38u as=0 ps=0 w=3u l=0.13u
X1586 VDD VDD VDD VDD sg13_lv_pmos ad=1.14p pd=6.38u as=0 ps=0 w=6u l=1u
X1587 VDD iqmod_mixer_0.iqmod_mixer_half_1.iqmod_mixer_se2diff$1_0.iqmod_mixer_se2diff_half_inv$2_0.iqmod_mixer_se2diff_inv_NF54$7_0.vin iqmod_mixer_0.iqmod_mixer_half_1.iqmod_mixer_tg$1_0.di_tg_ctrl VDD sg13_lv_pmos ad=0.57p pd=3.38u as=0.57p ps=3.38u w=3u l=0.13u
X1588 voutp_I_RF iqmod_mixer_0.iqmod_mixer_half_1.iqmod_mixer_tg$1_0.di_tg_ctrl voutp_I_RF VDD sg13_lv_pmos ad=1.71p pd=9.38u as=0 ps=0 w=9u l=0.13u
X1589 iqmod_mixer_0.iqmod_mixer_half_1.iqmod_mixer_se2diff$1_0.iqmod_mixer_se2diff_half_inv$2_0.iqmod_mixer_se2diff_inv_NF54$7_0.vin iqmod_mixer_0.iqmod_mixer_half_1.iqmod_mixer_se2diff$1_0.iqmod_mixer_se2diff_half_inv$2_0.iqmod_mixer_se2diff_inv_NF18$7_0.vin VDD VDD sg13_lv_pmos ad=0.57p pd=3.38u as=0.57p ps=3.38u w=3u l=0.13u
X1590 iqmod_mixer_0.iqmod_mixer_half_0.iqmod_mixer_tg$1_0.di_tg_ctrl_n iqmod_mixer_0.iqmod_mixer_half_0.iqmod_mixer_se2diff$1_0.iqmod_mixer_se2diff_half_tg$2_0.iqmod_mixer_se2diff_inv_NF54$6_0.vin VDD VDD sg13_lv_pmos ad=0.57p pd=3.38u as=0.57p ps=3.38u w=3u l=0.13u
X1591 VDD iqmod_mixer_0.iqmod_mixer_half_1.iqmod_mixer_se2diff$1_0.iqmod_mixer_se2diff_half_inv$2_0.iqmod_mixer_se2diff_inv_NF6$7_1.vin iqmod_mixer_0.iqmod_mixer_half_1.iqmod_mixer_se2diff$1_0.iqmod_mixer_se2diff_half_inv$2_0.iqmod_mixer_se2diff_inv_NF18$7_0.vin VDD sg13_lv_pmos ad=0.57p pd=3.38u as=0.57p ps=3.38u w=3u l=0.13u
X1592 voutn_I_RF iqmod_mixer_0.iqmod_mixer_half_0.iqmod_mixer_tg$1_0.di_tg_ctrl_n iqmod_mixer_0.vinn_IF VDD sg13_lv_pmos ad=1.71p pd=9.38u as=1.71p ps=9.38u w=9u l=0.13u
X1593 VSS iqmod_mixer_0.iqmod_mixer_half_1.iqmod_mixer_se2diff$1_0.iqmod_mixer_se2diff_half_tg$2_0.iqmod_mixer_se2diff_inv_NF54$6_0.vin iqmod_mixer_0.iqmod_mixer_half_1.iqmod_mixer_tg$1_0.di_tg_ctrl_n VSS sg13_lv_nmos ad=0.19p pd=1.38u as=0.19p ps=1.38u w=1u l=0.13u
X1594 iqmod_mixer_0.iqmod_mixer_half_0.iqmod_mixer_se2diff$1_0.iqmod_mixer_se2diff_half_inv$2_0.iqmod_mixer_se2diff_inv_NF6$7_0.vout iqmod_mixer_0.iqmod_mixer_half_0.iqmod_mixer_se2diff$1_0.iqmod_mixer_se2diff_half_inv$2_0.iqmod_mixer_se2diff_inv_NF6$7_0.vin VDD VDD sg13_lv_pmos ad=0.57p pd=3.38u as=0.57p ps=3.38u w=3u l=0.13u
X1595 VDD VDD VDD VDD sg13_lv_pmos ad=0.57p pd=3.38u as=0 ps=0 w=3u l=0.13u
X1596 voutn_I_RF iqmod_mixer_0.iqmod_mixer_half_0.iqmod_mixer_tg$1_0.di_tg_ctrl_n voutn_I_RF VSS sg13_lv_nmos ad=0.57p pd=3.38u as=0 ps=0 w=3u l=0.13u
X1597 iqmod_mixer_0.vinp_IF iqmod_mixer_0.iqmod_mixer_half_1.iqmod_mixer_tg$1_0.di_tg_ctrl_n voutp_I_RF VDD sg13_lv_pmos ad=1.71p pd=9.38u as=1.71p ps=9.38u w=9u l=0.13u
X1598 VDD VDD VDD VDD sg13_lv_pmos ad=1.14p pd=6.38u as=0 ps=0 w=6u l=0.13u
X1599 voutn_I_RF iqmod_mixer_0.iqmod_mixer_half_0.iqmod_mixer_tg$1_0.di_tg_ctrl iqmod_mixer_0.vinn_IF VSS sg13_lv_nmos ad=0.57p pd=3.38u as=0.57p ps=3.38u w=3u l=0.13u
X1600 voutp_I_RF iqmod_mixer_0.iqmod_mixer_half_1.iqmod_mixer_tg$1_0.di_tg_ctrl voutp_I_RF VDD sg13_lv_pmos ad=1.71p pd=9.38u as=0 ps=0 w=9u l=0.13u
X1601 VSS iqmod_mixer_0.iqmod_mixer_half_1.iqmod_mixer_se2diff$1_0.iqmod_mixer_se2diff_half_inv$2_0.iqmod_mixer_se2diff_inv_NF54$7_0.vin iqmod_mixer_0.iqmod_mixer_half_1.iqmod_mixer_tg$1_0.di_tg_ctrl VSS sg13_lv_nmos ad=0.19p pd=1.38u as=0.19p ps=1.38u w=1u l=0.13u
X1602 iqmod_mixer_0.vinn_IF iqmod_mfb_lpf_0.iqmod_mfb_lpf_half_0.iqmod_mfb_lpf_ota_core_hybrid_bm_half$1_0.iqmod_mfb_lpf_ota_core_tg$2_0.v_b VDD VDD sg13_lv_pmos ad=1.14p pd=6.38u as=1.14p ps=6.38u w=6u l=1u
X1603 iqmod_mixer_0.iqmod_mixer_half_1.iqmod_mixer_tg$1_0.di_tg_ctrl_n iqmod_mixer_0.iqmod_mixer_half_1.iqmod_mixer_se2diff$1_0.iqmod_mixer_se2diff_half_tg$2_0.iqmod_mixer_se2diff_inv_NF54$6_0.vin VDD VDD sg13_lv_pmos ad=0.57p pd=3.38u as=0.57p ps=3.38u w=3u l=0.13u
X1604 VSS iqmod_mfb_lpf_0.iqmod_mfb_lpf_half_0.iqmod_mfb_lpf_ota_core_hybrid_bm_half$1_0.iqmod_mfb_lpf_ota_core_tg$2_0.v_b iqmod_mixer_0.vinn_IF VSS sg13_lv_nmos ad=0.19p pd=1.38u as=0.19p ps=1.38u w=1u l=1u
X1605 voutn_I_RF iqmod_mixer_0.iqmod_mixer_half_0.iqmod_mixer_tg$1_0.di_tg_ctrl_n voutn_I_RF VSS sg13_lv_nmos ad=0.57p pd=3.38u as=0 ps=0 w=3u l=0.13u
X1606 voutn_I_RF iqmod_mixer_0.iqmod_mixer_half_0.iqmod_mixer_tg$1_0.di_tg_ctrl voutn_I_RF VDD sg13_lv_pmos ad=1.71p pd=9.38u as=0 ps=0 w=9u l=0.13u
X1607 VDD VDD VDD VDD sg13_lv_pmos ad=2.04p pd=12.68u as=0 ps=0 w=6u l=0.13u
X1608 iqmod_mixer_0.iqmod_mixer_half_1.iqmod_mixer_se2diff$1_0.iqmod_mixer_se2diff_half_inv$2_0.iqmod_mixer_se2diff_inv_NF54$7_0.vin iqmod_mixer_0.iqmod_mixer_half_1.iqmod_mixer_se2diff$1_0.iqmod_mixer_se2diff_half_inv$2_0.iqmod_mixer_se2diff_inv_NF18$7_0.vin VDD VDD sg13_lv_pmos ad=0.57p pd=3.38u as=0.57p ps=3.38u w=3u l=0.13u
X1609 VDD iqmod_mixer_0.iqmod_mixer_half_0.iqmod_mixer_se2diff$1_0.iqmod_mixer_se2diff_half_inv$2_0.iqmod_mixer_se2diff_inv_NF54$7_0.vin iqmod_mixer_0.iqmod_mixer_half_0.iqmod_mixer_tg$1_0.di_tg_ctrl VDD sg13_lv_pmos ad=0.57p pd=3.38u as=0.57p ps=3.38u w=3u l=0.13u
X1610 iqmod_mixer_0.vinp_IF iqmod_mixer_0.iqmod_mixer_half_1.iqmod_mixer_tg$1_0.di_tg_ctrl voutp_I_RF VSS sg13_lv_nmos ad=0.57p pd=3.38u as=0.57p ps=3.38u w=3u l=0.13u
X1611 VDD iqmod_mixer_0.iqmod_mixer_half_1.iqmod_mixer_se2diff$1_0.iqmod_mixer_se2diff_half_inv$2_0.iqmod_mixer_se2diff_inv_NF6$7_1.vin iqmod_mixer_0.iqmod_mixer_half_1.iqmod_mixer_se2diff$1_0.iqmod_mixer_se2diff_half_inv$2_0.iqmod_mixer_se2diff_inv_NF18$7_0.vin VDD sg13_lv_pmos ad=0.57p pd=3.38u as=0.57p ps=3.38u w=3u l=0.13u
X1612 voutp_I_RF iqmod_mixer_0.iqmod_mixer_half_1.iqmod_mixer_tg$1_0.di_tg_ctrl voutp_I_RF VDD sg13_lv_pmos ad=1.71p pd=9.38u as=0 ps=0 w=9u l=0.13u
X1613 iqmod_mixer_0.iqmod_mixer_half_0.iqmod_mixer_se2diff$1_0.iqmod_mixer_se2diff_half_tg$2_0.iqmod_mixer_se2diff_tg_NF6$3_0.v_b VDD iqmod_mixer_0.iqmod_mixer_half_0.iqmod_mixer_se2diff$1_0.iqmod_mixer_se2diff_half_inv$2_0.iqmod_mixer_se2diff_inv_NF6$7_0.vin VSS sg13_lv_nmos ad=0.19p pd=1.38u as=0.19p ps=1.38u w=1u l=0.13u
X1614 VSS VSS VSS VSS sg13_lv_nmos ad=0.34p pd=2.68u as=0 ps=0 w=1u l=0.13u
X1615 iqmod_mixer_0.iqmod_mixer_half_1.iqmod_mixer_se2diff$1_0.iqmod_mixer_se2diff_half_inv$2_0.iqmod_mixer_se2diff_inv_NF6$7_0.vin di_lo_I VSS VSS sg13_lv_nmos ad=0.19p pd=1.38u as=0.19p ps=1.38u w=1u l=0.13u
X1616 iqmod_spdt_switch_1.v_c iqmod_spdt_switch_1.spdt_switch_inv_0.vout di_ds_I_p VDD sg13_lv_pmos ad=1.14p pd=6.38u as=1.14p ps=6.38u w=6u l=0.13u
X1617 iqmod_spdt_switch_1.v_c a_36355_10752# VSS rhigh l=59u w=0.5u
X1618 VDD iqmod_mixer_0.iqmod_mixer_half_1.iqmod_mixer_se2diff$1_0.iqmod_mixer_se2diff_half_tg$2_0.iqmod_mixer_se2diff_inv_NF54$6_0.vin iqmod_mixer_0.iqmod_mixer_half_1.iqmod_mixer_tg$1_0.di_tg_ctrl_n VDD sg13_lv_pmos ad=0.57p pd=3.38u as=0.57p ps=3.38u w=3u l=0.13u
X1619 iqmod_mixer_0.vinp_IF iqmod_mixer_0.iqmod_mixer_half_1.iqmod_mixer_tg$1_0.di_tg_ctrl_n voutp_I_RF VDD sg13_lv_pmos ad=1.71p pd=9.38u as=3.06p ps=18.68u w=9u l=0.13u
X1620 VSS iqmod_mixer_0.iqmod_mixer_half_0.iqmod_mixer_se2diff$1_0.iqmod_mixer_se2diff_half_inv$2_0.iqmod_mixer_se2diff_inv_NF54$7_0.vin iqmod_mixer_0.iqmod_mixer_half_0.iqmod_mixer_tg$1_0.di_tg_ctrl VSS sg13_lv_nmos ad=0.19p pd=1.38u as=0.19p ps=1.38u w=1u l=0.13u
X1621 voutn_I_RF iqmod_mixer_0.iqmod_mixer_half_0.iqmod_mixer_tg$1_0.di_tg_ctrl iqmod_mixer_0.vinn_IF VSS sg13_lv_nmos ad=0.57p pd=3.38u as=0.57p ps=3.38u w=3u l=0.13u
X1622 iqmod_mixer_0.iqmod_mixer_half_0.iqmod_mixer_se2diff$1_0.iqmod_mixer_se2diff_half_inv$2_0.iqmod_mixer_se2diff_inv_NF6$7_0.vin VDD iqmod_mixer_0.iqmod_mixer_half_0.iqmod_mixer_se2diff$1_0.iqmod_mixer_se2diff_half_tg$2_0.iqmod_mixer_se2diff_tg_NF6$3_0.v_b VSS sg13_lv_nmos ad=0.19p pd=1.38u as=0.19p ps=1.38u w=1u l=0.13u
X1623 iqmod_mfb_lpf_0.iqmod_mfb_lpf_half_0.iqmod_mfb_lpf_ota_core_hybrid_bm_half$1_0.iqmod_mfb_lpf_ota_core_tg$2_0.v_a iqmod_mfb_lpf_0.iqmod_mfb_lpf_half_1.iqmod_mfb_lpf_ota_core_hybrid_bm_half$1_0.iqmod_mfb_lpf_ota_core_inv_NF20$2_1.vin VDD VDD sg13_lv_pmos ad=1.14p pd=6.38u as=1.14p ps=6.38u w=6u l=1u
X1624 iqmod_mixer_0.vinn_IF iqmod_mfb_lpf_0.iqmod_mfb_lpf_half_0.iqmod_mfb_lpf_ota_core_hybrid_bm_half$1_0.iqmod_mfb_lpf_ota_core_tg$2_0.v_b VSS VSS sg13_lv_nmos ad=0.19p pd=1.38u as=0.19p ps=1.38u w=1u l=1u
X1625 VDD VDD VDD VDD sg13_lv_pmos ad=0.57p pd=3.38u as=0 ps=0 w=3u l=0.13u
X1626 iqmod_mixer_0.iqmod_mixer_half_1.iqmod_mixer_tg$1_0.di_tg_ctrl_n iqmod_mixer_0.iqmod_mixer_half_1.iqmod_mixer_se2diff$1_0.iqmod_mixer_se2diff_half_tg$2_0.iqmod_mixer_se2diff_inv_NF54$6_0.vin VDD VDD sg13_lv_pmos ad=0.57p pd=3.38u as=0.57p ps=3.38u w=3u l=0.13u
X1627 iqmod_mixer_0.iqmod_mixer_half_1.iqmod_mixer_tg$1_0.di_tg_ctrl iqmod_mixer_0.iqmod_mixer_half_1.iqmod_mixer_se2diff$1_0.iqmod_mixer_se2diff_half_inv$2_0.iqmod_mixer_se2diff_inv_NF54$7_0.vin VSS VSS sg13_lv_nmos ad=0.19p pd=1.38u as=0.19p ps=1.38u w=1u l=0.13u
X1628 voutn_I_RF iqmod_mixer_0.iqmod_mixer_half_0.iqmod_mixer_tg$1_0.di_tg_ctrl voutn_I_RF VDD sg13_lv_pmos ad=1.71p pd=9.38u as=0 ps=0 w=9u l=0.13u
X1629 iqmod_mixer_0.iqmod_mixer_half_0.iqmod_mixer_tg$1_0.di_tg_ctrl_n iqmod_mixer_0.iqmod_mixer_half_0.iqmod_mixer_se2diff$1_0.iqmod_mixer_se2diff_half_tg$2_0.iqmod_mixer_se2diff_inv_NF54$6_0.vin VDD VDD sg13_lv_pmos ad=0.57p pd=3.38u as=0.57p ps=3.38u w=3u l=0.13u
X1630 iqmod_mixer_0.iqmod_mixer_half_0.iqmod_mixer_tg$1_0.di_tg_ctrl iqmod_mixer_0.iqmod_mixer_half_0.iqmod_mixer_se2diff$1_0.iqmod_mixer_se2diff_half_inv$2_0.iqmod_mixer_se2diff_inv_NF54$7_0.vin VDD VDD sg13_lv_pmos ad=0.57p pd=3.38u as=0.57p ps=3.38u w=3u l=0.13u
X1631 iqmod_mixer_0.iqmod_mixer_half_0.iqmod_mixer_tg$1_0.di_tg_ctrl_n iqmod_mixer_0.iqmod_mixer_half_0.iqmod_mixer_se2diff$1_0.iqmod_mixer_se2diff_half_tg$2_0.iqmod_mixer_se2diff_inv_NF54$6_0.vin VSS VSS sg13_lv_nmos ad=0.19p pd=1.38u as=0.19p ps=1.38u w=1u l=0.13u
X1632 VSS iqmod_mixer_0.iqmod_mixer_half_1.iqmod_mixer_se2diff$1_0.iqmod_mixer_se2diff_half_inv$2_0.iqmod_mixer_se2diff_inv_NF54$7_0.vin iqmod_mixer_0.iqmod_mixer_half_1.iqmod_mixer_tg$1_0.di_tg_ctrl VSS sg13_lv_nmos ad=0.19p pd=1.38u as=0.19p ps=1.38u w=1u l=0.13u
X1633 iqmod_mixer_0.vinn_IF iqmod_mfb_lpf_0.iqmod_mfb_lpf_half_0.iqmod_mfb_lpf_ota_core_hybrid_bm_half$1_0.iqmod_mfb_lpf_ota_core_inv_NF20$2_1.vin VDD VDD sg13_lv_pmos ad=1.14p pd=6.38u as=1.14p ps=6.38u w=6u l=1u
X1634 VDD iqmod_mfb_lpf_0.iqmod_mfb_lpf_half_1.iqmod_mfb_lpf_ota_core_hybrid_bm_half$1_0.iqmod_mfb_lpf_ota_core_inv_NF20$2_1.vin iqmod_mfb_lpf_0.iqmod_mfb_lpf_half_0.iqmod_mfb_lpf_ota_core_hybrid_bm_half$1_0.iqmod_mfb_lpf_ota_core_tg$2_0.v_a VDD sg13_lv_pmos ad=1.14p pd=6.38u as=1.14p ps=6.38u w=6u l=1u
X1635 iqmod_mfb_lpf_0.iqmod_mfb_lpf_half_0.iqmod_mfb_lpf_ota_core_hybrid_bm_half$1_0.iqmod_mfb_lpf_ota_core_tg$2_0.v_b iqmod_mfb_lpf_0.iqmod_mfb_lpf_half_0.iqmod_mfb_lpf_ota_core_hybrid_bm_half$1_0.iqmod_mfb_lpf_ota_core_tg$2_0.v_a VDD VDD sg13_lv_pmos ad=1.14p pd=6.38u as=1.14p ps=6.38u w=6u l=1u
X1636 VDD iqmod_mixer_0.iqmod_mixer_half_0.iqmod_mixer_se2diff$1_0.iqmod_mixer_se2diff_half_inv$2_0.iqmod_mixer_se2diff_inv_NF54$7_0.vin iqmod_mixer_0.iqmod_mixer_half_0.iqmod_mixer_tg$1_0.di_tg_ctrl VDD sg13_lv_pmos ad=0.57p pd=3.38u as=0.57p ps=3.38u w=3u l=0.13u
X1637 VSS VSS VSS VSS sg13_lv_nmos ad=0.34p pd=2.68u as=0 ps=0 w=1u l=0.13u
X1638 iqmod_mixer_0.iqmod_mixer_half_1.iqmod_mixer_tg$1_0.di_tg_ctrl iqmod_mixer_0.iqmod_mixer_half_1.iqmod_mixer_se2diff$1_0.iqmod_mixer_se2diff_half_inv$2_0.iqmod_mixer_se2diff_inv_NF54$7_0.vin VSS VSS sg13_lv_nmos ad=0.19p pd=1.38u as=0.19p ps=1.38u w=1u l=0.13u
X1639 VDD iqmod_mixer_0.iqmod_mixer_half_1.iqmod_mixer_se2diff$1_0.iqmod_mixer_se2diff_half_tg$2_0.iqmod_mixer_se2diff_inv_NF54$6_0.vin iqmod_mixer_0.iqmod_mixer_half_1.iqmod_mixer_tg$1_0.di_tg_ctrl_n VDD sg13_lv_pmos ad=0.57p pd=3.38u as=0.57p ps=3.38u w=3u l=0.13u
X1640 VDD VDD VDD VDD sg13_lv_pmos ad=2.04p pd=12.68u as=0 ps=0 w=6u l=1u
X1641 iqmod_mfb_lpf_0.iqmod_mfb_lpf_half_0.iqmod_mfb_lpf_ota_core_hybrid_bm_half$1_0.iqmod_mfb_lpf_ota_core_inv_NF20$2_0.vout iqmod_mfb_lpf_0.iqmod_mfb_lpf_half_1.iqmod_mfb_lpf_ota_core_hybrid_bm_half$1_0.iqmod_mfb_lpf_ota_core_tg$2_0.di_tg_ctrl_n iqmod_mfb_lpf_0.iqmod_mfb_lpf_half_0.iqmod_mfb_lpf_ota_core_hybrid_bm_half$1_0.iqmod_mfb_lpf_ota_core_inv_NF6$2_1.vout VDD sg13_lv_pmos ad=1.14p pd=6.38u as=1.14p ps=6.38u w=6u l=0.13u
X1642 VSS iqmod_mfb_lpf_0.iqmod_mfb_lpf_half_0.iqmod_mfb_lpf_ota_core_hybrid_bm_half$1_0.iqmod_mfb_lpf_ota_core_tg$2_0.v_b iqmod_mixer_0.vinp_IF VSS sg13_lv_nmos ad=0.19p pd=1.38u as=0.19p ps=1.38u w=1u l=1u
X1643 iqmod_mixer_0.iqmod_mixer_half_0.iqmod_mixer_tg$1_0.di_tg_ctrl iqmod_mixer_0.iqmod_mixer_half_0.iqmod_mixer_se2diff$1_0.iqmod_mixer_se2diff_half_inv$2_0.iqmod_mixer_se2diff_inv_NF54$7_0.vin VDD VDD sg13_lv_pmos ad=0.57p pd=3.38u as=0.57p ps=3.38u w=3u l=0.13u
X1644 voutp_I_RF iqmod_mixer_0.iqmod_mixer_half_1.iqmod_mixer_tg$1_0.di_tg_ctrl iqmod_mixer_0.vinp_IF VSS sg13_lv_nmos ad=0.57p pd=3.38u as=0.57p ps=3.38u w=3u l=0.13u
X1645 VDD iqmod_mfb_lpf_0.iqmod_mfb_lpf_half_0.iqmod_mfb_lpf_ota_core_hybrid_bm_half$1_0.iqmod_mfb_lpf_ota_core_inv_NF20$2_1.vin iqmod_mixer_0.vinn_IF VDD sg13_lv_pmos ad=1.14p pd=6.38u as=1.14p ps=6.38u w=6u l=1u
X1646 iqmod_mixer_0.vinn_IF iqmod_mfb_lpf_0.iqmod_mfb_lpf_half_0.iqmod_mfb_lpf_ota_core_hybrid_bm_half$1_0.iqmod_mfb_lpf_ota_core_tg$2_0.v_b VSS VSS sg13_lv_nmos ad=0.19p pd=1.38u as=0.19p ps=1.38u w=1u l=1u
X1647 iqmod_mfb_lpf_0.iqmod_mfb_lpf_half_0.iqmod_mfb_lpf_ota_core_hybrid_bm_half$1_0.iqmod_mfb_lpf_ota_core_tg$2_0.v_a iqmod_mfb_lpf_0.iqmod_mfb_lpf_half_1.iqmod_mfb_lpf_ota_core_hybrid_bm_half$1_0.iqmod_mfb_lpf_ota_core_inv_NF20$2_1.vin VDD VDD sg13_lv_pmos ad=1.14p pd=6.38u as=1.14p ps=6.38u w=6u l=1u
X1648 VSS iqmod_mixer_0.vinn_IF iqmod_mfb_lpf_0.iqmod_mfb_lpf_half_0.iqmod_mfb_lpf_ota_core_hybrid_bm_half$1_0.iqmod_mfb_lpf_ota_core_inv_NF20$2_0.vout VSS sg13_lv_nmos ad=0.19p pd=1.38u as=0.19p ps=1.38u w=1u l=1u
X1649 VDD iqmod_mixer_0.iqmod_mixer_half_1.iqmod_mixer_se2diff$1_0.iqmod_mixer_se2diff_half_inv$2_0.iqmod_mixer_se2diff_inv_NF6$7_0.vout iqmod_mixer_0.iqmod_mixer_half_1.iqmod_mixer_se2diff$1_0.iqmod_mixer_se2diff_half_inv$2_0.iqmod_mixer_se2diff_inv_NF6$7_1.vin VDD sg13_lv_pmos ad=0.57p pd=3.38u as=0.57p ps=3.38u w=3u l=0.13u
X1650 iqmod_mixer_0.iqmod_mixer_half_1.iqmod_mixer_tg$1_0.di_tg_ctrl iqmod_mixer_0.iqmod_mixer_half_1.iqmod_mixer_se2diff$1_0.iqmod_mixer_se2diff_half_inv$2_0.iqmod_mixer_se2diff_inv_NF54$7_0.vin VDD VDD sg13_lv_pmos ad=0.57p pd=3.38u as=0.57p ps=3.38u w=3u l=0.13u
X1651 iqmod_mixer_0.vinn_IF iqmod_mfb_lpf_0.iqmod_mfb_lpf_half_0.iqmod_mfb_lpf_ota_core_hybrid_bm_half$1_0.iqmod_mfb_lpf_ota_core_inv_NF20$2_1.vin VSS VSS sg13_lv_nmos ad=0.19p pd=1.38u as=0.19p ps=1.38u w=1u l=1u
X1652 VSS iqmod_mixer_0.iqmod_mixer_half_0.iqmod_mixer_se2diff$1_0.iqmod_mixer_se2diff_half_tg$2_0.iqmod_mixer_se2diff_inv_NF54$6_0.vin iqmod_mixer_0.iqmod_mixer_half_0.iqmod_mixer_tg$1_0.di_tg_ctrl_n VSS sg13_lv_nmos ad=0.19p pd=1.38u as=0.19p ps=1.38u w=1u l=0.13u
X1653 VDD VDD VDD VDD sg13_lv_pmos ad=0.57p pd=3.38u as=0 ps=0 w=3u l=0.13u
X1654 iqmod_spdt_switch_1.spdt_switch_inv_0.vout iqmod_spdt_switch_1.spdt_switch_inv_0.vin VDD VDD sg13_lv_pmos ad=1.14p pd=6.38u as=1.14p ps=6.38u w=6u l=0.13u
X1655 iqmod_spdt_switch_1.v_c iqmod_spdt_switch_1.spdt_switch_inv_0.vin vinp_I VDD sg13_lv_pmos ad=1.14p pd=6.38u as=2.04p ps=12.68u w=6u l=0.13u
X1656 iqmod_mixer_0.iqmod_mixer_half_0.iqmod_mixer_tg$1_0.di_tg_ctrl_n iqmod_mixer_0.iqmod_mixer_half_0.iqmod_mixer_se2diff$1_0.iqmod_mixer_se2diff_half_tg$2_0.iqmod_mixer_se2diff_inv_NF54$6_0.vin VSS VSS sg13_lv_nmos ad=0.19p pd=1.38u as=0.19p ps=1.38u w=1u l=0.13u
X1657 VSS VSS VSS VSS sg13_lv_nmos ad=0.19p pd=1.38u as=0 ps=0 w=1u l=1u
X1658 iqmod_mfb_lpf_0.iqmod_mfb_lpf_half_0.iqmod_mfb_lpf_ota_core_hybrid_bm_half$1_0.iqmod_mfb_lpf_ota_core_inv_NF20$2_0.vout iqmod_mixer_0.vinp_IF VDD VDD sg13_lv_pmos ad=1.14p pd=6.38u as=1.14p ps=6.38u w=6u l=1u
X1659 VDD iqmod_mfb_lpf_0.iqmod_mfb_lpf_half_1.iqmod_mfb_lpf_ota_core_hybrid_bm_half$1_0.iqmod_mfb_lpf_ota_core_tg$2_0.di_tg_ctrl_n iqmod_mfb_lpf_0.iqmod_mfb_lpf_half_1.iqmod_mfb_lpf_ota_core_hybrid_bm_half$1_0.iqmod_mfb_lpf_ota_core_inv_NF20$2_1.vin VSS sg13_lv_nmos ad=0.34p pd=2.68u as=0.19p ps=1.38u w=1u l=0.13u
X1660 iqmod_mfb_lpf_0.iqmod_mfb_lpf_half_0.iqmod_mfb_lpf_ota_core_hybrid_bm_half$1_0.iqmod_mfb_lpf_ota_core_tg$2_0.v_b iqmod_mfb_lpf_0.iqmod_mfb_lpf_half_1.iqmod_mfb_lpf_ota_core_hybrid_bm_half$1_0.iqmod_mfb_lpf_ota_core_tg$2_0.di_tg_ctrl_n iqmod_mfb_lpf_0.iqmod_mfb_lpf_half_0.iqmod_mfb_lpf_ota_core_hybrid_bm_half$1_0.iqmod_mfb_lpf_ota_core_tg$2_0.v_a VDD sg13_lv_pmos ad=1.14p pd=6.38u as=1.14p ps=6.38u w=6u l=0.13u
X1661 VSS iqmod_mixer_0.iqmod_mixer_half_1.iqmod_mixer_se2diff$1_0.iqmod_mixer_se2diff_half_inv$2_0.iqmod_mixer_se2diff_inv_NF54$7_0.vin iqmod_mixer_0.iqmod_mixer_half_1.iqmod_mixer_tg$1_0.di_tg_ctrl VSS sg13_lv_nmos ad=0.19p pd=1.38u as=0.19p ps=1.38u w=1u l=0.13u
X1662 VDD iqmod_mixer_0.vinn_IF iqmod_mfb_lpf_0.iqmod_mfb_lpf_half_0.iqmod_mfb_lpf_ota_core_hybrid_bm_half$1_0.iqmod_mfb_lpf_ota_core_inv_NF20$2_0.vout VDD sg13_lv_pmos ad=1.14p pd=6.38u as=1.14p ps=6.38u w=6u l=1u
X1663 iqmod_mixer_0.vinn_IF iqmod_mfb_lpf_0.iqmod_mfb_lpf_half_0.iqmod_mfb_lpf_ota_core_hybrid_bm_half$1_0.iqmod_mfb_lpf_ota_core_inv_NF20$2_1.vin VDD VDD sg13_lv_pmos ad=1.14p pd=6.38u as=1.14p ps=6.38u w=6u l=1u
X1664 VDD iqmod_mixer_0.iqmod_mixer_half_1.iqmod_mixer_se2diff$1_0.iqmod_mixer_se2diff_half_inv$2_0.iqmod_mixer_se2diff_inv_NF6$7_0.vout iqmod_mixer_0.iqmod_mixer_half_1.iqmod_mixer_se2diff$1_0.iqmod_mixer_se2diff_half_inv$2_0.iqmod_mixer_se2diff_inv_NF6$7_1.vin VDD sg13_lv_pmos ad=0.57p pd=3.38u as=0.57p ps=3.38u w=3u l=0.13u
X1665 iqmod_mixer_0.iqmod_mixer_half_1.iqmod_mixer_tg$1_0.di_tg_ctrl iqmod_mixer_0.iqmod_mixer_half_1.iqmod_mixer_se2diff$1_0.iqmod_mixer_se2diff_half_inv$2_0.iqmod_mixer_se2diff_inv_NF54$7_0.vin VDD VDD sg13_lv_pmos ad=0.57p pd=3.38u as=0.57p ps=3.38u w=3u l=0.13u
X1666 VDD iqmod_mfb_lpf_0.iqmod_mfb_lpf_half_1.iqmod_mfb_lpf_ota_core_hybrid_bm_half$1_0.iqmod_mfb_lpf_ota_core_inv_NF20$2_1.vin iqmod_mfb_lpf_0.iqmod_mfb_lpf_half_0.iqmod_mfb_lpf_ota_core_hybrid_bm_half$1_0.iqmod_mfb_lpf_ota_core_tg$2_0.v_a VDD sg13_lv_pmos ad=1.14p pd=6.38u as=1.14p ps=6.38u w=6u l=1u
X1667 iqmod_mfb_lpf_0.iqmod_mfb_lpf_half_0.iqmod_mfb_lpf_ota_core_hybrid_bm_half$1_0.iqmod_mfb_lpf_ota_core_inv_NF20$2_0.vout iqmod_mixer_0.vinn_IF VSS VSS sg13_lv_nmos ad=0.19p pd=1.38u as=0.19p ps=1.38u w=1u l=1u
X1668 VSS iqmod_mfb_lpf_0.iqmod_mfb_lpf_half_0.iqmod_mfb_lpf_ota_core_hybrid_bm_half$1_0.iqmod_mfb_lpf_ota_core_inv_NF20$2_1.vin iqmod_mixer_0.vinn_IF VSS sg13_lv_nmos ad=0.19p pd=1.38u as=0.19p ps=1.38u w=1u l=1u
X1669 iqmod_mixer_0.iqmod_mixer_half_1.iqmod_mixer_se2diff$1_0.iqmod_mixer_se2diff_half_inv$2_0.iqmod_mixer_se2diff_inv_NF6$7_0.vout iqmod_mixer_0.iqmod_mixer_half_1.iqmod_mixer_se2diff$1_0.iqmod_mixer_se2diff_half_inv$2_0.iqmod_mixer_se2diff_inv_NF6$7_0.vin VDD VDD sg13_lv_pmos ad=0.57p pd=3.38u as=0.57p ps=3.38u w=3u l=0.13u
X1670 VDD iqmod_mixer_0.iqmod_mixer_half_0.iqmod_mixer_se2diff$1_0.iqmod_mixer_se2diff_half_inv$2_0.iqmod_mixer_se2diff_inv_NF54$7_0.vin iqmod_mixer_0.iqmod_mixer_half_0.iqmod_mixer_tg$1_0.di_tg_ctrl VDD sg13_lv_pmos ad=0.57p pd=3.38u as=0.57p ps=3.38u w=3u l=0.13u
X1671 iqmod_mfb_lpf_0.iqmod_mfb_lpf_half_1.iqmod_mfb_lpf_ota_core_hybrid_bm_half$1_0.iqmod_mfb_lpf_ota_core_inv_NF20$2_1.vin iqmod_mfb_lpf_0.iqmod_mfb_lpf_half_1.iqmod_mfb_lpf_ota_core_hybrid_bm_half$1_0.iqmod_mfb_lpf_ota_core_tg$2_0.di_tg_ctrl_n VDD VSS sg13_lv_nmos ad=0.19p pd=1.38u as=0.19p ps=1.38u w=1u l=0.13u
X1672 VSS VSS VSS VSS sg13_lv_nmos ad=0.34p pd=2.68u as=0 ps=0 w=1u l=0.13u
X1673 iqmod_mixer_0.iqmod_mixer_half_0.iqmod_mixer_se2diff$1_0.iqmod_mixer_se2diff_half_inv$2_0.iqmod_mixer_se2diff_inv_NF54$7_0.vin iqmod_mixer_0.iqmod_mixer_half_0.iqmod_mixer_se2diff$1_0.iqmod_mixer_se2diff_half_inv$2_0.iqmod_mixer_se2diff_inv_NF18$7_0.vin VSS VSS sg13_lv_nmos ad=0.19p pd=1.38u as=0.19p ps=1.38u w=1u l=0.13u
X1674 VSS iqmod_mixer_0.iqmod_mixer_half_0.iqmod_mixer_se2diff$1_0.iqmod_mixer_se2diff_half_tg$2_0.iqmod_mixer_se2diff_inv_NF54$6_0.vin iqmod_mixer_0.iqmod_mixer_half_0.iqmod_mixer_tg$1_0.di_tg_ctrl_n VSS sg13_lv_nmos ad=0.19p pd=1.38u as=0.19p ps=1.38u w=1u l=0.13u
X1675 VDD VDD VDD VDD sg13_lv_pmos ad=0.57p pd=3.38u as=0 ps=0 w=3u l=0.13u
X1676 VDD iqmod_mfb_lpf_0.iqmod_mfb_lpf_half_0.iqmod_mfb_lpf_ota_core_hybrid_bm_half$1_0.iqmod_mfb_lpf_ota_core_inv_NF20$2_0.vout iqmod_mfb_lpf_0.iqmod_mfb_lpf_half_0.iqmod_mfb_lpf_ota_core_hybrid_bm_half$1_0.iqmod_mfb_lpf_ota_core_inv_NF6$2_1.vout VDD sg13_lv_pmos ad=1.14p pd=6.38u as=1.14p ps=6.38u w=6u l=1u
X1677 iqmod_mixer_0.iqmod_mixer_half_1.iqmod_mixer_tg$1_0.di_tg_ctrl iqmod_mixer_0.iqmod_mixer_half_1.iqmod_mixer_se2diff$1_0.iqmod_mixer_se2diff_half_inv$2_0.iqmod_mixer_se2diff_inv_NF54$7_0.vin VDD VDD sg13_lv_pmos ad=0.57p pd=3.38u as=0.57p ps=3.38u w=3u l=0.13u
X1678 iqmod_mixer_0.vinp_IF iqmod_mfb_lpf_0.iqmod_mfb_lpf_half_1.iqmod_mfb_lpf_ota_core_hybrid_bm_half$1_0.iqmod_mfb_lpf_ota_core_inv_NF20$2_1.vin VSS VSS sg13_lv_nmos ad=0.19p pd=1.38u as=0.19p ps=1.38u w=1u l=1u
X1679 VDD VDD VDD VDD sg13_lv_pmos ad=0.57p pd=3.38u as=0 ps=0 w=3u l=0.13u
X1680 VDD iqmod_mixer_0.iqmod_mixer_half_0.iqmod_mixer_se2diff$1_0.iqmod_mixer_se2diff_half_tg$2_0.iqmod_mixer_se2diff_inv_NF18$6_0.vin iqmod_mixer_0.iqmod_mixer_half_0.iqmod_mixer_se2diff$1_0.iqmod_mixer_se2diff_half_tg$2_0.iqmod_mixer_se2diff_inv_NF54$6_0.vin VDD sg13_lv_pmos ad=0.57p pd=3.38u as=0.57p ps=3.38u w=3u l=0.13u
X1681 VDD iqmod_mfb_lpf_0.iqmod_mfb_lpf_half_0.iqmod_mfb_lpf_ota_core_hybrid_bm_half$1_0.iqmod_mfb_lpf_ota_core_inv_NF20$2_1.vin iqmod_mixer_0.vinn_IF VDD sg13_lv_pmos ad=1.14p pd=6.38u as=1.14p ps=6.38u w=6u l=1u
X1682 VSS VSS VSS VSS sg13_lv_nmos ad=0.34p pd=2.68u as=0 ps=0 w=1u l=0.13u
X1683 VSS iqmod_mixer_0.vinn_IF iqmod_mfb_lpf_0.iqmod_mfb_lpf_half_0.iqmod_mfb_lpf_ota_core_hybrid_bm_half$1_0.iqmod_mfb_lpf_ota_core_inv_NF20$2_0.vout VSS sg13_lv_nmos ad=0.19p pd=1.38u as=0.19p ps=1.38u w=1u l=1u
X1684 iqmod_mixer_0.iqmod_mixer_half_1.iqmod_mixer_se2diff$1_0.iqmod_mixer_se2diff_half_tg$2_0.iqmod_mixer_se2diff_inv_NF54$6_0.vin iqmod_mixer_0.iqmod_mixer_half_1.iqmod_mixer_se2diff$1_0.iqmod_mixer_se2diff_half_tg$2_0.iqmod_mixer_se2diff_inv_NF18$6_0.vin VDD VDD sg13_lv_pmos ad=0.57p pd=3.38u as=0.57p ps=3.38u w=3u l=0.13u
X1685 iqmod_mixer_0.vinn_IF iqmod_mfb_lpf_0.iqmod_mfb_lpf_half_0.iqmod_mfb_lpf_ota_core_hybrid_bm_half$1_0.iqmod_mfb_lpf_ota_core_inv_NF20$2_1.vin VSS VSS sg13_lv_nmos ad=0.19p pd=1.38u as=0.19p ps=1.38u w=1u l=1u
X1686 VSS iqmod_mfb_lpf_0.iqmod_mfb_lpf_half_0.iqmod_mfb_lpf_ota_core_hybrid_bm_half$1_0.iqmod_mfb_lpf_ota_core_inv_NF6$2_1.vout iqmod_mfb_lpf_0.iqmod_mfb_lpf_half_0.iqmod_mfb_lpf_ota_core_hybrid_bm_half$1_0.iqmod_mfb_lpf_ota_core_tg$2_0.v_b VSS sg13_lv_nmos ad=0.19p pd=1.38u as=0.19p ps=1.38u w=1u l=1u
X1687 VDD VDD VDD VDD sg13_lv_pmos ad=1.02p pd=6.68u as=0 ps=0 w=3u l=0.13u
X1688 iqmod_mixer_0.iqmod_mixer_half_0.iqmod_mixer_tg$1_0.di_tg_ctrl iqmod_mixer_0.iqmod_mixer_half_0.iqmod_mixer_se2diff$1_0.iqmod_mixer_se2diff_half_inv$2_0.iqmod_mixer_se2diff_inv_NF54$7_0.vin VSS VSS sg13_lv_nmos ad=0.19p pd=1.38u as=0.19p ps=1.38u w=1u l=0.13u
X1689 iqmod_mixer_0.iqmod_mixer_half_0.iqmod_mixer_tg$1_0.di_tg_ctrl_n iqmod_mixer_0.iqmod_mixer_half_0.iqmod_mixer_se2diff$1_0.iqmod_mixer_se2diff_half_tg$2_0.iqmod_mixer_se2diff_inv_NF54$6_0.vin VSS VSS sg13_lv_nmos ad=0.19p pd=1.38u as=0.19p ps=1.38u w=1u l=0.13u
X1690 VDD VDD VDD VDD sg13_lv_pmos ad=1.14p pd=6.38u as=0 ps=0 w=6u l=1u
X1691 VSS iqmod_mixer_0.iqmod_mixer_half_1.iqmod_mixer_se2diff$1_0.iqmod_mixer_se2diff_half_tg$2_0.iqmod_mixer_se2diff_inv_NF54$6_0.vin iqmod_mixer_0.iqmod_mixer_half_1.iqmod_mixer_tg$1_0.di_tg_ctrl_n VSS sg13_lv_nmos ad=0.19p pd=1.38u as=0.19p ps=1.38u w=1u l=0.13u
X1692 VDD iqmod_mixer_0.iqmod_mixer_half_1.iqmod_mixer_se2diff$1_0.iqmod_mixer_se2diff_half_inv$2_0.iqmod_mixer_se2diff_inv_NF18$7_0.vin iqmod_mixer_0.iqmod_mixer_half_1.iqmod_mixer_se2diff$1_0.iqmod_mixer_se2diff_half_inv$2_0.iqmod_mixer_se2diff_inv_NF54$7_0.vin VDD sg13_lv_pmos ad=0.57p pd=3.38u as=0.57p ps=3.38u w=3u l=0.13u
X1693 iqmod_mixer_0.iqmod_mixer_half_1.iqmod_mixer_tg$1_0.di_tg_ctrl iqmod_mixer_0.iqmod_mixer_half_1.iqmod_mixer_se2diff$1_0.iqmod_mixer_se2diff_half_inv$2_0.iqmod_mixer_se2diff_inv_NF54$7_0.vin VDD VDD sg13_lv_pmos ad=0.57p pd=3.38u as=0.57p ps=3.38u w=3u l=0.13u
X1694 VSS VSS VSS VSS sg13_lv_nmos ad=0.19p pd=1.38u as=0 ps=0 w=1u l=0.13u
X1695 VSS iqmod_mfb_lpf_0.iqmod_mfb_lpf_half_1.iqmod_mfb_lpf_ota_core_hybrid_bm_half$1_0.iqmod_mfb_lpf_ota_core_inv_NF20$2_1.vin iqmod_mixer_0.vinp_IF VSS sg13_lv_nmos ad=0.19p pd=1.38u as=0.19p ps=1.38u w=1u l=1u
X1696 voutn_I_RF iqmod_mixer_0.iqmod_mixer_half_0.iqmod_mixer_tg$1_0.di_tg_ctrl voutn_I_RF VDD sg13_lv_pmos ad=1.71p pd=9.38u as=0 ps=0 w=9u l=0.13u
X1697 VSS iqmod_mixer_0.iqmod_mixer_half_1.iqmod_mixer_se2diff$1_0.iqmod_mixer_se2diff_half_tg$2_0.iqmod_mixer_se2diff_inv_NF54$6_0.vin iqmod_mixer_0.iqmod_mixer_half_1.iqmod_mixer_tg$1_0.di_tg_ctrl_n VSS sg13_lv_nmos ad=0.19p pd=1.38u as=0.19p ps=1.38u w=1u l=0.13u
X1698 VSS VSS VSS VSS sg13_lv_nmos ad=0.19p pd=1.38u as=0 ps=0 w=1u l=0.13u
X1699 VDD iqmod_mixer_0.iqmod_mixer_half_0.iqmod_mixer_se2diff$1_0.iqmod_mixer_se2diff_half_tg$2_0.iqmod_mixer_se2diff_inv_NF54$6_0.vin iqmod_mixer_0.iqmod_mixer_half_0.iqmod_mixer_tg$1_0.di_tg_ctrl_n VDD sg13_lv_pmos ad=0.57p pd=3.38u as=0.57p ps=3.38u w=3u l=0.13u
X1700 VSS iqmod_mixer_0.iqmod_mixer_half_1.iqmod_mixer_se2diff$1_0.iqmod_mixer_se2diff_half_inv$2_0.iqmod_mixer_se2diff_inv_NF2$7_1.vout iqmod_mixer_0.iqmod_mixer_half_1.iqmod_mixer_se2diff$1_0.iqmod_mixer_se2diff_half_tg$2_0.iqmod_mixer_se2diff_inv_NF18$6_0.vin VSS sg13_lv_nmos ad=0.19p pd=1.38u as=0.19p ps=1.38u w=1u l=0.13u
X1701 iqmod_mixer_0.iqmod_mixer_half_1.iqmod_mixer_se2diff$1_0.iqmod_mixer_se2diff_half_inv$2_0.iqmod_mixer_se2diff_inv_NF54$7_0.vin iqmod_mixer_0.iqmod_mixer_half_1.iqmod_mixer_se2diff$1_0.iqmod_mixer_se2diff_half_inv$2_0.iqmod_mixer_se2diff_inv_NF18$7_0.vin VSS VSS sg13_lv_nmos ad=0.19p pd=1.38u as=0.19p ps=1.38u w=1u l=0.13u
X1702 iqmod_mixer_0.vinn_IF iqmod_mixer_0.iqmod_mixer_half_0.iqmod_mixer_tg$1_0.di_tg_ctrl_n voutn_I_RF VDD sg13_lv_pmos ad=1.71p pd=9.38u as=1.71p ps=9.38u w=9u l=0.13u
X1703 VSS di_spdt_ctrl_I iqmod_spdt_switch_0.spdt_switch_inv_0.vin VSS sg13_lv_nmos ad=0.19p pd=1.38u as=0.19p ps=1.38u w=1u l=0.13u
X1704 iqmod_mixer_0.iqmod_mixer_half_1.iqmod_mixer_tg$1_0.di_tg_ctrl_n iqmod_mixer_0.iqmod_mixer_half_1.iqmod_mixer_se2diff$1_0.iqmod_mixer_se2diff_half_tg$2_0.iqmod_mixer_se2diff_inv_NF54$6_0.vin VSS VSS sg13_lv_nmos ad=0.19p pd=1.38u as=0.19p ps=1.38u w=1u l=0.13u
X1705 iqmod_mixer_0.vinp_IF iqmod_mfb_lpf_0.iqmod_mfb_lpf_half_0.iqmod_mfb_lpf_ota_core_hybrid_bm_half$1_0.iqmod_mfb_lpf_ota_core_tg$2_0.v_b VDD VDD sg13_lv_pmos ad=1.14p pd=6.38u as=1.14p ps=6.38u w=6u l=1u
X1706 VDD iqmod_mixer_0.iqmod_mixer_half_0.iqmod_mixer_se2diff$1_0.iqmod_mixer_se2diff_half_tg$2_0.iqmod_mixer_se2diff_inv_NF54$6_0.vin iqmod_mixer_0.iqmod_mixer_half_0.iqmod_mixer_tg$1_0.di_tg_ctrl_n VDD sg13_lv_pmos ad=0.57p pd=3.38u as=0.57p ps=3.38u w=3u l=0.13u
X1707 VDD VDD VDD VDD sg13_lv_pmos ad=0.57p pd=3.38u as=0 ps=0 w=3u l=0.13u
X1708 voutn_I_RF iqmod_mixer_0.iqmod_mixer_half_0.iqmod_mixer_tg$1_0.di_tg_ctrl voutn_I_RF VDD sg13_lv_pmos ad=1.71p pd=9.38u as=0 ps=0 w=9u l=0.13u
X1709 iqmod_mixer_0.iqmod_mixer_half_1.iqmod_mixer_tg$1_0.di_tg_ctrl iqmod_mixer_0.iqmod_mixer_half_1.iqmod_mixer_se2diff$1_0.iqmod_mixer_se2diff_half_inv$2_0.iqmod_mixer_se2diff_inv_NF54$7_0.vin VDD VDD sg13_lv_pmos ad=0.57p pd=3.38u as=0.57p ps=3.38u w=3u l=0.13u
X1710 iqmod_mixer_0.iqmod_mixer_half_0.iqmod_mixer_se2diff$1_0.iqmod_mixer_se2diff_half_inv$2_0.iqmod_mixer_se2diff_inv_NF54$7_0.vin iqmod_mixer_0.iqmod_mixer_half_0.iqmod_mixer_se2diff$1_0.iqmod_mixer_se2diff_half_inv$2_0.iqmod_mixer_se2diff_inv_NF18$7_0.vin VDD VDD sg13_lv_pmos ad=0.57p pd=3.38u as=0.57p ps=3.38u w=3u l=0.13u
X1711 a_36853_1946# iqmod_mixer_0.vinp_IF VSS rhigh l=60u w=0.5u
X1712 voutp_I_RF iqmod_mixer_0.iqmod_mixer_half_1.iqmod_mixer_tg$1_0.di_tg_ctrl_n iqmod_mixer_0.vinp_IF VDD sg13_lv_pmos ad=1.71p pd=9.38u as=1.71p ps=9.38u w=9u l=0.13u
X1713 a_11701_1946# iqmod_mfb_lpf_0.iqmod_mfb_lpf_half_0.C1_half VSS rhigh l=27u w=0.5u
X1714 iqmod_mixer_0.iqmod_mixer_half_0.iqmod_mixer_tg$1_0.di_tg_ctrl_n iqmod_mixer_0.iqmod_mixer_half_0.iqmod_mixer_se2diff$1_0.iqmod_mixer_se2diff_half_tg$2_0.iqmod_mixer_se2diff_inv_NF54$6_0.vin VDD VDD sg13_lv_pmos ad=0.57p pd=3.38u as=0.57p ps=3.38u w=3u l=0.13u
X1715 VSS VSS VSS VSS sg13_lv_nmos ad=0.34p pd=2.68u as=0 ps=0 w=1u l=0.13u
X1716 iqmod_mixer_0.iqmod_mixer_half_1.iqmod_mixer_se2diff$1_0.iqmod_mixer_se2diff_half_inv$2_0.iqmod_mixer_se2diff_inv_NF18$7_0.vin iqmod_mixer_0.iqmod_mixer_half_1.iqmod_mixer_se2diff$1_0.iqmod_mixer_se2diff_half_inv$2_0.iqmod_mixer_se2diff_inv_NF6$7_1.vin VDD VDD sg13_lv_pmos ad=0.57p pd=3.38u as=0.57p ps=3.38u w=3u l=0.13u
X1717 iqmod_mixer_0.vinn_IF iqmod_mixer_0.iqmod_mixer_half_0.iqmod_mixer_tg$1_0.di_tg_ctrl voutn_I_RF VSS sg13_lv_nmos ad=0.57p pd=3.38u as=0.57p ps=3.38u w=3u l=0.13u
X1718 VDD VDD VDD VDD sg13_lv_pmos ad=1.02p pd=6.68u as=0 ps=0 w=3u l=0.13u
X1719 voutn_I_RF iqmod_mixer_0.iqmod_mixer_half_0.iqmod_mixer_tg$1_0.di_tg_ctrl voutn_I_RF VDD sg13_lv_pmos ad=1.71p pd=9.38u as=0 ps=0 w=9u l=0.13u
X1720 iqmod_spdt_switch_0.v_c iqmod_spdt_switch_0.spdt_switch_inv_0.vout di_ds_I_n VDD sg13_lv_pmos ad=1.14p pd=6.38u as=1.14p ps=6.38u w=6u l=0.13u
X1721 VDD iqmod_mixer_0.iqmod_mixer_half_1.iqmod_mixer_se2diff$1_0.iqmod_mixer_se2diff_half_tg$2_0.iqmod_mixer_se2diff_inv_NF54$6_0.vin iqmod_mixer_0.iqmod_mixer_half_1.iqmod_mixer_tg$1_0.di_tg_ctrl_n VDD sg13_lv_pmos ad=0.57p pd=3.38u as=0.57p ps=3.38u w=3u l=0.13u
X1722 a_17685_10452# iqmod_mfb_lpf_0.iqmod_mfb_lpf_half_0.iqmod_mfb_lpf_R3$1_0.v_a VSS rhigh l=31u w=0.5u
X1723 VDD VDD VDD VDD sg13_lv_pmos ad=1.02p pd=6.68u as=0 ps=0 w=3u l=0.13u
X1724 iqmod_mixer_0.vinp_IF iqmod_mixer_0.iqmod_mixer_half_1.iqmod_mixer_tg$1_0.di_tg_ctrl_n voutp_I_RF VDD sg13_lv_pmos ad=1.71p pd=9.38u as=1.71p ps=9.38u w=9u l=0.13u
X1725 VDD VDD VDD VDD sg13_lv_pmos ad=2.04p pd=12.68u as=0 ps=0 w=6u l=1u
X1726 voutn_I_RF iqmod_mixer_0.iqmod_mixer_half_0.iqmod_mixer_tg$1_0.di_tg_ctrl iqmod_mixer_0.vinn_IF VSS sg13_lv_nmos ad=0.57p pd=3.38u as=0.57p ps=3.38u w=3u l=0.13u
X1727 iqmod_mixer_0.vinn_IF iqmod_mixer_0.iqmod_mixer_half_0.iqmod_mixer_tg$1_0.di_tg_ctrl_n voutn_I_RF VDD sg13_lv_pmos ad=1.71p pd=9.38u as=3.06p ps=18.68u w=9u l=0.13u
X1728 voutp_I_RF iqmod_mixer_0.iqmod_mixer_half_1.iqmod_mixer_tg$1_0.di_tg_ctrl iqmod_mixer_0.vinp_IF VSS sg13_lv_nmos ad=0.57p pd=3.38u as=0.57p ps=3.38u w=3u l=0.13u
X1729 VDD VDD VDD VDD sg13_lv_pmos ad=1.02p pd=6.68u as=0 ps=0 w=3u l=0.13u
X1730 VSS VSS VSS VSS sg13_lv_nmos ad=0.19p pd=1.38u as=0 ps=0 w=1u l=0.13u
X1731 iqmod_mixer_0.iqmod_mixer_half_1.iqmod_mixer_tg$1_0.di_tg_ctrl_n iqmod_mixer_0.iqmod_mixer_half_1.iqmod_mixer_se2diff$1_0.iqmod_mixer_se2diff_half_tg$2_0.iqmod_mixer_se2diff_inv_NF54$6_0.vin VDD VDD sg13_lv_pmos ad=0.57p pd=3.38u as=0.57p ps=3.38u w=3u l=0.13u
X1732 VDD VDD VDD VDD sg13_lv_pmos ad=1.14p pd=6.38u as=0 ps=0 w=6u l=1u
X1733 VSS VSS VSS VSS sg13_lv_nmos ad=0.34p pd=2.68u as=0 ps=0 w=1u l=1u
X1734 voutp_I_RF iqmod_mixer_0.iqmod_mixer_half_1.iqmod_mixer_tg$1_0.di_tg_ctrl_n iqmod_mixer_0.vinp_IF VDD sg13_lv_pmos ad=1.71p pd=9.38u as=1.71p ps=9.38u w=9u l=0.13u
X1735 iqmod_mixer_0.iqmod_mixer_half_0.iqmod_mixer_tg$1_0.di_tg_ctrl iqmod_mixer_0.iqmod_mixer_half_0.iqmod_mixer_se2diff$1_0.iqmod_mixer_se2diff_half_inv$2_0.iqmod_mixer_se2diff_inv_NF54$7_0.vin VSS VSS sg13_lv_nmos ad=0.19p pd=1.38u as=0.19p ps=1.38u w=1u l=0.13u
X1736 iqmod_mixer_0.vinp_IF iqmod_mixer_0.iqmod_mixer_half_1.iqmod_mixer_tg$1_0.di_tg_ctrl voutp_I_RF VSS sg13_lv_nmos ad=0.57p pd=3.38u as=0.57p ps=3.38u w=3u l=0.13u
X1737 VSS iqmod_mixer_0.iqmod_mixer_half_0.iqmod_mixer_se2diff$1_0.iqmod_mixer_se2diff_half_tg$2_0.iqmod_mixer_se2diff_tg_NF6$3_0.v_b iqmod_mixer_0.iqmod_mixer_half_0.iqmod_mixer_se2diff$1_0.iqmod_mixer_se2diff_half_inv$2_0.iqmod_mixer_se2diff_inv_NF2$7_1.vout VSS sg13_lv_nmos ad=0.19p pd=1.38u as=0.19p ps=1.38u w=1u l=0.13u
X1738 iqmod_mixer_0.iqmod_mixer_half_0.iqmod_mixer_se2diff$1_0.iqmod_mixer_se2diff_half_inv$2_0.iqmod_mixer_se2diff_inv_NF18$7_0.vin iqmod_mixer_0.iqmod_mixer_half_0.iqmod_mixer_se2diff$1_0.iqmod_mixer_se2diff_half_inv$2_0.iqmod_mixer_se2diff_inv_NF6$7_1.vin VSS VSS sg13_lv_nmos ad=0.19p pd=1.38u as=0.19p ps=1.38u w=1u l=0.13u
X1739 iqmod_mfb_lpf_0.iqmod_mfb_lpf_half_0.iqmod_mfb_lpf_ota_core_hybrid_bm_half$1_0.iqmod_mfb_lpf_ota_core_inv_NF20$2_1.vin iqmod_mfb_lpf_0.iqmod_mfb_lpf_half_0.iqmod_mfb_lpf_ota_core_hybrid_bm_half$1_0.iqmod_mfb_lpf_ota_core_tg$2_0.di_tg_ctrl_n VDD VSS sg13_lv_nmos ad=0.19p pd=1.38u as=0.19p ps=1.38u w=1u l=0.13u
X1740 iqmod_mixer_0.iqmod_mixer_half_1.iqmod_mixer_se2diff$1_0.iqmod_mixer_se2diff_half_inv$2_0.iqmod_mixer_se2diff_inv_NF6$7_0.vin VDD iqmod_mixer_0.iqmod_mixer_half_1.iqmod_mixer_se2diff$1_0.iqmod_mixer_se2diff_half_tg$2_0.iqmod_mixer_se2diff_tg_NF6$3_0.v_b VSS sg13_lv_nmos ad=0.34p pd=2.68u as=0.19p ps=1.38u w=1u l=0.13u
X1741 VSS iqmod_mixer_0.iqmod_mixer_half_0.iqmod_mixer_se2diff$1_0.iqmod_mixer_se2diff_half_inv$2_0.iqmod_mixer_se2diff_inv_NF54$7_0.vin iqmod_mixer_0.iqmod_mixer_half_0.iqmod_mixer_tg$1_0.di_tg_ctrl VSS sg13_lv_nmos ad=0.19p pd=1.38u as=0.19p ps=1.38u w=1u l=0.13u
X1742 iqmod_mixer_0.vinn_IF iqmod_spdt_switch_1.v_c cap_cmim l=8u w=8u
X1743 VSS iqmod_mixer_0.iqmod_mixer_half_1.iqmod_mixer_se2diff$1_0.iqmod_mixer_se2diff_half_inv$2_0.iqmod_mixer_se2diff_inv_NF54$7_0.vin iqmod_mixer_0.iqmod_mixer_half_1.iqmod_mixer_tg$1_0.di_tg_ctrl VSS sg13_lv_nmos ad=0.19p pd=1.38u as=0.19p ps=1.38u w=1u l=0.13u
X1744 VSS iqmod_mfb_lpf_0.iqmod_mfb_lpf_half_0.iqmod_mfb_lpf_ota_core_hybrid_bm_half$1_0.iqmod_mfb_lpf_ota_core_tg$2_0.v_a iqmod_mfb_lpf_0.iqmod_mfb_lpf_half_0.iqmod_mfb_lpf_ota_core_hybrid_bm_half$1_0.iqmod_mfb_lpf_ota_core_tg$2_0.v_b VSS sg13_lv_nmos ad=0.19p pd=1.38u as=0.19p ps=1.38u w=1u l=1u
X1745 iqmod_mixer_0.vinp_IF iqmod_mfb_lpf_0.iqmod_mfb_lpf_half_1.iqmod_mfb_lpf_ota_core_hybrid_bm_half$1_0.iqmod_mfb_lpf_ota_core_inv_NF20$2_1.vin VDD VDD sg13_lv_pmos ad=1.14p pd=6.38u as=1.14p ps=6.38u w=6u l=1u
C0 iqmod_mfb_lpf_0.iqmod_mfb_lpf_half_0.iqmod_mfb_lpf_ota_core_hybrid_bm_half$1_0.iqmod_mfb_lpf_ota_core_tg$2_0.di_tg_ctrl_n iqmod_spdt_switch_1.v_c 1.12442f
C1 vinn_I iqmod_spdt_switch_0.spdt_switch_inv_0.vin 1.17767f
C2 iqmod_mfb_lpf_0.iqmod_mfb_lpf_half_0.C2_half di_lo_I 0.11163f
C3 a_11787_10752# iqmod_spdt_switch_1.v_c 0.08056f
C4 iqmod_mixer_0.vinn_IF di_lo_Ix 0.94984f
C5 iqmod_mfb_lpf_0.iqmod_mfb_lpf_half_0.iqmod_mfb_lpf_ota_core_hybrid_bm_half$1_0.iqmod_mfb_lpf_ota_core_inv_NF20$2_1.vin iqmod_mfb_lpf_0.iqmod_mfb_lpf_half_0.C2_half 0.32127f
C6 a_17771_2846# iqmod_mfb_lpf_0.iqmod_mfb_lpf_half_0.iqmod_mfb_lpf_ota_core_hybrid_bm_half$1_0.iqmod_mfb_lpf_ota_core_tg$2_0.v_a 0.01489f
C7 iqmod_mfb_lpf_0.iqmod_mfb_lpf_half_0.iqmod_mfb_lpf_ota_core_hybrid_bm_half$1_0.iqmod_mfb_lpf_ota_core_inv_NF6$2_1.vout di_analog_en 2.54867f
C8 a_36939_11352# di_lo_I 0.0538f
C9 iqmod_mixer_0.vinn_IF a_17771_10752# 0.02469f
C10 di_analog_en VDD 2.24274f
C11 iqmod_mfb_lpf_0.iqmod_mfb_lpf_half_0.iqmod_mfb_lpf_ota_core_hybrid_bm_half$1_0.iqmod_mfb_lpf_ota_core_spdt_switch$2_0.iqmod_mfb_lpf_ota_core_spdt_switch_inv$3_0.vout iqmod_spdt_switch_1.v_c 1.07725f
C12 iqmod_mixer_0.iqmod_mixer_half_0.iqmod_mixer_se2diff$1_0.iqmod_mixer_se2diff_half_inv$2_0.iqmod_mixer_se2diff_inv_NF54$7_0.vin iqmod_mixer_0.iqmod_mixer_half_0.iqmod_mixer_se2diff$1_0.iqmod_mixer_se2diff_half_inv$2_0.iqmod_mixer_se2diff_inv_NF18$7_0.vin 4.09415f
C13 a_11787_10152# VDD 0.17311f
C14 iqmod_mfb_lpf_0.iqmod_mfb_lpf_half_0.C1_half a_11787_1646# 0.1399f
C15 voutp_I_RF iqmod_mixer_0.vinp_IF 0.13043p
C16 di_lo_I iqmod_mfb_lpf_0.iqmod_mfb_lpf_half_0.iqmod_mfb_lpf_R3$1_0.v_a 0.15018f
C17 a_17771_11052# a_17771_11352# 0.3708f
C18 iqmod_mfb_lpf_0.iqmod_mfb_lpf_half_0.iqmod_mfb_lpf_ota_core_hybrid_bm_half$1_0.iqmod_mfb_lpf_ota_core_inv_NF20$2_1.vin iqmod_mfb_lpf_0.iqmod_mfb_lpf_half_0.iqmod_mfb_lpf_R3$1_0.v_a 0.344f
C19 a_17771_10152# VDD 0.21216f
C20 iqmod_mfb_lpf_0.iqmod_mfb_lpf_half_1.iqmod_mfb_lpf_ota_core_hybrid_bm_half$1_0.iqmod_mfb_lpf_ota_core_inv_NF20$2_1.vin iqmod_mfb_lpf_0.iqmod_mfb_lpf_half_0.iqmod_mfb_lpf_R1$1_0.v_b 0.51996f
C21 iqmod_mixer_0.vinn_IF iqmod_mfb_lpf_0.iqmod_mfb_lpf_half_0.iqmod_mfb_lpf_R1$1_0.v_b 0.03953f
C22 a_11701_10752# a_11787_11052# 0.01901f
C23 iqmod_mixer_0.iqmod_mixer_half_0.iqmod_mixer_se2diff$1_0.iqmod_mixer_se2diff_half_inv$2_0.iqmod_mixer_se2diff_inv_NF6$7_0.vin di_lo_Ix 1.04865f
C24 di_lo_Ix VDD 2.54102f
C25 iqmod_mixer_0.iqmod_mixer_half_1.iqmod_mixer_se2diff$1_0.iqmod_mixer_se2diff_half_inv$2_0.iqmod_mixer_se2diff_inv_NF6$7_0.vin iqmod_mixer_0.iqmod_mixer_half_1.iqmod_mixer_se2diff$1_0.iqmod_mixer_se2diff_half_tg$2_0.iqmod_mixer_se2diff_tg_NF6$3_0.v_b 7.58107f
C26 a_24555_2246# a_24555_1946# 0.70571f
C27 iqmod_mfb_lpf_0.iqmod_mfb_lpf_half_0.iqmod_mfb_lpf_ota_core_hybrid_bm_half$1_0.iqmod_mfb_lpf_ota_core_tg$2_0.di_tg_ctrl_n iqmod_mfb_lpf_0.iqmod_mfb_lpf_half_1.iqmod_mfb_lpf_ota_core_hybrid_bm_half$1_0.iqmod_mfb_lpf_ota_core_tg$2_0.di_tg_ctrl_n 0.15543f
C28 a_11787_10752# a_11787_10452# 0.32295f
C29 iqmod_spdt_switch_1.spdt_switch_inv_0.vin VDD 7.88583f
C30 iqmod_mixer_0.iqmod_mixer_half_0.iqmod_mixer_tg$1_0.di_tg_ctrl_n iqmod_mixer_0.iqmod_mixer_half_0.iqmod_mixer_se2diff$1_0.iqmod_mixer_se2diff_half_tg$2_0.iqmod_mixer_se2diff_inv_NF54$6_0.vin 12.0077f
C31 iqmod_mfb_lpf_0.iqmod_mfb_lpf_half_0.C1_half iqmod_mixer_0.vinp_IF 0.03916f
C32 a_17771_10752# VDD 0.02615f
C33 iqmod_mfb_lpf_0.iqmod_mfb_lpf_half_1.iqmod_mfb_lpf_ota_core_hybrid_bm_half$1_0.iqmod_mfb_lpf_ota_core_spdt_switch$2_0.iqmod_mfb_lpf_ota_core_spdt_switch_inv$3_0.vout di_analog_en 0.0847f
C34 a_24555_10152# iqmod_mfb_lpf_0.iqmod_mfb_lpf_half_0.C2_half 0.02113f
C35 a_17771_2246# a_23971_1946# 0.01901f
C36 a_11787_2246# iqmod_mfb_lpf_0.iqmod_mfb_lpf_half_0.C1_half 0.14136f
C37 iqmod_mfb_lpf_0.iqmod_mfb_lpf_half_0.C2_half iqmod_mixer_0.vinp_IF 4.73469f
C38 a_36853_1946# a_36939_2246# 0.01901f
C39 iqmod_spdt_switch_0.spdt_switch_inv_0.vin iqmod_spdt_switch_0.spdt_switch_inv_0.vout 1.10866f
C40 di_ds_I_n VDD 1.92838f
C41 iqmod_mfb_lpf_0.iqmod_mfb_lpf_half_0.iqmod_mfb_lpf_ota_core_hybrid_bm_half$1_0.iqmod_mfb_lpf_ota_core_tg$2_0.v_b iqmod_mfb_lpf_0.iqmod_mfb_lpf_half_1.iqmod_mfb_lpf_ota_core_hybrid_bm_half$1_0.iqmod_mfb_lpf_ota_core_tg$2_0.di_tg_ctrl_n 1.96204f
C42 a_36939_11352# iqmod_mixer_0.vinp_IF 0.01024f
C43 iqmod_mixer_0.iqmod_mixer_half_1.iqmod_mixer_se2diff$1_0.iqmod_mixer_se2diff_half_inv$2_0.iqmod_mixer_se2diff_inv_NF54$7_0.vin voutp_I_RF 0.03061f
C44 iqmod_mfb_lpf_0.iqmod_mfb_lpf_half_0.iqmod_mfb_lpf_ota_core_hybrid_bm_half$1_0.iqmod_mfb_lpf_ota_core_inv_NF20$2_0.vout iqmod_mfb_lpf_0.iqmod_mfb_lpf_half_1.iqmod_mfb_lpf_ota_core_hybrid_bm_half$1_0.iqmod_mfb_lpf_ota_core_tg$2_0.di_tg_ctrl_n 0.77311f
C45 iqmod_mfb_lpf_0.iqmod_mfb_lpf_half_0.iqmod_mfb_lpf_R1$1_0.v_b VDD 2.91718f
C46 iqmod_mfb_lpf_0.iqmod_mfb_lpf_half_0.C2_half a_24555_11052# 0.04612f
C47 iqmod_mixer_0.iqmod_mixer_half_1.iqmod_mixer_se2diff$1_0.iqmod_mixer_se2diff_half_inv$2_0.iqmod_mixer_se2diff_inv_NF2$7_1.vout VDD 13.7357f
C48 a_24555_10152# iqmod_mfb_lpf_0.iqmod_mfb_lpf_half_0.iqmod_mfb_lpf_R3$1_0.v_a 0.35902f
C49 a_11787_2546# iqmod_spdt_switch_0.v_c 0.29023f
C50 iqmod_mfb_lpf_0.iqmod_mfb_lpf_half_0.iqmod_mfb_lpf_R3$1_0.v_a iqmod_mixer_0.vinp_IF 0.99383f
C51 a_23971_10752# iqmod_spdt_switch_1.v_c 0.06354f
C52 iqmod_spdt_switch_1.v_c iqmod_mfb_lpf_0.iqmod_mfb_lpf_half_0.C1_half 0.17821f
C53 iqmod_mixer_0.vinn_IF a_48939_10452# 0.03212f
C54 iqmod_mfb_lpf_0.iqmod_mfb_lpf_half_0.C2_half iqmod_spdt_switch_1.v_c 1.02004f
C55 iqmod_mfb_lpf_0.iqmod_mfb_lpf_half_0.iqmod_mfb_lpf_ota_core_hybrid_bm_half$1_0.iqmod_mfb_lpf_ota_core_tg$2_0.di_tg_ctrl_n iqmod_mixer_0.vinn_IF 2.50644f
C56 iqmod_mixer_0.vinn_IF a_36939_10752# 0.01719f
C57 a_17771_2246# iqmod_mfb_lpf_0.iqmod_mfb_lpf_half_0.iqmod_mfb_lpf_R1$1_0.v_b 0.02356f
C58 iqmod_mfb_lpf_0.iqmod_mfb_lpf_half_0.iqmod_mfb_lpf_R3$1_0.v_a a_24555_11052# 0.3204f
C59 a_24469_2246# iqmod_spdt_switch_0.v_c 0.01853f
C60 iqmod_mixer_0.iqmod_mixer_half_1.iqmod_mixer_se2diff$1_0.iqmod_mixer_se2diff_half_inv$2_0.iqmod_mixer_se2diff_inv_NF6$7_1.vin VDD 13.6373f
C61 di_analog_en iqmod_spdt_switch_0.v_c 1.29771f
C62 iqmod_mfb_lpf_0.iqmod_mfb_lpf_half_0.iqmod_mfb_lpf_R1$1_0.v_b a_11787_11352# 0.13325f
C63 iqmod_mfb_lpf_0.iqmod_mfb_lpf_half_1.iqmod_mfb_lpf_ota_core_hybrid_bm_half$1_0.iqmod_mfb_lpf_ota_core_spdt_switch$2_0.iqmod_mfb_lpf_ota_core_spdt_switch_inv$3_0.vout iqmod_mfb_lpf_0.iqmod_mfb_lpf_half_0.iqmod_mfb_lpf_R1$1_0.v_b 0.0237f
C64 iqmod_mfb_lpf_0.iqmod_mfb_lpf_half_0.iqmod_mfb_lpf_ota_core_hybrid_bm_half$1_0.iqmod_mfb_lpf_ota_core_inv_NF20$2_0.vout a_36939_2846# 0.01652f
C65 a_36939_10752# a_36939_11052# 0.71767f
C66 iqmod_mfb_lpf_0.iqmod_mfb_lpf_half_0.iqmod_mfb_lpf_ota_core_hybrid_bm_half$1_0.iqmod_mfb_lpf_ota_core_tg$2_0.v_b iqmod_mfb_lpf_0.iqmod_mfb_lpf_half_1.iqmod_mfb_lpf_ota_core_hybrid_bm_half$1_0.iqmod_mfb_lpf_ota_core_inv_NF20$2_1.vin 1.85127f
C67 iqmod_mfb_lpf_0.iqmod_mfb_lpf_half_0.C2_half a_24555_10752# 0.02756f
C68 a_17771_2246# a_17771_1946# 0.3708f
C69 iqmod_mixer_0.vinn_IF iqmod_mfb_lpf_0.iqmod_mfb_lpf_half_0.iqmod_mfb_lpf_ota_core_hybrid_bm_half$1_0.iqmod_mfb_lpf_ota_core_tg$2_0.v_b 24.245f
C70 a_23971_1946# iqmod_spdt_switch_0.v_c 0.06327f
C71 iqmod_mixer_0.iqmod_mixer_half_1.iqmod_mixer_se2diff$1_0.iqmod_mixer_se2diff_half_inv$2_0.iqmod_mixer_se2diff_inv_NF6$7_0.vin iqmod_mixer_0.iqmod_mixer_half_1.iqmod_mixer_se2diff$1_0.iqmod_mixer_se2diff_half_inv$2_0.iqmod_mixer_se2diff_inv_NF6$7_0.vout 1.47119f
C72 iqmod_spdt_switch_1.v_c iqmod_mfb_lpf_0.iqmod_mfb_lpf_half_0.iqmod_mfb_lpf_R3$1_0.v_a 1.4264f
C73 iqmod_mixer_0.vinn_IF iqmod_mfb_lpf_0.iqmod_mfb_lpf_half_0.iqmod_mfb_lpf_ota_core_hybrid_bm_half$1_0.iqmod_mfb_lpf_ota_core_inv_NF20$2_0.vout 22.0685f
C74 iqmod_mfb_lpf_0.iqmod_mfb_lpf_half_0.iqmod_mfb_lpf_ota_core_hybrid_bm_half$1_0.iqmod_mfb_lpf_ota_core_tg$2_0.di_tg_ctrl_n iqmod_mfb_lpf_0.iqmod_mfb_lpf_half_0.iqmod_mfb_lpf_ota_core_hybrid_bm_half$1_0.iqmod_mfb_lpf_ota_core_inv_NF6$2_1.vout 1.43086f
C75 a_11787_1946# a_11787_1646# 0.32295f
C76 a_24555_2246# iqmod_mixer_0.vinp_IF 0.04019f
C77 di_spdt_ctrl_I di_analog_en 0.08399f
C78 di_lo_Ix iqmod_spdt_switch_0.v_c 0.11202f
C79 iqmod_mfb_lpf_0.iqmod_mfb_lpf_half_0.C1_half iqmod_mfb_lpf_0.iqmod_mfb_lpf_half_1.iqmod_mfb_lpf_ota_core_hybrid_bm_half$1_0.iqmod_mfb_lpf_ota_core_tg$2_0.di_tg_ctrl_n 0.13553f
C80 vinp_I di_ds_I_p 0.84822f
C81 iqmod_mfb_lpf_0.iqmod_mfb_lpf_half_0.iqmod_mfb_lpf_ota_core_hybrid_bm_half$1_0.iqmod_mfb_lpf_ota_core_tg$2_0.di_tg_ctrl_n VDD 32.2565f
C82 a_11787_10752# VDD 0.02f
C83 iqmod_mixer_0.iqmod_mixer_half_0.iqmod_mixer_se2diff$1_0.iqmod_mixer_se2diff_half_inv$2_0.iqmod_mixer_se2diff_inv_NF6$7_0.vin iqmod_mixer_0.iqmod_mixer_half_0.iqmod_mixer_se2diff$1_0.iqmod_mixer_se2diff_half_inv$2_0.iqmod_mixer_se2diff_inv_NF6$7_0.vout 1.47119f
C84 a_36939_10752# VDD 0.08726f
C85 iqmod_mixer_0.iqmod_mixer_half_0.iqmod_mixer_se2diff$1_0.iqmod_mixer_se2diff_half_inv$2_0.iqmod_mixer_se2diff_inv_NF6$7_0.vout VDD 9.24859f
C86 iqmod_mfb_lpf_0.iqmod_mfb_lpf_half_0.C2_half iqmod_mfb_lpf_0.iqmod_mfb_lpf_half_1.iqmod_mfb_lpf_ota_core_hybrid_bm_half$1_0.iqmod_mfb_lpf_ota_core_tg$2_0.di_tg_ctrl_n 0.10091f
C87 iqmod_mfb_lpf_0.iqmod_mfb_lpf_half_0.iqmod_mfb_lpf_R3$1_0.v_a a_24555_10752# 0.46468f
C88 a_24469_2246# a_24555_2546# 0.01901f
C89 iqmod_spdt_switch_1.v_c a_11701_10752# 0.02535f
C90 iqmod_mfb_lpf_0.iqmod_mfb_lpf_half_0.iqmod_mfb_lpf_ota_core_hybrid_bm_half$1_0.iqmod_mfb_lpf_ota_core_tg$2_0.v_b iqmod_mfb_lpf_0.iqmod_mfb_lpf_half_0.iqmod_mfb_lpf_ota_core_hybrid_bm_half$1_0.iqmod_mfb_lpf_ota_core_inv_NF6$2_1.vout 11.0111f
C91 iqmod_mfb_lpf_0.iqmod_mfb_lpf_half_0.iqmod_mfb_lpf_ota_core_hybrid_bm_half$1_0.iqmod_mfb_lpf_ota_core_spdt_switch$2_0.iqmod_mfb_lpf_ota_core_spdt_switch_inv$3_0.vout VDD 7.58236f
C92 iqmod_mfb_lpf_0.iqmod_mfb_lpf_half_0.iqmod_mfb_lpf_ota_core_hybrid_bm_half$1_0.iqmod_mfb_lpf_ota_core_inv_NF20$2_0.vout iqmod_mfb_lpf_0.iqmod_mfb_lpf_half_0.iqmod_mfb_lpf_ota_core_hybrid_bm_half$1_0.iqmod_mfb_lpf_ota_core_inv_NF6$2_1.vout 37.0719f
C93 iqmod_mfb_lpf_0.iqmod_mfb_lpf_half_0.iqmod_mfb_lpf_ota_core_hybrid_bm_half$1_0.iqmod_mfb_lpf_ota_core_inv_NF20$2_1.vin iqmod_mfb_lpf_0.iqmod_mfb_lpf_half_0.iqmod_mfb_lpf_ota_core_hybrid_bm_half$1_0.iqmod_mfb_lpf_ota_core_tg$2_0.v_a 10.7435f
C94 a_36939_1946# iqmod_mixer_0.vinp_IF 0.07087f
C95 a_17771_2846# iqmod_mixer_0.vinp_IF 0.02469f
C96 iqmod_mfb_lpf_0.iqmod_mfb_lpf_half_0.iqmod_mfb_lpf_R3$1_0.v_a a_24469_10452# 0.0688f
C97 di_ds_I_n iqmod_spdt_switch_0.v_c 13.96185f
C98 iqmod_mfb_lpf_0.iqmod_mfb_lpf_half_0.iqmod_mfb_lpf_ota_core_hybrid_bm_half$1_0.iqmod_mfb_lpf_ota_core_tg$2_0.v_b VDD 75.8581f
C99 iqmod_mixer_0.iqmod_mixer_half_0.iqmod_mixer_se2diff$1_0.iqmod_mixer_se2diff_half_tg$2_0.iqmod_mixer_se2diff_inv_NF18$6_0.vin iqmod_mixer_0.iqmod_mixer_half_0.iqmod_mixer_se2diff$1_0.iqmod_mixer_se2diff_half_inv$2_0.iqmod_mixer_se2diff_inv_NF2$7_1.vout 1.42637f
C100 iqmod_mixer_0.iqmod_mixer_half_1.iqmod_mixer_tg$1_0.di_tg_ctrl_n iqmod_mixer_0.iqmod_mixer_half_1.iqmod_mixer_tg$1_0.di_tg_ctrl 1.75305f
C101 iqmod_mfb_lpf_0.iqmod_mfb_lpf_half_0.iqmod_mfb_lpf_ota_core_hybrid_bm_half$1_0.iqmod_mfb_lpf_ota_core_inv_NF20$2_0.vout VDD 51.8859f
C102 a_11787_2246# a_11787_1946# 0.32295f
C103 a_11701_1946# iqmod_mfb_lpf_0.iqmod_mfb_lpf_half_0.C1_half 0.01181f
C104 iqmod_spdt_switch_1.spdt_switch_inv_0.vin di_spdt_ctrl_I 0.55351f
C105 a_24555_2846# iqmod_mixer_0.vinp_IF 0.12245f
C106 VDD iqmod_spdt_switch_0.spdt_switch_inv_0.vin 7.88583f
C107 iqmod_mfb_lpf_0.iqmod_mfb_lpf_half_0.iqmod_mfb_lpf_R1$1_0.v_b iqmod_spdt_switch_0.v_c 0.18901f
C108 iqmod_mfb_lpf_0.iqmod_mfb_lpf_half_0.iqmod_mfb_lpf_R3$1_0.v_a iqmod_mfb_lpf_0.iqmod_mfb_lpf_half_1.iqmod_mfb_lpf_ota_core_hybrid_bm_half$1_0.iqmod_mfb_lpf_ota_core_tg$2_0.di_tg_ctrl_n 0.09776f
C109 a_17771_11352# di_lo_I 0.02516f
C110 iqmod_mixer_0.iqmod_mixer_half_1.iqmod_mixer_se2diff$1_0.iqmod_mixer_se2diff_half_inv$2_0.iqmod_mixer_se2diff_inv_NF6$7_0.vin di_lo_I 1.04865f
C111 iqmod_mixer_0.iqmod_mixer_half_0.iqmod_mixer_se2diff$1_0.iqmod_mixer_se2diff_half_inv$2_0.iqmod_mixer_se2diff_inv_NF6$7_1.vin VDD 13.6373f
C112 di_spdt_ctrl_I di_ds_I_n 0.01624f
C113 iqmod_mfb_lpf_0.iqmod_mfb_lpf_half_1.iqmod_mfb_lpf_ota_core_hybrid_bm_half$1_0.iqmod_mfb_lpf_ota_core_inv_NF20$2_1.vin iqmod_mfb_lpf_0.iqmod_mfb_lpf_half_0.C1_half 0.61765f
C114 a_17771_1946# iqmod_spdt_switch_0.v_c 0.26645f
C115 iqmod_mixer_0.vinn_IF iqmod_mfb_lpf_0.iqmod_mfb_lpf_half_0.C1_half 0.41142f
C116 a_48939_10452# a_36939_10452# 0.01901f
C117 iqmod_mfb_lpf_0.iqmod_mfb_lpf_half_0.C2_half iqmod_mfb_lpf_0.iqmod_mfb_lpf_half_1.iqmod_mfb_lpf_ota_core_hybrid_bm_half$1_0.iqmod_mfb_lpf_ota_core_inv_NF20$2_1.vin 0.33326f
C118 iqmod_mixer_0.iqmod_mixer_half_0.iqmod_mixer_tg$1_0.di_tg_ctrl_n iqmod_mixer_0.vinn_IF 8.19883f
C119 a_17771_11052# iqmod_spdt_switch_1.v_c 0.26719f
C120 iqmod_mixer_0.vinn_IF iqmod_mfb_lpf_0.iqmod_mfb_lpf_half_0.C2_half 0.91842f
C121 iqmod_spdt_switch_1.spdt_switch_inv_0.vin di_analog_en 0.3803f
C122 voutp_I_RF VDD 7.23337f
C123 a_36939_10752# a_36939_10452# 0.71767f
C124 iqmod_mixer_0.iqmod_mixer_half_0.iqmod_mixer_tg$1_0.di_tg_ctrl_n iqmod_mixer_0.iqmod_mixer_half_0.iqmod_mixer_tg$1_0.di_tg_ctrl 1.75305f
C125 iqmod_spdt_switch_1.v_c a_17685_10452# 0.04974f
C126 a_24555_11352# di_lo_I 0.05094f
C127 iqmod_mfb_lpf_0.iqmod_mfb_lpf_half_0.iqmod_mfb_lpf_ota_core_hybrid_bm_half$1_0.iqmod_mfb_lpf_ota_core_tg$2_0.v_a iqmod_mixer_0.vinp_IF 0.01512f
C128 di_analog_en di_ds_I_n 0.01562f
C129 iqmod_mfb_lpf_0.iqmod_mfb_lpf_half_1.iqmod_mfb_lpf_ota_core_hybrid_bm_half$1_0.iqmod_mfb_lpf_ota_core_inv_NF20$2_1.vin iqmod_mfb_lpf_0.iqmod_mfb_lpf_half_0.iqmod_mfb_lpf_R3$1_0.v_a 0.33201f
C130 a_36939_11352# a_36939_11052# 0.71767f
C131 iqmod_mixer_0.vinn_IF iqmod_mfb_lpf_0.iqmod_mfb_lpf_half_0.iqmod_mfb_lpf_R3$1_0.v_a 4.80131f
C132 a_36939_10752# a_36853_10752# 0.01901f
C133 iqmod_mixer_0.iqmod_mixer_half_0.iqmod_mixer_se2diff$1_0.iqmod_mixer_se2diff_half_tg$2_0.iqmod_mixer_se2diff_inv_NF18$6_0.vin iqmod_mixer_0.iqmod_mixer_half_0.iqmod_mixer_se2diff$1_0.iqmod_mixer_se2diff_half_tg$2_0.iqmod_mixer_se2diff_inv_NF54$6_0.vin 4.09415f
C134 iqmod_mfb_lpf_0.iqmod_mfb_lpf_half_0.C1_half VDD 3.19877f
C135 iqmod_mfb_lpf_0.iqmod_mfb_lpf_half_0.iqmod_mfb_lpf_R1$1_0.v_b di_analog_en 0.15881f
C136 iqmod_mixer_0.iqmod_mixer_half_0.iqmod_mixer_tg$1_0.di_tg_ctrl_n VDD 69.5869f
C137 iqmod_spdt_switch_1.v_c a_17771_10452# 0.25165f
C138 iqmod_mixer_0.iqmod_mixer_half_1.iqmod_mixer_tg$1_0.di_tg_ctrl_n iqmod_mixer_0.vinp_IF 8.19883f
C139 a_11787_10152# iqmod_mfb_lpf_0.iqmod_mfb_lpf_half_0.iqmod_mfb_lpf_R1$1_0.v_b 0.12216f
C140 a_36939_2246# a_36939_1946# 0.71767f
C141 iqmod_mfb_lpf_0.iqmod_mfb_lpf_half_0.C2_half VDD 2.64269f
C142 iqmod_mixer_0.iqmod_mixer_half_1.iqmod_mixer_se2diff$1_0.iqmod_mixer_se2diff_half_inv$2_0.iqmod_mixer_se2diff_inv_NF18$7_0.vin iqmod_mixer_0.iqmod_mixer_half_1.iqmod_mixer_se2diff$1_0.iqmod_mixer_se2diff_half_tg$2_0.iqmod_mixer_se2diff_inv_NF18$6_0.vin 0.01813f
C143 iqmod_mixer_0.iqmod_mixer_half_0.iqmod_mixer_se2diff$1_0.iqmod_mixer_se2diff_half_inv$2_0.iqmod_mixer_se2diff_inv_NF6$7_1.vin iqmod_mixer_0.iqmod_mixer_half_0.iqmod_mixer_se2diff$1_0.iqmod_mixer_se2diff_half_inv$2_0.iqmod_mixer_se2diff_inv_NF18$7_0.vin 1.432f
C144 a_17187_10452# iqmod_mfb_lpf_0.iqmod_mfb_lpf_half_0.iqmod_mfb_lpf_R1$1_0.v_b 0.03652f
C145 a_17771_10152# iqmod_mfb_lpf_0.iqmod_mfb_lpf_half_0.iqmod_mfb_lpf_R1$1_0.v_b 0.1132f
C146 iqmod_spdt_switch_1.v_c iqmod_mfb_lpf_0.iqmod_mfb_lpf_half_0.iqmod_mfb_lpf_ota_core_hybrid_bm_half$1_0.iqmod_mfb_lpf_ota_core_tg$2_0.v_a 0.01072f
C147 iqmod_mfb_lpf_0.iqmod_mfb_lpf_half_0.iqmod_mfb_lpf_R1$1_0.v_b di_lo_Ix 0.16802f
C148 a_17771_1946# a_23971_1946# 0.01901f
C149 a_17771_2246# iqmod_mfb_lpf_0.iqmod_mfb_lpf_half_0.C1_half 0.09927f
C150 iqmod_mfb_lpf_0.iqmod_mfb_lpf_half_0.iqmod_mfb_lpf_R3$1_0.v_a VDD 2.6398f
C151 iqmod_spdt_switch_0.v_c iqmod_spdt_switch_0.spdt_switch_inv_0.vin 1.77598f
C152 a_17771_2246# iqmod_mfb_lpf_0.iqmod_mfb_lpf_half_0.C2_half 0.0556f
C153 a_17771_1646# iqmod_mixer_0.vinp_IF 0.01957f
C154 iqmod_mfb_lpf_0.iqmod_mfb_lpf_half_0.C1_half a_11787_11352# 0.0329f
C155 iqmod_mfb_lpf_0.iqmod_mfb_lpf_half_1.iqmod_mfb_lpf_ota_core_hybrid_bm_half$1_0.iqmod_mfb_lpf_ota_core_spdt_switch$2_0.iqmod_mfb_lpf_ota_core_spdt_switch_inv$3_0.vout iqmod_mfb_lpf_0.iqmod_mfb_lpf_half_0.C1_half 0.04495f
C156 iqmod_mfb_lpf_0.iqmod_mfb_lpf_half_0.iqmod_mfb_lpf_R1$1_0.v_b a_17771_10752# 0.1078f
C157 iqmod_mixer_0.iqmod_mixer_half_0.iqmod_mixer_se2diff$1_0.iqmod_mixer_se2diff_half_tg$2_0.iqmod_mixer_se2diff_inv_NF54$6_0.vin voutn_I_RF 0.02709f
C158 a_11701_1946# a_11787_1946# 0.01901f
C159 iqmod_spdt_switch_1.v_c a_17771_11352# 0.1724f
C160 a_24555_1946# iqmod_mixer_0.vinp_IF 0.03036f
C161 iqmod_spdt_switch_1.v_c di_ds_I_p 13.96185f
C162 a_17187_2246# a_11787_2246# 0.01901f
C163 voutp_I_RF iqmod_mixer_0.iqmod_mixer_half_1.iqmod_mixer_se2diff$1_0.iqmod_mixer_se2diff_half_tg$2_0.iqmod_mixer_se2diff_inv_NF54$6_0.vin 0.02709f
C164 a_24555_11352# a_24555_11052# 0.70571f
C165 di_spdt_ctrl_I iqmod_spdt_switch_0.spdt_switch_inv_0.vin 0.55351f
C166 iqmod_mfb_lpf_0.iqmod_mfb_lpf_half_1.iqmod_mfb_lpf_ota_core_hybrid_bm_half$1_0.iqmod_mfb_lpf_ota_core_inv_NF20$2_1.vin a_17771_2846# 0.01348f
C167 a_17771_2246# iqmod_mfb_lpf_0.iqmod_mfb_lpf_half_0.iqmod_mfb_lpf_R3$1_0.v_a 0.03659f
C168 iqmod_mfb_lpf_0.iqmod_mfb_lpf_half_0.iqmod_mfb_lpf_ota_core_hybrid_bm_half$1_0.iqmod_mfb_lpf_ota_core_tg$2_0.di_tg_ctrl_n di_analog_en 1.12955f
C169 a_24555_11052# a_36355_10752# 0.01901f
C170 iqmod_mfb_lpf_0.iqmod_mfb_lpf_half_0.C2_half a_36939_2546# 0.04232f
C171 iqmod_mixer_0.iqmod_mixer_half_1.iqmod_mixer_tg$1_0.di_tg_ctrl iqmod_mixer_0.vinp_IF 6.62923f
C172 iqmod_mfb_lpf_0.iqmod_mfb_lpf_half_0.iqmod_mfb_lpf_ota_core_hybrid_bm_half$1_0.iqmod_mfb_lpf_ota_core_tg$2_0.v_a iqmod_mfb_lpf_0.iqmod_mfb_lpf_half_1.iqmod_mfb_lpf_ota_core_hybrid_bm_half$1_0.iqmod_mfb_lpf_ota_core_tg$2_0.di_tg_ctrl_n 1.38606f
C173 a_24555_2846# iqmod_mfb_lpf_0.iqmod_mfb_lpf_half_1.iqmod_mfb_lpf_ota_core_hybrid_bm_half$1_0.iqmod_mfb_lpf_ota_core_inv_NF20$2_1.vin 0.04124f
C174 iqmod_spdt_switch_1.v_c vinp_I 12.969f
C175 a_24555_10152# iqmod_mfb_lpf_0.iqmod_mfb_lpf_half_0.iqmod_mfb_lpf_ota_core_hybrid_bm_half$1_0.iqmod_mfb_lpf_ota_core_inv_NF20$2_1.vin 0.04124f
C176 di_lo_I iqmod_mixer_0.vinp_IF 0.57015f
C177 a_17771_1946# iqmod_mfb_lpf_0.iqmod_mfb_lpf_half_0.iqmod_mfb_lpf_R1$1_0.v_b 0.0315f
C178 a_11787_10752# a_17187_10452# 0.01901f
C179 a_24555_2246# VDD 0.04299f
C180 iqmod_mfb_lpf_0.iqmod_mfb_lpf_half_0.iqmod_mfb_lpf_ota_core_hybrid_bm_half$1_0.iqmod_mfb_lpf_ota_core_spdt_switch$2_0.iqmod_mfb_lpf_ota_core_spdt_switch_inv$3_0.vout di_analog_en 0.0847f
C181 iqmod_mfb_lpf_0.iqmod_mfb_lpf_half_0.iqmod_mfb_lpf_ota_core_hybrid_bm_half$1_0.iqmod_mfb_lpf_ota_core_tg$2_0.v_b di_analog_en 7.27796f
C182 iqmod_mfb_lpf_0.iqmod_mfb_lpf_half_0.iqmod_mfb_lpf_ota_core_hybrid_bm_half$1_0.iqmod_mfb_lpf_ota_core_spdt_switch$2_0.iqmod_mfb_lpf_ota_core_spdt_switch_inv$3_0.vout a_11787_10152# 0.01232f
C183 iqmod_mfb_lpf_0.iqmod_mfb_lpf_half_0.iqmod_mfb_lpf_ota_core_hybrid_bm_half$1_0.iqmod_mfb_lpf_ota_core_inv_NF20$2_0.vout di_analog_en 0.95997f
C184 di_analog_en iqmod_spdt_switch_0.spdt_switch_inv_0.vin 0.3803f
C185 a_36939_10452# iqmod_mfb_lpf_0.iqmod_mfb_lpf_half_0.iqmod_mfb_lpf_R3$1_0.v_a 0.04232f
C186 iqmod_mfb_lpf_0.iqmod_mfb_lpf_half_0.C1_half iqmod_spdt_switch_0.v_c 2.01927f
C187 iqmod_mixer_0.iqmod_mixer_half_1.iqmod_mixer_se2diff$1_0.iqmod_mixer_se2diff_half_inv$2_0.iqmod_mixer_se2diff_inv_NF6$7_1.vin iqmod_mixer_0.iqmod_mixer_half_1.iqmod_mixer_se2diff$1_0.iqmod_mixer_se2diff_half_inv$2_0.iqmod_mixer_se2diff_inv_NF2$7_1.vout 2.73056f
C188 iqmod_spdt_switch_1.spdt_switch_inv_0.vout di_ds_I_p 1.07601f
C189 iqmod_spdt_switch_1.v_c a_11787_11052# 0.03862f
C190 iqmod_mfb_lpf_0.iqmod_mfb_lpf_half_0.C2_half iqmod_spdt_switch_0.v_c 0.96311f
C191 a_36939_1946# VDD 0.05607f
C192 a_36355_10752# a_24555_10752# 0.01901f
C193 a_17771_2846# VDD 0.21216f
C194 a_11787_1946# VDD 0.0137f
C195 a_36939_1646# di_lo_Ix 0.0538f
C196 VDD iqmod_mixer_0.iqmod_mixer_half_1.iqmod_mixer_se2diff$1_0.iqmod_mixer_se2diff_half_tg$2_0.iqmod_mixer_se2diff_tg_NF6$3_0.v_b 4.31411f
C197 iqmod_mixer_0.iqmod_mixer_half_1.iqmod_mixer_se2diff$1_0.iqmod_mixer_se2diff_half_inv$2_0.iqmod_mixer_se2diff_inv_NF54$7_0.vin iqmod_mixer_0.iqmod_mixer_half_1.iqmod_mixer_tg$1_0.di_tg_ctrl 12.0097f
C198 a_24555_2846# VDD 0.38425f
C199 iqmod_spdt_switch_1.v_c di_lo_I 0.11299f
C200 iqmod_mfb_lpf_0.iqmod_mfb_lpf_half_1.iqmod_mfb_lpf_ota_core_hybrid_bm_half$1_0.iqmod_mfb_lpf_ota_core_inv_NF20$2_1.vin iqmod_mfb_lpf_0.iqmod_mfb_lpf_half_0.iqmod_mfb_lpf_ota_core_hybrid_bm_half$1_0.iqmod_mfb_lpf_ota_core_tg$2_0.v_a 10.7435f
C201 a_36853_10752# iqmod_mfb_lpf_0.iqmod_mfb_lpf_half_0.iqmod_mfb_lpf_R3$1_0.v_a 0.01934f
C202 iqmod_mfb_lpf_0.iqmod_mfb_lpf_half_0.iqmod_mfb_lpf_ota_core_hybrid_bm_half$1_0.iqmod_mfb_lpf_ota_core_inv_NF20$2_1.vin iqmod_spdt_switch_1.v_c 12.9702f
C203 iqmod_mixer_0.vinn_IF iqmod_mfb_lpf_0.iqmod_mfb_lpf_half_0.iqmod_mfb_lpf_ota_core_hybrid_bm_half$1_0.iqmod_mfb_lpf_ota_core_tg$2_0.v_a 0.01506f
C204 iqmod_mfb_lpf_0.iqmod_mfb_lpf_half_0.iqmod_mfb_lpf_ota_core_hybrid_bm_half$1_0.iqmod_mfb_lpf_ota_core_tg$2_0.di_tg_ctrl_n iqmod_mfb_lpf_0.iqmod_mfb_lpf_half_0.iqmod_mfb_lpf_R1$1_0.v_b 0.11862f
C205 a_24555_1646# di_lo_Ix 0.05046f
C206 iqmod_spdt_switch_1.spdt_switch_inv_0.vout vinp_I 1.09149f
C207 a_11787_10752# iqmod_mfb_lpf_0.iqmod_mfb_lpf_half_0.iqmod_mfb_lpf_R1$1_0.v_b 0.12777f
C208 a_11787_2546# iqmod_mfb_lpf_0.iqmod_mfb_lpf_half_0.C1_half 0.07082f
C209 iqmod_mixer_0.iqmod_mixer_half_1.iqmod_mixer_se2diff$1_0.iqmod_mixer_se2diff_half_inv$2_0.iqmod_mixer_se2diff_inv_NF18$7_0.vin iqmod_mixer_0.iqmod_mixer_half_1.iqmod_mixer_se2diff$1_0.iqmod_mixer_se2diff_half_inv$2_0.iqmod_mixer_se2diff_inv_NF54$7_0.vin 4.09415f
C210 iqmod_mfb_lpf_0.iqmod_mfb_lpf_half_0.iqmod_mfb_lpf_R3$1_0.v_a iqmod_spdt_switch_0.v_c 2.00157f
C211 iqmod_mfb_lpf_0.iqmod_mfb_lpf_half_0.iqmod_mfb_lpf_ota_core_hybrid_bm_half$1_0.iqmod_mfb_lpf_ota_core_spdt_switch$2_0.iqmod_mfb_lpf_ota_core_spdt_switch_inv$3_0.vout iqmod_mfb_lpf_0.iqmod_mfb_lpf_half_0.iqmod_mfb_lpf_R1$1_0.v_b 0.03798f
C212 di_ds_I_n iqmod_spdt_switch_0.spdt_switch_inv_0.vin 0.8151f
C213 a_17771_10452# VDD 0.01411f
C214 a_24555_2546# iqmod_mfb_lpf_0.iqmod_mfb_lpf_half_0.C2_half 0.82887f
C215 iqmod_mfb_lpf_0.iqmod_mfb_lpf_half_0.iqmod_mfb_lpf_ota_core_hybrid_bm_half$1_0.iqmod_mfb_lpf_ota_core_tg$2_0.v_b iqmod_mfb_lpf_0.iqmod_mfb_lpf_half_0.iqmod_mfb_lpf_R1$1_0.v_b 0.02501f
C216 a_17771_2246# a_17771_2546# 0.3708f
C217 iqmod_mixer_0.vinn_IF a_17771_11352# 0.02162f
C218 iqmod_mfb_lpf_0.iqmod_mfb_lpf_half_0.C1_half di_analog_en 0.18801f
C219 a_17771_2246# a_17685_2246# 0.01901f
C220 a_24469_2246# iqmod_mfb_lpf_0.iqmod_mfb_lpf_half_0.C2_half 0.0688f
C221 a_11787_10152# iqmod_mfb_lpf_0.iqmod_mfb_lpf_half_0.C1_half 0.03281f
C222 iqmod_mfb_lpf_0.iqmod_mfb_lpf_half_0.iqmod_mfb_lpf_ota_core_hybrid_bm_half$1_0.iqmod_mfb_lpf_ota_core_tg$2_0.v_a VDD 35.3535f
C223 iqmod_mfb_lpf_0.iqmod_mfb_lpf_half_0.C2_half di_analog_en 0.15668f
C224 a_17771_10152# iqmod_mfb_lpf_0.iqmod_mfb_lpf_half_0.C1_half 0.01023f
C225 iqmod_mfb_lpf_0.iqmod_mfb_lpf_half_0.C2_half a_23971_1946# 0.01929f
C226 a_24555_11352# iqmod_mixer_0.vinn_IF 0.02318f
C227 iqmod_mfb_lpf_0.iqmod_mfb_lpf_half_0.C2_half a_17771_10152# 0.02784f
C228 iqmod_mfb_lpf_0.iqmod_mfb_lpf_half_0.C1_half di_lo_Ix 0.18127f
C229 iqmod_mixer_0.iqmod_mixer_half_0.iqmod_mixer_se2diff$1_0.iqmod_mixer_se2diff_half_tg$2_0.iqmod_mixer_se2diff_inv_NF18$6_0.vin VDD 12.7551f
C230 iqmod_mixer_0.vinn_IF voutn_I_RF 0.13043p
C231 iqmod_mixer_0.iqmod_mixer_half_1.iqmod_mixer_tg$1_0.di_tg_ctrl_n VDD 69.5869f
C232 a_36939_10752# a_48939_10452# 0.01901f
C233 iqmod_mfb_lpf_0.iqmod_mfb_lpf_half_0.C2_half di_lo_Ix 0.14938f
C234 a_23971_10752# a_17771_10752# 0.01901f
C235 iqmod_mixer_0.iqmod_mixer_half_1.iqmod_mixer_se2diff$1_0.iqmod_mixer_se2diff_half_inv$2_0.iqmod_mixer_se2diff_inv_NF54$7_0.vin iqmod_mixer_0.vinp_IF 0.02693f
C236 iqmod_mixer_0.iqmod_mixer_half_1.iqmod_mixer_se2diff$1_0.iqmod_mixer_se2diff_half_inv$2_0.iqmod_mixer_se2diff_inv_NF6$7_0.vin VDD 10.5726f
C237 di_ds_I_p VDD 1.92838f
C238 iqmod_mfb_lpf_0.iqmod_mfb_lpf_half_0.iqmod_mfb_lpf_R3$1_0.v_a di_analog_en 0.15146f
C239 iqmod_mixer_0.iqmod_mixer_half_0.iqmod_mixer_tg$1_0.di_tg_ctrl voutn_I_RF 9.95187f
C240 iqmod_spdt_switch_1.v_c a_24555_11052# 0.04232f
C241 iqmod_mixer_0.iqmod_mixer_half_1.iqmod_mixer_se2diff$1_0.iqmod_mixer_se2diff_half_inv$2_0.iqmod_mixer_se2diff_inv_NF6$7_0.vout VDD 9.24859f
C242 iqmod_mfb_lpf_0.iqmod_mfb_lpf_half_0.C2_half a_17771_10752# 0.04268f
C243 iqmod_mfb_lpf_0.iqmod_mfb_lpf_half_0.C2_half m3_27149_1441# 0.22787f
C244 a_17771_2846# iqmod_spdt_switch_0.v_c 0.10857f
C245 iqmod_mfb_lpf_0.iqmod_mfb_lpf_half_0.iqmod_mfb_lpf_ota_core_hybrid_bm_half$1_0.iqmod_mfb_lpf_ota_core_tg$2_0.di_tg_ctrl_n iqmod_mfb_lpf_0.iqmod_mfb_lpf_half_0.iqmod_mfb_lpf_ota_core_hybrid_bm_half$1_0.iqmod_mfb_lpf_ota_core_spdt_switch$2_0.iqmod_mfb_lpf_ota_core_spdt_switch_inv$3_0.vout 1.34626f
C246 a_17771_10152# iqmod_mfb_lpf_0.iqmod_mfb_lpf_half_0.iqmod_mfb_lpf_R3$1_0.v_a 0.05899f
C247 a_11787_1946# iqmod_spdt_switch_0.v_c 0.03862f
C248 iqmod_mfb_lpf_0.iqmod_mfb_lpf_half_0.iqmod_mfb_lpf_ota_core_hybrid_bm_half$1_0.iqmod_mfb_lpf_ota_core_tg$2_0.di_tg_ctrl_n iqmod_mfb_lpf_0.iqmod_mfb_lpf_half_0.iqmod_mfb_lpf_ota_core_hybrid_bm_half$1_0.iqmod_mfb_lpf_ota_core_tg$2_0.v_b 1.96204f
C249 a_17771_2546# iqmod_spdt_switch_0.v_c 0.23938f
C250 vinp_I VDD 1.56491f
C251 iqmod_mfb_lpf_0.iqmod_mfb_lpf_half_0.iqmod_mfb_lpf_R3$1_0.v_a di_lo_Ix 0.10726f
C252 iqmod_mfb_lpf_0.iqmod_mfb_lpf_half_0.iqmod_mfb_lpf_ota_core_hybrid_bm_half$1_0.iqmod_mfb_lpf_ota_core_tg$2_0.di_tg_ctrl_n iqmod_mfb_lpf_0.iqmod_mfb_lpf_half_0.iqmod_mfb_lpf_ota_core_hybrid_bm_half$1_0.iqmod_mfb_lpf_ota_core_inv_NF20$2_0.vout 0.77311f
C253 iqmod_mfb_lpf_0.iqmod_mfb_lpf_half_0.iqmod_mfb_lpf_ota_core_hybrid_bm_half$1_0.iqmod_mfb_lpf_ota_core_inv_NF20$2_1.vin iqmod_mfb_lpf_0.iqmod_mfb_lpf_half_1.iqmod_mfb_lpf_ota_core_hybrid_bm_half$1_0.iqmod_mfb_lpf_ota_core_inv_NF20$2_1.vin 0.08649f
C254 a_11787_2846# VDD 0.16955f
C255 iqmod_mfb_lpf_0.iqmod_mfb_lpf_half_0.C1_half iqmod_mfb_lpf_0.iqmod_mfb_lpf_half_0.iqmod_mfb_lpf_R1$1_0.v_b 13.2125f
C256 a_24555_11052# a_24555_10752# 0.70571f
C257 iqmod_mixer_0.vinn_IF di_lo_I 0.10035f
C258 a_24555_10452# iqmod_mfb_lpf_0.iqmod_mfb_lpf_half_0.iqmod_mfb_lpf_R3$1_0.v_a 0.82887f
C259 a_36939_2246# iqmod_mixer_0.vinp_IF 0.01719f
C260 a_24555_2546# a_24555_2246# 0.70571f
C261 iqmod_mfb_lpf_0.iqmod_mfb_lpf_half_0.iqmod_mfb_lpf_ota_core_hybrid_bm_half$1_0.iqmod_mfb_lpf_ota_core_inv_NF20$2_1.vin iqmod_mixer_0.vinn_IF 18.4877f
C262 vinn_I iqmod_spdt_switch_0.spdt_switch_inv_0.vout 1.09149f
C263 voutn_I_RF VDD 7.23337f
C264 iqmod_mixer_0.vinp_IF iqmod_mfb_lpf_0.iqmod_mfb_lpf_half_1.iqmod_mfb_lpf_ota_core_hybrid_bm_half$1_0.iqmod_mfb_lpf_ota_core_tg$2_0.di_tg_ctrl_n 2.50645f
C265 iqmod_mfb_lpf_0.iqmod_mfb_lpf_half_0.C2_half iqmod_mfb_lpf_0.iqmod_mfb_lpf_half_0.iqmod_mfb_lpf_R1$1_0.v_b 1.12599f
C266 a_17685_2246# iqmod_spdt_switch_0.v_c 0.04974f
C267 a_17771_10752# iqmod_mfb_lpf_0.iqmod_mfb_lpf_half_0.iqmod_mfb_lpf_R3$1_0.v_a 0.04272f
C268 m3_27149_1441# iqmod_mfb_lpf_0.iqmod_mfb_lpf_half_0.iqmod_mfb_lpf_R3$1_0.v_a 0.03248f
C269 a_24555_1946# VDD 0.03006f
C270 a_24469_2246# a_24555_2246# 0.01901f
C271 a_17771_1946# iqmod_mfb_lpf_0.iqmod_mfb_lpf_half_0.C1_half 0.1281f
C272 iqmod_mixer_0.iqmod_mixer_half_0.iqmod_mixer_se2diff$1_0.iqmod_mixer_se2diff_half_inv$2_0.iqmod_mixer_se2diff_inv_NF6$7_1.vin iqmod_mixer_0.iqmod_mixer_half_0.iqmod_mixer_se2diff$1_0.iqmod_mixer_se2diff_half_inv$2_0.iqmod_mixer_se2diff_inv_NF6$7_0.vout 1.46378f
C273 iqmod_mfb_lpf_0.iqmod_mfb_lpf_half_0.iqmod_mfb_lpf_ota_core_hybrid_bm_half$1_0.iqmod_mfb_lpf_ota_core_tg$2_0.v_b iqmod_mfb_lpf_0.iqmod_mfb_lpf_half_0.iqmod_mfb_lpf_ota_core_hybrid_bm_half$1_0.iqmod_mfb_lpf_ota_core_inv_NF20$2_0.vout 0.01573f
C274 a_11787_11052# VDD 0.0137f
C275 iqmod_mixer_0.iqmod_mixer_half_0.iqmod_mixer_se2diff$1_0.iqmod_mixer_se2diff_half_tg$2_0.iqmod_mixer_se2diff_inv_NF18$6_0.vin iqmod_mixer_0.iqmod_mixer_half_0.iqmod_mixer_se2diff$1_0.iqmod_mixer_se2diff_half_inv$2_0.iqmod_mixer_se2diff_inv_NF18$7_0.vin 0.01813f
C276 iqmod_mixer_0.iqmod_mixer_half_1.iqmod_mixer_tg$1_0.di_tg_ctrl VDD 64.37611f
C277 iqmod_mixer_0.iqmod_mixer_half_0.iqmod_mixer_se2diff$1_0.iqmod_mixer_se2diff_half_inv$2_0.iqmod_mixer_se2diff_inv_NF2$7_1.vout VDD 13.7357f
C278 iqmod_spdt_switch_1.v_c a_24469_10452# 0.01853f
C279 VDD iqmod_mixer_0.iqmod_mixer_half_1.iqmod_mixer_se2diff$1_0.iqmod_mixer_se2diff_half_tg$2_0.iqmod_mixer_se2diff_inv_NF18$6_0.vin 12.7551f
C280 iqmod_mfb_lpf_0.iqmod_mfb_lpf_half_0.iqmod_mfb_lpf_R1$1_0.v_b iqmod_mfb_lpf_0.iqmod_mfb_lpf_half_0.iqmod_mfb_lpf_R3$1_0.v_a 0.01071f
C281 iqmod_mixer_0.iqmod_mixer_half_0.iqmod_mixer_se2diff$1_0.iqmod_mixer_se2diff_half_tg$2_0.iqmod_mixer_se2diff_tg_NF6$3_0.v_b iqmod_mixer_0.iqmod_mixer_half_0.iqmod_mixer_se2diff$1_0.iqmod_mixer_se2diff_half_inv$2_0.iqmod_mixer_se2diff_inv_NF2$7_1.vout 1.4633f
C282 iqmod_mfb_lpf_0.iqmod_mfb_lpf_half_1.iqmod_mfb_lpf_ota_core_hybrid_bm_half$1_0.iqmod_mfb_lpf_ota_core_spdt_switch$2_0.iqmod_mfb_lpf_ota_core_spdt_switch_inv$3_0.vout a_11787_2846# 0.01232f
C283 a_24555_2546# a_24555_2846# 0.70571f
C284 di_lo_I VDD 2.55037f
C285 iqmod_mfb_lpf_0.iqmod_mfb_lpf_half_0.iqmod_mfb_lpf_ota_core_hybrid_bm_half$1_0.iqmod_mfb_lpf_ota_core_tg$2_0.v_a iqmod_spdt_switch_0.v_c 0.01072f
C286 a_11701_1946# a_11787_2246# 0.01901f
C287 iqmod_mixer_0.iqmod_mixer_half_1.iqmod_mixer_se2diff$1_0.iqmod_mixer_se2diff_half_inv$2_0.iqmod_mixer_se2diff_inv_NF18$7_0.vin VDD 12.7834f
C288 iqmod_mfb_lpf_0.iqmod_mfb_lpf_half_0.iqmod_mfb_lpf_ota_core_hybrid_bm_half$1_0.iqmod_mfb_lpf_ota_core_inv_NF20$2_1.vin VDD 58.4869f
C289 a_36939_10152# iqmod_mixer_0.vinn_IF 0.063f
C290 iqmod_spdt_switch_1.v_c a_11787_10452# 0.29023f
C291 a_48939_2246# iqmod_mixer_0.vinp_IF 0.03212f
C292 iqmod_mixer_0.iqmod_mixer_half_1.iqmod_mixer_tg$1_0.di_tg_ctrl_n iqmod_mixer_0.iqmod_mixer_half_1.iqmod_mixer_se2diff$1_0.iqmod_mixer_se2diff_half_tg$2_0.iqmod_mixer_se2diff_inv_NF54$6_0.vin 12.0077f
C293 a_36939_2846# iqmod_mixer_0.vinp_IF 0.063f
C294 iqmod_spdt_switch_1.spdt_switch_inv_0.vout iqmod_spdt_switch_1.v_c 2.06116f
C295 a_24469_10452# a_24555_10752# 0.01901f
C296 a_24555_10152# iqmod_mixer_0.vinn_IF 0.12245f
C297 iqmod_mfb_lpf_0.iqmod_mfb_lpf_half_1.iqmod_mfb_lpf_ota_core_hybrid_bm_half$1_0.iqmod_mfb_lpf_ota_core_inv_NF20$2_1.vin iqmod_mixer_0.vinp_IF 18.4877f
C298 a_11701_10752# iqmod_mfb_lpf_0.iqmod_mfb_lpf_half_0.iqmod_mfb_lpf_R1$1_0.v_b 0.01181f
C299 iqmod_mixer_0.vinn_IF iqmod_mixer_0.vinp_IF 1.35199f
C300 iqmod_mfb_lpf_0.iqmod_mfb_lpf_half_0.iqmod_mfb_lpf_ota_core_hybrid_bm_half$1_0.iqmod_mfb_lpf_ota_core_tg$2_0.di_tg_ctrl_n iqmod_mfb_lpf_0.iqmod_mfb_lpf_half_0.C1_half 0.13043f
C301 a_11787_10752# iqmod_mfb_lpf_0.iqmod_mfb_lpf_half_0.C1_half 0.02351f
C302 a_11787_11052# a_11787_11352# 0.32295f
C303 iqmod_mfb_lpf_0.iqmod_mfb_lpf_half_0.iqmod_mfb_lpf_ota_core_hybrid_bm_half$1_0.iqmod_mfb_lpf_ota_core_tg$2_0.di_tg_ctrl_n iqmod_mfb_lpf_0.iqmod_mfb_lpf_half_0.C2_half 0.10115f
C304 a_36939_10152# iqmod_mfb_lpf_0.iqmod_mfb_lpf_half_0.iqmod_mfb_lpf_ota_core_hybrid_bm_half$1_0.iqmod_mfb_lpf_ota_core_inv_NF6$2_1.vout 0.01424f
C305 a_11787_11352# di_lo_I 0.02323f
C306 iqmod_mixer_0.vinn_IF a_24555_11052# 0.03036f
C307 iqmod_mfb_lpf_0.iqmod_mfb_lpf_half_0.iqmod_mfb_lpf_ota_core_hybrid_bm_half$1_0.iqmod_mfb_lpf_ota_core_spdt_switch$2_0.iqmod_mfb_lpf_ota_core_spdt_switch_inv$3_0.vout iqmod_mfb_lpf_0.iqmod_mfb_lpf_half_0.C1_half 0.03067f
C308 a_17771_11052# a_17771_10752# 0.3708f
C309 a_36939_10152# VDD 0.40596f
C310 iqmod_mfb_lpf_0.iqmod_mfb_lpf_half_0.iqmod_mfb_lpf_ota_core_hybrid_bm_half$1_0.iqmod_mfb_lpf_ota_core_tg$2_0.v_b iqmod_mfb_lpf_0.iqmod_mfb_lpf_half_0.C1_half 0.02501f
C311 iqmod_mfb_lpf_0.iqmod_mfb_lpf_half_0.iqmod_mfb_lpf_ota_core_hybrid_bm_half$1_0.iqmod_mfb_lpf_ota_core_inv_NF6$2_1.vout iqmod_mixer_0.vinp_IF 1.83884f
C312 iqmod_mfb_lpf_0.iqmod_mfb_lpf_half_0.C2_half a_36853_1946# 0.01934f
C313 a_17771_10752# a_17685_10452# 0.01901f
C314 di_spdt_ctrl_I di_ds_I_p 0.01624f
C315 iqmod_mfb_lpf_0.iqmod_mfb_lpf_half_0.iqmod_mfb_lpf_ota_core_hybrid_bm_half$1_0.iqmod_mfb_lpf_ota_core_tg$2_0.v_b iqmod_mfb_lpf_0.iqmod_mfb_lpf_half_0.C2_half 1.1806f
C316 iqmod_mixer_0.iqmod_mixer_half_0.iqmod_mixer_se2diff$1_0.iqmod_mixer_se2diff_half_inv$2_0.iqmod_mixer_se2diff_inv_NF2$7_1.vout iqmod_mixer_0.iqmod_mixer_half_0.iqmod_mixer_se2diff$1_0.iqmod_mixer_se2diff_half_inv$2_0.iqmod_mixer_se2diff_inv_NF18$7_0.vin 0.08082f
C317 a_24555_10152# VDD 0.38425f
C318 a_17771_1646# iqmod_spdt_switch_0.v_c 0.1688f
C319 iqmod_mixer_0.iqmod_mixer_half_0.iqmod_mixer_se2diff$1_0.iqmod_mixer_se2diff_half_tg$2_0.iqmod_mixer_se2diff_inv_NF54$6_0.vin VDD 35.9453f
C320 a_11787_2846# iqmod_spdt_switch_0.v_c 0.18764f
C321 iqmod_mfb_lpf_0.iqmod_mfb_lpf_half_0.iqmod_mfb_lpf_ota_core_hybrid_bm_half$1_0.iqmod_mfb_lpf_ota_core_tg$2_0.di_tg_ctrl_n iqmod_mfb_lpf_0.iqmod_mfb_lpf_half_0.iqmod_mfb_lpf_R3$1_0.v_a 0.09751f
C322 iqmod_mixer_0.iqmod_mixer_half_0.iqmod_mixer_se2diff$1_0.iqmod_mixer_se2diff_half_inv$2_0.iqmod_mixer_se2diff_inv_NF54$7_0.vin voutn_I_RF 0.03061f
C323 a_17771_10152# a_17771_10452# 0.3708f
C324 VDD iqmod_mixer_0.vinp_IF 77.865f
C325 iqmod_mixer_0.vinn_IF iqmod_spdt_switch_1.v_c 2.93983f
C326 iqmod_mfb_lpf_0.iqmod_mfb_lpf_half_0.iqmod_mfb_lpf_ota_core_hybrid_bm_half$1_0.iqmod_mfb_lpf_ota_core_tg$2_0.v_a di_analog_en 2.35658f
C327 a_17187_2246# iqmod_spdt_switch_0.v_c 0.04974f
C328 a_11787_2246# VDD 0.02f
C329 a_17771_11052# iqmod_mfb_lpf_0.iqmod_mfb_lpf_half_0.iqmod_mfb_lpf_R1$1_0.v_b 0.13974f
C330 iqmod_mfb_lpf_0.iqmod_mfb_lpf_half_0.C2_half a_24555_1646# 0.25811f
C331 iqmod_mfb_lpf_0.iqmod_mfb_lpf_half_0.iqmod_mfb_lpf_R1$1_0.v_b a_17771_2846# 0.03215f
C332 a_24555_1946# iqmod_spdt_switch_0.v_c 0.04232f
C333 a_11787_1946# iqmod_mfb_lpf_0.iqmod_mfb_lpf_half_0.iqmod_mfb_lpf_R1$1_0.v_b 0.0172f
C334 vinn_I VDD 1.56491f
C335 iqmod_mixer_0.iqmod_mixer_half_1.iqmod_mixer_se2diff$1_0.iqmod_mixer_se2diff_half_tg$2_0.iqmod_mixer_se2diff_inv_NF18$6_0.vin iqmod_mixer_0.iqmod_mixer_half_1.iqmod_mixer_se2diff$1_0.iqmod_mixer_se2diff_half_tg$2_0.iqmod_mixer_se2diff_inv_NF54$6_0.vin 4.09415f
C336 iqmod_mfb_lpf_0.iqmod_mfb_lpf_half_0.iqmod_mfb_lpf_R1$1_0.v_b a_17685_10452# 0.03901f
C337 a_17771_10152# iqmod_mfb_lpf_0.iqmod_mfb_lpf_half_0.iqmod_mfb_lpf_ota_core_hybrid_bm_half$1_0.iqmod_mfb_lpf_ota_core_tg$2_0.v_a 0.01489f
C338 di_spdt_ctrl_I vinp_I 0.12027f
C339 a_24555_11052# VDD 0.03006f
C340 iqmod_mixer_0.iqmod_mixer_half_1.iqmod_mixer_se2diff$1_0.iqmod_mixer_se2diff_half_inv$2_0.iqmod_mixer_se2diff_inv_NF2$7_1.vout iqmod_mixer_0.iqmod_mixer_half_1.iqmod_mixer_se2diff$1_0.iqmod_mixer_se2diff_half_tg$2_0.iqmod_mixer_se2diff_tg_NF6$3_0.v_b 1.4633f
C341 iqmod_mfb_lpf_0.iqmod_mfb_lpf_half_0.iqmod_mfb_lpf_ota_core_hybrid_bm_half$1_0.iqmod_mfb_lpf_ota_core_tg$2_0.v_b iqmod_mfb_lpf_0.iqmod_mfb_lpf_half_0.iqmod_mfb_lpf_R3$1_0.v_a 1.29189f
C342 a_17771_10752# a_17771_10452# 0.3708f
C343 iqmod_mixer_0.vinn_IF a_24555_10752# 0.04019f
C344 a_11787_10752# a_11701_10752# 0.01901f
C345 a_48939_2246# a_36939_2246# 0.01901f
C346 a_11787_2546# a_11787_2846# 0.32295f
C347 a_17771_2246# iqmod_mixer_0.vinp_IF 0.02251f
C348 di_analog_en di_ds_I_p 0.01562f
C349 a_36355_1946# iqmod_mfb_lpf_0.iqmod_mfb_lpf_half_0.C2_half 0.01934f
C350 a_24555_1646# iqmod_mfb_lpf_0.iqmod_mfb_lpf_half_0.iqmod_mfb_lpf_R3$1_0.v_a 0.0673f
C351 a_11787_2546# a_17187_2246# 0.01901f
C352 iqmod_spdt_switch_1.v_c VDD 4.78792f
C353 iqmod_mfb_lpf_0.iqmod_mfb_lpf_half_1.iqmod_mfb_lpf_ota_core_hybrid_bm_half$1_0.iqmod_mfb_lpf_ota_core_inv_NF20$2_1.vin iqmod_mfb_lpf_0.iqmod_mfb_lpf_half_1.iqmod_mfb_lpf_ota_core_hybrid_bm_half$1_0.iqmod_mfb_lpf_ota_core_tg$2_0.di_tg_ctrl_n 2.64211f
C354 a_36939_10152# a_36939_10452# 0.71767f
C355 iqmod_mfb_lpf_0.iqmod_mfb_lpf_half_0.iqmod_mfb_lpf_R1$1_0.v_b a_17771_10452# 0.03319f
C356 iqmod_mixer_0.iqmod_mixer_half_1.iqmod_mixer_se2diff$1_0.iqmod_mixer_se2diff_half_inv$2_0.iqmod_mixer_se2diff_inv_NF54$7_0.vin VDD 36.1841f
C357 di_analog_en vinp_I 0.07154f
C358 a_36939_2546# iqmod_mixer_0.vinp_IF 0.0164f
C359 iqmod_spdt_switch_1.spdt_switch_inv_0.vin di_ds_I_p 0.8151f
C360 VDD a_24555_10752# 0.04299f
C361 iqmod_mfb_lpf_0.iqmod_mfb_lpf_half_0.C2_half iqmod_mfb_lpf_0.iqmod_mfb_lpf_half_0.C1_half 0.54843f
C362 iqmod_mfb_lpf_0.iqmod_mfb_lpf_half_0.iqmod_mfb_lpf_R1$1_0.v_b iqmod_mfb_lpf_0.iqmod_mfb_lpf_half_0.iqmod_mfb_lpf_ota_core_hybrid_bm_half$1_0.iqmod_mfb_lpf_ota_core_tg$2_0.v_a 1.4773f
C363 a_11787_1646# iqmod_spdt_switch_0.v_c 0.02114f
C364 VDD iqmod_spdt_switch_0.spdt_switch_inv_0.vout 6.55002f
C365 iqmod_spdt_switch_1.v_c a_11787_11352# 0.02114f
C366 iqmod_mixer_0.iqmod_mixer_half_0.iqmod_mixer_se2diff$1_0.iqmod_mixer_se2diff_half_tg$2_0.iqmod_mixer_se2diff_inv_NF54$6_0.vin iqmod_mixer_0.iqmod_mixer_half_1.iqmod_mixer_se2diff$1_0.iqmod_mixer_se2diff_half_tg$2_0.iqmod_mixer_se2diff_inv_NF54$6_0.vin 0.02261f
C367 iqmod_mfb_lpf_0.iqmod_mfb_lpf_half_0.iqmod_mfb_lpf_ota_core_hybrid_bm_half$1_0.iqmod_mfb_lpf_ota_core_inv_NF6$2_1.vout iqmod_mfb_lpf_0.iqmod_mfb_lpf_half_1.iqmod_mfb_lpf_ota_core_hybrid_bm_half$1_0.iqmod_mfb_lpf_ota_core_tg$2_0.di_tg_ctrl_n 1.43086f
C368 a_17771_1646# di_lo_Ix 0.02339f
C369 a_36939_2246# VDD 0.08726f
C370 VDD a_11787_10452# 0.0145f
C371 iqmod_spdt_switch_1.spdt_switch_inv_0.vin vinp_I 1.17767f
C372 a_23971_10752# iqmod_mfb_lpf_0.iqmod_mfb_lpf_half_0.iqmod_mfb_lpf_R3$1_0.v_a 0.01929f
C373 iqmod_mixer_0.iqmod_mixer_half_0.iqmod_mixer_se2diff$1_0.iqmod_mixer_se2diff_half_inv$2_0.iqmod_mixer_se2diff_inv_NF54$7_0.vin iqmod_mixer_0.iqmod_mixer_half_0.iqmod_mixer_se2diff$1_0.iqmod_mixer_se2diff_half_tg$2_0.iqmod_mixer_se2diff_inv_NF54$6_0.vin 0.0557f
C374 VDD iqmod_mfb_lpf_0.iqmod_mfb_lpf_half_1.iqmod_mfb_lpf_ota_core_hybrid_bm_half$1_0.iqmod_mfb_lpf_ota_core_tg$2_0.di_tg_ctrl_n 32.2565f
C375 a_36853_1946# a_36939_1946# 0.01901f
C376 iqmod_mfb_lpf_0.iqmod_mfb_lpf_half_0.iqmod_mfb_lpf_R1$1_0.v_b a_17771_11352# 0.11143f
C377 iqmod_mfb_lpf_0.iqmod_mfb_lpf_half_0.C1_half iqmod_mfb_lpf_0.iqmod_mfb_lpf_half_0.iqmod_mfb_lpf_R3$1_0.v_a 0.06519f
C378 iqmod_spdt_switch_1.spdt_switch_inv_0.vout VDD 6.55002f
C379 a_36939_1946# a_36939_1646# 0.71767f
C380 iqmod_mixer_0.vinp_IF iqmod_spdt_switch_0.v_c 2.93139f
C381 iqmod_mfb_lpf_0.iqmod_mfb_lpf_half_0.C2_half iqmod_mfb_lpf_0.iqmod_mfb_lpf_half_0.iqmod_mfb_lpf_R3$1_0.v_a 8.20896f
C382 iqmod_mfb_lpf_0.iqmod_mfb_lpf_half_0.iqmod_mfb_lpf_ota_core_hybrid_bm_half$1_0.iqmod_mfb_lpf_ota_core_inv_NF20$2_1.vin di_analog_en 0.84832f
C383 a_11787_2246# iqmod_spdt_switch_0.v_c 0.08056f
C384 a_24555_2846# iqmod_mfb_lpf_0.iqmod_mfb_lpf_half_0.iqmod_mfb_lpf_ota_core_hybrid_bm_half$1_0.iqmod_mfb_lpf_ota_core_tg$2_0.v_b 0.04647f
C385 vinn_I iqmod_spdt_switch_0.v_c 12.969f
C386 a_24555_2246# a_36355_1946# 0.01901f
C387 iqmod_mixer_0.vinn_IF iqmod_mixer_0.iqmod_mixer_half_0.iqmod_mixer_tg$1_0.di_tg_ctrl 6.62923f
C388 iqmod_mixer_0.vinn_IF a_36939_11052# 0.07087f
C389 iqmod_mfb_lpf_0.iqmod_mfb_lpf_half_0.iqmod_mfb_lpf_ota_core_hybrid_bm_half$1_0.iqmod_mfb_lpf_ota_core_inv_NF20$2_1.vin a_17771_10152# 0.01348f
C390 a_17771_1646# iqmod_mfb_lpf_0.iqmod_mfb_lpf_half_0.iqmod_mfb_lpf_R1$1_0.v_b 0.03425f
C391 iqmod_mfb_lpf_0.iqmod_mfb_lpf_half_0.iqmod_mfb_lpf_R1$1_0.v_b a_11787_2846# 0.01294f
C392 a_36939_2846# iqmod_mfb_lpf_0.iqmod_mfb_lpf_half_0.iqmod_mfb_lpf_ota_core_hybrid_bm_half$1_0.iqmod_mfb_lpf_ota_core_inv_NF6$2_1.vout 0.01424f
C393 iqmod_mfb_lpf_0.iqmod_mfb_lpf_half_1.iqmod_mfb_lpf_ota_core_hybrid_bm_half$1_0.iqmod_mfb_lpf_ota_core_spdt_switch$2_0.iqmod_mfb_lpf_ota_core_spdt_switch_inv$3_0.vout iqmod_mfb_lpf_0.iqmod_mfb_lpf_half_1.iqmod_mfb_lpf_ota_core_hybrid_bm_half$1_0.iqmod_mfb_lpf_ota_core_tg$2_0.di_tg_ctrl_n 1.34626f
C394 iqmod_mfb_lpf_0.iqmod_mfb_lpf_half_0.iqmod_mfb_lpf_ota_core_hybrid_bm_half$1_0.iqmod_mfb_lpf_ota_core_tg$2_0.di_tg_ctrl_n iqmod_mfb_lpf_0.iqmod_mfb_lpf_half_0.iqmod_mfb_lpf_ota_core_hybrid_bm_half$1_0.iqmod_mfb_lpf_ota_core_tg$2_0.v_a 1.38606f
C395 a_36939_2846# VDD 0.40596f
C396 di_spdt_ctrl_I vinn_I 0.12027f
C397 iqmod_mixer_0.vinn_IF iqmod_mfb_lpf_0.iqmod_mfb_lpf_half_0.iqmod_mfb_lpf_ota_core_hybrid_bm_half$1_0.iqmod_mfb_lpf_ota_core_inv_NF6$2_1.vout 1.83884f
C398 iqmod_mixer_0.iqmod_mixer_half_1.iqmod_mixer_se2diff$1_0.iqmod_mixer_se2diff_half_inv$2_0.iqmod_mixer_se2diff_inv_NF54$7_0.vin iqmod_mixer_0.iqmod_mixer_half_1.iqmod_mixer_se2diff$1_0.iqmod_mixer_se2diff_half_tg$2_0.iqmod_mixer_se2diff_inv_NF54$6_0.vin 0.0557f
C399 a_17771_1946# a_17771_1646# 0.3708f
C400 a_11787_2546# a_11787_2246# 0.32295f
C401 iqmod_mixer_0.iqmod_mixer_half_1.iqmod_mixer_se2diff$1_0.iqmod_mixer_se2diff_half_inv$2_0.iqmod_mixer_se2diff_inv_NF6$7_0.vout iqmod_mixer_0.iqmod_mixer_half_1.iqmod_mixer_se2diff$1_0.iqmod_mixer_se2diff_half_inv$2_0.iqmod_mixer_se2diff_inv_NF6$7_1.vin 1.46378f
C402 iqmod_mfb_lpf_0.iqmod_mfb_lpf_half_1.iqmod_mfb_lpf_ota_core_hybrid_bm_half$1_0.iqmod_mfb_lpf_ota_core_inv_NF20$2_1.vin VDD 58.4869f
C403 a_36939_2546# a_36939_2246# 0.71767f
C404 iqmod_mixer_0.vinn_IF VDD 77.2839f
C405 a_11787_11052# iqmod_mfb_lpf_0.iqmod_mfb_lpf_half_0.iqmod_mfb_lpf_R1$1_0.v_b 0.17855f
C406 a_24555_2246# iqmod_mfb_lpf_0.iqmod_mfb_lpf_half_0.C2_half 0.46468f
C407 iqmod_mfb_lpf_0.iqmod_mfb_lpf_half_0.iqmod_mfb_lpf_ota_core_hybrid_bm_half$1_0.iqmod_mfb_lpf_ota_core_tg$2_0.v_b iqmod_mfb_lpf_0.iqmod_mfb_lpf_half_0.iqmod_mfb_lpf_ota_core_hybrid_bm_half$1_0.iqmod_mfb_lpf_ota_core_tg$2_0.v_a 37.0404f
C408 iqmod_mixer_0.iqmod_mixer_half_0.iqmod_mixer_tg$1_0.di_tg_ctrl VDD 64.37611f
C409 a_11787_1646# di_lo_Ix 0.02143f
C410 a_36939_11052# VDD 0.05607f
C411 iqmod_mixer_0.iqmod_mixer_half_1.iqmod_mixer_se2diff$1_0.iqmod_mixer_se2diff_half_inv$2_0.iqmod_mixer_se2diff_inv_NF2$7_1.vout iqmod_mixer_0.iqmod_mixer_half_1.iqmod_mixer_se2diff$1_0.iqmod_mixer_se2diff_half_tg$2_0.iqmod_mixer_se2diff_inv_NF18$6_0.vin 1.42637f
C412 di_analog_en iqmod_mixer_0.vinp_IF 2.37508f
C413 iqmod_mfb_lpf_0.iqmod_mfb_lpf_half_0.iqmod_mfb_lpf_R1$1_0.v_b di_lo_I 0.18787f
C414 a_17771_11052# a_23971_10752# 0.01901f
C415 iqmod_mfb_lpf_0.iqmod_mfb_lpf_half_0.iqmod_mfb_lpf_ota_core_hybrid_bm_half$1_0.iqmod_mfb_lpf_ota_core_inv_NF20$2_1.vin iqmod_mfb_lpf_0.iqmod_mfb_lpf_half_0.iqmod_mfb_lpf_R1$1_0.v_b 0.53488f
C416 iqmod_mfb_lpf_0.iqmod_mfb_lpf_half_0.C1_half a_17771_2846# 0.09628f
C417 iqmod_mixer_0.iqmod_mixer_half_1.iqmod_mixer_se2diff$1_0.iqmod_mixer_se2diff_half_inv$2_0.iqmod_mixer_se2diff_inv_NF18$7_0.vin iqmod_mixer_0.iqmod_mixer_half_1.iqmod_mixer_se2diff$1_0.iqmod_mixer_se2diff_half_inv$2_0.iqmod_mixer_se2diff_inv_NF2$7_1.vout 0.08082f
C418 a_11787_1946# iqmod_mfb_lpf_0.iqmod_mfb_lpf_half_0.C1_half 0.19074f
C419 vinn_I di_analog_en 0.07154f
C420 iqmod_mfb_lpf_0.iqmod_mfb_lpf_half_0.iqmod_mfb_lpf_ota_core_hybrid_bm_half$1_0.iqmod_mfb_lpf_ota_core_inv_NF6$2_1.vout VDD 26.3329f
C421 iqmod_spdt_switch_0.v_c iqmod_spdt_switch_0.spdt_switch_inv_0.vout 2.06116f
C422 iqmod_mfb_lpf_0.iqmod_mfb_lpf_half_0.C2_half a_17771_2846# 0.07442f
C423 a_24555_2246# iqmod_mfb_lpf_0.iqmod_mfb_lpf_half_0.iqmod_mfb_lpf_R3$1_0.v_a 0.02756f
C424 a_17771_2546# iqmod_mfb_lpf_0.iqmod_mfb_lpf_half_0.C1_half 0.03057f
C425 iqmod_mfb_lpf_0.iqmod_mfb_lpf_half_1.iqmod_mfb_lpf_ota_core_hybrid_bm_half$1_0.iqmod_mfb_lpf_ota_core_spdt_switch$2_0.iqmod_mfb_lpf_ota_core_spdt_switch_inv$3_0.vout iqmod_mfb_lpf_0.iqmod_mfb_lpf_half_1.iqmod_mfb_lpf_ota_core_hybrid_bm_half$1_0.iqmod_mfb_lpf_ota_core_inv_NF20$2_1.vin 2.05787f
C426 a_24555_10152# a_24555_10452# 0.70571f
C427 iqmod_mixer_0.iqmod_mixer_half_0.iqmod_mixer_se2diff$1_0.iqmod_mixer_se2diff_half_inv$2_0.iqmod_mixer_se2diff_inv_NF6$7_0.vin VDD 10.5726f
C428 a_24555_2846# iqmod_mfb_lpf_0.iqmod_mfb_lpf_half_0.C2_half 0.35902f
C429 di_lo_Ix iqmod_mixer_0.vinp_IF 0.05995f
C430 a_17771_2546# iqmod_mfb_lpf_0.iqmod_mfb_lpf_half_0.C2_half 0.20092f
C431 iqmod_mfb_lpf_0.iqmod_mfb_lpf_half_1.iqmod_mfb_lpf_ota_core_hybrid_bm_half$1_0.iqmod_mfb_lpf_ota_core_tg$2_0.di_tg_ctrl_n iqmod_spdt_switch_0.v_c 1.12442f
C432 a_36939_2546# a_48939_2246# 0.01901f
C433 iqmod_mixer_0.iqmod_mixer_half_0.iqmod_mixer_se2diff$1_0.iqmod_mixer_se2diff_half_inv$2_0.iqmod_mixer_se2diff_inv_NF6$7_0.vin iqmod_mixer_0.iqmod_mixer_half_0.iqmod_mixer_se2diff$1_0.iqmod_mixer_se2diff_half_tg$2_0.iqmod_mixer_se2diff_tg_NF6$3_0.v_b 7.58107f
C434 a_17685_2246# iqmod_mfb_lpf_0.iqmod_mfb_lpf_half_0.C1_half 0.03614f
C435 iqmod_mixer_0.iqmod_mixer_half_0.iqmod_mixer_se2diff$1_0.iqmod_mixer_se2diff_half_tg$2_0.iqmod_mixer_se2diff_tg_NF6$3_0.v_b VDD 4.31411f
C436 a_36939_2546# a_36939_2846# 0.71767f
C437 iqmod_mixer_0.iqmod_mixer_half_1.iqmod_mixer_se2diff$1_0.iqmod_mixer_se2diff_half_inv$2_0.iqmod_mixer_se2diff_inv_NF6$7_1.vin iqmod_mixer_0.iqmod_mixer_half_1.iqmod_mixer_se2diff$1_0.iqmod_mixer_se2diff_half_tg$2_0.iqmod_mixer_se2diff_inv_NF18$6_0.vin 0.06987f
C438 iqmod_mixer_0.iqmod_mixer_half_0.iqmod_mixer_se2diff$1_0.iqmod_mixer_se2diff_half_inv$2_0.iqmod_mixer_se2diff_inv_NF6$7_1.vin iqmod_mixer_0.iqmod_mixer_half_0.iqmod_mixer_se2diff$1_0.iqmod_mixer_se2diff_half_tg$2_0.iqmod_mixer_se2diff_inv_NF18$6_0.vin 0.06987f
C439 a_11787_1646# iqmod_mfb_lpf_0.iqmod_mfb_lpf_half_0.iqmod_mfb_lpf_R1$1_0.v_b 0.02288f
C440 iqmod_mixer_0.iqmod_mixer_half_1.iqmod_mixer_se2diff$1_0.iqmod_mixer_se2diff_half_inv$2_0.iqmod_mixer_se2diff_inv_NF18$7_0.vin iqmod_mixer_0.iqmod_mixer_half_1.iqmod_mixer_se2diff$1_0.iqmod_mixer_se2diff_half_inv$2_0.iqmod_mixer_se2diff_inv_NF6$7_1.vin 1.432f
C441 iqmod_spdt_switch_1.v_c di_analog_en 1.29771f
C442 a_17771_2846# iqmod_mfb_lpf_0.iqmod_mfb_lpf_half_0.iqmod_mfb_lpf_R3$1_0.v_a 0.02394f
C443 iqmod_mixer_0.vinn_IF a_36939_10452# 0.0164f
C444 a_11787_10152# iqmod_spdt_switch_1.v_c 0.18764f
C445 a_24555_2846# iqmod_mfb_lpf_0.iqmod_mfb_lpf_half_0.iqmod_mfb_lpf_R3$1_0.v_a 0.02113f
C446 a_11787_10752# a_11787_11052# 0.32295f
C447 iqmod_mfb_lpf_0.iqmod_mfb_lpf_half_0.C2_half a_17771_10452# 0.01928f
C448 a_17771_2246# VDD 0.02451f
C449 a_17187_10452# iqmod_spdt_switch_1.v_c 0.04974f
C450 iqmod_spdt_switch_1.v_c a_17771_10152# 0.11164f
C451 a_11701_1946# iqmod_spdt_switch_0.v_c 0.02535f
C452 iqmod_mixer_0.iqmod_mixer_half_1.iqmod_mixer_tg$1_0.di_tg_ctrl_n voutp_I_RF 9.96664f
C453 vinn_I di_ds_I_n 0.84822f
C454 iqmod_mfb_lpf_0.iqmod_mfb_lpf_half_0.C1_half iqmod_mfb_lpf_0.iqmod_mfb_lpf_half_0.iqmod_mfb_lpf_ota_core_hybrid_bm_half$1_0.iqmod_mfb_lpf_ota_core_tg$2_0.v_a 0.55183f
C455 iqmod_mfb_lpf_0.iqmod_mfb_lpf_half_1.iqmod_mfb_lpf_ota_core_hybrid_bm_half$1_0.iqmod_mfb_lpf_ota_core_spdt_switch$2_0.iqmod_mfb_lpf_ota_core_spdt_switch_inv$3_0.vout VDD 7.58236f
C456 iqmod_mfb_lpf_0.iqmod_mfb_lpf_half_0.iqmod_mfb_lpf_R1$1_0.v_b iqmod_mixer_0.vinp_IF 0.41142f
C457 iqmod_mfb_lpf_0.iqmod_mfb_lpf_half_0.iqmod_mfb_lpf_ota_core_hybrid_bm_half$1_0.iqmod_mfb_lpf_ota_core_tg$2_0.di_tg_ctrl_n iqmod_mfb_lpf_0.iqmod_mfb_lpf_half_0.iqmod_mfb_lpf_ota_core_hybrid_bm_half$1_0.iqmod_mfb_lpf_ota_core_inv_NF20$2_1.vin 2.64211f
C458 iqmod_mfb_lpf_0.iqmod_mfb_lpf_half_0.C2_half iqmod_mfb_lpf_0.iqmod_mfb_lpf_half_0.iqmod_mfb_lpf_ota_core_hybrid_bm_half$1_0.iqmod_mfb_lpf_ota_core_tg$2_0.v_a 0.26579f
C459 iqmod_spdt_switch_1.spdt_switch_inv_0.vin iqmod_spdt_switch_1.v_c 1.77598f
C460 a_24555_1946# a_24555_1646# 0.70571f
C461 iqmod_mfb_lpf_0.iqmod_mfb_lpf_half_1.iqmod_mfb_lpf_ota_core_hybrid_bm_half$1_0.iqmod_mfb_lpf_ota_core_inv_NF20$2_1.vin iqmod_spdt_switch_0.v_c 12.9702f
C462 iqmod_mixer_0.iqmod_mixer_half_0.iqmod_mixer_se2diff$1_0.iqmod_mixer_se2diff_half_inv$2_0.iqmod_mixer_se2diff_inv_NF54$7_0.vin iqmod_mixer_0.vinn_IF 0.02693f
C463 iqmod_spdt_switch_1.v_c a_17771_10752# 0.22279f
C464 a_36853_10752# a_36939_11052# 0.01901f
C465 a_17771_10452# iqmod_mfb_lpf_0.iqmod_mfb_lpf_half_0.iqmod_mfb_lpf_R3$1_0.v_a 0.16562f
C466 a_36939_2546# VDD 0.13335f
C467 a_36939_10452# VDD 0.13335f
C468 iqmod_mfb_lpf_0.iqmod_mfb_lpf_half_0.iqmod_mfb_lpf_ota_core_hybrid_bm_half$1_0.iqmod_mfb_lpf_ota_core_spdt_switch$2_0.iqmod_mfb_lpf_ota_core_spdt_switch_inv$3_0.vout iqmod_mfb_lpf_0.iqmod_mfb_lpf_half_0.iqmod_mfb_lpf_ota_core_hybrid_bm_half$1_0.iqmod_mfb_lpf_ota_core_inv_NF20$2_1.vin 2.05787f
C469 iqmod_mixer_0.iqmod_mixer_half_0.iqmod_mixer_se2diff$1_0.iqmod_mixer_se2diff_half_inv$2_0.iqmod_mixer_se2diff_inv_NF54$7_0.vin iqmod_mixer_0.iqmod_mixer_half_0.iqmod_mixer_tg$1_0.di_tg_ctrl 12.0097f
C470 iqmod_mfb_lpf_0.iqmod_mfb_lpf_half_0.C1_half a_17771_11352# 0.01165f
C471 iqmod_mixer_0.iqmod_mixer_half_0.iqmod_mixer_se2diff$1_0.iqmod_mixer_se2diff_half_inv$2_0.iqmod_mixer_se2diff_inv_NF18$7_0.vin VDD 12.7834f
C472 di_analog_en iqmod_mfb_lpf_0.iqmod_mfb_lpf_half_1.iqmod_mfb_lpf_ota_core_hybrid_bm_half$1_0.iqmod_mfb_lpf_ota_core_tg$2_0.di_tg_ctrl_n 1.12955f
C473 iqmod_mfb_lpf_0.iqmod_mfb_lpf_half_0.iqmod_mfb_lpf_ota_core_hybrid_bm_half$1_0.iqmod_mfb_lpf_ota_core_inv_NF20$2_1.vin iqmod_mfb_lpf_0.iqmod_mfb_lpf_half_0.iqmod_mfb_lpf_ota_core_hybrid_bm_half$1_0.iqmod_mfb_lpf_ota_core_tg$2_0.v_b 1.85127f
C474 a_24555_10452# a_24555_10752# 0.70571f
C475 a_11787_10152# a_11787_10452# 0.32295f
C476 iqmod_mfb_lpf_0.iqmod_mfb_lpf_half_0.C2_half a_17771_11352# 0.06322f
C477 iqmod_mfb_lpf_0.iqmod_mfb_lpf_half_0.iqmod_mfb_lpf_R3$1_0.v_a iqmod_mfb_lpf_0.iqmod_mfb_lpf_half_0.iqmod_mfb_lpf_ota_core_hybrid_bm_half$1_0.iqmod_mfb_lpf_ota_core_tg$2_0.v_a 0.239f
C478 iqmod_mixer_0.iqmod_mixer_half_0.iqmod_mixer_se2diff$1_0.iqmod_mixer_se2diff_half_inv$2_0.iqmod_mixer_se2diff_inv_NF6$7_1.vin iqmod_mixer_0.iqmod_mixer_half_0.iqmod_mixer_se2diff$1_0.iqmod_mixer_se2diff_half_inv$2_0.iqmod_mixer_se2diff_inv_NF2$7_1.vout 2.73056f
C479 a_36355_1946# a_24555_1946# 0.01901f
C480 a_24555_10452# a_24469_10452# 0.01901f
C481 a_17187_10452# a_11787_10452# 0.01901f
C482 iqmod_spdt_switch_1.v_c iqmod_mfb_lpf_0.iqmod_mfb_lpf_half_0.iqmod_mfb_lpf_R1$1_0.v_b 1.99062f
C483 VDD iqmod_mixer_0.iqmod_mixer_half_1.iqmod_mixer_se2diff$1_0.iqmod_mixer_se2diff_half_tg$2_0.iqmod_mixer_se2diff_inv_NF54$6_0.vin 35.9453f
C484 iqmod_mfb_lpf_0.iqmod_mfb_lpf_half_0.C1_half a_17771_1646# 0.10934f
C485 iqmod_mfb_lpf_0.iqmod_mfb_lpf_half_0.C1_half a_11787_2846# 0.13998f
C486 iqmod_mixer_0.iqmod_mixer_half_0.iqmod_mixer_se2diff$1_0.iqmod_mixer_se2diff_half_inv$2_0.iqmod_mixer_se2diff_inv_NF54$7_0.vin VDD 36.1841f
C487 iqmod_mixer_0.iqmod_mixer_half_1.iqmod_mixer_tg$1_0.di_tg_ctrl voutp_I_RF 9.95187f
C488 VDD iqmod_spdt_switch_0.v_c 4.76969f
C489 di_ds_I_n iqmod_spdt_switch_0.spdt_switch_inv_0.vout 1.07601f
C490 a_24555_11352# iqmod_mfb_lpf_0.iqmod_mfb_lpf_half_0.C2_half 0.0673f
C491 a_17771_2546# a_17771_2846# 0.3708f
C492 iqmod_spdt_switch_1.spdt_switch_inv_0.vout iqmod_spdt_switch_1.spdt_switch_inv_0.vin 1.10866f
C493 a_17187_2246# iqmod_mfb_lpf_0.iqmod_mfb_lpf_half_0.C1_half 0.03927f
C494 iqmod_mixer_0.iqmod_mixer_half_0.iqmod_mixer_tg$1_0.di_tg_ctrl_n voutn_I_RF 9.96664f
C495 a_36939_10152# iqmod_mfb_lpf_0.iqmod_mfb_lpf_half_0.iqmod_mfb_lpf_ota_core_hybrid_bm_half$1_0.iqmod_mfb_lpf_ota_core_inv_NF20$2_0.vout 0.01652f
C496 iqmod_mfb_lpf_0.iqmod_mfb_lpf_half_1.iqmod_mfb_lpf_ota_core_hybrid_bm_half$1_0.iqmod_mfb_lpf_ota_core_inv_NF20$2_1.vin di_analog_en 0.84832f
C497 iqmod_mfb_lpf_0.iqmod_mfb_lpf_half_0.C2_half a_24555_1946# 0.3204f
C498 a_24555_10152# iqmod_mfb_lpf_0.iqmod_mfb_lpf_half_0.iqmod_mfb_lpf_ota_core_hybrid_bm_half$1_0.iqmod_mfb_lpf_ota_core_tg$2_0.v_b 0.04647f
C499 iqmod_mixer_0.vinn_IF di_analog_en 2.37508f
C500 iqmod_mfb_lpf_0.iqmod_mfb_lpf_half_0.C1_half a_11787_11052# 0.03249f
C501 di_spdt_ctrl_I VDD 1.53261f
C502 iqmod_mfb_lpf_0.iqmod_mfb_lpf_half_0.iqmod_mfb_lpf_ota_core_hybrid_bm_half$1_0.iqmod_mfb_lpf_ota_core_tg$2_0.v_b iqmod_mixer_0.vinp_IF 24.245f
C503 iqmod_mfb_lpf_0.iqmod_mfb_lpf_half_0.iqmod_mfb_lpf_R1$1_0.v_b a_11787_10452# 0.07002f
C504 a_17685_2246# a_17771_2546# 0.01901f
C505 iqmod_mfb_lpf_0.iqmod_mfb_lpf_half_0.iqmod_mfb_lpf_R1$1_0.v_b iqmod_mfb_lpf_0.iqmod_mfb_lpf_half_1.iqmod_mfb_lpf_ota_core_hybrid_bm_half$1_0.iqmod_mfb_lpf_ota_core_tg$2_0.di_tg_ctrl_n 0.11362f
C506 a_17771_2246# iqmod_spdt_switch_0.v_c 0.21787f
C507 a_24555_11352# iqmod_mfb_lpf_0.iqmod_mfb_lpf_half_0.iqmod_mfb_lpf_R3$1_0.v_a 0.25837f
C508 a_17771_1646# iqmod_mfb_lpf_0.iqmod_mfb_lpf_half_0.iqmod_mfb_lpf_R3$1_0.v_a 0.04852f
C509 a_11787_2546# VDD 0.0145f
C510 iqmod_mfb_lpf_0.iqmod_mfb_lpf_half_0.iqmod_mfb_lpf_ota_core_hybrid_bm_half$1_0.iqmod_mfb_lpf_ota_core_inv_NF20$2_0.vout iqmod_mixer_0.vinp_IF 22.1388f
C511 iqmod_mixer_0.vinn_IF a_17771_10152# 0.02468f
C512 iqmod_mfb_lpf_0.iqmod_mfb_lpf_half_0.C1_half di_lo_I 0.10272f
C513 iqmod_mfb_lpf_0.iqmod_mfb_lpf_half_1.iqmod_mfb_lpf_ota_core_hybrid_bm_half$1_0.iqmod_mfb_lpf_ota_core_spdt_switch$2_0.iqmod_mfb_lpf_ota_core_spdt_switch_inv$3_0.vout iqmod_spdt_switch_0.v_c 1.07725f
C514 iqmod_mfb_lpf_0.iqmod_mfb_lpf_half_0.iqmod_mfb_lpf_ota_core_hybrid_bm_half$1_0.iqmod_mfb_lpf_ota_core_inv_NF20$2_1.vin iqmod_mfb_lpf_0.iqmod_mfb_lpf_half_0.C1_half 0.59812f
C515 a_17771_10452# a_17685_10452# 0.01901f
C516 iqmod_mfb_lpf_0.iqmod_mfb_lpf_half_0.iqmod_mfb_lpf_R3$1_0.v_a a_36355_10752# 0.01934f
C517 a_24555_1646# iqmod_mixer_0.vinp_IF 0.02318f
C518 a_24555_1946# iqmod_mfb_lpf_0.iqmod_mfb_lpf_half_0.iqmod_mfb_lpf_R3$1_0.v_a 0.04612f
C519 voutn_I_RF VSS 4.45448f
C520 di_lo_Ix VSS 17.9383f
C521 di_ds_I_n VSS 1.20364f
C522 vinn_I VSS 0.78351f
C523 voutp_I_RF VSS 4.45448f
C524 di_analog_en VSS 44.0909f
C525 di_ds_I_p VSS 1.20364f
C526 vinp_I VSS 0.78351f
C527 di_spdt_ctrl_I VSS 2.51476f
C528 di_lo_I VSS 18.2008f
C529 VDD VSS 0.15405p
C530 m3_27149_1441# VSS 0.1545f $ **FLOATING
C531 a_36939_1646# VSS 7.87022f $ **FLOATING
C532 a_24555_1646# VSS 7.73096f $ **FLOATING
C533 a_36939_1946# VSS 6.2999f $ **FLOATING
C534 a_17771_1646# VSS 4.08028f $ **FLOATING
C535 a_24555_1946# VSS 6.1949f $ **FLOATING
C536 a_11787_1646# VSS 3.56763f $ **FLOATING
C537 a_36939_2246# VSS 6.27738f $ **FLOATING
C538 a_36853_1946# VSS 0.29587f
C539 a_17771_1946# VSS 3.25499f $ **FLOATING
C540 a_36355_1946# VSS 0.29587f
C541 a_24555_2246# VSS 6.16404f $ **FLOATING
C542 iqmod_mfb_lpf_0.iqmod_mfb_lpf_half_0.C1_half VSS 13.3875f
C543 a_11787_1946# VSS 2.84388f $ **FLOATING
C544 a_48939_2246# VSS 0.317f
C545 a_36939_2546# VSS 6.30877f $ **FLOATING
C546 a_23971_1946# VSS 0.29587f
C547 a_17771_2246# VSS 3.23892f $ **FLOATING
C548 a_24555_2546# VSS 6.1949f $ **FLOATING
C549 a_24469_2246# VSS 0.29587f
C550 a_11787_2246# VSS 2.82992f $ **FLOATING
C551 a_11701_1946# VSS 0.317f
C552 a_36939_2846# VSS 7.40475f $ **FLOATING
C553 iqmod_mfb_lpf_0.iqmod_mfb_lpf_half_0.C2_half VSS 14.9485f
C554 a_17771_2546# VSS 3.25499f $ **FLOATING
C555 a_17685_2246# VSS 0.29587f
C556 a_24555_2846# VSS 7.26941f $ **FLOATING
C557 a_17187_2246# VSS 0.29587f
C558 a_11787_2546# VSS 2.83501f $ **FLOATING
C559 a_17771_2846# VSS 3.84371f $ **FLOATING
C560 a_11787_2846# VSS 3.39002f $ **FLOATING
C561 iqmod_mixer_0.iqmod_mixer_half_0.iqmod_mixer_se2diff$1_0.iqmod_mixer_se2diff_half_inv$2_0.iqmod_mixer_se2diff_inv_NF54$7_0.vin VSS 19.357f
C562 iqmod_mixer_0.iqmod_mixer_half_0.iqmod_mixer_se2diff$1_0.iqmod_mixer_se2diff_half_inv$2_0.iqmod_mixer_se2diff_inv_NF18$7_0.vin VSS 6.57195f
C563 iqmod_mixer_0.iqmod_mixer_half_0.iqmod_mixer_se2diff$1_0.iqmod_mixer_se2diff_half_inv$2_0.iqmod_mixer_se2diff_inv_NF6$7_0.vout VSS 3.83821f
C564 iqmod_mixer_0.iqmod_mixer_half_0.iqmod_mixer_tg$1_0.di_tg_ctrl VSS 26.5896f
C565 iqmod_mixer_0.iqmod_mixer_half_0.iqmod_mixer_tg$1_0.di_tg_ctrl_n VSS 28.0115f
C566 iqmod_mixer_0.iqmod_mixer_half_0.iqmod_mixer_se2diff$1_0.iqmod_mixer_se2diff_half_tg$2_0.iqmod_mixer_se2diff_inv_NF54$6_0.vin VSS 21.4871f
C567 iqmod_mixer_0.iqmod_mixer_half_0.iqmod_mixer_se2diff$1_0.iqmod_mixer_se2diff_half_tg$2_0.iqmod_mixer_se2diff_inv_NF18$6_0.vin VSS 6.89995f
C568 iqmod_mixer_0.iqmod_mixer_half_0.iqmod_mixer_se2diff$1_0.iqmod_mixer_se2diff_half_inv$2_0.iqmod_mixer_se2diff_inv_NF6$7_1.vin VSS 6.12851f
C569 iqmod_mixer_0.iqmod_mixer_half_0.iqmod_mixer_se2diff$1_0.iqmod_mixer_se2diff_half_inv$2_0.iqmod_mixer_se2diff_inv_NF2$7_1.vout VSS 6.25201f
C570 iqmod_mixer_0.iqmod_mixer_half_0.iqmod_mixer_se2diff$1_0.iqmod_mixer_se2diff_half_tg$2_0.iqmod_mixer_se2diff_tg_NF6$3_0.v_b VSS 3.47796f
C571 iqmod_mixer_0.iqmod_mixer_half_0.iqmod_mixer_se2diff$1_0.iqmod_mixer_se2diff_half_inv$2_0.iqmod_mixer_se2diff_inv_NF6$7_0.vin VSS 5.87993f
C572 iqmod_mfb_lpf_0.iqmod_mfb_lpf_half_1.iqmod_mfb_lpf_ota_core_hybrid_bm_half$1_0.iqmod_mfb_lpf_ota_core_inv_NF20$2_1.vin VSS 23.6137f
C573 iqmod_mfb_lpf_0.iqmod_mfb_lpf_half_1.iqmod_mfb_lpf_ota_core_hybrid_bm_half$1_0.iqmod_mfb_lpf_ota_core_spdt_switch$2_0.iqmod_mfb_lpf_ota_core_spdt_switch_inv$3_0.vout VSS 2.59994f
C574 iqmod_mfb_lpf_0.iqmod_mfb_lpf_half_1.iqmod_mfb_lpf_ota_core_hybrid_bm_half$1_0.iqmod_mfb_lpf_ota_core_tg$2_0.di_tg_ctrl_n VSS 3.9232f
C575 iqmod_spdt_switch_0.v_c VSS 10.82915f
C576 iqmod_spdt_switch_0.spdt_switch_inv_0.vout VSS 2.70354f
C577 iqmod_spdt_switch_0.spdt_switch_inv_0.vin VSS 3.62355f
C578 iqmod_mixer_0.iqmod_mixer_half_1.iqmod_mixer_se2diff$1_0.iqmod_mixer_se2diff_half_tg$2_0.iqmod_mixer_se2diff_inv_NF54$6_0.vin VSS 21.4871f
C579 iqmod_mixer_0.iqmod_mixer_half_1.iqmod_mixer_se2diff$1_0.iqmod_mixer_se2diff_half_tg$2_0.iqmod_mixer_se2diff_inv_NF18$6_0.vin VSS 6.89995f
C580 iqmod_mixer_0.iqmod_mixer_half_1.iqmod_mixer_se2diff$1_0.iqmod_mixer_se2diff_half_tg$2_0.iqmod_mixer_se2diff_tg_NF6$3_0.v_b VSS 3.47796f
C581 iqmod_mixer_0.vinp_IF VSS 39.7678f
C582 iqmod_mfb_lpf_0.iqmod_mfb_lpf_half_0.iqmod_mfb_lpf_ota_core_hybrid_bm_half$1_0.iqmod_mfb_lpf_ota_core_inv_NF20$2_0.vout VSS 20.4596f
C583 iqmod_mfb_lpf_0.iqmod_mfb_lpf_half_0.iqmod_mfb_lpf_ota_core_hybrid_bm_half$1_0.iqmod_mfb_lpf_ota_core_inv_NF6$2_1.vout VSS 12.5149f
C584 iqmod_mfb_lpf_0.iqmod_mfb_lpf_half_0.iqmod_mfb_lpf_ota_core_hybrid_bm_half$1_0.iqmod_mfb_lpf_ota_core_tg$2_0.v_b VSS 43.0148f
C585 iqmod_mfb_lpf_0.iqmod_mfb_lpf_half_0.iqmod_mfb_lpf_ota_core_hybrid_bm_half$1_0.iqmod_mfb_lpf_ota_core_tg$2_0.v_a VSS 15.2091f
C586 iqmod_mfb_lpf_0.iqmod_mfb_lpf_half_0.iqmod_mfb_lpf_ota_core_hybrid_bm_half$1_0.iqmod_mfb_lpf_ota_core_inv_NF20$2_1.vin VSS 23.6137f
C587 iqmod_mfb_lpf_0.iqmod_mfb_lpf_half_0.iqmod_mfb_lpf_ota_core_hybrid_bm_half$1_0.iqmod_mfb_lpf_ota_core_spdt_switch$2_0.iqmod_mfb_lpf_ota_core_spdt_switch_inv$3_0.vout VSS 2.59994f
C588 iqmod_mfb_lpf_0.iqmod_mfb_lpf_half_0.iqmod_mfb_lpf_ota_core_hybrid_bm_half$1_0.iqmod_mfb_lpf_ota_core_tg$2_0.di_tg_ctrl_n VSS 3.9232f
C589 iqmod_spdt_switch_1.spdt_switch_inv_0.vout VSS 2.70354f
C590 iqmod_spdt_switch_1.spdt_switch_inv_0.vin VSS 3.62355f
C591 iqmod_mixer_0.iqmod_mixer_half_1.iqmod_mixer_tg$1_0.di_tg_ctrl_n VSS 28.0115f
C592 iqmod_mixer_0.iqmod_mixer_half_1.iqmod_mixer_tg$1_0.di_tg_ctrl VSS 26.5896f
C593 iqmod_mixer_0.iqmod_mixer_half_1.iqmod_mixer_se2diff$1_0.iqmod_mixer_se2diff_half_inv$2_0.iqmod_mixer_se2diff_inv_NF54$7_0.vin VSS 19.357f
C594 iqmod_mixer_0.iqmod_mixer_half_1.iqmod_mixer_se2diff$1_0.iqmod_mixer_se2diff_half_inv$2_0.iqmod_mixer_se2diff_inv_NF18$7_0.vin VSS 6.57195f
C595 iqmod_mixer_0.iqmod_mixer_half_1.iqmod_mixer_se2diff$1_0.iqmod_mixer_se2diff_half_inv$2_0.iqmod_mixer_se2diff_inv_NF2$7_1.vout VSS 6.25201f
C596 iqmod_mixer_0.iqmod_mixer_half_1.iqmod_mixer_se2diff$1_0.iqmod_mixer_se2diff_half_inv$2_0.iqmod_mixer_se2diff_inv_NF6$7_1.vin VSS 6.12851f
C597 iqmod_mixer_0.iqmod_mixer_half_1.iqmod_mixer_se2diff$1_0.iqmod_mixer_se2diff_half_inv$2_0.iqmod_mixer_se2diff_inv_NF6$7_0.vout VSS 3.83821f
C598 iqmod_mixer_0.iqmod_mixer_half_1.iqmod_mixer_se2diff$1_0.iqmod_mixer_se2diff_half_inv$2_0.iqmod_mixer_se2diff_inv_NF6$7_0.vin VSS 5.87993f
C599 a_36939_10152# VSS 7.40475f $ **FLOATING
C600 a_24555_10152# VSS 7.26941f $ **FLOATING
C601 a_36939_10452# VSS 6.30877f $ **FLOATING
C602 a_17771_10152# VSS 3.84371f $ **FLOATING
C603 a_24555_10452# VSS 6.1949f $ **FLOATING
C604 a_11787_10152# VSS 3.39635f $ **FLOATING
C605 a_48939_10452# VSS 0.317f
C606 a_36939_10752# VSS 6.27738f $ **FLOATING
C607 iqmod_mfb_lpf_0.iqmod_mfb_lpf_half_0.iqmod_mfb_lpf_R3$1_0.v_a VSS 14.3672f
C608 a_17771_10452# VSS 3.25499f $ **FLOATING
C609 a_24555_10752# VSS 6.16404f $ **FLOATING
C610 a_24469_10452# VSS 0.29587f
C611 a_11787_10452# VSS 2.83501f $ **FLOATING
C612 iqmod_spdt_switch_1.v_c VSS 10.87015f
C613 iqmod_mixer_0.vinn_IF VSS 39.6658f
C614 a_36939_11052# VSS 6.2999f $ **FLOATING
C615 a_36853_10752# VSS 0.29587f
C616 a_17771_10752# VSS 3.23892f $ **FLOATING
C617 a_17685_10452# VSS 0.29587f
C618 a_36355_10752# VSS 0.29587f
C619 a_24555_11052# VSS 6.1949f $ **FLOATING
C620 a_17187_10452# VSS 0.29587f
C621 a_11787_10752# VSS 2.82992f $ **FLOATING
C622 a_36939_11352# VSS 7.87022f $ **FLOATING
C623 a_23971_10752# VSS 0.29587f
C624 a_17771_11052# VSS 3.25499f $ **FLOATING
C625 a_24555_11352# VSS 7.73096f $ **FLOATING
C626 iqmod_mfb_lpf_0.iqmod_mfb_lpf_half_0.iqmod_mfb_lpf_R1$1_0.v_b VSS 13.5213f
C627 a_11787_11052# VSS 2.84388f $ **FLOATING
C628 a_11701_10752# VSS 0.317f
C629 a_17771_11352# VSS 4.08028f $ **FLOATING
C630 a_11787_11352# VSS 3.56763f $ **FLOATING
.ends
