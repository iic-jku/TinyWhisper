** sch_path: /foss/designs/TinyWhisper/ihp130/macros/iqmod/schematic/xschem/iqmod_mfb_lpf_ota_core_inv_NF20.sch
.subckt iqmod_mfb_lpf_ota_core_inv_NF20 VDD vin vout VSS
*.PININFO vin:I VDD:B VSS:B vout:B
MMdummy1 VSS VSS VSS VSS sg13_lv_nmos w=2.0u l=1.0u ng=2
MMdummy2 VDD VDD VDD VDD sg13_lv_pmos w=12.0u l=1.0u ng=2
MM1 vout vin VSS VSS sg13_lv_nmos w=20.0u l=1.0u ng=20
MM2 vout vin VDD VDD sg13_lv_pmos w=120.0u l=1.0u ng=20
.ends
