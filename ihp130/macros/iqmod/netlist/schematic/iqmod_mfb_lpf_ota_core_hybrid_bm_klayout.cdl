** sch_path: /foss/designs/TinyWhisper/ihp130/macros/iqmod/schematic/xschem/iqmod_mfb_lpf_ota_core_hybrid_bm.sch
.subckt iqmod_mfb_lpf_ota_core_hybrid_bm voutp voutn vinn vinp VDD VSS di_ota_en
*.PININFO vinp:I vinn:I VDD:B VSS:B voutp:O voutn:O di_ota_en:I
x6 VDD node_CDG voutn VSS iqmod_mfb_lpf_ota_core_inv_NF20
x7 VDD node_CDG voutp VSS iqmod_mfb_lpf_ota_core_inv_NF20
x11 VDD voutn node_EF VSS iqmod_mfb_lpf_ota_core_inv_NF20
x12 VDD voutp node_EF VSS iqmod_mfb_lpf_ota_core_inv_NF20
x9 VDD node_vinp node_BC VSS iqmod_mfb_lpf_ota_core_inv_NF10
x10 VDD node_vinn node_BC VSS iqmod_mfb_lpf_ota_core_inv_NF10
x5 VDD node_EF node_FG VSS iqmod_mfb_lpf_ota_core_inv_NF6
x1 VDD node_BC node_CDG VSS iqmod_mfb_lpf_ota_core_inv_NF6
x4 VDD node_BC node_CDG VSS iqmod_mfb_lpf_ota_core_inv_NF6
x13 VDD node_EF node_FG VSS iqmod_mfb_lpf_ota_core_inv_NF6
x8 VDD node_FG node_CDG VSS iqmod_mfb_lpf_ota_core_inv_NF6
x14 VDD node_FG node_CDG VSS iqmod_mfb_lpf_ota_core_inv_NF6
x2 VDD node_vinp voutn VSS iqmod_mfb_lpf_ota_core_inv_NF20
x3 VDD node_vinn voutp VSS iqmod_mfb_lpf_ota_core_inv_NF20
x16 ota_en_n_1 VDD di_ota_en VSS node_vinp VDD vinp iqmod_mfb_lpf_ota_core_spdt_switch
x17 ota_en_n_2 VDD di_ota_en VSS node_vinn VDD vinn iqmod_mfb_lpf_ota_core_spdt_switch
x15 VDD di_ota_en VSS node_CDG node_BC ota_en_n_1 iqmod_mfb_lpf_ota_core_tg
x18 VDD di_ota_en VSS node_FG node_EF ota_en_n_1 iqmod_mfb_lpf_ota_core_tg
x20 VDD di_ota_en VSS node_CDG node_BC ota_en_n_2 iqmod_mfb_lpf_ota_core_tg
x23 VDD di_ota_en VSS node_FG node_EF ota_en_n_2 iqmod_mfb_lpf_ota_core_tg
.ends

* expanding   symbol:  iqmod_mfb_lpf_ota_core_inv_NF20.sym # of pins=4
** sym_path: /foss/designs/TinyWhisper/.claude/worktrees/magical-kare-6a0ff5/ihp130/macros/iqmod/schematic/xschem/iqmod_mfb_lpf_ota_core_inv_NF20.sym
** sch_path: /foss/designs/TinyWhisper/.claude/worktrees/magical-kare-6a0ff5/ihp130/macros/iqmod/schematic/xschem/iqmod_mfb_lpf_ota_core_inv_NF20.sch
.subckt iqmod_mfb_lpf_ota_core_inv_NF20 VDD vin vout VSS
*.PININFO vin:I VDD:B VSS:B vout:B
MMdummy1 VSS VSS VSS VSS sg13_lv_nmos w=2.0u l=1.0u ng=2
MMdummy2 VDD VDD VDD VDD sg13_lv_pmos w=12.0u l=1.0u ng=2
MM1 vout vin VSS VSS sg13_lv_nmos w=20.0u l=1.0u ng=20
MM2 vout vin VDD VDD sg13_lv_pmos w=120.0u l=1.0u ng=20
.ends

* expanding   symbol:  iqmod_mfb_lpf_ota_core_inv_NF10.sym # of pins=4
** sym_path: /foss/designs/TinyWhisper/.claude/worktrees/magical-kare-6a0ff5/ihp130/macros/iqmod/schematic/xschem/iqmod_mfb_lpf_ota_core_inv_NF10.sym
** sch_path: /foss/designs/TinyWhisper/.claude/worktrees/magical-kare-6a0ff5/ihp130/macros/iqmod/schematic/xschem/iqmod_mfb_lpf_ota_core_inv_NF10.sch
.subckt iqmod_mfb_lpf_ota_core_inv_NF10 VDD vin vout VSS
*.PININFO vin:I VDD:B VSS:B vout:B
MM1 vout vin VSS VSS sg13_lv_nmos w=10.0u l=1.0u ng=10
MM2 vout vin VDD VDD sg13_lv_pmos w=60.0u l=1.0u ng=10
MMdummy1 VSS VSS VSS VSS sg13_lv_nmos w=2.0u l=1.0u ng=2
MMdummy2 VDD VDD VDD VDD sg13_lv_pmos w=12.0u l=1.0u ng=2
.ends

* expanding   symbol:  iqmod_mfb_lpf_ota_core_inv_NF6.sym # of pins=4
** sym_path: /foss/designs/TinyWhisper/.claude/worktrees/magical-kare-6a0ff5/ihp130/macros/iqmod/schematic/xschem/iqmod_mfb_lpf_ota_core_inv_NF6.sym
** sch_path: /foss/designs/TinyWhisper/.claude/worktrees/magical-kare-6a0ff5/ihp130/macros/iqmod/schematic/xschem/iqmod_mfb_lpf_ota_core_inv_NF6.sch
.subckt iqmod_mfb_lpf_ota_core_inv_NF6 VDD vin vout VSS
*.PININFO vin:I VDD:B VSS:B vout:B
MMdummy1 VSS VSS VSS VSS sg13_lv_nmos w=2.0u l=1.0u ng=2
MMdummy2 VDD VDD VDD VDD sg13_lv_pmos w=12.0u l=1.0u ng=2
MM1 vout vin VSS VSS sg13_lv_nmos w=6.0u l=1.0u ng=6
MM2 vout vin VDD VDD sg13_lv_pmos w=36.0u l=1.0u ng=6
.ends

* expanding   symbol:  iqmod_mfb_lpf_ota_core_spdt_switch.sym # of pins=7
** sym_path: /foss/designs/TinyWhisper/.claude/worktrees/magical-kare-6a0ff5/ihp130/macros/iqmod/schematic/xschem/iqmod_mfb_lpf_ota_core_spdt_switch.sym
** sch_path: /foss/designs/TinyWhisper/.claude/worktrees/magical-kare-6a0ff5/ihp130/macros/iqmod/schematic/xschem/iqmod_mfb_lpf_ota_core_spdt_switch.sch
.subckt iqmod_mfb_lpf_ota_core_spdt_switch do_spdt_ctrl_n VDD di_spdt_ctrl VSS v_c v_b v_a
*.PININFO v_a:B v_b:B v_c:B VDD:B VSS:B di_spdt_ctrl:I do_spdt_ctrl_n:O
x1 VDD di_spdt_ctrl do_spdt_ctrl_n VSS iqmod_mfb_lpf_ota_core_spdt_switch_inv
x2 VDD do_spdt_ctrl_n spdt_ctrl_buf VSS iqmod_mfb_lpf_ota_core_spdt_switch_inv
x3 VDD spdt_ctrl_buf VSS v_c v_a do_spdt_ctrl_n iqmod_mfb_lpf_ota_core_spdt_switch_tg
x4 VDD do_spdt_ctrl_n VSS v_c v_b spdt_ctrl_buf iqmod_mfb_lpf_ota_core_spdt_switch_tg
.ends

* expanding   symbol:  iqmod_mfb_lpf_ota_core_tg.sym # of pins=6
** sym_path: /foss/designs/TinyWhisper/.claude/worktrees/magical-kare-6a0ff5/ihp130/macros/iqmod/schematic/xschem/iqmod_mfb_lpf_ota_core_tg.sym
** sch_path: /foss/designs/TinyWhisper/.claude/worktrees/magical-kare-6a0ff5/ihp130/macros/iqmod/schematic/xschem/iqmod_mfb_lpf_ota_core_tg.sch
.subckt iqmod_mfb_lpf_ota_core_tg VDD di_tg_ctrl VSS v_b v_a di_tg_ctrl_n
*.PININFO v_a:B v_b:B VDD:B VSS:B di_tg_ctrl:I di_tg_ctrl_n:I
MM2 v_a di_tg_ctrl_n v_b VDD sg13_lv_pmos w=36.0u l=0.13u ng=6
MM1 v_a di_tg_ctrl v_b VSS sg13_lv_nmos w=6.0u l=0.13u ng=6
.ends

* expanding   symbol:  iqmod_mfb_lpf_ota_core_spdt_switch_inv.sym # of pins=4
** sym_path: /foss/designs/TinyWhisper/.claude/worktrees/magical-kare-6a0ff5/ihp130/macros/iqmod/schematic/xschem/iqmod_mfb_lpf_ota_core_spdt_switch_inv.sym
** sch_path: /foss/designs/TinyWhisper/.claude/worktrees/magical-kare-6a0ff5/ihp130/macros/iqmod/schematic/xschem/iqmod_mfb_lpf_ota_core_spdt_switch_inv.sch
.subckt iqmod_mfb_lpf_ota_core_spdt_switch_inv VDD vin vout VSS
*.PININFO vin:I VDD:B VSS:B vout:B
MM1 vout vin VSS VSS sg13_lv_nmos w=2.0u l=0.13u ng=2
MM2 vout vin VDD VDD sg13_lv_pmos w=12.0u l=0.13u ng=2
MMdummy1 VSS VSS VSS VSS sg13_lv_nmos w=2.0u l=0.13u ng=2
MMdummy2 VDD VDD VDD VDD sg13_lv_pmos w=12.0u l=0.13u ng=2
.ends

* expanding   symbol:  iqmod_mfb_lpf_ota_core_spdt_switch_tg.sym # of pins=6
** sym_path: /foss/designs/TinyWhisper/.claude/worktrees/magical-kare-6a0ff5/ihp130/macros/iqmod/schematic/xschem/iqmod_mfb_lpf_ota_core_spdt_switch_tg.sym
** sch_path: /foss/designs/TinyWhisper/.claude/worktrees/magical-kare-6a0ff5/ihp130/macros/iqmod/schematic/xschem/iqmod_mfb_lpf_ota_core_spdt_switch_tg.sch
.subckt iqmod_mfb_lpf_ota_core_spdt_switch_tg VDD di_tg_ctrl VSS v_b v_a di_tg_ctrl_n
*.PININFO v_a:B v_b:B VDD:B VSS:B di_tg_ctrl:I di_tg_ctrl_n:I
MM2 v_a di_tg_ctrl_n v_b VDD sg13_lv_pmos w=36.0u l=0.13u ng=6
MM1 v_a di_tg_ctrl v_b VSS sg13_lv_nmos w=6.0u l=0.13u ng=6
.ends
