** sch_path: /foss/designs/TinyWhisper/ihp130/macros/iqmod/schematic/iqmod_mfb_lpf_R1.sch
.subckt iqmod_mfb_lpf_R1 v_b v_a VSS
*.PININFO v_a:B v_b:B VSS:B
XR1 v_a net1 VSS rhigh w=0.5e-6 l=27.0e-6 m=1 b=0 mm_ok=1
XR2 net1 net2 VSS rhigh w=0.5e-6 l=27.0e-6 m=1 b=0 mm_ok=1
XR3 net2 v_b VSS rhigh w=0.5e-6 l=27.0e-6 m=1 b=0 mm_ok=1
XRdummy1 VSS VSS VSS rhigh w=0.5e-6 l=27.0e-6 m=1 b=0 mm_ok=1
XRdummy2 VSS VSS VSS rhigh w=0.5e-6 l=27.0e-6 m=1 b=0 mm_ok=1
.ends
