** sch_path: /foss/designs/TinyWhisper/ihp130/macros/iqmod/schematic/iqmod_mixer.sch
.subckt iqmod_mixer vinp_IF vinn_IF voutp_RF vinp_LO vinn_LO VDD VSS voutn_RF
*.PININFO VDD:B VSS:B vinp_IF:I vinn_IF:I voutp_RF:B vinp_LO:I vinn_LO:I voutn_RF:B
x2 VDD vinp_LO_buf VSS voutp_RF vinp_IF vinp_LO_inv iqmod_mixer_tg
x4 VDD vinn_LO_buf VSS voutn_RF vinn_IF vinn_LO_inv iqmod_mixer_tg
x1 VDD vinp_LO vinp_LO_buf VSS vinp_LO_inv iqmod_mixer_se2diff
x3 VDD vinn_LO vinn_LO_buf VSS vinn_LO_inv iqmod_mixer_se2diff
.ends

* expanding   symbol:  iqmod_mixer_tg.sym # of pins=6
** sym_path: schematic/iqmod_mixer_tg.sym
** sch_path: /foss/designs/TinyWhisper/ihp130/macros/iqmod/schematic/iqmod_mixer_tg.sch
.subckt iqmod_mixer_tg VDD di_tg_ctrl VSS v_b v_a di_tg_ctrl_n
*.PININFO v_a:B v_b:B di_tg_ctrl:I di_tg_ctrl_n:I VDD:B VSS:B
XM1 v_a di_tg_ctrl v_b VSS sg13_lv_nmos w=108.0u l=0.13u ng=36 m=1 mm_ok=1
XM2 v_a di_tg_ctrl_n v_b VDD sg13_lv_pmos w=324.0u l=0.13u ng=36 m=1 mm_ok=1
XMdummy2 v_b di_tg_ctrl v_b VDD sg13_lv_pmos w=162.0u l=0.13u ng=18 m=1 mm_ok=1
XMdummy1 v_b di_tg_ctrl_n v_b VSS sg13_lv_nmos w=54.0u l=0.13u ng=18 m=1 mm_ok=1
.ends

* expanding   symbol:  iqmod_mixer_se2diff.sym # of pins=5
** sym_path: schematic/iqmod_mixer_se2diff.sym
** sch_path: /foss/designs/TinyWhisper/ihp130/macros/iqmod/schematic/iqmod_mixer_se2diff.sch
.subckt iqmod_mixer_se2diff VDD vin voutp VSS voutn
*.PININFO vin:I VDD:B VSS:B voutp:O voutn:O
x3 VDD VDD VSS net2 vse VSS iqmod_mixer_se2diff_tg_NF6
x8 VDD vscale1n vscale2p VSS iqmod_mixer_se2diff_inv_NF18
x5 VDD vcrossp vcrossn VSS iqmod_mixer_se2diff_inv_NF2
x6 VDD vcrossn vcrossp VSS iqmod_mixer_se2diff_inv_NF2
x2 VDD net1 vcrossp VSS iqmod_mixer_se2diff_inv_NF6
x4 VDD net2 vcrossn VSS iqmod_mixer_se2diff_inv_NF6
x7 VDD vcrossp vscale1n VSS iqmod_mixer_se2diff_inv_NF6
x1 VDD vse net1 VSS iqmod_mixer_se2diff_inv_NF6
x9 VDD vscale2p voutp VSS iqmod_mixer_se2diff_inv_NF54
x10 VDD vcrossn vscale1p VSS iqmod_mixer_se2diff_inv_NF6
x11 VDD vscale1p vscale2n VSS iqmod_mixer_se2diff_inv_NF18
x12 VDD vscale2n voutn VSS iqmod_mixer_se2diff_inv_NF54
x13 VDD vin vse VSS iqmod_mixer_se2diff_inv_NF2
x14 VDD vin vse VSS iqmod_mixer_se2diff_inv_NF2
.ends

* expanding   symbol:  iqmod_mixer_se2diff_tg_NF6.sym # of pins=6
** sym_path: schematic/iqmod_mixer_se2diff_tg_NF6.sym
** sch_path: /foss/designs/TinyWhisper/ihp130/macros/iqmod/schematic/iqmod_mixer_se2diff_tg_NF6.sch
.subckt iqmod_mixer_se2diff_tg_NF6 VDD di_tg_ctrl VSS v_b v_a di_tg_ctrl_n
*.PININFO v_a:B v_b:B VDD:B VSS:B di_tg_ctrl:I di_tg_ctrl_n:I
XM2 v_a di_tg_ctrl_n v_b VDD sg13_lv_pmos w=18.0u l=0.13u ng=6 m=1 mm_ok=1
XM1 v_a di_tg_ctrl v_b VSS sg13_lv_nmos w=6.0u l=0.13u ng=6 m=1 mm_ok=1
.ends

* expanding   symbol:  iqmod_mixer_se2diff_inv_NF18.sym # of pins=4
** sym_path: schematic/iqmod_mixer_se2diff_inv_NF18.sym
** sch_path: /foss/designs/TinyWhisper/ihp130/macros/iqmod/schematic/iqmod_mixer_se2diff_inv_NF18.sch
.subckt iqmod_mixer_se2diff_inv_NF18 VDD vin vout VSS
*.PININFO vin:I VDD:B VSS:B vout:B
XM1 vout vin VSS VSS sg13_lv_nmos w=18.0u l=0.13u ng=18 m=1 mm_ok=1
XM2 vout vin VDD VDD sg13_lv_pmos w=54.0u l=0.13u ng=18 m=1 mm_ok=1
XMdummy1 VSS VSS VSS VSS sg13_lv_nmos w=2.0u l=0.13u ng=2 m=1 mm_ok=1
XMdummy2 VDD VDD VDD VDD sg13_lv_pmos w=6.0u l=0.13u ng=2 m=1 mm_ok=1
.ends

* expanding   symbol:  iqmod_mixer_se2diff_inv_NF2.sym # of pins=4
** sym_path: schematic/iqmod_mixer_se2diff_inv_NF2.sym
** sch_path: /foss/designs/TinyWhisper/ihp130/macros/iqmod/schematic/iqmod_mixer_se2diff_inv_NF2.sch
.subckt iqmod_mixer_se2diff_inv_NF2 VDD vin vout VSS
*.PININFO vin:I VDD:B VSS:B vout:B
XM1 vout vin VSS VSS sg13_lv_nmos w=2.0u l=0.13u ng=2 m=1 mm_ok=1
XM2 vout vin VDD VDD sg13_lv_pmos w=6.0u l=0.13u ng=2 m=1 mm_ok=1
XMdummy1 VSS VSS VSS VSS sg13_lv_nmos w=2.0u l=0.13u ng=2 m=1 mm_ok=1
XMdummy2 VDD VDD VDD VDD sg13_lv_pmos w=6.0u l=0.13u ng=2 m=1 mm_ok=1
.ends

* expanding   symbol:  iqmod_mixer_se2diff_inv_NF6.sym # of pins=4
** sym_path: schematic/iqmod_mixer_se2diff_inv_NF6.sym
** sch_path: /foss/designs/TinyWhisper/ihp130/macros/iqmod/schematic/iqmod_mixer_se2diff_inv_NF6.sch
.subckt iqmod_mixer_se2diff_inv_NF6 VDD vin vout VSS
*.PININFO vin:I VDD:B VSS:B vout:B
XM1 vout vin VSS VSS sg13_lv_nmos w=6.0u l=0.13u ng=6 m=1 mm_ok=1
XM2 vout vin VDD VDD sg13_lv_pmos w=18.0u l=0.13u ng=6 m=1 mm_ok=1
XMdummy1 VSS VSS VSS VSS sg13_lv_nmos w=2.0u l=0.13u ng=2 m=1 mm_ok=1
XMdummy2 VDD VDD VDD VDD sg13_lv_pmos w=6.0u l=0.13u ng=2 m=1 mm_ok=1
.ends

* expanding   symbol:  iqmod_mixer_se2diff_inv_NF54.sym # of pins=4
** sym_path: schematic/iqmod_mixer_se2diff_inv_NF54.sym
** sch_path: /foss/designs/TinyWhisper/ihp130/macros/iqmod/schematic/iqmod_mixer_se2diff_inv_NF54.sch
.subckt iqmod_mixer_se2diff_inv_NF54 VDD vin vout VSS
*.PININFO vin:I VDD:B VSS:B vout:B
XM1 vout vin VSS VSS sg13_lv_nmos w=54.0u l=0.13u ng=54 m=1 mm_ok=1
XM2 vout vin VDD VDD sg13_lv_pmos w=162.0u l=0.13u ng=54 m=1 mm_ok=1
XMdummy1 VSS VSS VSS VSS sg13_lv_nmos w=2.0u l=0.13u ng=2 m=1 mm_ok=1
XMdummy2 VDD VDD VDD VDD sg13_lv_pmos w=6.0u l=0.13u ng=2 m=1 mm_ok=1
.ends
