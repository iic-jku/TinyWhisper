** sch_path: /foss/designs/TinyWhisper/ihp130/macros/iqmod/schematic/xschem/iqmod_mixer_se2diff_inv_NF54.sch
.subckt iqmod_mixer_se2diff_inv_NF54 VDD vin vout VSS
*.PININFO vin:I VDD:B VSS:B vout:B
MM1 vout vin VSS VSS sg13_lv_nmos w=54.0u l=0.13u ng=54
MM2 vout vin VDD VDD sg13_lv_pmos w=162.0u l=0.13u ng=54
MMdummy1 VSS VSS VSS VSS sg13_lv_nmos w=2.0u l=0.13u ng=2
MMdummy2 VDD VDD VDD VDD sg13_lv_pmos w=6.0u l=0.13u ng=2
.ends
