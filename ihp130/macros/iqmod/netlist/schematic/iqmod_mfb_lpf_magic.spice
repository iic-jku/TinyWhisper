** sch_path: /foss/designs/TinyWhisper/ihp130/macros/iqmod/schematic/iqmod_mfb_lpf.sch
.subckt iqmod_mfb_lpf voutp vinp voutn vinn VDD VSS di_filter_en
*.PININFO VDD:B VSS:B vinp:I vinn:I voutp:O voutn:O di_filter_en:I
x1 voutp voutn vinn_ota vinp_ota VDD VSS di_filter_en iqmod_mfb_lpf_ota_core_hybrid_bm
XC1a vinp_stage1 vinn_stage1 cap_cmim w=8.0e-6 l=8.0e-6 m=5 mm_ok=1
XC1b vinn_stage1 vinp_stage1 cap_cmim w=8.0e-6 l=8.0e-6 m=5 mm_ok=1
XC2a vinp_stage2 vinn_stage2 cap_cmim w=8.0e-6 l=8.0e-6 m=3 mm_ok=1
XC2b vinn_stage2 vinp_stage2 cap_cmim w=8.0e-6 l=8.0e-6 m=3 mm_ok=1
XC3a voutn vinp_ota cap_cmim w=8.0e-6 l=8.0e-6 m=1 mm_ok=1
XC3b voutp vinn_ota cap_cmim w=8.0e-6 l=8.0e-6 m=1 mm_ok=1
x2 vinp_stage1 vinp VSS iqmod_mfb_lpf_R1
x3 vinn_stage1 vinn VSS iqmod_mfb_lpf_R1
x4 vinp_stage1 vinp_stage2 VSS iqmod_mfb_lpf_R2
x5 vinn_stage1 vinn_stage2 VSS iqmod_mfb_lpf_R2
x6 vinp_ota vinp_stage2 VSS iqmod_mfb_lpf_R3
x7 vinn_ota vinn_stage2 VSS iqmod_mfb_lpf_R3
x8 voutn vinp_stage2 VSS iqmod_mfb_lpf_R4
x9 voutp vinn_stage2 VSS iqmod_mfb_lpf_R4
.ends

* expanding   symbol:  iqmod_mfb_lpf_ota_core_hybrid_bm.sym # of pins=7
** sym_path: schematic/iqmod_mfb_lpf_ota_core_hybrid_bm.sym
** sch_path: /foss/designs/TinyWhisper/ihp130/macros/iqmod/schematic/iqmod_mfb_lpf_ota_core_hybrid_bm.sch
.subckt iqmod_mfb_lpf_ota_core_hybrid_bm voutp voutn vinn vinp VDD VSS di_ota_en
*.PININFO vinp:I vinn:I VDD:B VSS:B voutp:O voutn:O di_ota_en:I
x6 VDD node_CDG voutn VSS iqmod_mfb_lpf_ota_core_inv_NF20
x7 VDD node_CDG voutp VSS iqmod_mfb_lpf_ota_core_inv_NF20
x11 VDD voutn node_EF VSS iqmod_mfb_lpf_ota_core_inv_NF20
x12 VDD voutp node_EF VSS iqmod_mfb_lpf_ota_core_inv_NF20
x9 VDD node_vinp node_BC VSS iqmod_mfb_lpf_ota_core_inv_NF10
x10 VDD node_vinn node_BC VSS iqmod_mfb_lpf_ota_core_inv_NF10
x5 VDD node_EF node_FG VSS iqmod_mfb_lpf_ota_core_inv_NF6
x1 VDD node_BC node_CDG VSS iqmod_mfb_lpf_ota_core_inv_NF6
x4 VDD node_BC node_CDG VSS iqmod_mfb_lpf_ota_core_inv_NF6
x13 VDD node_EF node_FG VSS iqmod_mfb_lpf_ota_core_inv_NF6
x8 VDD node_FG node_CDG VSS iqmod_mfb_lpf_ota_core_inv_NF6
x14 VDD node_FG node_CDG VSS iqmod_mfb_lpf_ota_core_inv_NF6
x2 VDD node_vinp voutn VSS iqmod_mfb_lpf_ota_core_inv_NF20
x3 VDD node_vinn voutp VSS iqmod_mfb_lpf_ota_core_inv_NF20
x16 ota_en_n_1 VDD di_ota_en VSS node_vinp VDD vinp iqmod_mfb_lpf_ota_core_spdt_switch
x17 ota_en_n_2 VDD di_ota_en VSS node_vinn VDD vinn iqmod_mfb_lpf_ota_core_spdt_switch
x15 VDD di_ota_en VSS node_CDG node_BC ota_en_n_1 iqmod_mfb_lpf_ota_core_tg
x18 VDD di_ota_en VSS node_FG node_EF ota_en_n_1 iqmod_mfb_lpf_ota_core_tg
x20 VDD di_ota_en VSS node_CDG node_BC ota_en_n_2 iqmod_mfb_lpf_ota_core_tg
x23 VDD di_ota_en VSS node_FG node_EF ota_en_n_2 iqmod_mfb_lpf_ota_core_tg
.ends

* expanding   symbol:  iqmod_mfb_lpf_R1.sym # of pins=3
** sym_path: schematic/iqmod_mfb_lpf_R1.sym
** sch_path: /foss/designs/TinyWhisper/ihp130/macros/iqmod/schematic/iqmod_mfb_lpf_R1.sch
.subckt iqmod_mfb_lpf_R1 v_b v_a VSS
*.PININFO v_a:B v_b:B VSS:B
XR1 v_a net1 VSS rhigh w=0.5e-6 l=27.0e-6 m=1 b=0 mm_ok=1
XR2 net1 net2 VSS rhigh w=0.5e-6 l=27.0e-6 m=1 b=0 mm_ok=1
XR3 net2 v_b VSS rhigh w=0.5e-6 l=27.0e-6 m=1 b=0 mm_ok=1
XRdummy1 VSS VSS VSS rhigh w=0.5e-6 l=27.0e-6 m=1 b=0 mm_ok=1
XRdummy2 VSS VSS VSS rhigh w=0.5e-6 l=27.0e-6 m=1 b=0 mm_ok=1
.ends

* expanding   symbol:  iqmod_mfb_lpf_R2.sym # of pins=3
** sym_path: schematic/iqmod_mfb_lpf_R2.sym
** sch_path: /foss/designs/TinyWhisper/ihp130/macros/iqmod/schematic/iqmod_mfb_lpf_R2.sch
.subckt iqmod_mfb_lpf_R2 v_b v_a VSS
*.PININFO v_a:B v_b:B VSS:B
XR1 v_a net1 VSS rhigh w=0.5e-6 l=31.0e-6 m=1 b=0 mm_ok=1
XR2 net1 net2 VSS rhigh w=0.5e-6 l=31.0e-6 m=1 b=0 mm_ok=1
XR3 net2 v_b VSS rhigh w=0.5e-6 l=31.0e-6 m=1 b=0 mm_ok=1
XRdummy1 VSS VSS VSS rhigh w=0.5e-6 l=31.0e-6 m=1 b=0 mm_ok=1
XRdummy2 VSS VSS VSS rhigh w=0.5e-6 l=31.0e-6 m=1 b=0 mm_ok=1
.ends

* expanding   symbol:  iqmod_mfb_lpf_R3.sym # of pins=3
** sym_path: schematic/iqmod_mfb_lpf_R3.sym
** sch_path: /foss/designs/TinyWhisper/ihp130/macros/iqmod/schematic/iqmod_mfb_lpf_R3.sch
.subckt iqmod_mfb_lpf_R3 v_b v_a VSS
*.PININFO v_a:B v_b:B VSS:B
XR1 v_a net1 VSS rhigh w=0.5e-6 l=59.0e-6 m=1 b=0 mm_ok=1
XR2 net1 net2 VSS rhigh w=0.5e-6 l=59.0e-6 m=1 b=0 mm_ok=1
XR3 net2 v_b VSS rhigh w=0.5e-6 l=59.0e-6 m=1 b=0 mm_ok=1
XRdummy1 VSS VSS VSS rhigh w=0.5e-6 l=59.0e-6 m=1 b=0 mm_ok=1
XRdummy2 VSS VSS VSS rhigh w=0.5e-6 l=59.0e-6 m=1 b=0 mm_ok=1
.ends

* expanding   symbol:  iqmod_mfb_lpf_R4.sym # of pins=3
** sym_path: schematic/iqmod_mfb_lpf_R4.sym
** sch_path: /foss/designs/TinyWhisper/ihp130/macros/iqmod/schematic/iqmod_mfb_lpf_R4.sch
.subckt iqmod_mfb_lpf_R4 v_b v_a VSS
*.PININFO v_a:B v_b:B VSS:B
XR1 v_a net1 VSS rhigh w=0.5e-6 l=60.0e-6 m=1 b=0 mm_ok=1
XR2 net1 net2 VSS rhigh w=0.5e-6 l=60.0e-6 m=1 b=0 mm_ok=1
XR3 net2 v_b VSS rhigh w=0.5e-6 l=60.0e-6 m=1 b=0 mm_ok=1
XRdummy1 VSS VSS VSS rhigh w=0.5e-6 l=60.0e-6 m=1 b=0 mm_ok=1
XRdummy2 VSS VSS VSS rhigh w=0.5e-6 l=60.0e-6 m=1 b=0 mm_ok=1
.ends

* expanding   symbol:  iqmod_mfb_lpf_ota_core_inv_NF20.sym # of pins=4
** sym_path: schematic/iqmod_mfb_lpf_ota_core_inv_NF20.sym
** sch_path: /foss/designs/TinyWhisper/ihp130/macros/iqmod/schematic/iqmod_mfb_lpf_ota_core_inv_NF20.sch
.subckt iqmod_mfb_lpf_ota_core_inv_NF20 VDD vin vout VSS
*.PININFO vin:I VDD:B VSS:B vout:B
XMdummy1 VSS VSS VSS VSS sg13_lv_nmos w=2.0u l=1.0u ng=2 m=1 mm_ok=1
XMdummy2 VDD VDD VDD VDD sg13_lv_pmos w=12.0u l=1.0u ng=2 m=1 mm_ok=1
XM1 vout vin VSS VSS sg13_lv_nmos w=20.0u l=1.0u ng=20 m=1 mm_ok=1
XM2 vout vin VDD VDD sg13_lv_pmos w=120.0u l=1.0u ng=20 m=1 mm_ok=1
.ends

* expanding   symbol:  iqmod_mfb_lpf_ota_core_inv_NF10.sym # of pins=4
** sym_path: schematic/iqmod_mfb_lpf_ota_core_inv_NF10.sym
** sch_path: /foss/designs/TinyWhisper/ihp130/macros/iqmod/schematic/iqmod_mfb_lpf_ota_core_inv_NF10.sch
.subckt iqmod_mfb_lpf_ota_core_inv_NF10 VDD vin vout VSS
*.PININFO vin:I VDD:B VSS:B vout:B
XM1 vout vin VSS VSS sg13_lv_nmos w=10.0u l=1.0u ng=10 m=1 mm_ok=1
XM2 vout vin VDD VDD sg13_lv_pmos w=60.0u l=1.0u ng=10 m=1 mm_ok=1
XMdummy1 VSS VSS VSS VSS sg13_lv_nmos w=2.0u l=1.0u ng=2 m=1 mm_ok=1
XMdummy2 VDD VDD VDD VDD sg13_lv_pmos w=12.0u l=1.0u ng=2 m=1 mm_ok=1
.ends

* expanding   symbol:  iqmod_mfb_lpf_ota_core_inv_NF6.sym # of pins=4
** sym_path: schematic/iqmod_mfb_lpf_ota_core_inv_NF6.sym
** sch_path: /foss/designs/TinyWhisper/ihp130/macros/iqmod/schematic/iqmod_mfb_lpf_ota_core_inv_NF6.sch
.subckt iqmod_mfb_lpf_ota_core_inv_NF6 VDD vin vout VSS
*.PININFO vin:I VDD:B VSS:B vout:B
XMdummy1 VSS VSS VSS VSS sg13_lv_nmos w=2.0u l=1.0u ng=2 m=1 mm_ok=1
XMdummy2 VDD VDD VDD VDD sg13_lv_pmos w=12.0u l=1.0u ng=2 m=1 mm_ok=1
XM1 vout vin VSS VSS sg13_lv_nmos w=6.0u l=1.0u ng=6 m=1 mm_ok=1
XM2 vout vin VDD VDD sg13_lv_pmos w=36.0u l=1.0u ng=6 m=1 mm_ok=1
.ends

* expanding   symbol:  iqmod_mfb_lpf_ota_core_spdt_switch.sym # of pins=7
** sym_path: schematic/iqmod_mfb_lpf_ota_core_spdt_switch.sym
** sch_path: /foss/designs/TinyWhisper/ihp130/macros/iqmod/schematic/iqmod_mfb_lpf_ota_core_spdt_switch.sch
.subckt iqmod_mfb_lpf_ota_core_spdt_switch do_spdt_ctrl_n VDD di_spdt_ctrl VSS v_c v_b v_a
*.PININFO v_a:B v_b:B v_c:B VDD:B VSS:B di_spdt_ctrl:I do_spdt_ctrl_n:O
x1 VDD di_spdt_ctrl do_spdt_ctrl_n VSS iqmod_mfb_lpf_ota_core_spdt_switch_inv
x2 VDD do_spdt_ctrl_n spdt_ctrl_buf VSS iqmod_mfb_lpf_ota_core_spdt_switch_inv
x3 VDD spdt_ctrl_buf VSS v_c v_a do_spdt_ctrl_n iqmod_mfb_lpf_ota_core_spdt_switch_tg
x4 VDD do_spdt_ctrl_n VSS v_c v_b spdt_ctrl_buf iqmod_mfb_lpf_ota_core_spdt_switch_tg
.ends

* expanding   symbol:  iqmod_mfb_lpf_ota_core_tg.sym # of pins=6
** sym_path: schematic/iqmod_mfb_lpf_ota_core_tg.sym
** sch_path: /foss/designs/TinyWhisper/ihp130/macros/iqmod/schematic/iqmod_mfb_lpf_ota_core_tg.sch
.subckt iqmod_mfb_lpf_ota_core_tg VDD di_tg_ctrl VSS v_b v_a di_tg_ctrl_n
*.PININFO v_a:B v_b:B VDD:B VSS:B di_tg_ctrl:I di_tg_ctrl_n:I
XM2 v_a di_tg_ctrl_n v_b VDD sg13_lv_pmos w=36.0u l=0.13u ng=6 m=1 mm_ok=1
XM1 v_a di_tg_ctrl v_b VSS sg13_lv_nmos w=6.0u l=0.13u ng=6 m=1 mm_ok=1
.ends

* expanding   symbol:  iqmod_mfb_lpf_ota_core_spdt_switch_inv.sym # of pins=4
** sym_path: schematic/iqmod_mfb_lpf_ota_core_spdt_switch_inv.sym
** sch_path: /foss/designs/TinyWhisper/ihp130/macros/iqmod/schematic/iqmod_mfb_lpf_ota_core_spdt_switch_inv.sch
.subckt iqmod_mfb_lpf_ota_core_spdt_switch_inv VDD vin vout VSS
*.PININFO vin:I VDD:B VSS:B vout:B
XM1 vout vin VSS VSS sg13_lv_nmos w=2.0u l=0.13u ng=2 m=1 mm_ok=1
XM2 vout vin VDD VDD sg13_lv_pmos w=12.0u l=0.13u ng=2 m=1 mm_ok=1
XMdummy1 VSS VSS VSS VSS sg13_lv_nmos w=2.0u l=0.13u ng=2 m=1 mm_ok=1
XMdummy2 VDD VDD VDD VDD sg13_lv_pmos w=12.0u l=0.13u ng=2 m=1 mm_ok=1
.ends

* expanding   symbol:  iqmod_mfb_lpf_ota_core_spdt_switch_tg.sym # of pins=6
** sym_path: schematic/iqmod_mfb_lpf_ota_core_spdt_switch_tg.sym
** sch_path: /foss/designs/TinyWhisper/ihp130/macros/iqmod/schematic/iqmod_mfb_lpf_ota_core_spdt_switch_tg.sch
.subckt iqmod_mfb_lpf_ota_core_spdt_switch_tg VDD di_tg_ctrl VSS v_b v_a di_tg_ctrl_n
*.PININFO v_a:B v_b:B VDD:B VSS:B di_tg_ctrl:I di_tg_ctrl_n:I
XM2 v_a di_tg_ctrl_n v_b VDD sg13_lv_pmos w=36.0u l=0.13u ng=6 m=1 mm_ok=1
XM1 v_a di_tg_ctrl v_b VSS sg13_lv_nmos w=6.0u l=0.13u ng=6 m=1 mm_ok=1
.ends
