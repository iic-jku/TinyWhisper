* Extracted by KLayout with SG13G2 LVS runset on : 25/07/2026 19:17

.SUBCKT iqmod_mixer VDD VSS vinn_IF vinn_LO vinp_IF vinp_LO voutn_RF voutp_RF
X$53 VSS vinn_IF \$I208 voutn_RF \$I207 VDD iqmod_mixer_tg
X$54 VSS vinn_LO VDD \$I208 \$I207 iqmod_mixer_se2diff
X$55 VSS vinp_IF \$I210 voutp_RF \$I209 VDD iqmod_mixer_tg
X$56 VSS vinp_LO VDD \$I210 \$I209 iqmod_mixer_se2diff
.ENDS iqmod_mixer

.SUBCKT iqmod_mixer_tg VSS v_a di_tg_ctrl v_b di_tg_ctrl_n VDD
M$1 v_b di_tg_ctrl v_a VSS sg13_lv_nmos L=0.13u W=108u AS=20.97p AD=20.52p
+ PS=124.98u PD=121.68u rfmode=0
M$37 v_b di_tg_ctrl_n v_b VSS sg13_lv_nmos L=0.13u W=54u AS=10.26p AD=10.71p
+ PS=60.84u PD=64.14u rfmode=0
M$55 v_b di_tg_ctrl_n v_a VDD sg13_lv_pmos L=0.13u W=324u AS=62.91p AD=61.56p
+ PS=346.98u PD=337.68u rfmode=0
M$91 v_b di_tg_ctrl v_b VDD sg13_lv_pmos L=0.13u W=162u AS=30.78p AD=32.13p
+ PS=168.84u PD=178.14u rfmode=0
.ENDS iqmod_mixer_tg

.SUBCKT iqmod_mixer_se2diff VSS vin VDD voutp voutn
M$1 VSS VSS VSS VSS sg13_lv_nmos L=0.13u W=26u AS=6.89p AD=6.89p PS=52.78u
+ PD=52.78u rfmode=0
M$2 VSS \$I9 voutp VSS sg13_lv_nmos L=0.13u W=54u AS=10.26p AD=10.26p PS=74.52u
+ PD=74.52u rfmode=0
M$57 VDD VDD VDD VDD sg13_lv_pmos L=0.13u W=78u AS=20.67p AD=20.67p PS=130.78u
+ PD=130.78u rfmode=0
M$58 VDD \$I9 voutp VDD sg13_lv_pmos L=0.13u W=162u AS=30.78p AD=30.78p
+ PS=182.52u PD=182.52u rfmode=0
M$114 VSS \$I8 \$I9 VSS sg13_lv_nmos L=0.13u W=18u AS=3.42p AD=3.42p PS=24.84u
+ PD=24.84u rfmode=0
M$134 VDD \$I8 \$I9 VDD sg13_lv_pmos L=0.13u W=54u AS=10.26p AD=10.26p
+ PS=60.84u PD=60.84u rfmode=0
M$154 VDD vin \$9 VDD sg13_lv_pmos L=0.13u W=12u AS=2.28p AD=2.28p PS=13.52u
+ PD=13.52u rfmode=0
M$158 VDD \$5 \$4 VDD sg13_lv_pmos L=0.13u W=6u AS=1.14p AD=1.14p PS=6.76u
+ PD=6.76u rfmode=0
M$162 VSS vin \$9 VSS sg13_lv_nmos L=0.13u W=4u AS=0.76p AD=0.76p PS=5.52u
+ PD=5.52u rfmode=0
M$166 VSS \$5 \$4 VSS sg13_lv_nmos L=0.13u W=2u AS=0.38p AD=0.38p PS=2.76u
+ PD=2.76u rfmode=0
M$170 VSS \$I7 \$5 VSS sg13_lv_nmos L=0.13u W=6u AS=1.14p AD=1.14p PS=8.28u
+ PD=8.28u rfmode=0
M$178 VSS \$9 \$I7 VSS sg13_lv_nmos L=0.13u W=6u AS=1.14p AD=1.14p PS=8.28u
+ PD=8.28u rfmode=0
M$186 VSS \$5 \$I8 VSS sg13_lv_nmos L=0.13u W=6u AS=1.14p AD=1.14p PS=8.28u
+ PD=8.28u rfmode=0
M$194 VDD \$I7 \$5 VDD sg13_lv_pmos L=0.13u W=18u AS=3.42p AD=3.42p PS=20.28u
+ PD=20.28u rfmode=0
M$202 VDD \$9 \$I7 VDD sg13_lv_pmos L=0.13u W=18u AS=3.42p AD=3.42p PS=20.28u
+ PD=20.28u rfmode=0
M$210 VDD \$5 \$I8 VDD sg13_lv_pmos L=0.13u W=18u AS=3.42p AD=3.42p PS=20.28u
+ PD=20.28u rfmode=0
M$217 \$9 VDD \$I12 VSS sg13_lv_nmos L=0.13u W=6u AS=1.29p AD=1.29p PS=9.58u
+ PD=9.58u rfmode=0
M$223 \$9 VSS \$I12 VDD sg13_lv_pmos L=0.13u W=18u AS=3.87p AD=3.87p PS=23.58u
+ PD=23.58u rfmode=0
M$230 VSS \$I11 voutn VSS sg13_lv_nmos L=0.13u W=54u AS=10.26p AD=10.26p
+ PS=74.52u PD=74.52u rfmode=0
M$286 VDD \$I11 voutn VDD sg13_lv_pmos L=0.13u W=162u AS=30.78p AD=30.78p
+ PS=182.52u PD=182.52u rfmode=0
M$342 VSS \$I10 \$I11 VSS sg13_lv_nmos L=0.13u W=18u AS=3.42p AD=3.42p
+ PS=24.84u PD=24.84u rfmode=0
M$362 VDD \$I10 \$I11 VDD sg13_lv_pmos L=0.13u W=54u AS=10.26p AD=10.26p
+ PS=60.84u PD=60.84u rfmode=0
M$386 VDD \$4 \$5 VDD sg13_lv_pmos L=0.13u W=6u AS=1.14p AD=1.14p PS=6.76u
+ PD=6.76u rfmode=0
M$394 VSS \$4 \$5 VSS sg13_lv_nmos L=0.13u W=2u AS=0.38p AD=0.38p PS=2.76u
+ PD=2.76u rfmode=0
M$398 VSS \$I12 \$4 VSS sg13_lv_nmos L=0.13u W=6u AS=1.14p AD=1.14p PS=8.28u
+ PD=8.28u rfmode=0
M$406 VSS \$4 \$I10 VSS sg13_lv_nmos L=0.13u W=6u AS=1.14p AD=1.14p PS=8.28u
+ PD=8.28u rfmode=0
M$414 VDD \$I12 \$4 VDD sg13_lv_pmos L=0.13u W=18u AS=3.42p AD=3.42p PS=20.28u
+ PD=20.28u rfmode=0
M$422 VDD \$4 \$I10 VDD sg13_lv_pmos L=0.13u W=18u AS=3.42p AD=3.42p PS=20.28u
+ PD=20.28u rfmode=0
.ENDS iqmod_mixer_se2diff
