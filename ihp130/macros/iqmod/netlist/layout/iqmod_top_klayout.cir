* Extracted by KLayout with SG13G2 LVS runset on : 25/07/2026 19:28

.SUBCKT iqmod_top VDD VSS di_analog_en di_ds_I_n di_ds_I_p di_ds_Q_n di_ds_Q_p
+ di_lo_I di_lo_Ix di_lo_Q di_lo_Qx di_spdt_ctrl_I di_spdt_ctrl_Q vinn_I vinn_Q
+ vinp_I vinp_Q voutn_I_RF voutn_Q_RF voutp_I_RF voutp_Q_RF
X$1 VSS di_ds_Q_n di_lo_Qx vinn_Q VDD voutn_Q_RF di_ds_Q_p di_analog_en
+ di_spdt_ctrl_Q vinp_Q voutp_Q_RF di_lo_Q iqmod_top_half
X$2 VSS di_ds_I_n di_lo_Ix vinn_I VDD voutn_I_RF di_ds_I_p di_analog_en
+ di_spdt_ctrl_I vinp_I voutp_I_RF di_lo_I iqmod_top_half
.ENDS iqmod_top

.SUBCKT iqmod_top_half VSS di_ds_I_n di_lo_Ix vinn_I VDD voutn_I_RF di_ds_I_p
+ di_analog_en di_spdt_ctrl_I vinp_I voutp_I_RF di_lo_I
X$1 di_spdt_ctrl_I \$47 vinp_I di_ds_I_p VSS VDD iqmod_spdt_switch
X$3 \$22 VDD di_lo_Ix VSS voutn_I_RF di_lo_I voutp_I_RF \$42 iqmod_mixer
X$8 di_spdt_ctrl_I \$21 vinn_I di_ds_I_n VSS VDD iqmod_spdt_switch
X$16 di_analog_en VSS \$47 \$21 VDD \$42 \$22 iqmod_mfb_lpf
.ENDS iqmod_top_half

.SUBCKT iqmod_mixer vinn_IF VDD vinn_LO VSS voutn_RF vinp_LO voutp_RF vinp_IF
M$1 voutn_RF \$I208 vinn_IF VSS sg13_lv_nmos L=0.13u W=108u AS=20.97p AD=20.52p
+ PS=124.98u PD=121.68u rfmode=0
M$37 voutn_RF \$I207 voutn_RF VSS sg13_lv_nmos L=0.13u W=54u AS=10.26p
+ AD=10.71p PS=60.84u PD=64.14u rfmode=0
M$55 voutp_RF \$I210 vinp_IF VSS sg13_lv_nmos L=0.13u W=108u AS=20.97p
+ AD=20.52p PS=124.98u PD=121.68u rfmode=0
M$91 voutp_RF \$I209 voutp_RF VSS sg13_lv_nmos L=0.13u W=54u AS=10.26p
+ AD=10.71p PS=60.84u PD=64.14u rfmode=0
M$109 voutn_RF \$I207 vinn_IF VDD sg13_lv_pmos L=0.13u W=324u AS=62.91p
+ AD=61.56p PS=346.98u PD=337.68u rfmode=0
M$145 voutn_RF \$I208 voutn_RF VDD sg13_lv_pmos L=0.13u W=162u AS=30.78p
+ AD=32.13p PS=168.84u PD=178.14u rfmode=0
M$163 voutp_RF \$I209 vinp_IF VDD sg13_lv_pmos L=0.13u W=324u AS=62.91p
+ AD=61.56p PS=346.98u PD=337.68u rfmode=0
M$199 voutp_RF \$I210 voutp_RF VDD sg13_lv_pmos L=0.13u W=162u AS=30.78p
+ AD=32.13p PS=168.84u PD=178.14u rfmode=0
M$217 VSS VSS VSS VSS sg13_lv_nmos L=0.13u W=52u AS=13.78p AD=13.78p PS=105.56u
+ PD=105.56u rfmode=0
M$218 VSS \$I219 \$I208 VSS sg13_lv_nmos L=0.13u W=54u AS=10.26p AD=10.26p
+ PS=74.52u PD=74.52u rfmode=0
M$274 VSS \$I222 \$I210 VSS sg13_lv_nmos L=0.13u W=54u AS=10.26p AD=10.26p
+ PS=74.52u PD=74.52u rfmode=0
M$329 VDD VDD VDD VDD sg13_lv_pmos L=0.13u W=156u AS=41.34p AD=41.34p
+ PS=261.56u PD=261.56u rfmode=0
M$330 VDD \$I219 \$I208 VDD sg13_lv_pmos L=0.13u W=162u AS=30.78p AD=30.78p
+ PS=182.52u PD=182.52u rfmode=0
M$386 VDD \$I222 \$I210 VDD sg13_lv_pmos L=0.13u W=162u AS=30.78p AD=30.78p
+ PS=182.52u PD=182.52u rfmode=0
M$442 VSS \$I218 \$I219 VSS sg13_lv_nmos L=0.13u W=18u AS=3.42p AD=3.42p
+ PS=24.84u PD=24.84u rfmode=0
M$462 VSS \$I221 \$I222 VSS sg13_lv_nmos L=0.13u W=18u AS=3.42p AD=3.42p
+ PS=24.84u PD=24.84u rfmode=0
M$482 VDD \$I218 \$I219 VDD sg13_lv_pmos L=0.13u W=54u AS=10.26p AD=10.26p
+ PS=60.84u PD=60.84u rfmode=0
M$502 VDD \$I221 \$I222 VDD sg13_lv_pmos L=0.13u W=54u AS=10.26p AD=10.26p
+ PS=60.84u PD=60.84u rfmode=0
M$522 VDD vinn_LO \$I213 VDD sg13_lv_pmos L=0.13u W=12u AS=2.28p AD=2.28p
+ PS=13.52u PD=13.52u rfmode=0
M$526 VDD \$I212 \$I211 VDD sg13_lv_pmos L=0.13u W=6u AS=1.14p AD=1.14p
+ PS=6.76u PD=6.76u rfmode=0
M$530 VDD vinp_LO \$I216 VDD sg13_lv_pmos L=0.13u W=12u AS=2.28p AD=2.28p
+ PS=13.52u PD=13.52u rfmode=0
M$534 VDD \$I215 \$I214 VDD sg13_lv_pmos L=0.13u W=6u AS=1.14p AD=1.14p
+ PS=6.76u PD=6.76u rfmode=0
M$538 VSS vinn_LO \$I213 VSS sg13_lv_nmos L=0.13u W=4u AS=0.76p AD=0.76p
+ PS=5.52u PD=5.52u rfmode=0
M$542 VSS \$I212 \$I211 VSS sg13_lv_nmos L=0.13u W=2u AS=0.38p AD=0.38p
+ PS=2.76u PD=2.76u rfmode=0
M$546 VSS vinp_LO \$I216 VSS sg13_lv_nmos L=0.13u W=4u AS=0.76p AD=0.76p
+ PS=5.52u PD=5.52u rfmode=0
M$550 VSS \$I215 \$I214 VSS sg13_lv_nmos L=0.13u W=2u AS=0.38p AD=0.38p
+ PS=2.76u PD=2.76u rfmode=0
M$554 VSS \$I217 \$I212 VSS sg13_lv_nmos L=0.13u W=6u AS=1.14p AD=1.14p
+ PS=8.28u PD=8.28u rfmode=0
M$562 VSS \$I213 \$I217 VSS sg13_lv_nmos L=0.13u W=6u AS=1.14p AD=1.14p
+ PS=8.28u PD=8.28u rfmode=0
M$570 VSS \$I212 \$I218 VSS sg13_lv_nmos L=0.13u W=6u AS=1.14p AD=1.14p
+ PS=8.28u PD=8.28u rfmode=0
M$578 VSS \$I220 \$I215 VSS sg13_lv_nmos L=0.13u W=6u AS=1.14p AD=1.14p
+ PS=8.28u PD=8.28u rfmode=0
M$586 VSS \$I216 \$I220 VSS sg13_lv_nmos L=0.13u W=6u AS=1.14p AD=1.14p
+ PS=8.28u PD=8.28u rfmode=0
M$594 VSS \$I215 \$I221 VSS sg13_lv_nmos L=0.13u W=6u AS=1.14p AD=1.14p
+ PS=8.28u PD=8.28u rfmode=0
M$602 VDD \$I217 \$I212 VDD sg13_lv_pmos L=0.13u W=18u AS=3.42p AD=3.42p
+ PS=20.28u PD=20.28u rfmode=0
M$610 VDD \$I213 \$I217 VDD sg13_lv_pmos L=0.13u W=18u AS=3.42p AD=3.42p
+ PS=20.28u PD=20.28u rfmode=0
M$618 VDD \$I212 \$I218 VDD sg13_lv_pmos L=0.13u W=18u AS=3.42p AD=3.42p
+ PS=20.28u PD=20.28u rfmode=0
M$626 VDD \$I220 \$I215 VDD sg13_lv_pmos L=0.13u W=18u AS=3.42p AD=3.42p
+ PS=20.28u PD=20.28u rfmode=0
M$634 VDD \$I216 \$I220 VDD sg13_lv_pmos L=0.13u W=18u AS=3.42p AD=3.42p
+ PS=20.28u PD=20.28u rfmode=0
M$642 VDD \$I215 \$I221 VDD sg13_lv_pmos L=0.13u W=18u AS=3.42p AD=3.42p
+ PS=20.28u PD=20.28u rfmode=0
M$649 \$I213 VDD \$I225 VSS sg13_lv_nmos L=0.13u W=6u AS=1.29p AD=1.29p
+ PS=9.58u PD=9.58u rfmode=0
M$655 \$I216 VDD \$I228 VSS sg13_lv_nmos L=0.13u W=6u AS=1.29p AD=1.29p
+ PS=9.58u PD=9.58u rfmode=0
M$661 \$I213 VSS \$I225 VDD sg13_lv_pmos L=0.13u W=18u AS=3.87p AD=3.87p
+ PS=23.58u PD=23.58u rfmode=0
M$667 \$I216 VSS \$I228 VDD sg13_lv_pmos L=0.13u W=18u AS=3.87p AD=3.87p
+ PS=23.58u PD=23.58u rfmode=0
M$674 VSS \$I224 \$I207 VSS sg13_lv_nmos L=0.13u W=54u AS=10.26p AD=10.26p
+ PS=74.52u PD=74.52u rfmode=0
M$730 VSS \$I227 \$I209 VSS sg13_lv_nmos L=0.13u W=54u AS=10.26p AD=10.26p
+ PS=74.52u PD=74.52u rfmode=0
M$786 VDD \$I224 \$I207 VDD sg13_lv_pmos L=0.13u W=162u AS=30.78p AD=30.78p
+ PS=182.52u PD=182.52u rfmode=0
M$842 VDD \$I227 \$I209 VDD sg13_lv_pmos L=0.13u W=162u AS=30.78p AD=30.78p
+ PS=182.52u PD=182.52u rfmode=0
M$898 VSS \$I223 \$I224 VSS sg13_lv_nmos L=0.13u W=18u AS=3.42p AD=3.42p
+ PS=24.84u PD=24.84u rfmode=0
M$918 VSS \$I226 \$I227 VSS sg13_lv_nmos L=0.13u W=18u AS=3.42p AD=3.42p
+ PS=24.84u PD=24.84u rfmode=0
M$938 VDD \$I223 \$I224 VDD sg13_lv_pmos L=0.13u W=54u AS=10.26p AD=10.26p
+ PS=60.84u PD=60.84u rfmode=0
M$958 VDD \$I226 \$I227 VDD sg13_lv_pmos L=0.13u W=54u AS=10.26p AD=10.26p
+ PS=60.84u PD=60.84u rfmode=0
M$982 VDD \$I211 \$I212 VDD sg13_lv_pmos L=0.13u W=6u AS=1.14p AD=1.14p
+ PS=6.76u PD=6.76u rfmode=0
M$990 VDD \$I214 \$I215 VDD sg13_lv_pmos L=0.13u W=6u AS=1.14p AD=1.14p
+ PS=6.76u PD=6.76u rfmode=0
M$998 VSS \$I211 \$I212 VSS sg13_lv_nmos L=0.13u W=2u AS=0.38p AD=0.38p
+ PS=2.76u PD=2.76u rfmode=0
M$1006 VSS \$I214 \$I215 VSS sg13_lv_nmos L=0.13u W=2u AS=0.38p AD=0.38p
+ PS=2.76u PD=2.76u rfmode=0
M$1010 VSS \$I225 \$I211 VSS sg13_lv_nmos L=0.13u W=6u AS=1.14p AD=1.14p
+ PS=8.28u PD=8.28u rfmode=0
M$1018 VSS \$I211 \$I223 VSS sg13_lv_nmos L=0.13u W=6u AS=1.14p AD=1.14p
+ PS=8.28u PD=8.28u rfmode=0
M$1026 VSS \$I228 \$I214 VSS sg13_lv_nmos L=0.13u W=6u AS=1.14p AD=1.14p
+ PS=8.28u PD=8.28u rfmode=0
M$1034 VSS \$I214 \$I226 VSS sg13_lv_nmos L=0.13u W=6u AS=1.14p AD=1.14p
+ PS=8.28u PD=8.28u rfmode=0
M$1042 VDD \$I225 \$I211 VDD sg13_lv_pmos L=0.13u W=18u AS=3.42p AD=3.42p
+ PS=20.28u PD=20.28u rfmode=0
M$1050 VDD \$I211 \$I223 VDD sg13_lv_pmos L=0.13u W=18u AS=3.42p AD=3.42p
+ PS=20.28u PD=20.28u rfmode=0
M$1058 VDD \$I228 \$I214 VDD sg13_lv_pmos L=0.13u W=18u AS=3.42p AD=3.42p
+ PS=20.28u PD=20.28u rfmode=0
M$1066 VDD \$I214 \$I226 VDD sg13_lv_pmos L=0.13u W=18u AS=3.42p AD=3.42p
+ PS=20.28u PD=20.28u rfmode=0
.ENDS iqmod_mixer

.SUBCKT iqmod_spdt_switch di_spdt_ctrl v_c v_a v_b VSS VDD
M$1 v_b \$8 v_c VSS sg13_lv_nmos L=0.13u W=6u AS=1.29p AD=1.29p PS=9.58u
+ PD=9.58u rfmode=0
M$7 v_a \$7 v_c VSS sg13_lv_nmos L=0.13u W=6u AS=1.29p AD=1.29p PS=9.58u
+ PD=9.58u rfmode=0
M$13 v_b \$7 v_c VDD sg13_lv_pmos L=0.13u W=36u AS=7.74p AD=7.74p PS=44.58u
+ PD=44.58u rfmode=0
M$19 v_a \$8 v_c VDD sg13_lv_pmos L=0.13u W=36u AS=7.74p AD=7.74p PS=44.58u
+ PD=44.58u rfmode=0
M$25 VDD VDD VDD VDD sg13_lv_pmos L=0.13u W=24u AS=6.36p AD=6.36p PS=38.12u
+ PD=38.12u rfmode=0
M$26 VDD di_spdt_ctrl \$8 VDD sg13_lv_pmos L=0.13u W=12u AS=2.28p AD=2.28p
+ PS=12.76u PD=12.76u rfmode=0
M$30 VDD \$8 \$7 VDD sg13_lv_pmos L=0.13u W=12u AS=2.28p AD=2.28p PS=12.76u
+ PD=12.76u rfmode=0
M$33 VSS VSS VSS VSS sg13_lv_nmos L=0.13u W=4u AS=1.06p AD=1.06p PS=8.12u
+ PD=8.12u rfmode=0
M$34 VSS di_spdt_ctrl \$8 VSS sg13_lv_nmos L=0.13u W=2u AS=0.38p AD=0.38p
+ PS=2.76u PD=2.76u rfmode=0
M$38 VSS \$8 \$7 VSS sg13_lv_nmos L=0.13u W=2u AS=0.38p AD=0.38p PS=2.76u
+ PD=2.76u rfmode=0
.ENDS iqmod_spdt_switch

.SUBCKT iqmod_mfb_lpf di_filter_en VSS vinp vinn VDD voutp voutn
C$1 voutn \$1.vinp cap_cmim w=8u l=8u A=64p P=32u m=1
C$2 voutp \$2.vinp cap_cmim w=8u l=8u A=64p P=32u m=1
C$3 \$3 \$4 cap_cmim w=8u l=8u A=64p P=32u m=3
C$6 \$4 \$3 cap_cmim w=8u l=8u A=64p P=32u m=3
C$9 \$7 \$5 cap_cmim w=8u l=8u A=64p P=32u m=5
C$14 \$5 \$7 cap_cmim w=8u l=8u A=64p P=32u m=5
R$19 VSS VSS VSS rhigh w=0.5u l=59u ps=0u b=0 m=4
R$25 \$4 \$1.vinp VSS rhigh w=0.5u l=177u ps=0u b=0 m=1
R$28 \$3 \$2.vinp VSS rhigh w=0.5u l=177u ps=0u b=0 m=1
R$29 VSS VSS VSS rhigh w=0.5u l=60u ps=0u b=0 m=4
R$35 \$4 voutn VSS rhigh w=0.5u l=180u ps=0u b=0 m=1
R$38 \$3 voutp VSS rhigh w=0.5u l=180u ps=0u b=0 m=1
R$39 VSS VSS VSS rhigh w=0.5u l=27u ps=0u b=0 m=4
R$45 vinp \$5 VSS rhigh w=0.5u l=81u ps=0u b=0 m=1
R$48 vinn \$7 VSS rhigh w=0.5u l=81u ps=0u b=0 m=1
R$49 VSS VSS VSS rhigh w=0.5u l=31u ps=0u b=0 m=4
R$55 \$4 \$5 VSS rhigh w=0.5u l=93u ps=0u b=0 m=1
R$58 \$3 \$7 VSS rhigh w=0.5u l=93u ps=0u b=0 m=1
M$59 VSS VSS VSS VSS sg13_lv_nmos L=1u W=28u AS=7.42p AD=7.42p PS=56.84u
+ PD=56.84u rfmode=0
M$60 VSS \$I16 \$I17 VSS sg13_lv_nmos L=1u W=12u AS=2.28p AD=2.28p PS=16.56u
+ PD=16.56u rfmode=0
M$68 VSS \$I18 \$I19 VSS sg13_lv_nmos L=1u W=12u AS=2.28p AD=2.28p PS=16.56u
+ PD=16.56u rfmode=0
M$76 VSS \$I19 \$I17 VSS sg13_lv_nmos L=1u W=12u AS=2.28p AD=2.28p PS=16.56u
+ PD=16.56u rfmode=0
M$107 VDD VDD VDD VDD sg13_lv_pmos L=1u W=168u AS=44.52p AD=44.52p PS=266.84u
+ PD=266.84u rfmode=0
M$108 VDD \$I16 \$I17 VDD sg13_lv_pmos L=1u W=72u AS=13.68p AD=13.68p PS=76.56u
+ PD=76.56u rfmode=0
M$116 VDD \$I18 \$I19 VDD sg13_lv_pmos L=1u W=72u AS=13.68p AD=13.68p PS=76.56u
+ PD=76.56u rfmode=0
M$124 VDD \$I19 \$I17 VDD sg13_lv_pmos L=1u W=72u AS=13.68p AD=13.68p PS=76.56u
+ PD=76.56u rfmode=0
M$155 \$I16 di_filter_en \$I17 VSS sg13_lv_nmos L=0.13u W=12u AS=2.58p AD=2.58p
+ PS=19.16u PD=19.16u rfmode=0
M$161 \$I18 di_filter_en \$I19 VSS sg13_lv_nmos L=0.13u W=12u AS=2.58p AD=2.58p
+ PS=19.16u PD=19.16u rfmode=0
M$179 \$I16 \$I44 \$I17 VDD sg13_lv_pmos L=0.13u W=36u AS=7.74p AD=7.74p
+ PS=44.58u PD=44.58u rfmode=0
M$185 \$I18 \$I44 \$I19 VDD sg13_lv_pmos L=0.13u W=36u AS=7.74p AD=7.74p
+ PS=44.58u PD=44.58u rfmode=0
M$191 \$I16 \$I46 \$I17 VDD sg13_lv_pmos L=0.13u W=36u AS=7.74p AD=7.74p
+ PS=44.58u PD=44.58u rfmode=0
M$197 \$I18 \$I46 \$I19 VDD sg13_lv_pmos L=0.13u W=36u AS=7.74p AD=7.74p
+ PS=44.58u PD=44.58u rfmode=0
M$204 VSS \$I45 \$I16 VSS sg13_lv_nmos L=1u W=10u AS=1.9p AD=1.9p PS=13.8u
+ PD=13.8u rfmode=0
M$216 VSS \$I47 \$I16 VSS sg13_lv_nmos L=1u W=10u AS=1.9p AD=1.9p PS=13.8u
+ PD=13.8u rfmode=0
M$228 VDD \$I45 \$I16 VDD sg13_lv_pmos L=1u W=60u AS=11.4p AD=11.4p PS=63.8u
+ PD=63.8u rfmode=0
M$240 VDD \$I47 \$I16 VDD sg13_lv_pmos L=1u W=60u AS=11.4p AD=11.4p PS=63.8u
+ PD=63.8u rfmode=0
M$252 VSS voutn \$I18 VSS sg13_lv_nmos L=1u W=20u AS=3.8p AD=3.8p PS=27.6u
+ PD=27.6u rfmode=0
M$274 VSS \$I45 voutn VSS sg13_lv_nmos L=1u W=20u AS=3.8p AD=3.8p PS=27.6u
+ PD=27.6u rfmode=0
M$296 VSS \$I17 voutn VSS sg13_lv_nmos L=1u W=20u AS=3.8p AD=3.8p PS=27.6u
+ PD=27.6u rfmode=0
M$318 VSS voutp \$I18 VSS sg13_lv_nmos L=1u W=20u AS=3.8p AD=3.8p PS=27.6u
+ PD=27.6u rfmode=0
M$340 VSS \$I47 voutp VSS sg13_lv_nmos L=1u W=20u AS=3.8p AD=3.8p PS=27.6u
+ PD=27.6u rfmode=0
M$362 VSS \$I17 voutp VSS sg13_lv_nmos L=1u W=20u AS=3.8p AD=3.8p PS=27.6u
+ PD=27.6u rfmode=0
M$384 VDD voutn \$I18 VDD sg13_lv_pmos L=1u W=120u AS=22.8p AD=22.8p PS=127.6u
+ PD=127.6u rfmode=0
M$406 VDD \$I45 voutn VDD sg13_lv_pmos L=1u W=120u AS=22.8p AD=22.8p PS=127.6u
+ PD=127.6u rfmode=0
M$428 VDD \$I17 voutn VDD sg13_lv_pmos L=1u W=120u AS=22.8p AD=22.8p PS=127.6u
+ PD=127.6u rfmode=0
M$450 VDD voutp \$I18 VDD sg13_lv_pmos L=1u W=120u AS=22.8p AD=22.8p PS=127.6u
+ PD=127.6u rfmode=0
M$472 VDD \$I47 voutp VDD sg13_lv_pmos L=1u W=120u AS=22.8p AD=22.8p PS=127.6u
+ PD=127.6u rfmode=0
M$494 VDD \$I17 voutp VDD sg13_lv_pmos L=1u W=120u AS=22.8p AD=22.8p PS=127.6u
+ PD=127.6u rfmode=0
M$515 VDD \$I44 \$I45 VSS sg13_lv_nmos L=0.13u W=6u AS=1.29p AD=1.29p PS=9.58u
+ PD=9.58u rfmode=0
M$521 \$1.vinp \$I64 \$I45 VSS sg13_lv_nmos L=0.13u W=6u AS=1.29p AD=1.29p
+ PS=9.58u PD=9.58u rfmode=0
M$527 VDD \$I46 \$I47 VSS sg13_lv_nmos L=0.13u W=6u AS=1.29p AD=1.29p PS=9.58u
+ PD=9.58u rfmode=0
M$533 \$2.vinp \$I65 \$I47 VSS sg13_lv_nmos L=0.13u W=6u AS=1.29p AD=1.29p
+ PS=9.58u PD=9.58u rfmode=0
M$539 VDD \$I64 \$I45 VDD sg13_lv_pmos L=0.13u W=36u AS=7.74p AD=7.74p
+ PS=44.58u PD=44.58u rfmode=0
M$545 \$1.vinp \$I44 \$I45 VDD sg13_lv_pmos L=0.13u W=36u AS=7.74p AD=7.74p
+ PS=44.58u PD=44.58u rfmode=0
M$551 VDD \$I65 \$I47 VDD sg13_lv_pmos L=0.13u W=36u AS=7.74p AD=7.74p
+ PS=44.58u PD=44.58u rfmode=0
M$557 \$2.vinp \$I46 \$I47 VDD sg13_lv_pmos L=0.13u W=36u AS=7.74p AD=7.74p
+ PS=44.58u PD=44.58u rfmode=0
M$563 VDD VDD VDD VDD sg13_lv_pmos L=0.13u W=48u AS=12.72p AD=12.72p PS=76.24u
+ PD=76.24u rfmode=0
M$564 VDD \$I44 \$I64 VDD sg13_lv_pmos L=0.13u W=12u AS=2.28p AD=2.28p
+ PS=12.76u PD=12.76u rfmode=0
M$568 VDD di_filter_en \$I44 VDD sg13_lv_pmos L=0.13u W=12u AS=2.28p AD=2.28p
+ PS=12.76u PD=12.76u rfmode=0
M$572 VDD \$I46 \$I65 VDD sg13_lv_pmos L=0.13u W=12u AS=2.28p AD=2.28p
+ PS=12.76u PD=12.76u rfmode=0
M$576 VDD di_filter_en \$I46 VDD sg13_lv_pmos L=0.13u W=12u AS=2.28p AD=2.28p
+ PS=12.76u PD=12.76u rfmode=0
M$579 VSS VSS VSS VSS sg13_lv_nmos L=0.13u W=8u AS=2.12p AD=2.12p PS=16.24u
+ PD=16.24u rfmode=0
M$580 VSS \$I44 \$I64 VSS sg13_lv_nmos L=0.13u W=2u AS=0.38p AD=0.38p PS=2.76u
+ PD=2.76u rfmode=0
M$584 VSS di_filter_en \$I44 VSS sg13_lv_nmos L=0.13u W=2u AS=0.38p AD=0.38p
+ PS=2.76u PD=2.76u rfmode=0
M$588 VSS \$I46 \$I65 VSS sg13_lv_nmos L=0.13u W=2u AS=0.38p AD=0.38p PS=2.76u
+ PD=2.76u rfmode=0
M$592 VSS di_filter_en \$I46 VSS sg13_lv_nmos L=0.13u W=2u AS=0.38p AD=0.38p
+ PS=2.76u PD=2.76u rfmode=0
.ENDS iqmod_mfb_lpf
