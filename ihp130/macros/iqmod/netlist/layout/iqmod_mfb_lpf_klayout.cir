* Extracted by KLayout with SG13G2 LVS runset on : 25/07/2026 19:17

.SUBCKT iqmod_mfb_lpf VDD VSS di_filter_en vinn vinp voutn voutp
X$1 di_filter_en VSS VDD \$I14 \$I15 voutn voutp
+ iqmod_mfb_lpf_ota_core_hybrid_bm
X$10 VSS \$5 vinp iqmod_mfb_lpf_R1
X$11 VSS \$I14 \$4 iqmod_mfb_lpf_R3
X$13 VSS voutn \$4 iqmod_mfb_lpf_R4
X$15 VSS \$5 \$4 iqmod_mfb_lpf_R2
X$17 VSS \$7 vinn iqmod_mfb_lpf_R1
X$18 VSS \$I15 \$3 iqmod_mfb_lpf_R3
X$20 VSS voutp \$3 iqmod_mfb_lpf_R4
X$22 VSS \$7 \$3 iqmod_mfb_lpf_R2
C$1 voutn \$I14 cap_cmim w=8u l=8u A=64p P=32u m=1
C$2 voutp \$I15 cap_cmim w=8u l=8u A=64p P=32u m=1
C$3 \$3 \$4 cap_cmim w=8u l=8u A=64p P=32u m=3
C$6 \$4 \$3 cap_cmim w=8u l=8u A=64p P=32u m=3
C$9 \$7 \$5 cap_cmim w=8u l=8u A=64p P=32u m=5
C$14 \$5 \$7 cap_cmim w=8u l=8u A=64p P=32u m=5
.ENDS iqmod_mfb_lpf

.SUBCKT iqmod_mfb_lpf_ota_core_hybrid_bm di_ota_en VSS VDD vinp vinn voutn voutp
M$1 VSS VSS VSS VSS sg13_lv_nmos L=1u W=28u AS=7.42p AD=7.42p PS=56.84u
+ PD=56.84u rfmode=0
M$2 VSS \$11 \$12 VSS sg13_lv_nmos L=1u W=12u AS=2.28p AD=2.28p PS=16.56u
+ PD=16.56u rfmode=0
M$10 VSS \$14 \$15 VSS sg13_lv_nmos L=1u W=12u AS=2.28p AD=2.28p PS=16.56u
+ PD=16.56u rfmode=0
M$18 VSS \$15 \$12 VSS sg13_lv_nmos L=1u W=12u AS=2.28p AD=2.28p PS=16.56u
+ PD=16.56u rfmode=0
M$49 VDD VDD VDD VDD sg13_lv_pmos L=1u W=168u AS=44.52p AD=44.52p PS=266.84u
+ PD=266.84u rfmode=0
M$50 VDD \$11 \$12 VDD sg13_lv_pmos L=1u W=72u AS=13.68p AD=13.68p PS=76.56u
+ PD=76.56u rfmode=0
M$58 VDD \$14 \$15 VDD sg13_lv_pmos L=1u W=72u AS=13.68p AD=13.68p PS=76.56u
+ PD=76.56u rfmode=0
M$66 VDD \$15 \$12 VDD sg13_lv_pmos L=1u W=72u AS=13.68p AD=13.68p PS=76.56u
+ PD=76.56u rfmode=0
M$97 \$11 di_ota_en \$12 VSS sg13_lv_nmos L=0.13u W=12u AS=2.58p AD=2.58p
+ PS=19.16u PD=19.16u rfmode=0
M$103 \$14 di_ota_en \$15 VSS sg13_lv_nmos L=0.13u W=12u AS=2.58p AD=2.58p
+ PS=19.16u PD=19.16u rfmode=0
M$121 \$11 \$I26 \$12 VDD sg13_lv_pmos L=0.13u W=36u AS=7.74p AD=7.74p
+ PS=44.58u PD=44.58u rfmode=0
M$127 \$14 \$I26 \$15 VDD sg13_lv_pmos L=0.13u W=36u AS=7.74p AD=7.74p
+ PS=44.58u PD=44.58u rfmode=0
M$133 \$11 \$I28 \$12 VDD sg13_lv_pmos L=0.13u W=36u AS=7.74p AD=7.74p
+ PS=44.58u PD=44.58u rfmode=0
M$139 \$14 \$I28 \$15 VDD sg13_lv_pmos L=0.13u W=36u AS=7.74p AD=7.74p
+ PS=44.58u PD=44.58u rfmode=0
M$146 VSS \$I27 \$11 VSS sg13_lv_nmos L=1u W=10u AS=1.9p AD=1.9p PS=13.8u
+ PD=13.8u rfmode=0
M$158 VSS \$I29 \$11 VSS sg13_lv_nmos L=1u W=10u AS=1.9p AD=1.9p PS=13.8u
+ PD=13.8u rfmode=0
M$170 VDD \$I27 \$11 VDD sg13_lv_pmos L=1u W=60u AS=11.4p AD=11.4p PS=63.8u
+ PD=63.8u rfmode=0
M$182 VDD \$I29 \$11 VDD sg13_lv_pmos L=1u W=60u AS=11.4p AD=11.4p PS=63.8u
+ PD=63.8u rfmode=0
M$194 VSS voutn \$14 VSS sg13_lv_nmos L=1u W=20u AS=3.8p AD=3.8p PS=27.6u
+ PD=27.6u rfmode=0
M$216 VSS \$I27 voutn VSS sg13_lv_nmos L=1u W=20u AS=3.8p AD=3.8p PS=27.6u
+ PD=27.6u rfmode=0
M$238 VSS \$12 voutn VSS sg13_lv_nmos L=1u W=20u AS=3.8p AD=3.8p PS=27.6u
+ PD=27.6u rfmode=0
M$260 VSS voutp \$14 VSS sg13_lv_nmos L=1u W=20u AS=3.8p AD=3.8p PS=27.6u
+ PD=27.6u rfmode=0
M$282 VSS \$I29 voutp VSS sg13_lv_nmos L=1u W=20u AS=3.8p AD=3.8p PS=27.6u
+ PD=27.6u rfmode=0
M$304 VSS \$12 voutp VSS sg13_lv_nmos L=1u W=20u AS=3.8p AD=3.8p PS=27.6u
+ PD=27.6u rfmode=0
M$326 VDD voutn \$14 VDD sg13_lv_pmos L=1u W=120u AS=22.8p AD=22.8p PS=127.6u
+ PD=127.6u rfmode=0
M$348 VDD \$I27 voutn VDD sg13_lv_pmos L=1u W=120u AS=22.8p AD=22.8p PS=127.6u
+ PD=127.6u rfmode=0
M$370 VDD \$12 voutn VDD sg13_lv_pmos L=1u W=120u AS=22.8p AD=22.8p PS=127.6u
+ PD=127.6u rfmode=0
M$392 VDD voutp \$14 VDD sg13_lv_pmos L=1u W=120u AS=22.8p AD=22.8p PS=127.6u
+ PD=127.6u rfmode=0
M$414 VDD \$I29 voutp VDD sg13_lv_pmos L=1u W=120u AS=22.8p AD=22.8p PS=127.6u
+ PD=127.6u rfmode=0
M$436 VDD \$12 voutp VDD sg13_lv_pmos L=1u W=120u AS=22.8p AD=22.8p PS=127.6u
+ PD=127.6u rfmode=0
M$457 VDD \$I26 \$I27 VSS sg13_lv_nmos L=0.13u W=6u AS=1.29p AD=1.29p PS=9.58u
+ PD=9.58u rfmode=0
M$463 vinp \$I30 \$I27 VSS sg13_lv_nmos L=0.13u W=6u AS=1.29p AD=1.29p PS=9.58u
+ PD=9.58u rfmode=0
M$469 VDD \$I28 \$I29 VSS sg13_lv_nmos L=0.13u W=6u AS=1.29p AD=1.29p PS=9.58u
+ PD=9.58u rfmode=0
M$475 vinn \$I31 \$I29 VSS sg13_lv_nmos L=0.13u W=6u AS=1.29p AD=1.29p PS=9.58u
+ PD=9.58u rfmode=0
M$481 VDD \$I30 \$I27 VDD sg13_lv_pmos L=0.13u W=36u AS=7.74p AD=7.74p
+ PS=44.58u PD=44.58u rfmode=0
M$487 vinp \$I26 \$I27 VDD sg13_lv_pmos L=0.13u W=36u AS=7.74p AD=7.74p
+ PS=44.58u PD=44.58u rfmode=0
M$493 VDD \$I31 \$I29 VDD sg13_lv_pmos L=0.13u W=36u AS=7.74p AD=7.74p
+ PS=44.58u PD=44.58u rfmode=0
M$499 vinn \$I28 \$I29 VDD sg13_lv_pmos L=0.13u W=36u AS=7.74p AD=7.74p
+ PS=44.58u PD=44.58u rfmode=0
M$505 VDD VDD VDD VDD sg13_lv_pmos L=0.13u W=48u AS=12.72p AD=12.72p PS=76.24u
+ PD=76.24u rfmode=0
M$506 VDD \$I26 \$I30 VDD sg13_lv_pmos L=0.13u W=12u AS=2.28p AD=2.28p
+ PS=12.76u PD=12.76u rfmode=0
M$510 VDD di_ota_en \$I26 VDD sg13_lv_pmos L=0.13u W=12u AS=2.28p AD=2.28p
+ PS=12.76u PD=12.76u rfmode=0
M$514 VDD \$I28 \$I31 VDD sg13_lv_pmos L=0.13u W=12u AS=2.28p AD=2.28p
+ PS=12.76u PD=12.76u rfmode=0
M$518 VDD di_ota_en \$I28 VDD sg13_lv_pmos L=0.13u W=12u AS=2.28p AD=2.28p
+ PS=12.76u PD=12.76u rfmode=0
M$521 VSS VSS VSS VSS sg13_lv_nmos L=0.13u W=8u AS=2.12p AD=2.12p PS=16.24u
+ PD=16.24u rfmode=0
M$522 VSS \$I26 \$I30 VSS sg13_lv_nmos L=0.13u W=2u AS=0.38p AD=0.38p PS=2.76u
+ PD=2.76u rfmode=0
M$526 VSS di_ota_en \$I26 VSS sg13_lv_nmos L=0.13u W=2u AS=0.38p AD=0.38p
+ PS=2.76u PD=2.76u rfmode=0
M$530 VSS \$I28 \$I31 VSS sg13_lv_nmos L=0.13u W=2u AS=0.38p AD=0.38p PS=2.76u
+ PD=2.76u rfmode=0
M$534 VSS di_ota_en \$I28 VSS sg13_lv_nmos L=0.13u W=2u AS=0.38p AD=0.38p
+ PS=2.76u PD=2.76u rfmode=0
.ENDS iqmod_mfb_lpf_ota_core_hybrid_bm

.SUBCKT iqmod_mfb_lpf_R3 VSS v_b v_a
R$1 VSS VSS VSS rhigh w=0.5u l=59u ps=0u b=0 m=2
R$5 v_a v_b VSS rhigh w=0.5u l=177u ps=0u b=0 m=1
.ENDS iqmod_mfb_lpf_R3

.SUBCKT iqmod_mfb_lpf_R4 VSS v_b v_a
R$1 VSS VSS VSS rhigh w=0.5u l=60u ps=0u b=0 m=2
R$5 v_a v_b VSS rhigh w=0.5u l=180u ps=0u b=0 m=1
.ENDS iqmod_mfb_lpf_R4

.SUBCKT iqmod_mfb_lpf_R1 VSS v_b v_a
R$1 VSS VSS VSS rhigh w=0.5u l=27u ps=0u b=0 m=2
R$5 v_a v_b VSS rhigh w=0.5u l=81u ps=0u b=0 m=1
.ENDS iqmod_mfb_lpf_R1

.SUBCKT iqmod_mfb_lpf_R2 VSS v_b v_a
R$1 VSS VSS VSS rhigh w=0.5u l=31u ps=0u b=0 m=2
R$5 v_a v_b VSS rhigh w=0.5u l=93u ps=0u b=0 m=1
.ENDS iqmod_mfb_lpf_R2
