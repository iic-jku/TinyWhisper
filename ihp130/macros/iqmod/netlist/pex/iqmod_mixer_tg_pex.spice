* PEX produced on Sat Mar 28 07:06:41 PM CET 2026 using /foss/tools/sak/sak-pex.sh with m=1 and s=1
* NGSPICE file created from iqmod_mixer_tg_pex.ext - technology: ihp-sg13g2

.subckt iqmod_mixer_tg_pex VDD di_tg_ctrl_n VSS di_tg_ctrl v_a v_b
X0 v_b di_tg_ctrl_n v_b VSS sg13_lv_nmos ad=0.57p pd=3.38u as=93.24p ps=0.91908m w=3u l=0.13u
X1 v_b di_tg_ctrl v_b VDD sg13_lv_pmos ad=1.71p pd=9.38u as=0 ps=0 w=9u l=0.13u
X2 v_b di_tg_ctrl v_a VSS sg13_lv_nmos ad=0.57p pd=3.38u as=0.57p ps=3.38u w=3u l=0.13u
X3 v_a di_tg_ctrl v_b VSS sg13_lv_nmos ad=0.57p pd=3.38u as=0.57p ps=3.38u w=3u l=0.13u
X4 v_b di_tg_ctrl v_b VDD sg13_lv_pmos ad=1.71p pd=9.38u as=0 ps=0 w=9u l=0.13u
X5 v_b di_tg_ctrl_n v_b VSS sg13_lv_nmos ad=0.57p pd=3.38u as=0 ps=0 w=3u l=0.13u
X6 v_a di_tg_ctrl v_b VSS sg13_lv_nmos ad=0.57p pd=3.38u as=0.57p ps=3.38u w=3u l=0.13u
X7 v_b di_tg_ctrl v_a VSS sg13_lv_nmos ad=0.57p pd=3.38u as=0.57p ps=3.38u w=3u l=0.13u
X8 v_b di_tg_ctrl v_b VDD sg13_lv_pmos ad=1.71p pd=9.38u as=0 ps=0 w=9u l=0.13u
X9 v_b di_tg_ctrl v_b VDD sg13_lv_pmos ad=1.71p pd=9.38u as=0 ps=0 w=9u l=0.13u
X10 v_b di_tg_ctrl_n v_a VDD sg13_lv_pmos ad=1.71p pd=9.38u as=1.71p ps=9.38u w=9u l=0.13u
X11 v_b di_tg_ctrl_n v_a VDD sg13_lv_pmos ad=1.71p pd=9.38u as=1.71p ps=9.38u w=9u l=0.13u
X12 v_b di_tg_ctrl_n v_b VSS sg13_lv_nmos ad=0.57p pd=3.38u as=0 ps=0 w=3u l=0.13u
X13 v_b di_tg_ctrl v_a VSS sg13_lv_nmos ad=0.57p pd=3.38u as=0.57p ps=3.38u w=3u l=0.13u
X14 v_a di_tg_ctrl v_b VSS sg13_lv_nmos ad=0.57p pd=3.38u as=0.57p ps=3.38u w=3u l=0.13u
X15 v_a di_tg_ctrl_n v_b VDD sg13_lv_pmos ad=1.71p pd=9.38u as=1.71p ps=9.38u w=9u l=0.13u
X16 v_b di_tg_ctrl_n v_a VDD sg13_lv_pmos ad=1.71p pd=9.38u as=1.71p ps=9.38u w=9u l=0.13u
X17 v_a di_tg_ctrl_n v_b VDD sg13_lv_pmos ad=1.71p pd=9.38u as=1.71p ps=9.38u w=9u l=0.13u
X18 v_b di_tg_ctrl_n v_b VSS sg13_lv_nmos ad=0.57p pd=3.38u as=0 ps=0 w=3u l=0.13u
X19 v_b di_tg_ctrl_n v_b VSS sg13_lv_nmos ad=0.57p pd=3.38u as=0 ps=0 w=3u l=0.13u
X20 v_b di_tg_ctrl v_a VSS sg13_lv_nmos ad=0.57p pd=3.38u as=0.57p ps=3.38u w=3u l=0.13u
X21 v_b di_tg_ctrl_n v_a VDD sg13_lv_pmos ad=1.71p pd=9.38u as=1.71p ps=9.38u w=9u l=0.13u
X22 v_a di_tg_ctrl_n v_b VDD sg13_lv_pmos ad=1.71p pd=9.38u as=1.71p ps=9.38u w=9u l=0.13u
X23 v_b di_tg_ctrl_n v_b VSS sg13_lv_nmos ad=0.57p pd=3.38u as=0 ps=0 w=3u l=0.13u
X24 v_b di_tg_ctrl_n v_b VSS sg13_lv_nmos ad=0.57p pd=3.38u as=0 ps=0 w=3u l=0.13u
X25 v_b di_tg_ctrl v_a VSS sg13_lv_nmos ad=0.57p pd=3.38u as=0.57p ps=3.38u w=3u l=0.13u
X26 v_a di_tg_ctrl v_b VSS sg13_lv_nmos ad=0.57p pd=3.38u as=0.57p ps=3.38u w=3u l=0.13u
X27 v_b di_tg_ctrl_n v_a VDD sg13_lv_pmos ad=1.71p pd=9.38u as=1.71p ps=9.38u w=9u l=0.13u
X28 v_b di_tg_ctrl_n v_a VDD sg13_lv_pmos ad=1.71p pd=9.38u as=1.71p ps=9.38u w=9u l=0.13u
X29 v_b di_tg_ctrl_n v_b VSS sg13_lv_nmos ad=0.57p pd=3.38u as=0 ps=0 w=3u l=0.13u
X30 v_b di_tg_ctrl_n v_b VSS sg13_lv_nmos ad=0.57p pd=3.38u as=0 ps=0 w=3u l=0.13u
X31 v_a di_tg_ctrl v_b VSS sg13_lv_nmos ad=0.57p pd=3.38u as=0.57p ps=3.38u w=3u l=0.13u
X32 v_b di_tg_ctrl v_b VDD sg13_lv_pmos ad=1.71p pd=9.38u as=0 ps=0 w=9u l=0.13u
X33 v_b di_tg_ctrl v_a VSS sg13_lv_nmos ad=0.57p pd=3.38u as=0.57p ps=3.38u w=3u l=0.13u
X34 v_b di_tg_ctrl v_b VDD sg13_lv_pmos ad=1.71p pd=9.38u as=0 ps=0 w=9u l=0.13u
X35 v_b di_tg_ctrl v_b VDD sg13_lv_pmos ad=1.71p pd=9.38u as=0 ps=0 w=9u l=0.13u
X36 v_b di_tg_ctrl_n v_b VSS sg13_lv_nmos ad=0.57p pd=3.38u as=0 ps=0 w=3u l=0.13u
X37 v_b di_tg_ctrl_n v_b VSS sg13_lv_nmos ad=0.57p pd=3.38u as=0 ps=0 w=3u l=0.13u
X38 v_b di_tg_ctrl v_a VSS sg13_lv_nmos ad=0.57p pd=3.38u as=0.57p ps=3.38u w=3u l=0.13u
X39 v_a di_tg_ctrl v_b VSS sg13_lv_nmos ad=0.57p pd=3.38u as=0.57p ps=3.38u w=3u l=0.13u
X40 v_b di_tg_ctrl v_b VDD sg13_lv_pmos ad=1.71p pd=9.38u as=0 ps=0 w=9u l=0.13u
X41 v_b di_tg_ctrl_n v_b VSS sg13_lv_nmos ad=0.57p pd=3.38u as=0 ps=0 w=3u l=0.13u
X42 v_a di_tg_ctrl_n v_b VDD sg13_lv_pmos ad=1.71p pd=9.38u as=1.71p ps=9.38u w=9u l=0.13u
X43 v_b di_tg_ctrl_n v_a VDD sg13_lv_pmos ad=1.71p pd=9.38u as=1.71p ps=9.38u w=9u l=0.13u
X44 v_b di_tg_ctrl_n v_b VSS sg13_lv_nmos ad=0.57p pd=3.38u as=0 ps=0 w=3u l=0.13u
X45 v_a di_tg_ctrl v_b VSS sg13_lv_nmos ad=0.57p pd=3.38u as=0.57p ps=3.38u w=3u l=0.13u
X46 v_b di_tg_ctrl v_a VSS sg13_lv_nmos ad=0.57p pd=3.38u as=0.57p ps=3.38u w=3u l=0.13u
X47 v_b di_tg_ctrl v_b VDD sg13_lv_pmos ad=1.71p pd=9.38u as=0 ps=0 w=9u l=0.13u
X48 v_b di_tg_ctrl_n v_a VDD sg13_lv_pmos ad=1.71p pd=9.38u as=1.71p ps=9.38u w=9u l=0.13u
X49 v_a di_tg_ctrl_n v_b VDD sg13_lv_pmos ad=1.71p pd=9.38u as=1.71p ps=9.38u w=9u l=0.13u
X50 v_b di_tg_ctrl_n v_b VSS sg13_lv_nmos ad=0.57p pd=3.38u as=0 ps=0 w=3u l=0.13u
X51 v_b di_tg_ctrl v_a VSS sg13_lv_nmos ad=0.57p pd=3.38u as=0.57p ps=3.38u w=3u l=0.13u
X52 v_b di_tg_ctrl_n v_a VDD sg13_lv_pmos ad=1.71p pd=9.38u as=1.71p ps=9.38u w=9u l=0.13u
X53 v_a di_tg_ctrl v_b VSS sg13_lv_nmos ad=0.57p pd=3.38u as=0.57p ps=3.38u w=3u l=0.13u
X54 v_a di_tg_ctrl_n v_b VDD sg13_lv_pmos ad=1.71p pd=9.38u as=1.71p ps=9.38u w=9u l=0.13u
X55 v_b di_tg_ctrl_n v_a VDD sg13_lv_pmos ad=1.71p pd=9.38u as=1.71p ps=9.38u w=9u l=0.13u
X56 v_b di_tg_ctrl_n v_b VSS sg13_lv_nmos ad=0.57p pd=3.38u as=0 ps=0 w=3u l=0.13u
X57 v_b di_tg_ctrl v_a VSS sg13_lv_nmos ad=0.57p pd=3.38u as=0.57p ps=3.38u w=3u l=0.13u
X58 v_a di_tg_ctrl v_b VSS sg13_lv_nmos ad=0.57p pd=3.38u as=0.57p ps=3.38u w=3u l=0.13u
X59 v_b di_tg_ctrl_n v_a VDD sg13_lv_pmos ad=1.71p pd=9.38u as=1.71p ps=9.38u w=9u l=0.13u
X60 v_a di_tg_ctrl_n v_b VDD sg13_lv_pmos ad=1.71p pd=9.38u as=1.71p ps=9.38u w=9u l=0.13u
X61 v_a di_tg_ctrl_n v_b VDD sg13_lv_pmos ad=1.71p pd=9.38u as=1.71p ps=9.38u w=9u l=0.13u
X62 v_b di_tg_ctrl_n v_b VSS sg13_lv_nmos ad=0.57p pd=3.38u as=0 ps=0 w=3u l=0.13u
X63 v_a di_tg_ctrl v_b VSS sg13_lv_nmos ad=0.57p pd=3.38u as=0.57p ps=3.38u w=3u l=0.13u
X64 v_b di_tg_ctrl v_a VSS sg13_lv_nmos ad=0.57p pd=3.38u as=0.57p ps=3.38u w=3u l=0.13u
X65 v_a di_tg_ctrl v_b VSS sg13_lv_nmos ad=0.57p pd=3.38u as=1.02p ps=6.68u w=3u l=0.13u
X66 v_b di_tg_ctrl v_b VDD sg13_lv_pmos ad=1.71p pd=9.38u as=0 ps=0 w=9u l=0.13u
X67 v_b di_tg_ctrl v_b VDD sg13_lv_pmos ad=1.71p pd=9.38u as=0 ps=0 w=9u l=0.13u
X68 v_b di_tg_ctrl v_a VSS sg13_lv_nmos ad=0.57p pd=3.38u as=0.57p ps=3.38u w=3u l=0.13u
X69 v_a di_tg_ctrl v_b VSS sg13_lv_nmos ad=0.57p pd=3.38u as=0.57p ps=3.38u w=3u l=0.13u
X70 v_b di_tg_ctrl v_a VSS sg13_lv_nmos ad=0.57p pd=3.38u as=0.57p ps=3.38u w=3u l=0.13u
X71 v_a di_tg_ctrl_n v_b VDD sg13_lv_pmos ad=1.71p pd=9.38u as=1.71p ps=9.38u w=9u l=0.13u
X72 v_b di_tg_ctrl v_a VSS sg13_lv_nmos ad=0.57p pd=3.38u as=0.57p ps=3.38u w=3u l=0.13u
X73 v_b di_tg_ctrl v_b VDD sg13_lv_pmos ad=1.71p pd=9.38u as=0 ps=0 w=9u l=0.13u
X74 v_a di_tg_ctrl_n v_b VDD sg13_lv_pmos ad=1.71p pd=9.38u as=1.71p ps=9.38u w=9u l=0.13u
X75 v_b di_tg_ctrl v_b VDD sg13_lv_pmos ad=1.71p pd=9.38u as=0 ps=0 w=9u l=0.13u
X76 v_b di_tg_ctrl_n v_a VDD sg13_lv_pmos ad=1.71p pd=9.38u as=1.71p ps=9.38u w=9u l=0.13u
X77 v_a di_tg_ctrl v_b VSS sg13_lv_nmos ad=0.57p pd=3.38u as=0.57p ps=3.38u w=3u l=0.13u
X78 v_a di_tg_ctrl_n v_b VDD sg13_lv_pmos ad=1.71p pd=9.38u as=1.71p ps=9.38u w=9u l=0.13u
X79 v_a di_tg_ctrl_n v_b VDD sg13_lv_pmos ad=1.71p pd=9.38u as=1.71p ps=9.38u w=9u l=0.13u
X80 v_a di_tg_ctrl v_b VSS sg13_lv_nmos ad=0.57p pd=3.38u as=0.57p ps=3.38u w=3u l=0.13u
X81 v_b di_tg_ctrl_n v_a VDD sg13_lv_pmos ad=1.71p pd=9.38u as=1.71p ps=9.38u w=9u l=0.13u
X82 v_a di_tg_ctrl_n v_b VDD sg13_lv_pmos ad=1.71p pd=9.38u as=3.06p ps=18.68u w=9u l=0.13u
X83 v_b di_tg_ctrl v_a VSS sg13_lv_nmos ad=0.57p pd=3.38u as=0.57p ps=3.38u w=3u l=0.13u
X84 v_b di_tg_ctrl_n v_a VDD sg13_lv_pmos ad=1.71p pd=9.38u as=1.71p ps=9.38u w=9u l=0.13u
X85 v_b di_tg_ctrl_n v_a VDD sg13_lv_pmos ad=1.71p pd=9.38u as=1.71p ps=9.38u w=9u l=0.13u
X86 v_a di_tg_ctrl v_b VSS sg13_lv_nmos ad=0.57p pd=3.38u as=0.57p ps=3.38u w=3u l=0.13u
X87 v_b di_tg_ctrl v_a VSS sg13_lv_nmos ad=0.57p pd=3.38u as=0.57p ps=3.38u w=3u l=0.13u
X88 v_b di_tg_ctrl v_b VDD sg13_lv_pmos ad=1.71p pd=9.38u as=0 ps=0 w=9u l=0.13u
X89 v_b di_tg_ctrl v_b VDD sg13_lv_pmos ad=1.71p pd=9.38u as=0 ps=0 w=9u l=0.13u
X90 v_b di_tg_ctrl v_b VDD sg13_lv_pmos ad=1.71p pd=9.38u as=0 ps=0 w=9u l=0.13u
X91 v_a di_tg_ctrl v_b VSS sg13_lv_nmos ad=0.57p pd=3.38u as=0.57p ps=3.38u w=3u l=0.13u
X92 v_b di_tg_ctrl v_b VDD sg13_lv_pmos ad=1.71p pd=9.38u as=0 ps=0 w=9u l=0.13u
X93 v_b di_tg_ctrl_n v_a VDD sg13_lv_pmos ad=1.71p pd=9.38u as=1.71p ps=9.38u w=9u l=0.13u
X94 v_a di_tg_ctrl v_b VSS sg13_lv_nmos ad=0.57p pd=3.38u as=0.57p ps=3.38u w=3u l=0.13u
X95 v_b di_tg_ctrl v_b VDD sg13_lv_pmos ad=1.71p pd=9.38u as=0 ps=0 w=9u l=0.13u
X96 v_a di_tg_ctrl_n v_b VDD sg13_lv_pmos ad=1.71p pd=9.38u as=1.71p ps=9.38u w=9u l=0.13u
X97 v_a di_tg_ctrl_n v_b VDD sg13_lv_pmos ad=1.71p pd=9.38u as=1.71p ps=9.38u w=9u l=0.13u
X98 v_b di_tg_ctrl_n v_b VSS sg13_lv_nmos ad=0.57p pd=3.38u as=0 ps=0 w=3u l=0.13u
X99 v_b di_tg_ctrl_n v_a VDD sg13_lv_pmos ad=1.71p pd=9.38u as=1.71p ps=9.38u w=9u l=0.13u
X100 v_b di_tg_ctrl v_a VSS sg13_lv_nmos ad=0.57p pd=3.38u as=0.57p ps=3.38u w=3u l=0.13u
X101 v_a di_tg_ctrl_n v_b VDD sg13_lv_pmos ad=1.71p pd=9.38u as=1.71p ps=9.38u w=9u l=0.13u
X102 v_b di_tg_ctrl_n v_a VDD sg13_lv_pmos ad=1.71p pd=9.38u as=1.71p ps=9.38u w=9u l=0.13u
X103 v_a di_tg_ctrl_n v_b VDD sg13_lv_pmos ad=1.71p pd=9.38u as=1.71p ps=9.38u w=9u l=0.13u
X104 v_b di_tg_ctrl_n v_b VSS sg13_lv_nmos ad=0.57p pd=3.38u as=0 ps=0 w=3u l=0.13u
X105 v_a di_tg_ctrl v_b VSS sg13_lv_nmos ad=0.57p pd=3.38u as=0.57p ps=3.38u w=3u l=0.13u
X106 v_b di_tg_ctrl v_a VSS sg13_lv_nmos ad=0.57p pd=3.38u as=0.57p ps=3.38u w=3u l=0.13u
X107 v_a di_tg_ctrl_n v_b VDD sg13_lv_pmos ad=1.71p pd=9.38u as=1.71p ps=9.38u w=9u l=0.13u
C0 v_a VSS 53.518f
C1 v_b VSS 86.7685f
C2 di_tg_ctrl VSS 16.3123f
C3 di_tg_ctrl_n VSS 17.6566f
C4 VDD VSS 13.3327f
.ends
