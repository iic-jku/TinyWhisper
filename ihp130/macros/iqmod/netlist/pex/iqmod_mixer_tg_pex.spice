* PEX produced on 2026-11-14 using kpex 0.9.0 with --2.5D --mode RC --blackbox y --reduce ticer
*********************************************************
*** NGSPICE file created by KLayout-PEX 0.9.0
*** -----------------------------------------------------
***     Extraction Engine: KPEX/2.5D
***     Technology: ihp_sg13g2
***     Date: 2026-11-14 14:53:25
*********************************************************

.SUBCKT iqmod_mixer_tg_pex VDD di_tg_ctrl VSS v_b v_a di_tg_ctrl_n
X$1 v_a.P0.nSD di_tg_ctrl.P0.GatPoly v_b.P0.nSD VSS sg13_lv_nmos w=3e-06
+ l=1.3e-07 as=1.02e-12 ad=5.7e-13 ps=6.68e-06 pd=3.38e-06
X$2 v_b.P1.nSD di_tg_ctrl.P1.GatPoly v_a.P0.nSD VSS sg13_lv_nmos w=3e-06
+ l=1.3e-07 as=5.7e-13 ad=5.7e-13 ps=3.38e-06 pd=3.38e-06
X$3 v_a.P2.nSD di_tg_ctrl.P2.GatPoly v_b.P1.nSD VSS sg13_lv_nmos w=3e-06
+ l=1.3e-07 as=5.7e-13 ad=5.7e-13 ps=3.38e-06 pd=3.38e-06
X$4 v_b.P3.nSD di_tg_ctrl.P3.GatPoly v_a.P2.nSD VSS sg13_lv_nmos w=3e-06
+ l=1.3e-07 as=5.7e-13 ad=5.7e-13 ps=3.38e-06 pd=3.38e-06
X$5 v_a.P4.nSD di_tg_ctrl.P4.GatPoly v_b.P3.nSD VSS sg13_lv_nmos w=3e-06
+ l=1.3e-07 as=5.7e-13 ad=5.7e-13 ps=3.38e-06 pd=3.38e-06
X$6 v_b.P5.nSD di_tg_ctrl.P5.GatPoly v_a.P4.nSD VSS sg13_lv_nmos w=3e-06
+ l=1.3e-07 as=5.7e-13 ad=5.7e-13 ps=3.38e-06 pd=3.38e-06
X$7 v_a.P6.nSD di_tg_ctrl.P6.GatPoly v_b.P5.nSD VSS sg13_lv_nmos w=3e-06
+ l=1.3e-07 as=5.7e-13 ad=5.7e-13 ps=3.38e-06 pd=3.38e-06
X$8 v_b.P7.nSD di_tg_ctrl.P7.GatPoly v_a.P6.nSD VSS sg13_lv_nmos w=3e-06
+ l=1.3e-07 as=5.7e-13 ad=5.7e-13 ps=3.38e-06 pd=3.38e-06
X$9 v_a.P8.nSD di_tg_ctrl.P8.GatPoly v_b.P7.nSD VSS sg13_lv_nmos w=3e-06
+ l=1.3e-07 as=5.7e-13 ad=5.7e-13 ps=3.38e-06 pd=3.38e-06
X$10 v_b.P10.nSD di_tg_ctrl.P9.GatPoly v_a.P8.nSD VSS sg13_lv_nmos w=3e-06
+ l=1.3e-07 as=5.7e-13 ad=5.7e-13 ps=3.38e-06 pd=3.38e-06
X$11 v_a.P10.nSD di_tg_ctrl.P10.GatPoly v_b.P10.nSD VSS sg13_lv_nmos w=3e-06
+ l=1.3e-07 as=5.7e-13 ad=5.7e-13 ps=3.38e-06 pd=3.38e-06
X$12 v_b.P11.nSD di_tg_ctrl.P11.GatPoly v_a.P10.nSD VSS sg13_lv_nmos w=3e-06
+ l=1.3e-07 as=5.7e-13 ad=5.7e-13 ps=3.38e-06 pd=3.38e-06
X$13 v_a.P12.nSD di_tg_ctrl.P12.GatPoly v_b.P11.nSD VSS sg13_lv_nmos w=3e-06
+ l=1.3e-07 as=5.7e-13 ad=5.7e-13 ps=3.38e-06 pd=3.38e-06
X$14 v_b.P13.nSD di_tg_ctrl.P13.GatPoly v_a.P12.nSD VSS sg13_lv_nmos w=3e-06
+ l=1.3e-07 as=5.7e-13 ad=5.7e-13 ps=3.38e-06 pd=3.38e-06
X$15 v_a.P14.nSD di_tg_ctrl.P14.GatPoly v_b.P13.nSD VSS sg13_lv_nmos w=3e-06
+ l=1.3e-07 as=5.7e-13 ad=5.7e-13 ps=3.38e-06 pd=3.38e-06
X$16 v_b.P15.nSD di_tg_ctrl.P15.GatPoly v_a.P14.nSD VSS sg13_lv_nmos w=3e-06
+ l=1.3e-07 as=5.7e-13 ad=5.7e-13 ps=3.38e-06 pd=3.38e-06
X$17 v_a.P16.nSD di_tg_ctrl.P16.GatPoly v_b.P15.nSD VSS sg13_lv_nmos w=3e-06
+ l=1.3e-07 as=5.7e-13 ad=5.7e-13 ps=3.38e-06 pd=3.38e-06
X$18 v_b.P17.nSD di_tg_ctrl.P17.GatPoly v_a.P16.nSD VSS sg13_lv_nmos w=3e-06
+ l=1.3e-07 as=5.7e-13 ad=5.7e-13 ps=3.38e-06 pd=3.38e-06
X$19 v_a.P18.nSD di_tg_ctrl.P18.GatPoly v_b.P17.nSD VSS sg13_lv_nmos w=3e-06
+ l=1.3e-07 as=5.7e-13 ad=5.7e-13 ps=3.38e-06 pd=3.38e-06
X$20 v_b.P19.nSD di_tg_ctrl.P19.GatPoly v_a.P18.nSD VSS sg13_lv_nmos w=3e-06
+ l=1.3e-07 as=5.7e-13 ad=5.7e-13 ps=3.38e-06 pd=3.38e-06
X$21 v_a.P20.nSD di_tg_ctrl.P20.GatPoly v_b.P19.nSD VSS sg13_lv_nmos w=3e-06
+ l=1.3e-07 as=5.7e-13 ad=5.7e-13 ps=3.38e-06 pd=3.38e-06
X$22 v_b.P21.nSD di_tg_ctrl.P21.GatPoly v_a.P20.nSD VSS sg13_lv_nmos w=3e-06
+ l=1.3e-07 as=5.7e-13 ad=5.7e-13 ps=3.38e-06 pd=3.38e-06
X$23 v_a.P22.nSD di_tg_ctrl.P22.GatPoly v_b.P21.nSD VSS sg13_lv_nmos w=3e-06
+ l=1.3e-07 as=5.7e-13 ad=5.7e-13 ps=3.38e-06 pd=3.38e-06
X$24 v_b.P23.nSD di_tg_ctrl.P23.GatPoly v_a.P22.nSD VSS sg13_lv_nmos w=3e-06
+ l=1.3e-07 as=5.7e-13 ad=5.7e-13 ps=3.38e-06 pd=3.38e-06
X$25 v_a.P24.nSD di_tg_ctrl.P24.GatPoly v_b.P23.nSD VSS sg13_lv_nmos w=3e-06
+ l=1.3e-07 as=5.7e-13 ad=5.7e-13 ps=3.38e-06 pd=3.38e-06
X$26 v_b.P25.nSD di_tg_ctrl.P25.GatPoly v_a.P24.nSD VSS sg13_lv_nmos w=3e-06
+ l=1.3e-07 as=5.7e-13 ad=5.7e-13 ps=3.38e-06 pd=3.38e-06
X$27 v_a.P26.nSD di_tg_ctrl.P26.GatPoly v_b.P25.nSD VSS sg13_lv_nmos w=3e-06
+ l=1.3e-07 as=5.7e-13 ad=5.7e-13 ps=3.38e-06 pd=3.38e-06
X$28 v_b.P27.nSD di_tg_ctrl.P27.GatPoly v_a.P26.nSD VSS sg13_lv_nmos w=3e-06
+ l=1.3e-07 as=5.7e-13 ad=5.7e-13 ps=3.38e-06 pd=3.38e-06
X$29 v_a.P28.nSD di_tg_ctrl.P28.GatPoly v_b.P27.nSD VSS sg13_lv_nmos w=3e-06
+ l=1.3e-07 as=5.7e-13 ad=5.7e-13 ps=3.38e-06 pd=3.38e-06
X$30 v_b.P29.nSD di_tg_ctrl.P29.GatPoly v_a.P28.nSD VSS sg13_lv_nmos w=3e-06
+ l=1.3e-07 as=5.7e-13 ad=5.7e-13 ps=3.38e-06 pd=3.38e-06
X$31 v_a.P30.nSD di_tg_ctrl.P30.GatPoly v_b.P29.nSD VSS sg13_lv_nmos w=3e-06
+ l=1.3e-07 as=5.7e-13 ad=5.7e-13 ps=3.38e-06 pd=3.38e-06
X$32 v_b.P31.nSD di_tg_ctrl.P31.GatPoly v_a.P30.nSD VSS sg13_lv_nmos w=3e-06
+ l=1.3e-07 as=5.7e-13 ad=5.7e-13 ps=3.38e-06 pd=3.38e-06
X$33 v_a.P32.nSD di_tg_ctrl.P32.GatPoly v_b.P31.nSD VSS sg13_lv_nmos w=3e-06
+ l=1.3e-07 as=5.7e-13 ad=5.7e-13 ps=3.38e-06 pd=3.38e-06
X$34 v_b.P33.nSD di_tg_ctrl.P33.GatPoly v_a.P32.nSD VSS sg13_lv_nmos w=3e-06
+ l=1.3e-07 as=5.7e-13 ad=5.7e-13 ps=3.38e-06 pd=3.38e-06
X$35 v_a.P34.nSD di_tg_ctrl.P34.GatPoly v_b.P33.nSD VSS sg13_lv_nmos w=3e-06
+ l=1.3e-07 as=5.7e-13 ad=5.7e-13 ps=3.38e-06 pd=3.38e-06
X$36 v_b.P35.nSD di_tg_ctrl.P35.GatPoly v_a.P34.nSD VSS sg13_lv_nmos w=3e-06
+ l=1.3e-07 as=5.7e-13 ad=5.7e-13 ps=3.38e-06 pd=3.38e-06
X$37 v_b.P37.nSD di_tg_ctrl_n.P0.GatPoly v_b.P35.nSD VSS sg13_lv_nmos w=3e-06
+ l=1.3e-07 as=5.7e-13 ad=5.7e-13 ps=3.38e-06 pd=3.38e-06
X$38 v_b.P39.nSD di_tg_ctrl_n.P1.GatPoly v_b.P37.nSD VSS sg13_lv_nmos w=3e-06
+ l=1.3e-07 as=5.7e-13 ad=5.7e-13 ps=3.38e-06 pd=3.38e-06
X$39 v_b.P41.nSD di_tg_ctrl_n.P2.GatPoly v_b.P39.nSD VSS sg13_lv_nmos w=3e-06
+ l=1.3e-07 as=5.7e-13 ad=5.7e-13 ps=3.38e-06 pd=3.38e-06
X$40 v_b.P43.nSD di_tg_ctrl_n.P3.GatPoly v_b.P41.nSD VSS sg13_lv_nmos w=3e-06
+ l=1.3e-07 as=5.7e-13 ad=5.7e-13 ps=3.38e-06 pd=3.38e-06
X$41 v_b.P45.nSD di_tg_ctrl_n.P4.GatPoly v_b.P43.nSD VSS sg13_lv_nmos w=3e-06
+ l=1.3e-07 as=5.7e-13 ad=5.7e-13 ps=3.38e-06 pd=3.38e-06
X$42 v_b.P47.nSD di_tg_ctrl_n.P5.GatPoly v_b.P45.nSD VSS sg13_lv_nmos w=3e-06
+ l=1.3e-07 as=5.7e-13 ad=5.7e-13 ps=3.38e-06 pd=3.38e-06
X$43 v_b.P49.nSD di_tg_ctrl_n.P6.GatPoly v_b.P47.nSD VSS sg13_lv_nmos w=3e-06
+ l=1.3e-07 as=5.7e-13 ad=5.7e-13 ps=3.38e-06 pd=3.38e-06
X$44 v_b.P51.nSD di_tg_ctrl_n.P7.GatPoly v_b.P49.nSD VSS sg13_lv_nmos w=3e-06
+ l=1.3e-07 as=5.7e-13 ad=5.7e-13 ps=3.38e-06 pd=3.38e-06
X$45 v_b.P53.nSD di_tg_ctrl_n.P8.GatPoly v_b.P51.nSD VSS sg13_lv_nmos w=3e-06
+ l=1.3e-07 as=5.7e-13 ad=5.7e-13 ps=3.38e-06 pd=3.38e-06
X$46 v_b.P55.nSD di_tg_ctrl_n.P9.GatPoly v_b.P53.nSD VSS sg13_lv_nmos w=3e-06
+ l=1.3e-07 as=5.7e-13 ad=5.7e-13 ps=3.38e-06 pd=3.38e-06
X$47 v_b.P57.nSD di_tg_ctrl_n.P10.GatPoly v_b.P55.nSD VSS sg13_lv_nmos w=3e-06
+ l=1.3e-07 as=5.7e-13 ad=5.7e-13 ps=3.38e-06 pd=3.38e-06
X$48 v_b.P59.nSD di_tg_ctrl_n.P11.GatPoly v_b.P57.nSD VSS sg13_lv_nmos w=3e-06
+ l=1.3e-07 as=5.7e-13 ad=5.7e-13 ps=3.38e-06 pd=3.38e-06
X$49 v_b.P61.nSD di_tg_ctrl_n.P12.GatPoly v_b.P59.nSD VSS sg13_lv_nmos w=3e-06
+ l=1.3e-07 as=5.7e-13 ad=5.7e-13 ps=3.38e-06 pd=3.38e-06
X$50 v_b.P63.nSD di_tg_ctrl_n.P13.GatPoly v_b.P61.nSD VSS sg13_lv_nmos w=3e-06
+ l=1.3e-07 as=5.7e-13 ad=5.7e-13 ps=3.38e-06 pd=3.38e-06
X$51 v_b.P65.nSD di_tg_ctrl_n.P14.GatPoly v_b.P63.nSD VSS sg13_lv_nmos w=3e-06
+ l=1.3e-07 as=5.7e-13 ad=5.7e-13 ps=3.38e-06 pd=3.38e-06
X$52 v_b.P67.nSD di_tg_ctrl_n.P15.GatPoly v_b.P65.nSD VSS sg13_lv_nmos w=3e-06
+ l=1.3e-07 as=5.7e-13 ad=5.7e-13 ps=3.38e-06 pd=3.38e-06
X$53 v_b.P69.nSD di_tg_ctrl_n.P16.GatPoly v_b.P67.nSD VSS sg13_lv_nmos w=3e-06
+ l=1.3e-07 as=5.7e-13 ad=5.7e-13 ps=3.38e-06 pd=3.38e-06
X$54 v_b.P71.nSD di_tg_ctrl_n.P17.GatPoly v_b.P69.nSD VSS sg13_lv_nmos w=3e-06
+ l=1.3e-07 as=5.7e-13 ad=1.02e-12 ps=3.38e-06 pd=6.68e-06
X$55 VSS.P0.pSD VSS ptap1
X$56 v_a.P0.pSD di_tg_ctrl_n.P18.GatPoly v_b.P0.pSD \$I125 sg13_lv_pmos w=9e-06
+ l=1.3e-07 as=3.06e-12 ad=1.71e-12 ps=1.868e-05 pd=9.38e-06
X$57 v_b.P1.pSD di_tg_ctrl_n.P19.GatPoly v_a.P0.pSD \$I125 sg13_lv_pmos w=9e-06
+ l=1.3e-07 as=1.71e-12 ad=1.71e-12 ps=9.38e-06 pd=9.38e-06
X$58 v_a.P2.pSD di_tg_ctrl_n.P20.GatPoly v_b.P1.pSD \$I125 sg13_lv_pmos w=9e-06
+ l=1.3e-07 as=1.71e-12 ad=1.71e-12 ps=9.38e-06 pd=9.38e-06
X$59 v_b.P3.pSD di_tg_ctrl_n.P21.GatPoly v_a.P2.pSD \$I125 sg13_lv_pmos w=9e-06
+ l=1.3e-07 as=1.71e-12 ad=1.71e-12 ps=9.38e-06 pd=9.38e-06
X$60 v_a.P4.pSD di_tg_ctrl_n.P22.GatPoly v_b.P3.pSD \$I125 sg13_lv_pmos w=9e-06
+ l=1.3e-07 as=1.71e-12 ad=1.71e-12 ps=9.38e-06 pd=9.38e-06
X$61 v_b.P5.pSD di_tg_ctrl_n.P23.GatPoly v_a.P4.pSD \$I125 sg13_lv_pmos w=9e-06
+ l=1.3e-07 as=1.71e-12 ad=1.71e-12 ps=9.38e-06 pd=9.38e-06
X$62 v_a.P6.pSD di_tg_ctrl_n.P24.GatPoly v_b.P5.pSD \$I125 sg13_lv_pmos w=9e-06
+ l=1.3e-07 as=1.71e-12 ad=1.71e-12 ps=9.38e-06 pd=9.38e-06
X$63 v_b.P7.pSD di_tg_ctrl_n.P25.GatPoly v_a.P6.pSD \$I125 sg13_lv_pmos w=9e-06
+ l=1.3e-07 as=1.71e-12 ad=1.71e-12 ps=9.38e-06 pd=9.38e-06
X$64 v_a.P8.pSD di_tg_ctrl_n.P26.GatPoly v_b.P7.pSD \$I125 sg13_lv_pmos w=9e-06
+ l=1.3e-07 as=1.71e-12 ad=1.71e-12 ps=9.38e-06 pd=9.38e-06
X$65 v_b.P10.pSD di_tg_ctrl_n.P27.GatPoly v_a.P8.pSD \$I125 sg13_lv_pmos
+ w=9e-06 l=1.3e-07 as=1.71e-12 ad=1.71e-12 ps=9.38e-06 pd=9.38e-06
X$66 v_a.P10.pSD di_tg_ctrl_n.P28.GatPoly v_b.P10.pSD \$I125 sg13_lv_pmos
+ w=9e-06 l=1.3e-07 as=1.71e-12 ad=1.71e-12 ps=9.38e-06 pd=9.38e-06
X$67 v_b.P11.pSD di_tg_ctrl_n.P29.GatPoly v_a.P10.pSD \$I125 sg13_lv_pmos
+ w=9e-06 l=1.3e-07 as=1.71e-12 ad=1.71e-12 ps=9.38e-06 pd=9.38e-06
X$68 v_a.P12.pSD di_tg_ctrl_n.P30.GatPoly v_b.P11.pSD \$I125 sg13_lv_pmos
+ w=9e-06 l=1.3e-07 as=1.71e-12 ad=1.71e-12 ps=9.38e-06 pd=9.38e-06
X$69 v_b.P13.pSD di_tg_ctrl_n.P31.GatPoly v_a.P12.pSD \$I125 sg13_lv_pmos
+ w=9e-06 l=1.3e-07 as=1.71e-12 ad=1.71e-12 ps=9.38e-06 pd=9.38e-06
X$70 v_a.P14.pSD di_tg_ctrl_n.P32.GatPoly v_b.P13.pSD \$I125 sg13_lv_pmos
+ w=9e-06 l=1.3e-07 as=1.71e-12 ad=1.71e-12 ps=9.38e-06 pd=9.38e-06
X$71 v_b.P15.pSD di_tg_ctrl_n.P33.GatPoly v_a.P14.pSD \$I125 sg13_lv_pmos
+ w=9e-06 l=1.3e-07 as=1.71e-12 ad=1.71e-12 ps=9.38e-06 pd=9.38e-06
X$72 v_a.P16.pSD di_tg_ctrl_n.P34.GatPoly v_b.P15.pSD \$I125 sg13_lv_pmos
+ w=9e-06 l=1.3e-07 as=1.71e-12 ad=1.71e-12 ps=9.38e-06 pd=9.38e-06
X$73 v_b.P17.pSD di_tg_ctrl_n.P35.GatPoly v_a.P16.pSD \$I125 sg13_lv_pmos
+ w=9e-06 l=1.3e-07 as=1.71e-12 ad=1.71e-12 ps=9.38e-06 pd=9.38e-06
X$74 v_a.P18.pSD di_tg_ctrl_n.P36.GatPoly v_b.P17.pSD \$I125 sg13_lv_pmos
+ w=9e-06 l=1.3e-07 as=1.71e-12 ad=1.71e-12 ps=9.38e-06 pd=9.38e-06
X$75 v_b.P19.pSD di_tg_ctrl_n.P37.GatPoly v_a.P18.pSD \$I125 sg13_lv_pmos
+ w=9e-06 l=1.3e-07 as=1.71e-12 ad=1.71e-12 ps=9.38e-06 pd=9.38e-06
X$76 v_a.P20.pSD di_tg_ctrl_n.P38.GatPoly v_b.P19.pSD \$I125 sg13_lv_pmos
+ w=9e-06 l=1.3e-07 as=1.71e-12 ad=1.71e-12 ps=9.38e-06 pd=9.38e-06
X$77 v_b.P21.pSD di_tg_ctrl_n.P39.GatPoly v_a.P20.pSD \$I125 sg13_lv_pmos
+ w=9e-06 l=1.3e-07 as=1.71e-12 ad=1.71e-12 ps=9.38e-06 pd=9.38e-06
X$78 v_a.P22.pSD di_tg_ctrl_n.P40.GatPoly v_b.P21.pSD \$I125 sg13_lv_pmos
+ w=9e-06 l=1.3e-07 as=1.71e-12 ad=1.71e-12 ps=9.38e-06 pd=9.38e-06
X$79 v_b.P23.pSD di_tg_ctrl_n.P41.GatPoly v_a.P22.pSD \$I125 sg13_lv_pmos
+ w=9e-06 l=1.3e-07 as=1.71e-12 ad=1.71e-12 ps=9.38e-06 pd=9.38e-06
X$80 v_a.P24.pSD di_tg_ctrl_n.P42.GatPoly v_b.P23.pSD \$I125 sg13_lv_pmos
+ w=9e-06 l=1.3e-07 as=1.71e-12 ad=1.71e-12 ps=9.38e-06 pd=9.38e-06
X$81 v_b.P25.pSD di_tg_ctrl_n.P43.GatPoly v_a.P24.pSD \$I125 sg13_lv_pmos
+ w=9e-06 l=1.3e-07 as=1.71e-12 ad=1.71e-12 ps=9.38e-06 pd=9.38e-06
X$82 v_a.P26.pSD di_tg_ctrl_n.P44.GatPoly v_b.P25.pSD \$I125 sg13_lv_pmos
+ w=9e-06 l=1.3e-07 as=1.71e-12 ad=1.71e-12 ps=9.38e-06 pd=9.38e-06
X$83 v_b.P27.pSD di_tg_ctrl_n.P45.GatPoly v_a.P26.pSD \$I125 sg13_lv_pmos
+ w=9e-06 l=1.3e-07 as=1.71e-12 ad=1.71e-12 ps=9.38e-06 pd=9.38e-06
X$84 v_a.P28.pSD di_tg_ctrl_n.P46.GatPoly v_b.P27.pSD \$I125 sg13_lv_pmos
+ w=9e-06 l=1.3e-07 as=1.71e-12 ad=1.71e-12 ps=9.38e-06 pd=9.38e-06
X$85 v_b.P29.pSD di_tg_ctrl_n.P47.GatPoly v_a.P28.pSD \$I125 sg13_lv_pmos
+ w=9e-06 l=1.3e-07 as=1.71e-12 ad=1.71e-12 ps=9.38e-06 pd=9.38e-06
X$86 v_a.P30.pSD di_tg_ctrl_n.P48.GatPoly v_b.P29.pSD \$I125 sg13_lv_pmos
+ w=9e-06 l=1.3e-07 as=1.71e-12 ad=1.71e-12 ps=9.38e-06 pd=9.38e-06
X$87 v_b.P31.pSD di_tg_ctrl_n.P49.GatPoly v_a.P30.pSD \$I125 sg13_lv_pmos
+ w=9e-06 l=1.3e-07 as=1.71e-12 ad=1.71e-12 ps=9.38e-06 pd=9.38e-06
X$88 v_a.P32.pSD di_tg_ctrl_n.P50.GatPoly v_b.P31.pSD \$I125 sg13_lv_pmos
+ w=9e-06 l=1.3e-07 as=1.71e-12 ad=1.71e-12 ps=9.38e-06 pd=9.38e-06
X$89 v_b.P33.pSD di_tg_ctrl_n.P51.GatPoly v_a.P32.pSD \$I125 sg13_lv_pmos
+ w=9e-06 l=1.3e-07 as=1.71e-12 ad=1.71e-12 ps=9.38e-06 pd=9.38e-06
X$90 v_a.P34.pSD di_tg_ctrl_n.P52.GatPoly v_b.P33.pSD \$I125 sg13_lv_pmos
+ w=9e-06 l=1.3e-07 as=1.71e-12 ad=1.71e-12 ps=9.38e-06 pd=9.38e-06
X$91 v_b.P35.pSD di_tg_ctrl_n.P53.GatPoly v_a.P34.pSD \$I125 sg13_lv_pmos
+ w=9e-06 l=1.3e-07 as=1.71e-12 ad=1.71e-12 ps=9.38e-06 pd=9.38e-06
X$92 v_b.P37.pSD di_tg_ctrl.P36.GatPoly v_b.P35.pSD \$I125 sg13_lv_pmos w=9e-06
+ l=1.3e-07 as=1.71e-12 ad=1.71e-12 ps=9.38e-06 pd=9.38e-06
X$93 v_b.P39.pSD di_tg_ctrl.P37.GatPoly v_b.P37.pSD \$I125 sg13_lv_pmos w=9e-06
+ l=1.3e-07 as=1.71e-12 ad=1.71e-12 ps=9.38e-06 pd=9.38e-06
X$94 v_b.P41.pSD di_tg_ctrl.P38.GatPoly v_b.P39.pSD \$I125 sg13_lv_pmos w=9e-06
+ l=1.3e-07 as=1.71e-12 ad=1.71e-12 ps=9.38e-06 pd=9.38e-06
X$95 v_b.P43.pSD di_tg_ctrl.P39.GatPoly v_b.P41.pSD \$I125 sg13_lv_pmos w=9e-06
+ l=1.3e-07 as=1.71e-12 ad=1.71e-12 ps=9.38e-06 pd=9.38e-06
X$96 v_b.P45.pSD di_tg_ctrl.P40.GatPoly v_b.P43.pSD \$I125 sg13_lv_pmos w=9e-06
+ l=1.3e-07 as=1.71e-12 ad=1.71e-12 ps=9.38e-06 pd=9.38e-06
X$97 v_b.P47.pSD di_tg_ctrl.P41.GatPoly v_b.P45.pSD \$I125 sg13_lv_pmos w=9e-06
+ l=1.3e-07 as=1.71e-12 ad=1.71e-12 ps=9.38e-06 pd=9.38e-06
X$98 v_b.P49.pSD di_tg_ctrl.P42.GatPoly v_b.P47.pSD \$I125 sg13_lv_pmos w=9e-06
+ l=1.3e-07 as=1.71e-12 ad=1.71e-12 ps=9.38e-06 pd=9.38e-06
X$99 v_b.P51.pSD di_tg_ctrl.P43.GatPoly v_b.P49.pSD \$I125 sg13_lv_pmos w=9e-06
+ l=1.3e-07 as=1.71e-12 ad=1.71e-12 ps=9.38e-06 pd=9.38e-06
X$100 v_b.P53.pSD di_tg_ctrl.P44.GatPoly v_b.P51.pSD \$I125 sg13_lv_pmos
+ w=9e-06 l=1.3e-07 as=1.71e-12 ad=1.71e-12 ps=9.38e-06 pd=9.38e-06
X$101 v_b.P55.pSD di_tg_ctrl.P45.GatPoly v_b.P53.pSD \$I125 sg13_lv_pmos
+ w=9e-06 l=1.3e-07 as=1.71e-12 ad=1.71e-12 ps=9.38e-06 pd=9.38e-06
X$102 v_b.P57.pSD di_tg_ctrl.P46.GatPoly v_b.P55.pSD \$I125 sg13_lv_pmos
+ w=9e-06 l=1.3e-07 as=1.71e-12 ad=1.71e-12 ps=9.38e-06 pd=9.38e-06
X$103 v_b.P59.pSD di_tg_ctrl.P47.GatPoly v_b.P57.pSD \$I125 sg13_lv_pmos
+ w=9e-06 l=1.3e-07 as=1.71e-12 ad=1.71e-12 ps=9.38e-06 pd=9.38e-06
X$104 v_b.P61.pSD di_tg_ctrl.P48.GatPoly v_b.P59.pSD \$I125 sg13_lv_pmos
+ w=9e-06 l=1.3e-07 as=1.71e-12 ad=1.71e-12 ps=9.38e-06 pd=9.38e-06
X$105 v_b.P63.pSD di_tg_ctrl.P49.GatPoly v_b.P61.pSD \$I125 sg13_lv_pmos
+ w=9e-06 l=1.3e-07 as=1.71e-12 ad=1.71e-12 ps=9.38e-06 pd=9.38e-06
X$106 v_b.P65.pSD di_tg_ctrl.P50.GatPoly v_b.P63.pSD \$I125 sg13_lv_pmos
+ w=9e-06 l=1.3e-07 as=1.71e-12 ad=1.71e-12 ps=9.38e-06 pd=9.38e-06
X$107 v_b.P67.pSD di_tg_ctrl.P51.GatPoly v_b.P65.pSD \$I125 sg13_lv_pmos
+ w=9e-06 l=1.3e-07 as=1.71e-12 ad=1.71e-12 ps=9.38e-06 pd=9.38e-06
X$108 v_b.P69.pSD di_tg_ctrl.P52.GatPoly v_b.P67.pSD \$I125 sg13_lv_pmos
+ w=9e-06 l=1.3e-07 as=1.71e-12 ad=1.71e-12 ps=9.38e-06 pd=9.38e-06
X$109 v_b.P71.pSD di_tg_ctrl.P53.GatPoly v_b.P69.pSD \$I125 sg13_lv_pmos
+ w=9e-06 l=1.3e-07 as=1.71e-12 ad=3.06e-12 ps=9.38e-06 pd=1.868e-05
X$110 VDD.P0.nSD \$I125 ntap1
* netlist reduce (TICER tau=0.1ps max degree 5, floating max degree 64): 12985 R, 20362 C, 7853 nodes -> 4106 R, 15572 C, 1242 nodes
Cred_1 \$I125 di_tg_ctrl.$100.GatPoly 0.0338351f
Cred_2 \$I125 di_tg_ctrl.$103.GatPoly 0.0327115f
Cred_3 \$I125 di_tg_ctrl.$105.GatPoly 0.0378803f
Cred_4 \$I125 di_tg_ctrl.$109.GatPoly 0.0438026f
Cred_5 \$I125 di_tg_ctrl.$112.GatPoly 0.0338351f
Cred_6 \$I125 di_tg_ctrl.$115.GatPoly 0.0401651f
Cred_7 \$I125 di_tg_ctrl.$119.GatPoly 0.0438026f
Cred_8 \$I125 di_tg_ctrl.$122.GatPoly 0.0315503f
Cred_9 \$I125 di_tg_ctrl.$124.GatPoly 0.0262841f
Cred_10 \$I125 di_tg_ctrl.$126.GatPoly 0.0728072f
Cred_11 \$I125 di_tg_ctrl.$223.Metal1 0.017943f
Cred_12 \$I125 di_tg_ctrl.$225.Metal1 0.00391711f
Cred_13 \$I125 di_tg_ctrl.$227.Metal1 0.00733404f
Cred_14 \$I125 di_tg_ctrl.$230.Metal1 0.0107489f
Cred_15 \$I125 di_tg_ctrl.$232.Metal1 0.00847891f
Cred_16 \$I125 di_tg_ctrl.$234.Metal1 0.00405979f
Cred_17 \$I125 di_tg_ctrl.$236.Metal1 0.00394335f
Cred_18 \$I125 di_tg_ctrl.$238.Metal1 0.00733557f
Cred_19 \$I125 di_tg_ctrl.$241.Metal1 0.00488438f
Cred_20 \$I125 di_tg_ctrl.$243.Metal1 0.00847828f
Cred_21 \$I125 di_tg_ctrl.$245.Metal1 0.0107421f
Cred_22 \$I125 di_tg_ctrl.$249.Metal1 0.00733557f
Cred_23 \$I125 di_tg_ctrl.$250.Metal1 0.00394335f
Cred_24 \$I125 di_tg_ctrl.$252.Metal1 0.0040677f
Cred_25 \$I125 di_tg_ctrl.$254.Metal1 0.00847972f
Cred_26 \$I125 di_tg_ctrl.$256.Metal1 0.0107402f
Cred_27 \$I125 di_tg_ctrl.$260.Metal1 0.00733404f
Cred_28 \$I125 di_tg_ctrl.$261.Metal1 0.0113149f
Cred_29 \$I125 di_tg_ctrl.$350.Metal2 0.00288416f
Cred_30 \$I125 di_tg_ctrl.$352.Metal2 0.00236225f
Cred_31 \$I125 di_tg_ctrl.$356.Metal2 0.00303451f
Cred_32 \$I125 di_tg_ctrl.$360.Metal2 0.00220379f
Cred_33 \$I125 di_tg_ctrl.$362.Metal2 0.00232776f
Cred_34 \$I125 di_tg_ctrl.$366.Metal2 0.00306143f
Cred_35 \$I125 di_tg_ctrl.$370.Metal2 0.00220983f
Cred_36 \$I125 di_tg_ctrl.$372.Metal2 0.00233923f
Cred_37 \$I125 di_tg_ctrl.$376.Metal2 0.00306253f
Cred_38 \$I125 di_tg_ctrl.$380.Metal2 0.00220342f
Cred_39 \$I125 di_tg_ctrl.$382.Metal2 0.00230873f
Cred_40 \$I125 di_tg_ctrl.$386.Metal2 0.00714833f
Cred_41 \$I125 di_tg_ctrl.$446.Metal3 0.00296134f
Cred_42 \$I125 di_tg_ctrl.$450.Metal3 8.29405e-05f
Cred_43 \$I125 di_tg_ctrl.$456.Metal3 0.00170563f
Cred_44 \$I125 di_tg_ctrl.$459.Metal3 0.000843106f
Cred_45 \$I125 di_tg_ctrl.$462.Metal3 0.00230854f
Cred_46 \$I125 di_tg_ctrl.$464.Metal3 0.00052069f
Cred_47 \$I125 di_tg_ctrl.$467.Metal3 0.00523395f
Cred_48 \$I125 di_tg_ctrl.$471.Metal4 0.00437356f
Cred_49 \$I125 di_tg_ctrl.$487.Metal4 0.0145996f
Cred_50 \$I125 di_tg_ctrl.$495.Metal4 0.00292005f
Cred_51 \$I125 di_tg_ctrl.$87.GatPoly 0.051582f
Cred_52 \$I125 di_tg_ctrl.$90.GatPoly 0.0337448f
Cred_53 \$I125 di_tg_ctrl.$93.GatPoly 0.0438026f
Cred_54 \$I125 di_tg_ctrl.$97.GatPoly 0.0401651f
Cred_55 \$I125 di_tg_ctrl.P35.GatPoly 0.0207314f
Cred_56 \$I125 di_tg_ctrl.P36.GatPoly 0.00308702f
Cred_57 \$I125 di_tg_ctrl.P37.GatPoly 0.00448296f
Cred_58 \$I125 di_tg_ctrl.P38.GatPoly 0.00778276f
Cred_59 \$I125 di_tg_ctrl.P39.GatPoly 0.0118111f
Cred_60 \$I125 di_tg_ctrl.P40.GatPoly 0.0122368f
Cred_61 \$I125 di_tg_ctrl.P41.GatPoly 0.0117542f
Cred_62 \$I125 di_tg_ctrl.P42.GatPoly 0.0117542f
Cred_63 \$I125 di_tg_ctrl.P43.GatPoly 0.0118336f
Cred_64 \$I125 di_tg_ctrl.P44.GatPoly 0.0117542f
Cred_65 \$I125 di_tg_ctrl.P45.GatPoly 0.0122368f
Cred_66 \$I125 di_tg_ctrl.P46.GatPoly 0.0118786f
Cred_67 \$I125 di_tg_ctrl.P47.GatPoly 0.0117542f
Cred_68 \$I125 di_tg_ctrl.P48.GatPoly 0.0117542f
Cred_69 \$I125 di_tg_ctrl.P49.GatPoly 0.0122368f
Cred_70 \$I125 di_tg_ctrl.P50.GatPoly 0.0118786f
Cred_71 \$I125 di_tg_ctrl.P51.GatPoly 0.0117542f
Cred_72 \$I125 di_tg_ctrl.P52.GatPoly 0.0118274f
Cred_73 \$I125 di_tg_ctrl.P53.GatPoly 0.0147466f
Cred_74 \$I125 di_tg_ctrl_n 0.000724003f
Cred_75 \$I125 di_tg_ctrl_n.$128.Metal1 0.0403327f
Cred_76 \$I125 di_tg_ctrl_n.$13.GatPoly 0.0437974f
Cred_77 \$I125 di_tg_ctrl_n.$130.Metal1 0.00890533f
Cred_78 \$I125 di_tg_ctrl_n.$132.Metal1 0.00877478f
Cred_79 \$I125 di_tg_ctrl_n.$134.Metal1 0.00397789f
Cred_80 \$I125 di_tg_ctrl_n.$136.Metal1 0.00404887f
Cred_81 \$I125 di_tg_ctrl_n.$138.Metal1 0.00835074f
Cred_82 \$I125 di_tg_ctrl_n.$140.Metal1 0.00950371f
Cred_83 \$I125 di_tg_ctrl_n.$143.Metal1 0.00682092f
Cred_84 \$I125 di_tg_ctrl_n.$145.Metal1 0.0039935f
Cred_85 \$I125 di_tg_ctrl_n.$147.Metal1 0.00404217f
Cred_86 \$I125 di_tg_ctrl_n.$149.Metal1 0.0066563f
Cred_87 \$I125 di_tg_ctrl_n.$153.Metal1 0.00943479f
Cred_88 \$I125 di_tg_ctrl_n.$154.Metal1 0.00859594f
Cred_89 \$I125 di_tg_ctrl_n.$156.Metal1 0.00400528f
Cred_90 \$I125 di_tg_ctrl_n.$158.Metal1 0.00403443f
Cred_91 \$I125 di_tg_ctrl_n.$16.GatPoly 0.0338351f
Cred_92 \$I125 di_tg_ctrl_n.$160.Metal1 0.00669301f
Cred_93 \$I125 di_tg_ctrl_n.$163.Metal1 0.00946354f
Cred_94 \$I125 di_tg_ctrl_n.$165.Metal1 0.00854466f
Cred_95 \$I125 di_tg_ctrl_n.$167.Metal1 0.00401603f
Cred_96 \$I125 di_tg_ctrl_n.$169.Metal1 0.00402574f
Cred_97 \$I125 di_tg_ctrl_n.$171.Metal1 0.00672659f
Cred_98 \$I125 di_tg_ctrl_n.$174.Metal1 0.00949897f
Cred_99 \$I125 di_tg_ctrl_n.$176.Metal1 0.00848611f
Cred_100 \$I125 di_tg_ctrl_n.$178.Metal1 0.00402896f
Cred_101 \$I125 di_tg_ctrl_n.$180.Metal1 0.00402006f
Cred_102 \$I125 di_tg_ctrl_n.$182.Metal1 0.00674673f
Cred_103 \$I125 di_tg_ctrl_n.$185.Metal1 0.00951103f
Cred_104 \$I125 di_tg_ctrl_n.$187.Metal1 0.00843811f
Cred_105 \$I125 di_tg_ctrl_n.$189.Metal1 0.00402977f
Cred_106 \$I125 di_tg_ctrl_n.$19.GatPoly 0.0338351f
Cred_107 \$I125 di_tg_ctrl_n.$191.Metal1 0.00400528f
Cred_108 \$I125 di_tg_ctrl_n.$193.Metal1 0.00678836f
Cred_109 \$I125 di_tg_ctrl_n.$196.Metal1 0.0095014f
Cred_110 \$I125 di_tg_ctrl_n.$198.Metal1 0.00839754f
Cred_111 \$I125 di_tg_ctrl_n.$2.GatPoly 0.100611f
Cred_112 \$I125 di_tg_ctrl_n.$200.Metal1 0.00404217f
Cred_113 \$I125 di_tg_ctrl_n.$202.Metal1 0.0039935f
Cred_114 \$I125 di_tg_ctrl_n.$204.Metal1 0.00682092f
Cred_115 \$I125 di_tg_ctrl_n.$207.Metal1 0.00950371f
Cred_116 \$I125 di_tg_ctrl_n.$209.Metal1 0.00835074f
Cred_117 \$I125 di_tg_ctrl_n.$211.Metal1 0.00404887f
Cred_118 \$I125 di_tg_ctrl_n.$213.Metal1 0.00397789f
Cred_119 \$I125 di_tg_ctrl_n.$215.Metal1 0.00877478f
Cred_120 \$I125 di_tg_ctrl_n.$216.Metal1 0.00887101f
Cred_121 \$I125 di_tg_ctrl_n.$219.Metal1 0.0185567f
Cred_122 \$I125 di_tg_ctrl_n.$22.GatPoly 0.0437984f
Cred_123 \$I125 di_tg_ctrl_n.$26.GatPoly 0.0401651f
Cred_124 \$I125 di_tg_ctrl_n.$270.Metal2 0.0079524f
Cred_125 \$I125 di_tg_ctrl_n.$272.Metal2 0.00244911f
Cred_126 \$I125 di_tg_ctrl_n.$276.Metal2 0.00219877f
Cred_127 \$I125 di_tg_ctrl_n.$278.Metal2 0.00224747f
Cred_128 \$I125 di_tg_ctrl_n.$282.Metal2 0.00314185f
Cred_129 \$I125 di_tg_ctrl_n.$286.Metal2 0.00221149f
Cred_130 \$I125 di_tg_ctrl_n.$288.Metal2 0.00222532f
Cred_131 \$I125 di_tg_ctrl_n.$29.GatPoly 0.0338351f
Cred_132 \$I125 di_tg_ctrl_n.$292.Metal2 0.00315151f
Cred_133 \$I125 di_tg_ctrl_n.$296.Metal2 0.00221168f
Cred_134 \$I125 di_tg_ctrl_n.$298.Metal2 0.00221646f
Cred_135 \$I125 di_tg_ctrl_n.$302.Metal2 0.0031516f
Cred_136 \$I125 di_tg_ctrl_n.$306.Metal2 0.00282164f
Cred_137 \$I125 di_tg_ctrl_n.$310.Metal2 0.00296887f
Cred_138 \$I125 di_tg_ctrl_n.$314.Metal2 0.002331f
Cred_139 \$I125 di_tg_ctrl_n.$316.Metal2 0.00220923f
Cred_140 \$I125 di_tg_ctrl_n.$32.GatPoly 0.0437983f
Cred_141 \$I125 di_tg_ctrl_n.$320.Metal2 0.00220822f
Cred_142 \$I125 di_tg_ctrl_n.$322.Metal2 0.00242925f
Cred_143 \$I125 di_tg_ctrl_n.$326.Metal2 0.00223862f
Cred_144 \$I125 di_tg_ctrl_n.$328.Metal2 0.00219872f
Cred_145 \$I125 di_tg_ctrl_n.$332.Metal2 0.00314185f
Cred_146 \$I125 di_tg_ctrl_n.$336.Metal2 0.00224747f
Cred_147 \$I125 di_tg_ctrl_n.$338.Metal2 0.00219877f
Cred_148 \$I125 di_tg_ctrl_n.$342.Metal2 0.00242574f
Cred_149 \$I125 di_tg_ctrl_n.$344.Metal2 0.00610741f
Cred_150 \$I125 di_tg_ctrl_n.$36.GatPoly 0.0401651f
Cred_151 \$I125 di_tg_ctrl_n.$39.GatPoly 0.0338351f
Cred_152 \$I125 di_tg_ctrl_n.$394.Metal3 0.00510422f
Cred_153 \$I125 di_tg_ctrl_n.$397.Metal3 0.00161265f
Cred_154 \$I125 di_tg_ctrl_n.$399.Metal3 0.000563767f
Cred_155 \$I125 di_tg_ctrl_n.$402.Metal3 0.00160621f
Cred_156 \$I125 di_tg_ctrl_n.$404.Metal3 0.000569922f
Cred_157 \$I125 di_tg_ctrl_n.$407.Metal3 0.00159362f
Cred_158 \$I125 di_tg_ctrl_n.$409.Metal3 0.00164505f
Cred_159 \$I125 di_tg_ctrl_n.$413.Metal3 0.000574944f
Cred_160 \$I125 di_tg_ctrl_n.$417.Metal3 0.00165148f
Cred_161 \$I125 di_tg_ctrl_n.$419.Metal3 0.00102336f
Cred_162 \$I125 di_tg_ctrl_n.$42.GatPoly 0.0437981f
Cred_163 \$I125 di_tg_ctrl_n.$423.Metal3 0.00036984f
Cred_164 \$I125 di_tg_ctrl_n.$429.Metal3 0.00177582f
Cred_165 \$I125 di_tg_ctrl_n.$432.Metal3 0.000563767f
Cred_166 \$I125 di_tg_ctrl_n.$434.Metal3 0.00161265f
Cred_167 \$I125 di_tg_ctrl_n.$437.Metal3 0.00387974f
Cred_168 \$I125 di_tg_ctrl_n.$46.GatPoly 0.0401651f
Cred_169 \$I125 di_tg_ctrl_n.$471.Metal4 0.0149902f
Cred_170 \$I125 di_tg_ctrl_n.$483.Metal4 2.03905e-05f
Cred_171 \$I125 di_tg_ctrl_n.$49.GatPoly 0.0338351f
Cred_172 \$I125 di_tg_ctrl_n.$491.Metal4 0.010546f
Cred_173 \$I125 di_tg_ctrl_n.$52.GatPoly 0.0437979f
Cred_174 \$I125 di_tg_ctrl_n.$56.GatPoly 0.0401651f
Cred_175 \$I125 di_tg_ctrl_n.$59.GatPoly 0.0338351f
Cred_176 \$I125 di_tg_ctrl_n.$6.GatPoly 0.0401654f
Cred_177 \$I125 di_tg_ctrl_n.$62.GatPoly 0.0437976f
Cred_178 \$I125 di_tg_ctrl_n.$66.GatPoly 0.0401651f
Cred_179 \$I125 di_tg_ctrl_n.$69.GatPoly 0.0338351f
Cred_180 \$I125 di_tg_ctrl_n.$72.GatPoly 0.0437974f
Cred_181 \$I125 di_tg_ctrl_n.$76.GatPoly 0.0401651f
Cred_182 \$I125 di_tg_ctrl_n.$79.GatPoly 0.0401654f
Cred_183 \$I125 di_tg_ctrl_n.$83.GatPoly 0.0631886f
Cred_184 \$I125 di_tg_ctrl_n.$9.GatPoly 0.0401651f
Cred_185 \$I125 di_tg_ctrl_n.P0.GatPoly 0.0207314f
Cred_186 \$I125 di_tg_ctrl_n.P18.GatPoly 0.01662f
Cred_187 \$I125 di_tg_ctrl_n.P19.GatPoly 0.0123258f
Cred_188 \$I125 di_tg_ctrl_n.P20.GatPoly 0.0122368f
Cred_189 \$I125 di_tg_ctrl_n.P21.GatPoly 0.0117542f
Cred_190 \$I125 di_tg_ctrl_n.P22.GatPoly 0.0117542f
Cred_191 \$I125 di_tg_ctrl_n.P23.GatPoly 0.0122368f
Cred_192 \$I125 di_tg_ctrl_n.P24.GatPoly 0.0118786f
Cred_193 \$I125 di_tg_ctrl_n.P25.GatPoly 0.0117542f
Cred_194 \$I125 di_tg_ctrl_n.P26.GatPoly 0.0117542f
Cred_195 \$I125 di_tg_ctrl_n.P27.GatPoly 0.0118786f
Cred_196 \$I125 di_tg_ctrl_n.P28.GatPoly 0.0122368f
Cred_197 \$I125 di_tg_ctrl_n.P29.GatPoly 0.0117542f
Cred_198 \$I125 di_tg_ctrl_n.P30.GatPoly 0.0117542f
Cred_199 \$I125 di_tg_ctrl_n.P31.GatPoly 0.0118786f
Cred_200 \$I125 di_tg_ctrl_n.P32.GatPoly 0.0122368f
Cred_201 \$I125 di_tg_ctrl_n.P33.GatPoly 0.0117542f
Cred_202 \$I125 di_tg_ctrl_n.P34.GatPoly 0.0117542f
Cred_203 \$I125 di_tg_ctrl_n.P35.GatPoly 0.0118786f
Cred_204 \$I125 di_tg_ctrl_n.P36.GatPoly 0.0122368f
Cred_205 \$I125 di_tg_ctrl_n.P37.GatPoly 0.0117542f
Cred_206 \$I125 di_tg_ctrl_n.P38.GatPoly 0.0117542f
Cred_207 \$I125 di_tg_ctrl_n.P39.GatPoly 0.0118786f
Cred_208 \$I125 di_tg_ctrl_n.P40.GatPoly 0.0122368f
Cred_209 \$I125 di_tg_ctrl_n.P41.GatPoly 0.0117542f
Cred_210 \$I125 di_tg_ctrl_n.P42.GatPoly 0.0117542f
Cred_211 \$I125 di_tg_ctrl_n.P43.GatPoly 0.0118786f
Cred_212 \$I125 di_tg_ctrl_n.P44.GatPoly 0.0122368f
Cred_213 \$I125 di_tg_ctrl_n.P45.GatPoly 0.0117542f
Cred_214 \$I125 di_tg_ctrl_n.P46.GatPoly 0.0117542f
Cred_215 \$I125 di_tg_ctrl_n.P47.GatPoly 0.0118786f
Cred_216 \$I125 di_tg_ctrl_n.P48.GatPoly 0.0122368f
Cred_217 \$I125 di_tg_ctrl_n.P49.GatPoly 0.0117542f
Cred_218 \$I125 di_tg_ctrl_n.P50.GatPoly 0.0117542f
Cred_219 \$I125 di_tg_ctrl_n.P51.GatPoly 0.0082654f
Cred_220 \$I125 di_tg_ctrl_n.P52.GatPoly 0.00476003f
Cred_221 \$I125 di_tg_ctrl_n.P53.GatPoly 0.00326937f
Cred_222 \$I125 v_a 0.0163278f
Cred_223 \$I125 v_a.$102.Metal1 0.00255688f
Cred_224 \$I125 v_a.$1047.Metal1 0.00260115f
Cred_225 \$I125 v_a.$1152.Metal2 0.00170976f
Cred_226 \$I125 v_a.$1208.Metal2 0.00123215f
Cred_227 \$I125 v_a.$1268.Metal2 0.00120881f
Cred_228 \$I125 v_a.$1324.Metal2 0.00123215f
Cred_229 \$I125 v_a.$1384.Metal2 0.00120881f
Cred_230 \$I125 v_a.$1442.Metal2 0.00120881f
Cred_231 \$I125 v_a.$1500.Metal2 0.00114776f
Cred_232 \$I125 v_a.$1558.Metal2 0.00120881f
Cred_233 \$I125 v_a.$165.Metal1 0.00260033f
Cred_234 \$I125 v_a.$1674.Metal2 0.00124564f
Cred_235 \$I125 v_a.$1732.Metal2 0.00114785f
Cred_236 \$I125 v_a.$1790.Metal2 0.00124564f
Cred_237 \$I125 v_a.$1848.Metal2 0.00114785f
Cred_238 \$I125 v_a.$1906.Metal2 0.00124564f
Cred_239 \$I125 v_a.$1964.Metal2 0.00124564f
Cred_240 \$I125 v_a.$2022.Metal2 0.00114785f
Cred_241 \$I125 v_a.$2080.Metal2 0.00124564f
Cred_242 \$I125 v_a.$2187.Metal3 0.025646f
Cred_243 \$I125 v_a.$2215.Metal3 0.00593488f
Cred_244 \$I125 v_a.$2237.Metal3 0.00311835f
Cred_245 \$I125 v_a.$2247.Metal3 0.00279544f
Cred_246 \$I125 v_a.$2275.Metal3 0.00593488f
Cred_247 \$I125 v_a.$228.Metal1 0.00255688f
Cred_248 \$I125 v_a.$2297.Metal3 0.00311835f
Cred_249 \$I125 v_a.$2307.Metal3 0.00279544f
Cred_250 \$I125 v_a.$2327.Metal3 0.00311835f
Cred_251 \$I125 v_a.$2337.Metal3 0.00279544f
Cred_252 \$I125 v_a.$2365.Metal3 0.00596692f
Cred_253 \$I125 v_a.$2367.Metal3 1.09116e-05f
Cred_254 \$I125 v_a.$2387.Metal3 0.00663544f
Cred_255 \$I125 v_a.$2397.Metal3 0.00279544f
Cred_256 \$I125 v_a.$2447.Metal3 0.00720504f
Cred_257 \$I125 v_a.$2458.Metal3 0.00218816f
Cred_258 \$I125 v_a.$2485.Metal3 0.00597051f
Cred_259 \$I125 v_a.$2488.Metal3 7.22635e-06f
Cred_260 \$I125 v_a.$2507.Metal3 0.00368796f
Cred_261 \$I125 v_a.$2518.Metal3 0.00218816f
Cred_262 \$I125 v_a.$2545.Metal3 0.00597051f
Cred_263 \$I125 v_a.$2548.Metal3 7.22635e-06f
Cred_264 \$I125 v_a.$2567.Metal3 0.00368796f
Cred_265 \$I125 v_a.$2578.Metal3 0.00218816f
Cred_266 \$I125 v_a.$2597.Metal3 0.00368796f
Cred_267 \$I125 v_a.$2608.Metal3 0.00218816f
Cred_268 \$I125 v_a.$2635.Metal3 0.00597051f
Cred_269 \$I125 v_a.$2638.Metal3 7.22635e-06f
Cred_270 \$I125 v_a.$2657.Metal3 0.00970697f
Cred_271 \$I125 v_a.$2668.Metal3 0.00218816f
Cred_272 \$I125 v_a.$291.Metal1 0.00260033f
Cred_273 \$I125 v_a.$354.Metal1 0.00260033f
Cred_274 \$I125 v_a.$39.Metal1 0.00262426f
Cred_275 \$I125 v_a.$417.Metal1 0.00259741f
Cred_276 \$I125 v_a.$480.Metal1 0.00260033f
Cred_277 \$I125 v_a.$606.Metal1 0.00260115f
Cred_278 \$I125 v_a.$669.Metal1 0.00259741f
Cred_279 \$I125 v_a.$732.Metal1 0.00260115f
Cred_280 \$I125 v_a.$795.Metal1 0.00259741f
Cred_281 \$I125 v_a.$858.Metal1 0.00260115f
Cred_282 \$I125 v_a.$921.Metal1 0.00260115f
Cred_283 \$I125 v_a.$984.Metal1 0.00259741f
Cred_284 \$I125 v_a.P0.pSD 8.49219e-05f
Cred_285 \$I125 v_a.P10.pSD 8.43306e-05f
Cred_286 \$I125 v_a.P12.pSD 8.42586e-05f
Cred_287 \$I125 v_a.P14.pSD 8.43306e-05f
Cred_288 \$I125 v_a.P16.nSD 3.17195e-05f
Cred_289 \$I125 v_a.P16.pSD 0.00274138f
Cred_290 \$I125 v_a.P18.pSD 8.43503e-05f
Cred_291 \$I125 v_a.P2.pSD 8.33492e-05f
Cred_292 \$I125 v_a.P20.pSD 8.42586e-05f
Cred_293 \$I125 v_a.P22.pSD 8.43503e-05f
Cred_294 \$I125 v_a.P24.pSD 8.42586e-05f
Cred_295 \$I125 v_a.P26.pSD 8.43503e-05f
Cred_296 \$I125 v_a.P28.pSD 8.43503e-05f
Cred_297 \$I125 v_a.P30.pSD 8.42586e-05f
Cred_298 \$I125 v_a.P32.pSD 8.43503e-05f
Cred_299 \$I125 v_a.P34.nSD 3.9579e-05f
Cred_300 \$I125 v_a.P34.pSD 0.00325948f
Cred_301 \$I125 v_a.P4.pSD 8.43306e-05f
Cred_302 \$I125 v_a.P6.pSD 8.33492e-05f
Cred_303 \$I125 v_a.P8.pSD 8.43306e-05f
Cred_304 \$I125 v_b 0.0878986f
Cred_305 \$I125 v_b.$1992.Metal1 0.00255741f
Cred_306 \$I125 v_b.$2244.Metal1 0.00257563f
Cred_307 \$I125 v_b.$2361.Metal2 0.160797f
Cred_308 \$I125 v_b.$2421.Metal2 0.0442158f
Cred_309 \$I125 v_b.$2481.Metal2 0.0442158f
Cred_310 \$I125 v_b.$2541.Metal2 0.0442158f
Cred_311 \$I125 v_b.$2601.Metal2 0.0332473f
Cred_312 \$I125 v_b.$2631.Metal2 0.0332473f
Cred_313 \$I125 v_b.$2691.Metal2 0.0442158f
Cred_314 \$I125 v_b.$2751.Metal2 0.0442158f
Cred_315 \$I125 v_b.$2811.Metal2 0.0442158f
Cred_316 \$I125 v_b.$2871.Metal2 0.032754f
Cred_317 \$I125 v_b.$2962.Metal2 0.0210212f
Cred_318 \$I125 v_b.$3053.Metal2 0.00834869f
Cred_319 \$I125 v_b.$3056.Metal2 0.0133254f
Cred_320 \$I125 v_b.$3089.Metal2 0.00831145f
Cred_321 \$I125 v_b.$3153.Metal2 0.0190696f
Cred_322 \$I125 v_b.$3247.Metal2 0.0190218f
Cred_323 \$I125 v_b.$3294.Metal2 0.00831201f
Cred_324 \$I125 v_b.$3344.Metal2 0.0165298f
Cred_325 \$I125 v_b.$3435.Metal2 0.0087965f
Cred_326 \$I125 v_b.$3438.Metal2 0.0127463f
Cred_327 \$I125 v_b.$3487.Metal2 0.00127767f
Cred_328 \$I125 v_b.$3529.Metal2 0.00831145f
Cred_329 \$I125 v_b.$3535.Metal2 0.0133254f
Cred_330 \$I125 v_b.$3565.Metal2 0.00842607f
Cred_331 \$I125 v_b.$3629.Metal2 0.0208666f
Cred_332 \$I125 v_b.$3678.Metal2 0.00229676f
Cred_333 \$I125 v_b.$3779.Metal3 0.00601743f
Cred_334 \$I125 v_b.$3785.Metal3 0.00543439f
Cred_335 \$I125 v_b.$3821.Metal3 0.00547666f
Cred_336 \$I125 v_b.$3857.Metal3 0.00266759f
Cred_337 \$I125 v_b.$3890.Metal3 0.00279954f
Cred_338 \$I125 v_b.$3903.Metal3 0.00547967f
Cred_339 \$I125 v_b.$3934.Metal3 0.00543899f
Cred_340 \$I125 v_b.$3970.Metal3 0.00217422f
Cred_341 \$I125 v_b.$3980.Metal3 0.00193385f
Cred_342 \$I125 v_b.$4009.Metal3 0.00543448f
Cred_343 \$I125 v_b.$4042.Metal3 0.00541675f
Cred_344 \$I125 v_b.$4053.Metal3 0.00846319f
Cred_345 \$I125 v_b.P0.nSD 0.00115098f
Cred_346 \$I125 v_b.P0.pSD 0.169071f
Cred_347 \$I125 v_b.P1.pSD 0.00388534f
Cred_348 \$I125 v_b.P10.pSD 0.00388717f
Cred_349 \$I125 v_b.P11.nSD 0.000121372f
Cred_350 \$I125 v_b.P11.pSD 0.00410773f
Cred_351 \$I125 v_b.P13.pSD 0.00388717f
Cred_352 \$I125 v_b.P15.nSD 0.000121372f
Cred_353 \$I125 v_b.P15.pSD 0.00410773f
Cred_354 \$I125 v_b.P17.pSD 0.00388717f
Cred_355 \$I125 v_b.P19.pSD 0.00388717f
Cred_356 \$I125 v_b.P21.nSD 0.000121372f
Cred_357 \$I125 v_b.P21.pSD 0.00410773f
Cred_358 \$I125 v_b.P23.pSD 0.00388717f
Cred_359 \$I125 v_b.P25.nSD 0.000121372f
Cred_360 \$I125 v_b.P25.pSD 0.00410773f
Cred_361 \$I125 v_b.P27.pSD 0.00388717f
Cred_362 \$I125 v_b.P29.nSD 0.000121372f
Cred_363 \$I125 v_b.P29.pSD 0.00410773f
Cred_364 \$I125 v_b.P3.nSD 0.000121372f
Cred_365 \$I125 v_b.P3.pSD 0.00410773f
Cred_366 \$I125 v_b.P31.pSD 0.00388717f
Cred_367 \$I125 v_b.P33.nSD 0.000121372f
Cred_368 \$I125 v_b.P33.pSD 0.00410773f
Cred_369 \$I125 v_b.P35.pSD 0.00680787f
Cred_370 \$I125 v_b.P37.nSD 7.1689e-06f
Cred_371 \$I125 v_b.P37.pSD 0.00358063f
Cred_372 \$I125 v_b.P39.pSD 0.00281203f
Cred_373 \$I125 v_b.P41.pSD 0.0025459f
Cred_374 \$I125 v_b.P43.pSD 0.00281253f
Cred_375 \$I125 v_b.P45.pSD 0.00254914f
Cred_376 \$I125 v_b.P47.pSD 0.0028132f
Cred_377 \$I125 v_b.P49.nSD 4.89506e-06f
Cred_378 \$I125 v_b.P49.pSD 0.0025579f
Cred_379 \$I125 v_b.P5.pSD 0.00388717f
Cred_380 \$I125 v_b.P51.pSD 0.0028145f
Cred_381 \$I125 v_b.P53.pSD 0.00254914f
Cred_382 \$I125 v_b.P55.pSD 0.0028145f
Cred_383 \$I125 v_b.P57.pSD 0.00254587f
Cred_384 \$I125 v_b.P59.pSD 0.0028132f
Cred_385 \$I125 v_b.P61.pSD 8.33656e-05f
Cred_386 \$I125 v_b.P63.pSD 0.00281253f
Cred_387 \$I125 v_b.P65.pSD 0.0025459f
Cred_388 \$I125 v_b.P67.pSD 0.00281203f
Cred_389 \$I125 v_b.P69.nSD 2.32724e-06f
Cred_390 \$I125 v_b.P69.pSD 8.39326e-05f
Cred_391 \$I125 v_b.P7.nSD 0.000121372f
Cred_392 \$I125 v_b.P7.pSD 0.00410773f
Cred_393 \$I125 v_b.P71.pSD 0.150856f
Cred_394 \$I125 VDD 0.0053747f
Cred_395 \$I125 VDD.$107.Metal1 0.00836451f
Cred_396 \$I125 VDD.$111.Metal1 0.0115661f
Cred_397 \$I125 VDD.$121.Metal1 0.0141755f
Cred_398 \$I125 VDD.$129.Metal1 0.0111303f
Cred_399 \$I125 VDD.$134.Metal1 0.0118966f
Cred_400 \$I125 VDD.$143.Metal1 0.0111303f
Cred_401 \$I125 VDD.$151.Metal1 0.0141755f
Cred_402 \$I125 VDD.$161.Metal1 0.0115661f
Cred_403 \$I125 VDD.$165.Metal1 0.00558122f
Cred_404 \$I125 VDD.$169.Metal1 0.00558576f
Cred_405 \$I125 VDD.$173.Metal1 0.00845389f
Cred_406 \$I125 VDD.$179.Metal1 0.00900522f
Cred_407 \$I125 VDD.$183.Metal1 0.00549467f
Cred_408 \$I125 VDD.$189.Metal1 0.00549221f
Cred_409 \$I125 VDD.$193.Metal1 0.00556451f
Cred_410 \$I125 VDD.$197.Metal1 0.00900522f
Cred_411 \$I125 VDD.$203.Metal1 0.00845389f
Cred_412 \$I125 VDD.$207.Metal1 0.00558576f
Cred_413 \$I125 VDD.$211.Metal1 0.00558122f
Cred_414 \$I125 VDD.$215.Metal1 0.0115661f
Cred_415 \$I125 VDD.$225.Metal1 0.0128648f
Cred_416 \$I125 VDD.$230.Metal1 0.0128389f
Cred_417 \$I125 VDD.$238.Metal1 0.015112f
Cred_418 \$I125 VDD.$247.Metal1 0.00830142f
Cred_419 \$I125 VDD.$251.Metal1 0.0111078f
Cred_420 \$I125 VDD.$263.Metal1 0.0145916f
Cred_421 \$I125 VDD.$269.Metal1 0.00835079f
Cred_422 \$I125 VDD.$273.Metal1 0.0111577f
Cred_423 \$I125 VDD.$283.Metal1 0.0117842f
Cred_424 \$I125 VDD.$287.Metal1 0.00556452f
Cred_425 \$I125 VDD.$291.Metal1 0.00558283f
Cred_426 \$I125 VDD.$295.Metal1 0.00558511f
Cred_427 \$I125 VDD.$299.Metal1 0.0114604f
Cred_428 \$I125 VDD.$309.Metal1 0.0114952f
Cred_429 \$I125 VDD.$313.Metal1 0.00558413f
Cred_430 \$I125 VDD.$317.Metal1 0.00558413f
Cred_431 \$I125 VDD.$321.Metal1 0.0123697f
Cred_432 \$I125 VDD.$332.Metal1 0.0228723f
Cred_433 \$I125 VDD.$340.Metal1 0.113014f
Cred_434 \$I125 VDD.$388.Metal2 0.115793f
Cred_435 \$I125 VDD.$392.Metal2 4.42377e-05f
Cred_436 \$I125 VDD.$400.Metal2 1.76629e-05f
Cred_437 \$I125 VDD.$404.Metal2 1.14095e-05f
Cred_438 \$I125 VDD.$412.Metal2 2.28764e-05f
Cred_439 \$I125 VDD.$42.Metal1 0.132489f
Cred_440 \$I125 VDD.$420.Metal2 1.1292e-05f
Cred_441 \$I125 VDD.$428.Metal2 3.9701e-05f
Cred_442 \$I125 VDD.$432.Metal2 3.50558e-05f
Cred_443 \$I125 VDD.$436.Metal2 1.19591e-05f
Cred_444 \$I125 VDD.$440.Metal2 1.61989e-05f
Cred_445 \$I125 VDD.$448.Metal2 4.02141e-05f
Cred_446 \$I125 VDD.$452.Metal2 3.42549e-05f
Cred_447 \$I125 VDD.$456.Metal2 1.26722e-05f
Cred_448 \$I125 VDD.$460.Metal2 1.33426e-05f
Cred_449 \$I125 VDD.$464.Metal2 1.81386e-05f
Cred_450 \$I125 VDD.$472.Metal2 1.81386e-05f
Cred_451 \$I125 VDD.$476.Metal2 1.33426e-05f
Cred_452 \$I125 VDD.$480.Metal2 1.26722e-05f
Cred_453 \$I125 VDD.$484.Metal2 3.42549e-05f
Cred_454 \$I125 VDD.$488.Metal2 4.02141e-05f
Cred_455 \$I125 VDD.$496.Metal2 1.11651e-05f
Cred_456 \$I125 VDD.$504.Metal2 2.23579e-05f
Cred_457 \$I125 VDD.$512.Metal2 8.45697e-06f
Cred_458 \$I125 VDD.$520.Metal2 8.52265e-06f
Cred_459 \$I125 VDD.$528.Metal2 2.23579e-05f
Cred_460 \$I125 VDD.$536.Metal2 1.11651e-05f
Cred_461 \$I125 VDD.$544.Metal2 4.02141e-05f
Cred_462 \$I125 VDD.$548.Metal2 3.42549e-05f
Cred_463 \$I125 VDD.$55.Metal1 0.0123697f
Cred_464 \$I125 VDD.$552.Metal2 9.46806e-06f
Cred_465 \$I125 VDD.$560.Metal2 0.00300508f
Cred_466 \$I125 VDD.$568.Metal2 0.000612415f
Cred_467 \$I125 VDD.$576.Metal2 3.06548e-05f
Cred_468 \$I125 VDD.$580.Metal2 3.9225e-05f
Cred_469 \$I125 VDD.$584.Metal2 1.24203e-06f
Cred_470 \$I125 VDD.$588.Metal2 2.10685e-05f
Cred_471 \$I125 VDD.$59.Metal1 0.00836639f
Cred_472 \$I125 VDD.$596.Metal2 3.17636e-05f
Cred_473 \$I125 VDD.$600.Metal2 3.92324e-05f
Cred_474 \$I125 VDD.$604.Metal2 3.80404e-06f
Cred_475 \$I125 VDD.$612.Metal2 1.1292e-05f
Cred_476 \$I125 VDD.$620.Metal2 3.85304e-05f
Cred_477 \$I125 VDD.$624.Metal2 3.91398e-05f
Cred_478 \$I125 VDD.$632.Metal2 1.13343e-05f
Cred_479 \$I125 VDD.$640.Metal2 4.42377e-05f
Cred_480 \$I125 VDD.$644.Metal2 0.0255504f
Cred_481 \$I125 VDD.$666.Metal3 0.026891f
Cred_482 \$I125 VDD.$67.Metal1 0.00835123f
Cred_483 \$I125 VDD.$670.Metal3 2.05668e-08f
Cred_484 \$I125 VDD.$676.Metal3 8.05816e-09f
Cred_485 \$I125 VDD.$680.Metal3 2.16594e-08f
Cred_486 \$I125 VDD.$684.Metal3 1.93034e-08f
Cred_487 \$I125 VDD.$694.Metal3 1.78679e-08f
Cred_488 \$I125 VDD.$71.Metal1 0.00894638f
Cred_489 \$I125 VDD.$718.Metal3 1.78679e-08f
Cred_490 \$I125 VDD.$722.Metal3 2.25821e-08f
Cred_491 \$I125 VDD.$726.Metal3 5.55376e-09f
Cred_492 \$I125 VDD.$730.Metal3 2.38629e-08f
Cred_493 \$I125 VDD.$734.Metal3 5.55376e-09f
Cred_494 \$I125 VDD.$738.Metal3 2.25821e-08f
Cred_495 \$I125 VDD.$742.Metal3 1.78679e-08f
Cred_496 \$I125 VDD.$750.Metal3 0.00120266f
Cred_497 \$I125 VDD.$758.Metal3 0.000398218f
Cred_498 \$I125 VDD.$768.Metal3 2.43395e-08f
Cred_499 \$I125 VDD.$77.Metal1 0.00850725f
Cred_500 \$I125 VDD.$776.Metal3 1.93034e-08f
Cred_501 \$I125 VDD.$780.Metal3 2.16594e-08f
Cred_502 \$I125 VDD.$786.Metal3 2.05668e-08f
Cred_503 \$I125 VDD.$790.Metal3 2.05668e-08f
Cred_504 \$I125 VDD.$794.Metal3 0.0226746f
Cred_505 \$I125 VDD.$81.Metal1 0.00558511f
Cred_506 \$I125 VDD.$85.Metal1 0.00558283f
Cred_507 \$I125 VDD.$89.Metal1 0.0115303f
Cred_508 \$I125 VDD.$99.Metal1 0.0142096f
Cred_509 \$I125 VDD.P0.nSD 0.943193f
Cred_510 \$I125 VSS.$17.Metal1 0.00548584f
Cred_511 \$I125 VSS.$301.Metal1 0.00434193f
Cred_512 \$I125 VSS.$366.Metal2 0.00118484f
Cred_513 \$I125 VSS.$39.Metal1 6.60991e-05f
Cred_514 \$I125 VSS.$606.Metal2 0.00171839f
Cred_515 \$I125 VSS.$636.Metal3 0.00180247f
Cred_516 \$I125 VSS.$760.Metal3 0.00185442f
Cred_517 \$I125 VSS.P0.pSD 0.159125f
Cred_518 di_tg_ctrl VSS 0.0311927f
Cred_519 di_tg_ctrl v_a.$2447.Metal3 0.0152791f
Cred_520 di_tg_ctrl v_a.$2485.Metal3 0.00242751f
Cred_521 di_tg_ctrl v_a.$2507.Metal3 0.00889859f
Cred_522 di_tg_ctrl v_a.P18.nSD 7.44104e-05f
Cred_523 di_tg_ctrl v_a.P20.nSD 8.63175e-05f
Cred_524 di_tg_ctrl v_b.$2631.Metal2 0.00575638f
Cred_525 di_tg_ctrl v_b.$2691.Metal2 0.00119097f
Cred_526 di_tg_ctrl v_b.P19.nSD 0.00320662f
Cred_527 di_tg_ctrl v_b.P21.nSD 0.00154312f
Cred_528 di_tg_ctrl v_b.P21.pSD 2.39488e-05f
Cred_529 di_tg_ctrl VSS.$123.Metal1 2.50367e-06f
Cred_530 di_tg_ctrl VSS.$135.Metal1 2.46305e-06f
Cred_531 di_tg_ctrl VSS.$153.Metal1 6.82077e-09f
Cred_532 di_tg_ctrl VSS.$442.Metal2 2.11447e-05f
Cred_533 di_tg_ctrl VSS.$446.Metal2 2.56142e-05f
Cred_534 di_tg_ctrl VSS.$454.Metal2 1.36767e-05f
Cred_535 di_tg_ctrl VSS.$462.Metal2 3.44041e-06f
Cred_536 di_tg_ctrl VSS.$470.Metal2 1.70481e-06f
Cred_537 di_tg_ctrl VSS.$674.Metal3 0.00318481f
Cred_538 di_tg_ctrl VSS.$680.Metal3 0.00944125f
Cred_539 di_tg_ctrl VSS.$684.Metal3 0.00393135f
Cred_540 di_tg_ctrl VSS.$692.Metal3 0.000106526f
Cred_541 di_tg_ctrl VSS.P0.pSD 1.44239e-08f
Cred_542 di_tg_ctrl.$100.GatPoly di_tg_ctrl_n.$219.Metal1 0.000679601f
Cred_543 di_tg_ctrl.$100.GatPoly di_tg_ctrl_n.$471.Metal4 0.000878824f
Cred_544 di_tg_ctrl.$100.GatPoly di_tg_ctrl_n.$491.Metal4 0.0021575f
Cred_545 di_tg_ctrl.$100.GatPoly di_tg_ctrl_n.$83.GatPoly 0.0035273f
Cred_546 di_tg_ctrl.$100.GatPoly di_tg_ctrl_n.P52.GatPoly 2.77612e-05f
Cred_547 di_tg_ctrl.$100.GatPoly di_tg_ctrl_n.P53.GatPoly 3.81427e-05f
Cred_548 di_tg_ctrl.$100.GatPoly VSS 0.00685292f
Cred_549 di_tg_ctrl.$100.GatPoly v_b.$3153.Metal2 0.00567102f
Cred_550 di_tg_ctrl.$100.GatPoly v_b.$3247.Metal2 0.000893379f
Cred_551 di_tg_ctrl.$100.GatPoly v_b.$3857.Metal3 0.00577566f
Cred_552 di_tg_ctrl.$100.GatPoly v_b.$3890.Metal3 0.00606445f
Cred_553 di_tg_ctrl.$100.GatPoly v_b.P47.pSD 0.0197238f
Cred_554 di_tg_ctrl.$100.GatPoly v_b.P49.nSD 1.07242e-05f
Cred_555 di_tg_ctrl.$100.GatPoly v_b.P49.pSD 0.0268951f
Cred_556 di_tg_ctrl.$100.GatPoly v_b.P51.pSD 0.00316595f
Cred_557 di_tg_ctrl.$100.GatPoly VDD.$263.Metal1 0.000184412f
Cred_558 di_tg_ctrl.$100.GatPoly VDD.$269.Metal1 0.00252528f
Cred_559 di_tg_ctrl.$100.GatPoly VDD.$273.Metal1 0.0036977f
Cred_560 di_tg_ctrl.$100.GatPoly VDD.$283.Metal1 0.000530544f
Cred_561 di_tg_ctrl.$100.GatPoly VDD.$584.Metal2 3.46758e-08f
Cred_562 di_tg_ctrl.$100.GatPoly VDD.$588.Metal2 4.5731e-06f
Cred_563 di_tg_ctrl.$100.GatPoly VDD.$596.Metal2 1.11387e-05f
Cred_564 di_tg_ctrl.$100.GatPoly VDD.$600.Metal2 3.8915e-06f
Cred_565 di_tg_ctrl.$100.GatPoly VDD.$768.Metal3 2.49832e-08f
Cred_566 di_tg_ctrl.$100.GatPoly VDD.P0.nSD 3.01281e-06f
Cred_567 di_tg_ctrl.$103.GatPoly di_tg_ctrl_n.$219.Metal1 0.000446691f
Cred_568 di_tg_ctrl.$103.GatPoly di_tg_ctrl_n.$83.GatPoly 0.00231843f
Cred_569 di_tg_ctrl.$103.GatPoly di_tg_ctrl_n.P52.GatPoly 1.82469e-05f
Cred_570 di_tg_ctrl.$103.GatPoly di_tg_ctrl_n.P53.GatPoly 2.50706e-05f
Cred_571 di_tg_ctrl.$103.GatPoly VSS 0.00776353f
Cred_572 di_tg_ctrl.$103.GatPoly v_b.$3247.Metal2 0.00691604f
Cred_573 di_tg_ctrl.$103.GatPoly v_b.$3857.Metal3 0.00320049f
Cred_574 di_tg_ctrl.$103.GatPoly v_b.$3890.Metal3 0.00336051f
Cred_575 di_tg_ctrl.$103.GatPoly v_b.P49.nSD 5.94264e-06f
Cred_576 di_tg_ctrl.$103.GatPoly v_b.P49.pSD 0.0148502f
Cred_577 di_tg_ctrl.$103.GatPoly v_b.P51.pSD 0.0241637f
Cred_578 di_tg_ctrl.$103.GatPoly VDD.$273.Metal1 0.00296845f
Cred_579 di_tg_ctrl.$103.GatPoly VDD.$283.Metal1 0.00324538f
Cred_580 di_tg_ctrl.$103.GatPoly VDD.$287.Metal1 2.69969e-05f
Cred_581 di_tg_ctrl.$103.GatPoly VDD.$596.Metal2 1.22797e-05f
Cred_582 di_tg_ctrl.$103.GatPoly VDD.$600.Metal2 2.05454e-05f
Cred_583 di_tg_ctrl.$103.GatPoly VDD.$604.Metal2 1.62443e-07f
Cred_584 di_tg_ctrl.$103.GatPoly VDD.P0.nSD 8.68561e-06f
Cred_585 di_tg_ctrl.$105.GatPoly di_tg_ctrl_n.$219.Metal1 0.000221463f
Cred_586 di_tg_ctrl.$105.GatPoly di_tg_ctrl_n.$83.GatPoly 0.00239211f
Cred_587 di_tg_ctrl.$105.GatPoly di_tg_ctrl_n.P52.GatPoly 1.88268e-05f
Cred_588 di_tg_ctrl.$105.GatPoly di_tg_ctrl_n.P53.GatPoly 1.24297e-05f
Cred_589 di_tg_ctrl.$105.GatPoly VSS 0.00748012f
Cred_590 di_tg_ctrl.$105.GatPoly v_b.$3247.Metal2 0.00804572f
Cred_591 di_tg_ctrl.$105.GatPoly v_b.$3344.Metal2 0.00162908f
Cred_592 di_tg_ctrl.$105.GatPoly v_b.$3903.Metal3 0.0112007f
Cred_593 di_tg_ctrl.$105.GatPoly v_b.P51.pSD 0.0282907f
Cred_594 di_tg_ctrl.$105.GatPoly v_b.P53.pSD 0.0252848f
Cred_595 di_tg_ctrl.$105.GatPoly v_b.P55.pSD 0.005679f
Cred_596 di_tg_ctrl.$105.GatPoly VDD.$273.Metal1 0.000517042f
Cred_597 di_tg_ctrl.$105.GatPoly VDD.$283.Metal1 0.00398366f
Cred_598 di_tg_ctrl.$105.GatPoly VDD.$287.Metal1 0.00141283f
Cred_599 di_tg_ctrl.$105.GatPoly VDD.$291.Metal1 0.000437839f
Cred_600 di_tg_ctrl.$105.GatPoly VDD.$596.Metal2 2.13888e-06f
Cred_601 di_tg_ctrl.$105.GatPoly VDD.$600.Metal2 6.14623e-06f
Cred_602 di_tg_ctrl.$105.GatPoly VDD.$604.Metal2 2.20393e-06f
Cred_603 di_tg_ctrl.$105.GatPoly VDD.$612.Metal2 1.02092e-06f
Cred_604 di_tg_ctrl.$105.GatPoly VDD.$776.Metal3 8.18554e-09f
Cred_605 di_tg_ctrl.$105.GatPoly VDD.P0.nSD 2.29432e-06f
Cred_606 di_tg_ctrl.$109.GatPoly di_tg_ctrl_n.$219.Metal1 0.000178282f
Cred_607 di_tg_ctrl.$109.GatPoly di_tg_ctrl_n.$83.GatPoly 0.00192569f
Cred_608 di_tg_ctrl.$109.GatPoly di_tg_ctrl_n.P52.GatPoly 1.51559e-05f
Cred_609 di_tg_ctrl.$109.GatPoly di_tg_ctrl_n.P53.GatPoly 1.00061e-05f
Cred_610 di_tg_ctrl.$109.GatPoly VSS 0.00995367f
Cred_611 di_tg_ctrl.$109.GatPoly v_b.$3344.Metal2 0.00907333f
Cred_612 di_tg_ctrl.$109.GatPoly v_b.$3903.Metal3 0.00428504f
Cred_613 di_tg_ctrl.$109.GatPoly v_b.$3934.Metal3 0.00658155f
Cred_614 di_tg_ctrl.$109.GatPoly v_b.P53.pSD 0.00969297f
Cred_615 di_tg_ctrl.$109.GatPoly v_b.P55.pSD 0.0316879f
Cred_616 di_tg_ctrl.$109.GatPoly v_b.P57.pSD 0.0148356f
Cred_617 di_tg_ctrl.$109.GatPoly VDD.$283.Metal1 0.000415159f
Cred_618 di_tg_ctrl.$109.GatPoly VDD.$287.Metal1 0.00145196f
Cred_619 di_tg_ctrl.$109.GatPoly VDD.$291.Metal1 0.00342069f
Cred_620 di_tg_ctrl.$109.GatPoly VDD.$295.Metal1 0.00318643f
Cred_621 di_tg_ctrl.$109.GatPoly VDD.$299.Metal1 0.00121512f
Cred_622 di_tg_ctrl.$109.GatPoly VDD.$604.Metal2 1.35315e-06f
Cred_623 di_tg_ctrl.$109.GatPoly VDD.$612.Metal2 1.09309e-05f
Cred_624 di_tg_ctrl.$109.GatPoly VDD.$620.Metal2 1.24667e-06f
Cred_625 di_tg_ctrl.$109.GatPoly VDD.$776.Metal3 9.59749e-09f
Cred_626 di_tg_ctrl.$109.GatPoly VDD.$780.Metal3 9.99551e-09f
Cred_627 di_tg_ctrl.$112.GatPoly di_tg_ctrl_n.$219.Metal1 0.000147046f
Cred_628 di_tg_ctrl.$112.GatPoly di_tg_ctrl_n.$83.GatPoly 0.0015883f
Cred_629 di_tg_ctrl.$112.GatPoly di_tg_ctrl_n.P52.GatPoly 1.25005e-05f
Cred_630 di_tg_ctrl.$112.GatPoly di_tg_ctrl_n.P53.GatPoly 8.25296e-06f
Cred_631 di_tg_ctrl.$112.GatPoly VSS 0.00685292f
Cred_632 di_tg_ctrl.$112.GatPoly v_b.$3344.Metal2 0.00089877f
Cred_633 di_tg_ctrl.$112.GatPoly v_b.$3438.Metal2 0.00567102f
Cred_634 di_tg_ctrl.$112.GatPoly v_b.$3934.Metal3 0.0122546f
Cred_635 di_tg_ctrl.$112.GatPoly v_b.P55.pSD 0.00318528f
Cred_636 di_tg_ctrl.$112.GatPoly v_b.P57.pSD 0.0277145f
Cred_637 di_tg_ctrl.$112.GatPoly v_b.P59.pSD 0.0197238f
Cred_638 di_tg_ctrl.$112.GatPoly VDD.$295.Metal1 0.00104681f
Cred_639 di_tg_ctrl.$112.GatPoly VDD.$299.Metal1 0.00422056f
Cred_640 di_tg_ctrl.$112.GatPoly VDD.$309.Metal1 0.00102763f
Cred_641 di_tg_ctrl.$112.GatPoly VDD.$612.Metal2 2.2456e-06f
Cred_642 di_tg_ctrl.$112.GatPoly VDD.$620.Metal2 1.3707e-05f
Cred_643 di_tg_ctrl.$112.GatPoly VDD.$624.Metal2 5.99009e-06f
Cred_644 di_tg_ctrl.$112.GatPoly VDD.$780.Metal3 1.80047e-08f
Cred_645 di_tg_ctrl.$112.GatPoly VDD.P0.nSD 4.58336e-06f
Cred_646 di_tg_ctrl.$115.GatPoly di_tg_ctrl_n.$219.Metal1 0.000152606f
Cred_647 di_tg_ctrl.$115.GatPoly di_tg_ctrl_n.$83.GatPoly 0.00164835f
Cred_648 di_tg_ctrl.$115.GatPoly di_tg_ctrl_n.P52.GatPoly 1.29732e-05f
Cred_649 di_tg_ctrl.$115.GatPoly di_tg_ctrl_n.P53.GatPoly 8.56503e-06f
Cred_650 di_tg_ctrl.$115.GatPoly VSS 0.00829178f
Cred_651 di_tg_ctrl.$115.GatPoly v_b.$2003.Metal1 0.0138797f
Cred_652 di_tg_ctrl.$115.GatPoly v_b.$3438.Metal2 0.0081253f
Cred_653 di_tg_ctrl.$115.GatPoly v_b.$3507.Metal2 0.00680296f
Cred_654 di_tg_ctrl.$115.GatPoly v_b.$3535.Metal2 0.00162908f
Cred_655 di_tg_ctrl.$115.GatPoly v_b.$3990.Metal3 0.00475349f
Cred_656 di_tg_ctrl.$115.GatPoly v_b.P59.pSD 0.0285241f
Cred_657 di_tg_ctrl.$115.GatPoly v_b.P61.pSD 0.0110493f
Cred_658 di_tg_ctrl.$115.GatPoly v_b.P63.pSD 0.005679f
Cred_659 di_tg_ctrl.$115.GatPoly VDD.$295.Metal1 4.8359e-05f
Cred_660 di_tg_ctrl.$115.GatPoly VDD.$299.Metal1 0.00249151f
Cred_661 di_tg_ctrl.$115.GatPoly VDD.$309.Metal1 0.00404495f
Cred_662 di_tg_ctrl.$115.GatPoly VDD.$313.Metal1 0.000473897f
Cred_663 di_tg_ctrl.$115.GatPoly VDD.$612.Metal2 1.03739e-07f
Cred_664 di_tg_ctrl.$115.GatPoly VDD.$620.Metal2 1.3588e-05f
Cred_665 di_tg_ctrl.$115.GatPoly VDD.$624.Metal2 1.80094e-05f
Cred_666 di_tg_ctrl.$115.GatPoly VDD.$632.Metal2 1.0608e-06f
Cred_667 di_tg_ctrl.$115.GatPoly VDD.$780.Metal3 8.3176e-10f
Cred_668 di_tg_ctrl.$115.GatPoly VDD.$786.Metal3 8.50526e-09f
Cred_669 di_tg_ctrl.$115.GatPoly VDD.P0.nSD 8.07674e-06f
Cred_670 di_tg_ctrl.$119.GatPoly di_tg_ctrl_n.$219.Metal1 0.000128485f
Cred_671 di_tg_ctrl.$119.GatPoly di_tg_ctrl_n.$83.GatPoly 0.00138781f
Cred_672 di_tg_ctrl.$119.GatPoly di_tg_ctrl_n.P52.GatPoly 1.09226e-05f
Cred_673 di_tg_ctrl.$119.GatPoly di_tg_ctrl_n.P53.GatPoly 7.21123e-06f
Cred_674 di_tg_ctrl.$119.GatPoly VSS 0.00995367f
Cred_675 di_tg_ctrl.$119.GatPoly v_b.$2003.Metal1 0.00515653f
Cred_676 di_tg_ctrl.$119.GatPoly v_b.$3507.Metal2 0.00264011f
Cred_677 di_tg_ctrl.$119.GatPoly v_b.$3535.Metal2 0.00907333f
Cred_678 di_tg_ctrl.$119.GatPoly v_b.$3990.Metal3 0.00186253f
Cred_679 di_tg_ctrl.$119.GatPoly v_b.$4009.Metal3 0.00658155f
Cred_680 di_tg_ctrl.$119.GatPoly v_b.P61.pSD 0.00431884f
Cred_681 di_tg_ctrl.$119.GatPoly v_b.P63.pSD 0.0316879f
Cred_682 di_tg_ctrl.$119.GatPoly v_b.P65.pSD 0.0148356f
Cred_683 di_tg_ctrl.$119.GatPoly VDD.$299.Metal1 0.000138913f
Cred_684 di_tg_ctrl.$119.GatPoly VDD.$309.Metal1 0.00171559f
Cred_685 di_tg_ctrl.$119.GatPoly VDD.$313.Metal1 0.00333238f
Cred_686 di_tg_ctrl.$119.GatPoly VDD.$317.Metal1 0.00317999f
Cred_687 di_tg_ctrl.$119.GatPoly VDD.$321.Metal1 0.0010033f
Cred_688 di_tg_ctrl.$119.GatPoly VDD.$620.Metal2 7.83613e-07f
Cred_689 di_tg_ctrl.$119.GatPoly VDD.$624.Metal2 3.1646e-06f
Cred_690 di_tg_ctrl.$119.GatPoly VDD.$632.Metal2 1.07545e-05f
Cred_691 di_tg_ctrl.$119.GatPoly VDD.$640.Metal2 9.35775e-07f
Cred_692 di_tg_ctrl.$119.GatPoly VDD.$786.Metal3 1.044e-08f
Cred_693 di_tg_ctrl.$119.GatPoly VDD.$790.Metal3 7.50284e-09f
Cred_694 di_tg_ctrl.$119.GatPoly VDD.P0.nSD 7.07288e-07f
Cred_695 di_tg_ctrl.$12.GatPoly VSS 0.0419433f
Cred_696 di_tg_ctrl.$12.GatPoly v_a.$2237.Metal3 0.00340838f
Cred_697 di_tg_ctrl.$12.GatPoly v_a.P4.nSD 0.00457771f
Cred_698 di_tg_ctrl.$12.GatPoly v_b.$2421.Metal2 0.00439207f
Cred_699 di_tg_ctrl.$12.GatPoly v_b.P5.nSD 0.00407594f
Cred_700 di_tg_ctrl.$12.GatPoly VSS.$17.Metal1 4.73939e-07f
Cred_701 di_tg_ctrl.$12.GatPoly VSS.$301.Metal1 1.50917e-09f
Cred_702 di_tg_ctrl.$12.GatPoly VSS.$366.Metal2 1.00795e-06f
Cred_703 di_tg_ctrl.$12.GatPoly VSS.$370.Metal2 2.02608e-06f
Cred_704 di_tg_ctrl.$12.GatPoly VSS.$378.Metal2 7.98246e-06f
Cred_705 di_tg_ctrl.$12.GatPoly VSS.$39.Metal1 0.000130678f
Cred_706 di_tg_ctrl.$12.GatPoly VSS.$51.Metal1 0.00400041f
Cred_707 di_tg_ctrl.$12.GatPoly VSS.$606.Metal2 1.59461e-10f
Cred_708 di_tg_ctrl.$12.GatPoly VSS.$61.Metal1 0.001035f
Cred_709 di_tg_ctrl.$12.GatPoly VSS.$760.Metal3 9.43512e-12f
Cred_710 di_tg_ctrl.$12.GatPoly VSS.P0.pSD 8.37698e-06f
Cred_711 di_tg_ctrl.$122.GatPoly di_tg_ctrl_n.$219.Metal1 1.20136e-05f
Cred_712 di_tg_ctrl.$122.GatPoly di_tg_ctrl_n.$83.GatPoly 0.000129763f
Cred_713 di_tg_ctrl.$122.GatPoly di_tg_ctrl_n.P52.GatPoly 1.02129e-06f
Cred_714 di_tg_ctrl.$122.GatPoly di_tg_ctrl_n.P53.GatPoly 6.74265e-07f
Cred_715 di_tg_ctrl.$122.GatPoly VSS 0.00604125f
Cred_716 di_tg_ctrl.$122.GatPoly v_b.$3535.Metal2 0.00089877f
Cred_717 di_tg_ctrl.$122.GatPoly v_b.$3629.Metal2 0.00560645f
Cred_718 di_tg_ctrl.$122.GatPoly v_b.$4009.Metal3 0.0122546f
Cred_719 di_tg_ctrl.$122.GatPoly v_b.P63.pSD 0.00318528f
Cred_720 di_tg_ctrl.$122.GatPoly v_b.P65.pSD 0.0277145f
Cred_721 di_tg_ctrl.$122.GatPoly v_b.P67.pSD 0.0195442f
Cred_722 di_tg_ctrl.$122.GatPoly VDD.$317.Metal1 0.000823474f
Cred_723 di_tg_ctrl.$122.GatPoly VDD.$321.Metal1 0.00363957f
Cred_724 di_tg_ctrl.$122.GatPoly VDD.$332.Metal1 0.000625352f
Cred_725 di_tg_ctrl.$122.GatPoly VDD.$632.Metal2 1.84332e-06f
Cred_726 di_tg_ctrl.$122.GatPoly VDD.$640.Metal2 1.15384e-05f
Cred_727 di_tg_ctrl.$122.GatPoly VDD.$644.Metal2 4.82302e-06f
Cred_728 di_tg_ctrl.$122.GatPoly VDD.$790.Metal3 1.47793e-08f
Cred_729 di_tg_ctrl.$122.GatPoly VDD.P0.nSD 4.21622e-06f
Cred_730 di_tg_ctrl.$124.GatPoly VSS 0.00600077f
Cred_731 di_tg_ctrl.$124.GatPoly v_b 0.00251387f
Cred_732 di_tg_ctrl.$124.GatPoly v_b.$2255.Metal1 0.0151963f
Cred_733 di_tg_ctrl.$124.GatPoly v_b.$3629.Metal2 0.00446608f
Cred_734 di_tg_ctrl.$124.GatPoly v_b.$3698.Metal2 0.010218f
Cred_735 di_tg_ctrl.$124.GatPoly v_b.$4009.Metal3 8.97095e-09f
Cred_736 di_tg_ctrl.$124.GatPoly v_b.$4065.Metal3 0.0107615f
Cred_737 di_tg_ctrl.$124.GatPoly v_b.P65.pSD 5.35871e-09f
Cred_738 di_tg_ctrl.$124.GatPoly v_b.P67.pSD 0.0154268f
Cred_739 di_tg_ctrl.$124.GatPoly v_b.P69.pSD 0.0135522f
Cred_740 di_tg_ctrl.$124.GatPoly v_b.P71.pSD 0.0109552f
Cred_741 di_tg_ctrl.$124.GatPoly VDD.$317.Metal1 6.56981e-05f
Cred_742 di_tg_ctrl.$124.GatPoly VDD.$321.Metal1 0.00320324f
Cred_743 di_tg_ctrl.$124.GatPoly VDD.$332.Metal1 0.00256904f
Cred_744 di_tg_ctrl.$124.GatPoly VDD.$340.Metal1 4.01155e-05f
Cred_745 di_tg_ctrl.$124.GatPoly VDD.$388.Metal2 1.51694e-12f
Cred_746 di_tg_ctrl.$124.GatPoly VDD.$42.Metal1 7.12272e-11f
Cred_747 di_tg_ctrl.$124.GatPoly VDD.$632.Metal2 1.47063e-07f
Cred_748 di_tg_ctrl.$124.GatPoly VDD.$640.Metal2 1.84519e-05f
Cred_749 di_tg_ctrl.$124.GatPoly VDD.$644.Metal2 2.49981e-05f
Cred_750 di_tg_ctrl.$124.GatPoly VDD.$666.Metal3 6.6784e-14f
Cred_751 di_tg_ctrl.$124.GatPoly VDD.$790.Metal3 6.80113e-08f
Cred_752 di_tg_ctrl.$124.GatPoly VDD.$794.Metal3 3.37577e-07f
Cred_753 di_tg_ctrl.$124.GatPoly VDD.P0.nSD 2.76529e-05f
Cred_754 di_tg_ctrl.$126.GatPoly VSS 0.0109207f
Cred_755 di_tg_ctrl.$126.GatPoly v_b 0.0017336f
Cred_756 di_tg_ctrl.$126.GatPoly v_b.$2255.Metal1 0.01011f
Cred_757 di_tg_ctrl.$126.GatPoly v_b.$3629.Metal2 0.00134682f
Cred_758 di_tg_ctrl.$126.GatPoly v_b.$3698.Metal2 0.00471802f
Cred_759 di_tg_ctrl.$126.GatPoly v_b.$4009.Metal3 1.30301e-08f
Cred_760 di_tg_ctrl.$126.GatPoly v_b.$4065.Metal3 0.00528643f
Cred_761 di_tg_ctrl.$126.GatPoly v_b.P65.pSD 7.78338e-09f
Cred_762 di_tg_ctrl.$126.GatPoly v_b.P67.pSD 0.00478633f
Cred_763 di_tg_ctrl.$126.GatPoly v_b.P69.pSD 0.00643323f
Cred_764 di_tg_ctrl.$126.GatPoly v_b.P71.pSD 0.00767871f
Cred_765 di_tg_ctrl.$126.GatPoly VDD.$321.Metal1 0.00143797f
Cred_766 di_tg_ctrl.$126.GatPoly VDD.$332.Metal1 0.00715007f
Cred_767 di_tg_ctrl.$126.GatPoly VDD.$340.Metal1 0.000859532f
Cred_768 di_tg_ctrl.$126.GatPoly VDD.$388.Metal2 3.613e-11f
Cred_769 di_tg_ctrl.$126.GatPoly VDD.$42.Metal1 1.69646e-09f
Cred_770 di_tg_ctrl.$126.GatPoly VDD.$640.Metal2 9.18386e-06f
Cred_771 di_tg_ctrl.$126.GatPoly VDD.$644.Metal2 2.6778e-05f
Cred_772 di_tg_ctrl.$126.GatPoly VDD.$666.Metal3 1.59064e-12f
Cred_773 di_tg_ctrl.$126.GatPoly VDD.$790.Metal3 9.7072e-08f
Cred_774 di_tg_ctrl.$126.GatPoly VDD.$794.Metal3 4.90321e-07f
Cred_775 di_tg_ctrl.$126.GatPoly VDD.P0.nSD 0.000395752f
Cred_776 di_tg_ctrl.$128.Metal1 VSS 0.0625479f
Cred_777 di_tg_ctrl.$128.Metal1 v_a 0.0169935f
Cred_778 di_tg_ctrl.$128.Metal1 v_a.$2215.Metal3 2.33228e-05f
Cred_779 di_tg_ctrl.$128.Metal1 v_a.$2237.Metal3 6.88722e-05f
Cred_780 di_tg_ctrl.$128.Metal1 v_a.P0.nSD 0.0233339f
Cred_781 di_tg_ctrl.$128.Metal1 v_a.P2.nSD 3.39217e-05f
Cred_782 di_tg_ctrl.$128.Metal1 v_a.P4.nSD 4.85896e-08f
Cred_783 di_tg_ctrl.$128.Metal1 v_b.$2361.Metal2 0.0091755f
Cred_784 di_tg_ctrl.$128.Metal1 v_b.$2421.Metal2 3.26347e-06f
Cred_785 di_tg_ctrl.$128.Metal1 v_b.P0.nSD 0.00204952f
Cred_786 di_tg_ctrl.$128.Metal1 v_b.P0.pSD 2.67063e-05f
Cred_787 di_tg_ctrl.$128.Metal1 v_b.P1.nSD 0.00945293f
Cred_788 di_tg_ctrl.$128.Metal1 v_b.P3.nSD 3.5614e-06f
Cred_789 di_tg_ctrl.$128.Metal1 v_b.P3.pSD 6.56242e-08f
Cred_790 di_tg_ctrl.$128.Metal1 VSS.$17.Metal1 0.020418f
Cred_791 di_tg_ctrl.$128.Metal1 VSS.$301.Metal1 3.2575e-07f
Cred_792 di_tg_ctrl.$128.Metal1 VSS.$366.Metal2 0.00184288f
Cred_793 di_tg_ctrl.$128.Metal1 VSS.$370.Metal2 9.52591e-08f
Cred_794 di_tg_ctrl.$128.Metal1 VSS.$39.Metal1 0.02404f
Cred_795 di_tg_ctrl.$128.Metal1 VSS.$51.Metal1 4.70273e-07f
Cred_796 di_tg_ctrl.$128.Metal1 VSS.$606.Metal2 3.44192e-08f
Cred_797 di_tg_ctrl.$128.Metal1 VSS.$636.Metal3 0.00039687f
Cred_798 di_tg_ctrl.$128.Metal1 VSS.$642.Metal3 1.14286e-05f
Cred_799 di_tg_ctrl.$128.Metal1 VSS.$760.Metal3 2.03654e-09f
Cred_800 di_tg_ctrl.$128.Metal1 VSS.P0.pSD 0.00326548f
Cred_801 di_tg_ctrl.$130.Metal1 VSS 0.00821698f
Cred_802 di_tg_ctrl.$130.Metal1 v_a 0.00147711f
Cred_803 di_tg_ctrl.$130.Metal1 v_a.$2215.Metal3 0.000141678f
Cred_804 di_tg_ctrl.$130.Metal1 v_a.$2237.Metal3 0.000409473f
Cred_805 di_tg_ctrl.$130.Metal1 v_a.P0.nSD 0.000692658f
Cred_806 di_tg_ctrl.$130.Metal1 v_a.P2.nSD 8.60765e-05f
Cred_807 di_tg_ctrl.$130.Metal1 v_a.P4.nSD 3.27023e-08f
Cred_808 di_tg_ctrl.$130.Metal1 v_b.$2361.Metal2 0.00800905f
Cred_809 di_tg_ctrl.$130.Metal1 v_b.$2421.Metal2 2.19641e-06f
Cred_810 di_tg_ctrl.$130.Metal1 v_b.P0.nSD 0.000125687f
Cred_811 di_tg_ctrl.$130.Metal1 v_b.P0.pSD 1.63848e-06f
Cred_812 di_tg_ctrl.$130.Metal1 v_b.P1.nSD 0.0097815f
Cred_813 di_tg_ctrl.$130.Metal1 v_b.P3.nSD 2.39693e-06f
Cred_814 di_tg_ctrl.$130.Metal1 v_b.P3.pSD 4.4167e-08f
Cred_815 di_tg_ctrl.$130.Metal1 VSS.$17.Metal1 0.00362082f
Cred_816 di_tg_ctrl.$130.Metal1 VSS.$301.Metal1 2.09341e-07f
Cred_817 di_tg_ctrl.$130.Metal1 VSS.$366.Metal2 0.000939671f
Cred_818 di_tg_ctrl.$130.Metal1 VSS.$370.Metal2 6.41122e-08f
Cred_819 di_tg_ctrl.$130.Metal1 VSS.$39.Metal1 0.0190108f
Cred_820 di_tg_ctrl.$130.Metal1 VSS.$51.Metal1 3.16508e-07f
Cred_821 di_tg_ctrl.$130.Metal1 VSS.$606.Metal2 2.21193e-08f
Cred_822 di_tg_ctrl.$130.Metal1 VSS.$636.Metal3 0.00022328f
Cred_823 di_tg_ctrl.$130.Metal1 VSS.$642.Metal3 7.69181e-06f
Cred_824 di_tg_ctrl.$130.Metal1 VSS.$760.Metal3 1.30877e-09f
Cred_825 di_tg_ctrl.$130.Metal1 VSS.P0.pSD 0.000990436f
Cred_826 di_tg_ctrl.$132.Metal1 VSS 0.0119574f
Cred_827 di_tg_ctrl.$132.Metal1 v_a 0.00565198f
Cred_828 di_tg_ctrl.$132.Metal1 v_a.$2215.Metal3 0.00148028f
Cred_829 di_tg_ctrl.$132.Metal1 v_a.$2237.Metal3 0.00426669f
Cred_830 di_tg_ctrl.$132.Metal1 v_a.P2.nSD 0.0187012f
Cred_831 di_tg_ctrl.$132.Metal1 v_b.$2361.Metal2 0.00173696f
Cred_832 di_tg_ctrl.$132.Metal1 v_b.$2421.Metal2 0.00152062f
Cred_833 di_tg_ctrl.$132.Metal1 v_b.P1.nSD 0.000201036f
Cred_834 di_tg_ctrl.$132.Metal1 v_b.P3.nSD 0.00427073f
Cred_835 di_tg_ctrl.$132.Metal1 v_b.P3.pSD 3.05778e-05f
Cred_836 di_tg_ctrl.$132.Metal1 VSS.$17.Metal1 0.00052217f
Cred_837 di_tg_ctrl.$132.Metal1 VSS.$301.Metal1 3.07799e-09f
Cred_838 di_tg_ctrl.$132.Metal1 VSS.$366.Metal2 9.80791e-05f
Cred_839 di_tg_ctrl.$132.Metal1 VSS.$370.Metal2 3.94281e-05f
Cred_840 di_tg_ctrl.$132.Metal1 VSS.$39.Metal1 0.0261625f
Cred_841 di_tg_ctrl.$132.Metal1 VSS.$51.Metal1 0.00511237f
Cred_842 di_tg_ctrl.$132.Metal1 VSS.$606.Metal2 3.25225e-10f
Cred_843 di_tg_ctrl.$132.Metal1 VSS.$636.Metal3 3.46617e-06f
Cred_844 di_tg_ctrl.$132.Metal1 VSS.$760.Metal3 1.92431e-11f
Cred_845 di_tg_ctrl.$132.Metal1 VSS.P0.pSD 7.2848e-05f
Cred_846 di_tg_ctrl.$136.Metal1 VSS 0.00785673f
Cred_847 di_tg_ctrl.$136.Metal1 v_a 0.000206748f
Cred_848 di_tg_ctrl.$136.Metal1 v_a.$2215.Metal3 5.41482e-05f
Cred_849 di_tg_ctrl.$136.Metal1 v_a.$2237.Metal3 0.001545f
Cred_850 di_tg_ctrl.$136.Metal1 v_a.P2.nSD 0.000683455f
Cred_851 di_tg_ctrl.$136.Metal1 v_a.P4.nSD 0.00207326f
Cred_852 di_tg_ctrl.$136.Metal1 v_b.$2361.Metal2 0.00435075f
Cred_853 di_tg_ctrl.$136.Metal1 v_b.$2421.Metal2 0.00435075f
Cred_854 di_tg_ctrl.$136.Metal1 v_b.P3.nSD 0.0124363f
Cred_855 di_tg_ctrl.$136.Metal1 v_b.P3.pSD 8.74879e-05f
Cred_856 di_tg_ctrl.$136.Metal1 VSS.$366.Metal2 0.000100049f
Cred_857 di_tg_ctrl.$136.Metal1 VSS.$370.Metal2 0.000165894f
Cred_858 di_tg_ctrl.$136.Metal1 VSS.$378.Metal2 1.07161e-05f
Cred_859 di_tg_ctrl.$136.Metal1 VSS.$39.Metal1 0.0153371f
Cred_860 di_tg_ctrl.$136.Metal1 VSS.$51.Metal1 0.0157337f
Cred_861 di_tg_ctrl.$136.Metal1 VSS.$642.Metal3 8.59196e-08f
Cred_862 di_tg_ctrl.$136.Metal1 VSS.P0.pSD 7.73286e-05f
Cred_863 di_tg_ctrl.$138.Metal1 VSS 0.0105784f
Cred_864 di_tg_ctrl.$138.Metal1 v_a.$2237.Metal3 0.011497f
Cred_865 di_tg_ctrl.$138.Metal1 v_a.P4.nSD 0.0168467f
Cred_866 di_tg_ctrl.$138.Metal1 v_b.$2361.Metal2 6.07622e-06f
Cred_867 di_tg_ctrl.$138.Metal1 v_b.$2421.Metal2 0.00314845f
Cred_868 di_tg_ctrl.$138.Metal1 v_b.P3.nSD 1.19445e-06f
Cred_869 di_tg_ctrl.$138.Metal1 v_b.P3.pSD 1.22185e-07f
Cred_870 di_tg_ctrl.$138.Metal1 v_b.P5.nSD 0.00462513f
Cred_871 di_tg_ctrl.$138.Metal1 VSS.$17.Metal1 5.88993e-05f
Cred_872 di_tg_ctrl.$138.Metal1 VSS.$301.Metal1 1.87554e-07f
Cred_873 di_tg_ctrl.$138.Metal1 VSS.$366.Metal2 2.13178e-05f
Cred_874 di_tg_ctrl.$138.Metal1 VSS.$370.Metal2 0.000137495f
Cred_875 di_tg_ctrl.$138.Metal1 VSS.$378.Metal2 3.66253e-05f
Cred_876 di_tg_ctrl.$138.Metal1 VSS.$39.Metal1 0.0027638f
Cred_877 di_tg_ctrl.$138.Metal1 VSS.$51.Metal1 0.025015f
Cred_878 di_tg_ctrl.$138.Metal1 VSS.$606.Metal2 1.98173e-08f
Cred_879 di_tg_ctrl.$138.Metal1 VSS.$61.Metal1 0.00263892f
Cred_880 di_tg_ctrl.$138.Metal1 VSS.$642.Metal3 1.3047e-07f
Cred_881 di_tg_ctrl.$138.Metal1 VSS.$760.Metal3 1.17256e-09f
Cred_882 di_tg_ctrl.$138.Metal1 VSS.P0.pSD 0.000628945f
Cred_883 di_tg_ctrl.$14.GatPoly VSS 0.0389033f
Cred_884 di_tg_ctrl.$14.GatPoly v_a.$2237.Metal3 0.00195017f
Cred_885 di_tg_ctrl.$14.GatPoly v_a.$2275.Metal3 0.000676589f
Cred_886 di_tg_ctrl.$14.GatPoly v_a.$2297.Metal3 0.00195017f
Cred_887 di_tg_ctrl.$14.GatPoly v_a.P6.nSD 0.00618885f
Cred_888 di_tg_ctrl.$14.GatPoly v_b.$2421.Metal2 0.00500303f
Cred_889 di_tg_ctrl.$14.GatPoly v_b.$2481.Metal2 0.000237798f
Cred_890 di_tg_ctrl.$14.GatPoly v_b.P5.nSD 0.00441242f
Cred_891 di_tg_ctrl.$14.GatPoly v_b.P7.nSD 0.000451485f
Cred_892 di_tg_ctrl.$14.GatPoly v_b.P7.pSD 4.78182e-06f
Cred_893 di_tg_ctrl.$14.GatPoly VSS.$378.Metal2 7.12816e-06f
Cred_894 di_tg_ctrl.$14.GatPoly VSS.$51.Metal1 0.000924312f
Cred_895 di_tg_ctrl.$14.GatPoly VSS.$61.Metal1 0.00284419f
Cred_896 di_tg_ctrl.$14.GatPoly VSS.P0.pSD 2.34652e-06f
Cred_897 di_tg_ctrl.$142.Metal1 VSS 0.00782649f
Cred_898 di_tg_ctrl.$142.Metal1 v_a.$2237.Metal3 0.000961033f
Cred_899 di_tg_ctrl.$142.Metal1 v_a.$2275.Metal3 0.000145035f
Cred_900 di_tg_ctrl.$142.Metal1 v_a.$2297.Metal3 0.000418041f
Cred_901 di_tg_ctrl.$142.Metal1 v_a.P4.nSD 0.000713244f
Cred_902 di_tg_ctrl.$142.Metal1 v_a.P6.nSD 5.66334e-05f
Cred_903 di_tg_ctrl.$142.Metal1 v_b.$2421.Metal2 0.00879314f
Cred_904 di_tg_ctrl.$142.Metal1 v_b.P5.nSD 0.0121098f
Cred_905 di_tg_ctrl.$142.Metal1 VSS.$17.Metal1 0.000119447f
Cred_906 di_tg_ctrl.$142.Metal1 VSS.$301.Metal1 4.84182e-07f
Cred_907 di_tg_ctrl.$142.Metal1 VSS.$378.Metal2 6.62414e-05f
Cred_908 di_tg_ctrl.$142.Metal1 VSS.$51.Metal1 0.0148862f
Cred_909 di_tg_ctrl.$142.Metal1 VSS.$606.Metal2 5.11594e-08f
Cred_910 di_tg_ctrl.$142.Metal1 VSS.$61.Metal1 0.0151657f
Cred_911 di_tg_ctrl.$142.Metal1 VSS.$760.Metal3 3.02703e-09f
Cred_912 di_tg_ctrl.$142.Metal1 VSS.P0.pSD 0.00140106f
Cred_913 di_tg_ctrl.$143.Metal1 VSS 0.0106802f
Cred_914 di_tg_ctrl.$143.Metal1 v_a.$2237.Metal3 0.00475438f
Cred_915 di_tg_ctrl.$143.Metal1 v_a.$2275.Metal3 0.00164948f
Cred_916 di_tg_ctrl.$143.Metal1 v_a.$2297.Metal3 0.00475438f
Cred_917 di_tg_ctrl.$143.Metal1 v_a.P6.nSD 0.0188688f
Cred_918 di_tg_ctrl.$143.Metal1 v_b.$2421.Metal2 0.00147721f
Cred_919 di_tg_ctrl.$143.Metal1 v_b.$2481.Metal2 0.00147721f
Cred_920 di_tg_ctrl.$143.Metal1 v_b.P7.nSD 0.00418789f
Cred_921 di_tg_ctrl.$143.Metal1 v_b.P7.pSD 2.97047e-05f
Cred_922 di_tg_ctrl.$143.Metal1 VSS.$17.Metal1 1.187e-06f
Cred_923 di_tg_ctrl.$143.Metal1 VSS.$301.Metal1 5.32944e-09f
Cred_924 di_tg_ctrl.$143.Metal1 VSS.$378.Metal2 1.12252e-05f
Cred_925 di_tg_ctrl.$143.Metal1 VSS.$386.Metal2 4.40071e-05f
Cred_926 di_tg_ctrl.$143.Metal1 VSS.$51.Metal1 0.00145558f
Cred_927 di_tg_ctrl.$143.Metal1 VSS.$606.Metal2 5.63117e-10f
Cred_928 di_tg_ctrl.$143.Metal1 VSS.$61.Metal1 0.0227061f
Cred_929 di_tg_ctrl.$143.Metal1 VSS.$69.Metal1 0.00748131f
Cred_930 di_tg_ctrl.$143.Metal1 VSS.$760.Metal3 3.33189e-11f
Cred_931 di_tg_ctrl.$143.Metal1 VSS.P0.pSD 4.61484e-05f
Cred_932 di_tg_ctrl.$147.Metal1 VSS 0.00785311f
Cred_933 di_tg_ctrl.$147.Metal1 v_a.$2237.Metal3 0.000197264f
Cred_934 di_tg_ctrl.$147.Metal1 v_a.$2275.Metal3 6.84385e-05f
Cred_935 di_tg_ctrl.$147.Metal1 v_a.$2297.Metal3 0.00154708f
Cred_936 di_tg_ctrl.$147.Metal1 v_a.P6.nSD 0.000835688f
Cred_937 di_tg_ctrl.$147.Metal1 v_a.P8.nSD 0.00203162f
Cred_938 di_tg_ctrl.$147.Metal1 v_b.$2421.Metal2 0.00438123f
Cred_939 di_tg_ctrl.$147.Metal1 v_b.$2481.Metal2 0.00438123f
Cred_940 di_tg_ctrl.$147.Metal1 v_b.P7.nSD 0.0124953f
Cred_941 di_tg_ctrl.$147.Metal1 v_b.P7.pSD 8.81008e-05f
Cred_942 di_tg_ctrl.$147.Metal1 VSS.$386.Metal2 7.32882e-05f
Cred_943 di_tg_ctrl.$147.Metal1 VSS.$394.Metal2 5.16305e-05f
Cred_944 di_tg_ctrl.$147.Metal1 VSS.$61.Metal1 0.00893432f
Cred_945 di_tg_ctrl.$147.Metal1 VSS.$646.Metal3 9.35381e-08f
Cred_946 di_tg_ctrl.$147.Metal1 VSS.$654.Metal3 9.35381e-08f
Cred_947 di_tg_ctrl.$147.Metal1 VSS.$69.Metal1 0.0212855f
Cred_948 di_tg_ctrl.$147.Metal1 VSS.$79.Metal1 0.00102644f
Cred_949 di_tg_ctrl.$147.Metal1 VSS.P0.pSD 3.19606e-05f
Cred_950 di_tg_ctrl.$149.Metal1 VSS 0.0105937f
Cred_951 di_tg_ctrl.$149.Metal1 v_a.$2297.Metal3 0.0114499f
Cred_952 di_tg_ctrl.$149.Metal1 v_a.P8.nSD 0.0169581f
Cred_953 di_tg_ctrl.$149.Metal1 v_b.$2421.Metal2 6.10227e-06f
Cred_954 di_tg_ctrl.$149.Metal1 v_b.$2481.Metal2 0.00314818f
Cred_955 di_tg_ctrl.$149.Metal1 v_b.P10.nSD 0.00456519f
Cred_956 di_tg_ctrl.$149.Metal1 v_b.P7.nSD 1.19957e-06f
Cred_957 di_tg_ctrl.$149.Metal1 v_b.P7.pSD 1.22709e-07f
Cred_958 di_tg_ctrl.$149.Metal1 VSS.$17.Metal1 3.43685e-05f
Cred_959 di_tg_ctrl.$149.Metal1 VSS.$301.Metal1 3.06448e-07f
Cred_960 di_tg_ctrl.$149.Metal1 VSS.$386.Metal2 4.07783e-05f
Cred_961 di_tg_ctrl.$149.Metal1 VSS.$394.Metal2 0.000140523f
Cred_962 di_tg_ctrl.$149.Metal1 VSS.$606.Metal2 3.23798e-08f
Cred_963 di_tg_ctrl.$149.Metal1 VSS.$646.Metal3 1.60886e-07f
Cred_964 di_tg_ctrl.$149.Metal1 VSS.$654.Metal3 1.60886e-07f
Cred_965 di_tg_ctrl.$149.Metal1 VSS.$69.Metal1 0.0171732f
Cred_966 di_tg_ctrl.$149.Metal1 VSS.$760.Metal3 1.91587e-09f
Cred_967 di_tg_ctrl.$149.Metal1 VSS.$79.Metal1 0.0132987f
Cred_968 di_tg_ctrl.$149.Metal1 VSS.P0.pSD 0.000631966f
Cred_969 di_tg_ctrl.$153.Metal1 VSS 0.00783518f
Cred_970 di_tg_ctrl.$153.Metal1 v_a.$2297.Metal3 0.000537674f
Cred_971 di_tg_ctrl.$153.Metal1 v_a.$2327.Metal3 0.00101285f
Cred_972 di_tg_ctrl.$153.Metal1 v_a.P10.nSD 5.43641e-05f
Cred_973 di_tg_ctrl.$153.Metal1 v_a.P8.nSD 0.00067025f
Cred_974 di_tg_ctrl.$153.Metal1 v_b.$2481.Metal2 0.00879174f
Cred_975 di_tg_ctrl.$153.Metal1 v_b.P10.nSD 0.0122116f
Cred_976 di_tg_ctrl.$153.Metal1 VSS.$17.Metal1 7.23346e-05f
Cred_977 di_tg_ctrl.$153.Metal1 VSS.$301.Metal1 8.18358e-07f
Cred_978 di_tg_ctrl.$153.Metal1 VSS.$394.Metal2 2.61369e-05f
Cred_979 di_tg_ctrl.$153.Metal1 VSS.$402.Metal2 3.22809e-05f
Cred_980 di_tg_ctrl.$153.Metal1 VSS.$406.Metal2 1.60591e-05f
Cred_981 di_tg_ctrl.$153.Metal1 VSS.$606.Metal2 8.6469e-08f
Cred_982 di_tg_ctrl.$153.Metal1 VSS.$69.Metal1 0.00338907f
Cred_983 di_tg_ctrl.$153.Metal1 VSS.$760.Metal3 5.11626e-09f
Cred_984 di_tg_ctrl.$153.Metal1 VSS.$79.Metal1 0.0245613f
Cred_985 di_tg_ctrl.$153.Metal1 VSS.$91.Metal1 0.00208206f
Cred_986 di_tg_ctrl.$153.Metal1 VSS.P0.pSD 0.00146594f
Cred_987 di_tg_ctrl.$154.Metal1 VSS 0.0106581f
Cred_988 di_tg_ctrl.$154.Metal1 v_a.$2327.Metal3 0.0112231f
Cred_989 di_tg_ctrl.$154.Metal1 v_a.P10.nSD 0.0186957f
Cred_990 di_tg_ctrl.$154.Metal1 v_b.$2481.Metal2 0.00151855f
Cred_991 di_tg_ctrl.$154.Metal1 v_b.$2541.Metal2 0.00151855f
Cred_992 di_tg_ctrl.$154.Metal1 v_b.P11.nSD 0.00426654f
Cred_993 di_tg_ctrl.$154.Metal1 v_b.P11.pSD 3.05361e-05f
Cred_994 di_tg_ctrl.$154.Metal1 VSS.$17.Metal1 2.19591e-06f
Cred_995 di_tg_ctrl.$154.Metal1 VSS.$301.Metal1 2.75822e-08f
Cred_996 di_tg_ctrl.$154.Metal1 VSS.$402.Metal2 0.00010809f
Cred_997 di_tg_ctrl.$154.Metal1 VSS.$406.Metal2 9.67203e-05f
Cred_998 di_tg_ctrl.$154.Metal1 VSS.$606.Metal2 2.91438e-09f
Cred_999 di_tg_ctrl.$154.Metal1 VSS.$760.Metal3 1.7244e-10f
Cred_1000 di_tg_ctrl.$154.Metal1 VSS.$79.Metal1 0.0171968f
Cred_1001 di_tg_ctrl.$154.Metal1 VSS.$91.Metal1 0.0142018f
Cred_1002 di_tg_ctrl.$154.Metal1 VSS.P0.pSD 0.000124178f
Cred_1003 di_tg_ctrl.$158.Metal1 VSS 0.00784878f
Cred_1004 di_tg_ctrl.$158.Metal1 v_a.$2327.Metal3 0.00105837f
Cred_1005 di_tg_ctrl.$158.Metal1 v_a.$2365.Metal3 0.000191522f
Cred_1006 di_tg_ctrl.$158.Metal1 v_a.$2387.Metal3 0.000552033f
Cred_1007 di_tg_ctrl.$158.Metal1 v_a.P10.nSD 0.000928001f
Cred_1008 di_tg_ctrl.$158.Metal1 v_a.P12.nSD 0.00197715f
Cred_1009 di_tg_ctrl.$158.Metal1 v_b.$2481.Metal2 0.00433898f
Cred_1010 di_tg_ctrl.$158.Metal1 v_b.$2541.Metal2 0.00433898f
Cred_1011 di_tg_ctrl.$158.Metal1 v_b.P11.nSD 0.0124157f
Cred_1012 di_tg_ctrl.$158.Metal1 v_b.P11.pSD 8.72512e-05f
Cred_1013 di_tg_ctrl.$158.Metal1 VSS.$101.Metal1 0.00102055f
Cred_1014 di_tg_ctrl.$158.Metal1 VSS.$402.Metal2 4.51087e-05f
Cred_1015 di_tg_ctrl.$158.Metal1 VSS.$406.Metal2 9.21979e-05f
Cred_1016 di_tg_ctrl.$158.Metal1 VSS.$414.Metal2 4.82211e-05f
Cred_1017 di_tg_ctrl.$158.Metal1 VSS.$660.Metal3 1.75924e-07f
Cred_1018 di_tg_ctrl.$158.Metal1 VSS.$79.Metal1 0.00584866f
Cred_1019 di_tg_ctrl.$158.Metal1 VSS.$91.Metal1 0.0242781f
Cred_1020 di_tg_ctrl.$158.Metal1 VSS.P0.pSD 5.17618e-05f
Cred_1021 di_tg_ctrl.$160.Metal1 VSS 0.0106101f
Cred_1022 di_tg_ctrl.$160.Metal1 v_a.$2327.Metal3 0.00484697f
Cred_1023 di_tg_ctrl.$160.Metal1 v_a.$2365.Metal3 0.0016816f
Cred_1024 di_tg_ctrl.$160.Metal1 v_a.$2387.Metal3 0.00484697f
Cred_1025 di_tg_ctrl.$160.Metal1 v_a.P12.nSD 0.0171419f
Cred_1026 di_tg_ctrl.$160.Metal1 v_b.$2481.Metal2 6.10329e-06f
Cred_1027 di_tg_ctrl.$160.Metal1 v_b.$2541.Metal2 0.00314794f
Cred_1028 di_tg_ctrl.$160.Metal1 v_b.P11.nSD 1.19977e-06f
Cred_1029 di_tg_ctrl.$160.Metal1 v_b.P11.pSD 1.22729e-07f
Cred_1030 di_tg_ctrl.$160.Metal1 v_b.P13.nSD 0.00450924f
Cred_1031 di_tg_ctrl.$160.Metal1 VSS.$101.Metal1 0.0129247f
Cred_1032 di_tg_ctrl.$160.Metal1 VSS.$17.Metal1 2.0053e-05f
Cred_1033 di_tg_ctrl.$160.Metal1 VSS.$301.Metal1 4.99531e-07f
Cred_1034 di_tg_ctrl.$160.Metal1 VSS.$406.Metal2 4.29296e-05f
Cred_1035 di_tg_ctrl.$160.Metal1 VSS.$414.Metal2 0.000145088f
Cred_1036 di_tg_ctrl.$160.Metal1 VSS.$606.Metal2 5.27812e-08f
Cred_1037 di_tg_ctrl.$160.Metal1 VSS.$660.Metal3 3.442e-07f
Cred_1038 di_tg_ctrl.$160.Metal1 VSS.$760.Metal3 3.123e-09f
Cred_1039 di_tg_ctrl.$160.Metal1 VSS.$91.Metal1 0.0175747f
Cred_1040 di_tg_ctrl.$160.Metal1 VSS.P0.pSD 0.000629507f
Cred_1041 di_tg_ctrl.$163.Metal1 VSS 0.00784341f
Cred_1042 di_tg_ctrl.$163.Metal1 v_a.$2327.Metal3 0.000225221f
Cred_1043 di_tg_ctrl.$163.Metal1 v_a.$2365.Metal3 7.8138e-05f
Cred_1044 di_tg_ctrl.$163.Metal1 v_a.$2387.Metal3 0.00126247f
Cred_1045 di_tg_ctrl.$163.Metal1 v_a.P12.nSD 0.000624474f
Cred_1046 di_tg_ctrl.$163.Metal1 v_a.P14.nSD 0.00103955f
Cred_1047 di_tg_ctrl.$163.Metal1 v_b.$2541.Metal2 0.00879028f
Cred_1048 di_tg_ctrl.$163.Metal1 v_b.P13.nSD 0.0123174f
Cred_1049 di_tg_ctrl.$163.Metal1 VSS.$101.Metal1 0.0247248f
Cred_1050 di_tg_ctrl.$163.Metal1 VSS.$113.Metal1 0.00206628f
Cred_1051 di_tg_ctrl.$163.Metal1 VSS.$17.Metal1 4.33667e-05f
Cred_1052 di_tg_ctrl.$163.Metal1 VSS.$301.Metal1 1.36496e-06f
Cred_1053 di_tg_ctrl.$163.Metal1 VSS.$414.Metal2 2.82007e-05f
Cred_1054 di_tg_ctrl.$163.Metal1 VSS.$422.Metal2 3.2036e-05f
Cred_1055 di_tg_ctrl.$163.Metal1 VSS.$426.Metal2 1.59371e-05f
Cred_1056 di_tg_ctrl.$163.Metal1 VSS.$606.Metal2 1.44223e-07f
Cred_1057 di_tg_ctrl.$163.Metal1 VSS.$760.Metal3 8.53351e-09f
Cred_1058 di_tg_ctrl.$163.Metal1 VSS.$91.Metal1 0.0036568f
Cred_1059 di_tg_ctrl.$163.Metal1 VSS.P0.pSD 0.00149412f
Cred_1060 di_tg_ctrl.$165.Metal1 VSS 0.0106362f
Cred_1061 di_tg_ctrl.$165.Metal1 v_a.$2387.Metal3 0.0112455f
Cred_1062 di_tg_ctrl.$165.Metal1 v_a.P14.nSD 0.0177276f
Cred_1063 di_tg_ctrl.$165.Metal1 v_b.$2541.Metal2 0.00151702f
Cred_1064 di_tg_ctrl.$165.Metal1 v_b.$2601.Metal2 0.00151702f
Cred_1065 di_tg_ctrl.$165.Metal1 v_b.P15.nSD 0.00426345f
Cred_1066 di_tg_ctrl.$165.Metal1 v_b.P15.pSD 3.05053e-05f
Cred_1067 di_tg_ctrl.$165.Metal1 VSS.$101.Metal1 0.0171018f
Cred_1068 di_tg_ctrl.$165.Metal1 VSS.$113.Metal1 0.013842f
Cred_1069 di_tg_ctrl.$165.Metal1 VSS.$17.Metal1 2.22402e-06f
Cred_1070 di_tg_ctrl.$165.Metal1 VSS.$301.Metal1 7.79944e-08f
Cred_1071 di_tg_ctrl.$165.Metal1 VSS.$422.Metal2 0.000106399f
Cred_1072 di_tg_ctrl.$165.Metal1 VSS.$426.Metal2 9.48187e-05f
Cred_1073 di_tg_ctrl.$165.Metal1 VSS.$606.Metal2 8.24101e-09f
Cred_1074 di_tg_ctrl.$165.Metal1 VSS.$760.Metal3 4.8761e-10f
Cred_1075 di_tg_ctrl.$165.Metal1 VSS.P0.pSD 0.000156361f
Cred_1076 di_tg_ctrl.$169.Metal1 VSS 0.00784385f
Cred_1077 di_tg_ctrl.$169.Metal1 v_a.$2387.Metal3 0.00115123f
Cred_1078 di_tg_ctrl.$169.Metal1 v_a.$2447.Metal3 0.000608066f
Cred_1079 di_tg_ctrl.$169.Metal1 v_a.P14.nSD 0.000872227f
Cred_1080 di_tg_ctrl.$169.Metal1 v_a.P16.nSD 0.00190101f
Cred_1081 di_tg_ctrl.$169.Metal1 v_a.P16.pSD 1.34773e-05f
Cred_1082 di_tg_ctrl.$169.Metal1 v_b.$2541.Metal2 0.00433998f
Cred_1083 di_tg_ctrl.$169.Metal1 v_b.$2601.Metal2 0.00433998f
Cred_1084 di_tg_ctrl.$169.Metal1 v_b.P15.nSD 0.0124184f
Cred_1085 di_tg_ctrl.$169.Metal1 v_b.P15.pSD 8.72713e-05f
Cred_1086 di_tg_ctrl.$169.Metal1 VSS.$101.Metal1 0.00601776f
Cred_1087 di_tg_ctrl.$169.Metal1 VSS.$113.Metal1 0.0243942f
Cred_1088 di_tg_ctrl.$169.Metal1 VSS.$123.Metal1 0.000907534f
Cred_1089 di_tg_ctrl.$169.Metal1 VSS.$422.Metal2 4.64139e-05f
Cred_1090 di_tg_ctrl.$169.Metal1 VSS.$426.Metal2 9.19409e-05f
Cred_1091 di_tg_ctrl.$169.Metal1 VSS.$434.Metal2 4.3965e-05f
Cred_1092 di_tg_ctrl.$169.Metal1 VSS.$670.Metal3 1.61596e-07f
Cred_1093 di_tg_ctrl.$169.Metal1 VSS.P0.pSD 5.19032e-05f
Cred_1094 di_tg_ctrl.$17.GatPoly VSS 0.041943f
Cred_1095 di_tg_ctrl.$17.GatPoly v_a.$2237.Metal3 0.00144132f
Cred_1096 di_tg_ctrl.$17.GatPoly v_a.$2275.Metal3 0.000500049f
Cred_1097 di_tg_ctrl.$17.GatPoly v_a.$2297.Metal3 0.00144132f
Cred_1098 di_tg_ctrl.$17.GatPoly v_a.P6.nSD 0.00457652f
Cred_1099 di_tg_ctrl.$17.GatPoly v_b.$2421.Metal2 0.00216151f
Cred_1100 di_tg_ctrl.$17.GatPoly v_b.$2481.Metal2 0.00216151f
Cred_1101 di_tg_ctrl.$17.GatPoly v_b.P7.nSD 0.00409447f
Cred_1102 di_tg_ctrl.$17.GatPoly v_b.P7.pSD 4.34651e-05f
Cred_1103 di_tg_ctrl.$17.GatPoly VSS.$386.Metal2 1.61184e-05f
Cred_1104 di_tg_ctrl.$17.GatPoly VSS.$61.Metal1 0.00353626f
Cred_1105 di_tg_ctrl.$17.GatPoly VSS.$69.Metal1 0.00263004f
Cred_1106 di_tg_ctrl.$17.GatPoly VSS.P0.pSD 5.05317e-06f
Cred_1107 di_tg_ctrl.$171.Metal1 VSS 0.0105838f
Cred_1108 di_tg_ctrl.$171.Metal1 v_a.$2387.Metal3 0.00562483f
Cred_1109 di_tg_ctrl.$171.Metal1 v_a.$2447.Metal3 0.00562483f
Cred_1110 di_tg_ctrl.$171.Metal1 v_a.P16.nSD 0.0173646f
Cred_1111 di_tg_ctrl.$171.Metal1 v_a.P16.pSD 0.00012467f
Cred_1112 di_tg_ctrl.$171.Metal1 v_b.$2541.Metal2 6.07929e-06f
Cred_1113 di_tg_ctrl.$171.Metal1 v_b.$2601.Metal2 0.00322704f
Cred_1114 di_tg_ctrl.$171.Metal1 v_b.P15.nSD 1.19505e-06f
Cred_1115 di_tg_ctrl.$171.Metal1 v_b.P15.pSD 1.22247e-07f
Cred_1116 di_tg_ctrl.$171.Metal1 v_b.P17.nSD 0.00433343f
Cred_1117 di_tg_ctrl.$171.Metal1 VSS.$113.Metal1 0.0184574f
Cred_1118 di_tg_ctrl.$171.Metal1 VSS.$123.Metal1 0.0126898f
Cred_1119 di_tg_ctrl.$171.Metal1 VSS.$17.Metal1 1.17109e-05f
Cred_1120 di_tg_ctrl.$171.Metal1 VSS.$301.Metal1 8.13222e-07f
Cred_1121 di_tg_ctrl.$171.Metal1 VSS.$426.Metal2 4.51082e-05f
Cred_1122 di_tg_ctrl.$171.Metal1 VSS.$434.Metal2 0.000150758f
Cred_1123 di_tg_ctrl.$171.Metal1 VSS.$606.Metal2 8.59263e-08f
Cred_1124 di_tg_ctrl.$171.Metal1 VSS.$670.Metal3 3.61668e-07f
Cred_1125 di_tg_ctrl.$171.Metal1 VSS.$760.Metal3 5.08414e-09f
Cred_1126 di_tg_ctrl.$171.Metal1 VSS.P0.pSD 0.000621341f
Cred_1127 di_tg_ctrl.$174.Metal1 VSS 0.00770312f
Cred_1128 di_tg_ctrl.$174.Metal1 v_a.$2387.Metal3 0.000256897f
Cred_1129 di_tg_ctrl.$174.Metal1 v_a.$2447.Metal3 0.00134694f
Cred_1130 di_tg_ctrl.$174.Metal1 v_a.P16.nSD 0.000572139f
Cred_1131 di_tg_ctrl.$174.Metal1 v_a.P16.pSD 5.69391e-06f
Cred_1132 di_tg_ctrl.$174.Metal1 v_a.P18.nSD 0.00117484f
Cred_1133 di_tg_ctrl.$174.Metal1 v_b.$2601.Metal2 0.00898874f
Cred_1134 di_tg_ctrl.$174.Metal1 v_b.P17.nSD 0.0123527f
Cred_1135 di_tg_ctrl.$174.Metal1 VSS.$113.Metal1 0.00409589f
Cred_1136 di_tg_ctrl.$174.Metal1 VSS.$123.Metal1 0.0260746f
Cred_1137 di_tg_ctrl.$174.Metal1 VSS.$135.Metal1 0.00207518f
Cred_1138 di_tg_ctrl.$174.Metal1 VSS.$17.Metal1 2.57969e-05f
Cred_1139 di_tg_ctrl.$174.Metal1 VSS.$301.Metal1 2.25072e-06f
Cred_1140 di_tg_ctrl.$174.Metal1 VSS.$434.Metal2 8.74481e-05f
Cred_1141 di_tg_ctrl.$174.Metal1 VSS.$442.Metal2 0.000136986f
Cred_1142 di_tg_ctrl.$174.Metal1 VSS.$446.Metal2 1.60055e-05f
Cred_1143 di_tg_ctrl.$174.Metal1 VSS.$606.Metal2 2.37814e-07f
Cred_1144 di_tg_ctrl.$174.Metal1 VSS.$674.Metal3 4.4789e-07f
Cred_1145 di_tg_ctrl.$174.Metal1 VSS.$760.Metal3 1.40712e-08f
Cred_1146 di_tg_ctrl.$174.Metal1 VSS.P0.pSD 0.00149591f
Cred_1147 di_tg_ctrl.$176.Metal1 VSS 0.010602f
Cred_1148 di_tg_ctrl.$176.Metal1 v_a.$2447.Metal3 0.0113307f
Cred_1149 di_tg_ctrl.$176.Metal1 v_a.P18.nSD 0.0175923f
Cred_1150 di_tg_ctrl.$176.Metal1 v_b.$2601.Metal2 1.28874e-05f
Cred_1151 di_tg_ctrl.$176.Metal1 v_b.$2631.Metal2 0.00307831f
Cred_1152 di_tg_ctrl.$176.Metal1 v_b.P17.nSD 4.84034e-06f
Cred_1153 di_tg_ctrl.$176.Metal1 v_b.P19.nSD 0.00424368f
Cred_1154 di_tg_ctrl.$176.Metal1 VSS.$113.Metal1 1.20232e-07f
Cred_1155 di_tg_ctrl.$176.Metal1 VSS.$123.Metal1 0.0178008f
Cred_1156 di_tg_ctrl.$176.Metal1 VSS.$135.Metal1 0.0141266f
Cred_1157 di_tg_ctrl.$176.Metal1 VSS.$17.Metal1 1.86849e-06f
Cred_1158 di_tg_ctrl.$176.Metal1 VSS.$301.Metal1 1.82462e-07f
Cred_1159 di_tg_ctrl.$176.Metal1 VSS.$434.Metal2 6.41133e-06f
Cred_1160 di_tg_ctrl.$176.Metal1 VSS.$442.Metal2 0.000121697f
Cred_1161 di_tg_ctrl.$176.Metal1 VSS.$446.Metal2 9.73301e-05f
Cred_1162 di_tg_ctrl.$176.Metal1 VSS.$606.Metal2 1.92793e-08f
Cred_1163 di_tg_ctrl.$176.Metal1 VSS.$674.Metal3 5.13972e-08f
Cred_1164 di_tg_ctrl.$176.Metal1 VSS.$760.Metal3 1.14073e-09f
Cred_1165 di_tg_ctrl.$176.Metal1 VSS.P0.pSD 0.000191631f
Cred_1166 di_tg_ctrl.$180.Metal1 VSS 0.00783821f
Cred_1167 di_tg_ctrl.$180.Metal1 v_a.$2447.Metal3 0.00107219f
Cred_1168 di_tg_ctrl.$180.Metal1 v_a.$2485.Metal3 0.000172413f
Cred_1169 di_tg_ctrl.$180.Metal1 v_a.$2507.Metal3 0.000496956f
Cred_1170 di_tg_ctrl.$180.Metal1 v_a.P18.nSD 0.000918229f
Cred_1171 di_tg_ctrl.$180.Metal1 v_a.P20.nSD 0.00180406f
Cred_1172 di_tg_ctrl.$180.Metal1 v_b.$2631.Metal2 0.00881757f
Cred_1173 di_tg_ctrl.$180.Metal1 v_b.P19.nSD 0.0123734f
Cred_1174 di_tg_ctrl.$180.Metal1 VSS.$123.Metal1 0.00641299f
Cred_1175 di_tg_ctrl.$180.Metal1 VSS.$135.Metal1 0.0250136f
Cred_1176 di_tg_ctrl.$180.Metal1 VSS.$145.Metal1 0.000781401f
Cred_1177 di_tg_ctrl.$180.Metal1 VSS.$442.Metal2 4.9463e-05f
Cred_1178 di_tg_ctrl.$180.Metal1 VSS.$446.Metal2 9.46467e-05f
Cred_1179 di_tg_ctrl.$180.Metal1 VSS.$454.Metal2 3.95854e-05f
Cred_1180 di_tg_ctrl.$180.Metal1 VSS.$680.Metal3 1.47088e-07f
Cred_1181 di_tg_ctrl.$180.Metal1 VSS.P0.pSD 5.3726e-05f
Cred_1182 di_tg_ctrl.$182.Metal1 VSS 0.0106483f
Cred_1183 di_tg_ctrl.$182.Metal1 v_a.$2447.Metal3 0.00483547f
Cred_1184 di_tg_ctrl.$182.Metal1 v_a.$2485.Metal3 0.00167761f
Cred_1185 di_tg_ctrl.$182.Metal1 v_a.$2507.Metal3 0.00483547f
Cred_1186 di_tg_ctrl.$182.Metal1 v_a.P20.nSD 0.0174904f
Cred_1187 di_tg_ctrl.$182.Metal1 v_b.$2631.Metal2 0.00155889f
Cred_1188 di_tg_ctrl.$182.Metal1 v_b.$2691.Metal2 0.00154665f
Cred_1189 di_tg_ctrl.$182.Metal1 v_b.P19.nSD 1.11868e-06f
Cred_1190 di_tg_ctrl.$182.Metal1 v_b.P21.nSD 0.00419582f
Cred_1191 di_tg_ctrl.$182.Metal1 v_b.P21.pSD 3.1101e-05f
Cred_1192 di_tg_ctrl.$182.Metal1 VSS.$135.Metal1 0.0191912f
Cred_1193 di_tg_ctrl.$182.Metal1 VSS.$145.Metal1 0.0124427f
Cred_1194 di_tg_ctrl.$182.Metal1 VSS.$17.Metal1 6.86425e-06f
Cred_1195 di_tg_ctrl.$182.Metal1 VSS.$301.Metal1 1.32267e-06f
Cred_1196 di_tg_ctrl.$182.Metal1 VSS.$446.Metal2 4.73113e-05f
Cred_1197 di_tg_ctrl.$182.Metal1 VSS.$454.Metal2 0.000153648f
Cred_1198 di_tg_ctrl.$182.Metal1 VSS.$606.Metal2 1.39755e-07f
Cred_1199 di_tg_ctrl.$182.Metal1 VSS.$680.Metal3 3.79331e-07f
Cred_1200 di_tg_ctrl.$182.Metal1 VSS.$760.Metal3 8.26914e-09f
Cred_1201 di_tg_ctrl.$182.Metal1 VSS.P0.pSD 0.000609253f
Cred_1202 di_tg_ctrl.$185.Metal1 VSS 0.00787684f
Cred_1203 di_tg_ctrl.$185.Metal1 v_a.$2447.Metal3 0.000217004f
Cred_1204 di_tg_ctrl.$185.Metal1 v_a.$2485.Metal3 7.52871e-05f
Cred_1205 di_tg_ctrl.$185.Metal1 v_a.$2507.Metal3 0.00135715f
Cred_1206 di_tg_ctrl.$185.Metal1 v_a.P20.nSD 0.000514343f
Cred_1207 di_tg_ctrl.$185.Metal1 v_a.P22.nSD 0.00128635f
Cred_1208 di_tg_ctrl.$185.Metal1 v_b.$2631.Metal2 0.00437561f
Cred_1209 di_tg_ctrl.$185.Metal1 v_b.$2691.Metal2 0.00437561f
Cred_1210 di_tg_ctrl.$185.Metal1 v_b.P21.nSD 0.0127523f
Cred_1211 di_tg_ctrl.$185.Metal1 v_b.P21.pSD 8.79878e-05f
Cred_1212 di_tg_ctrl.$185.Metal1 VSS.$135.Metal1 0.00452509f
Cred_1213 di_tg_ctrl.$185.Metal1 VSS.$145.Metal1 0.0251424f
Cred_1214 di_tg_ctrl.$185.Metal1 VSS.$153.Metal1 0.00295966f
Cred_1215 di_tg_ctrl.$185.Metal1 VSS.$17.Metal1 1.54283e-05f
Cred_1216 di_tg_ctrl.$185.Metal1 VSS.$301.Metal1 3.71007e-06f
Cred_1217 di_tg_ctrl.$185.Metal1 VSS.$454.Metal2 8.78598e-05f
Cred_1218 di_tg_ctrl.$185.Metal1 VSS.$462.Metal2 0.00012416f
Cred_1219 di_tg_ctrl.$185.Metal1 VSS.$606.Metal2 3.92011e-07f
Cred_1220 di_tg_ctrl.$185.Metal1 VSS.$684.Metal3 4.33014e-07f
Cred_1221 di_tg_ctrl.$185.Metal1 VSS.$760.Metal3 2.31948e-08f
Cred_1222 di_tg_ctrl.$185.Metal1 VSS.P0.pSD 0.00148136f
Cred_1223 di_tg_ctrl.$187.Metal1 VSS 0.010598f
Cred_1224 di_tg_ctrl.$187.Metal1 v_a.$2507.Metal3 0.011351f
Cred_1225 di_tg_ctrl.$187.Metal1 v_a.P22.nSD 0.0173728f
Cred_1226 di_tg_ctrl.$187.Metal1 v_b.$2631.Metal2 7.53999e-06f
Cred_1227 di_tg_ctrl.$187.Metal1 v_b.$2691.Metal2 0.0030829f
Cred_1228 di_tg_ctrl.$187.Metal1 v_b.P21.nSD 5.98944e-06f
Cred_1229 di_tg_ctrl.$187.Metal1 v_b.P21.pSD 1.51619e-07f
Cred_1230 di_tg_ctrl.$187.Metal1 v_b.P23.nSD 0.00424077f
Cred_1231 di_tg_ctrl.$187.Metal1 VSS.$135.Metal1 1.6678e-07f
Cred_1232 di_tg_ctrl.$187.Metal1 VSS.$145.Metal1 0.0118558f
Cred_1233 di_tg_ctrl.$187.Metal1 VSS.$153.Metal1 0.0195104f
Cred_1234 di_tg_ctrl.$187.Metal1 VSS.$163.Metal1 0.000683691f
Cred_1235 di_tg_ctrl.$187.Metal1 VSS.$17.Metal1 1.45055e-06f
Cred_1236 di_tg_ctrl.$187.Metal1 VSS.$301.Metal1 3.91959e-07f
Cred_1237 di_tg_ctrl.$187.Metal1 VSS.$454.Metal2 8.23961e-06f
Cred_1238 di_tg_ctrl.$187.Metal1 VSS.$462.Metal2 7.72445e-05f
Cred_1239 di_tg_ctrl.$187.Metal1 VSS.$470.Metal2 5.2725e-06f
Cred_1240 di_tg_ctrl.$187.Metal1 VSS.$606.Metal2 4.1415e-08f
Cred_1241 di_tg_ctrl.$187.Metal1 VSS.$684.Metal3 6.60531e-08f
Cred_1242 di_tg_ctrl.$187.Metal1 VSS.$760.Metal3 2.45047e-09f
Cred_1243 di_tg_ctrl.$187.Metal1 VSS.P0.pSD 0.000181157f
Cred_1244 di_tg_ctrl.$19.GatPoly VSS 0.0389033f
Cred_1245 di_tg_ctrl.$19.GatPoly v_a.$2297.Metal3 0.00459452f
Cred_1246 di_tg_ctrl.$19.GatPoly v_a.P8.nSD 0.00617126f
Cred_1247 di_tg_ctrl.$19.GatPoly v_b.$2421.Metal2 0.00234605f
Cred_1248 di_tg_ctrl.$19.GatPoly v_b.$2481.Metal2 0.00282906f
Cred_1249 di_tg_ctrl.$19.GatPoly v_b.P10.nSD 0.000448854f
Cred_1250 di_tg_ctrl.$19.GatPoly v_b.P7.nSD 0.00443838f
Cred_1251 di_tg_ctrl.$19.GatPoly v_b.P7.pSD 4.7176e-05f
Cred_1252 di_tg_ctrl.$19.GatPoly VSS.$394.Metal2 3.86222e-06f
Cred_1253 di_tg_ctrl.$19.GatPoly VSS.$69.Metal1 0.00316276f
Cred_1254 di_tg_ctrl.$19.GatPoly VSS.$79.Metal1 0.000500818f
Cred_1255 di_tg_ctrl.$19.GatPoly VSS.P0.pSD 1.32137e-06f
Cred_1256 di_tg_ctrl.$191.Metal1 VSS 0.00783186f
Cred_1257 di_tg_ctrl.$191.Metal1 v_a.$2507.Metal3 0.00106509f
Cred_1258 di_tg_ctrl.$191.Metal1 v_a.$2545.Metal3 0.000160474f
Cred_1259 di_tg_ctrl.$191.Metal1 v_a.$2567.Metal3 0.000462543f
Cred_1260 di_tg_ctrl.$191.Metal1 v_a.P22.nSD 0.00095555f
Cred_1261 di_tg_ctrl.$191.Metal1 v_a.P24.nSD 0.00191457f
Cred_1262 di_tg_ctrl.$191.Metal1 v_b.$2691.Metal2 0.0088202f
Cred_1263 di_tg_ctrl.$191.Metal1 v_b.P23.nSD 0.0123766f
Cred_1264 di_tg_ctrl.$191.Metal1 VSS.$145.Metal1 0.00156774f
Cred_1265 di_tg_ctrl.$191.Metal1 VSS.$153.Metal1 0.0221635f
Cred_1266 di_tg_ctrl.$191.Metal1 VSS.$163.Metal1 0.00823369f
Cred_1267 di_tg_ctrl.$191.Metal1 VSS.$462.Metal2 1.20921e-05f
Cred_1268 di_tg_ctrl.$191.Metal1 VSS.$470.Metal2 9.36662e-05f
Cred_1269 di_tg_ctrl.$191.Metal1 VSS.$478.Metal2 6.75403e-06f
Cred_1270 di_tg_ctrl.$191.Metal1 VSS.$692.Metal3 5.41523e-08f
Cred_1271 di_tg_ctrl.$191.Metal1 VSS.P0.pSD 3.29762e-05f
Cred_1272 di_tg_ctrl.$193.Metal1 VSS 0.0106689f
Cred_1273 di_tg_ctrl.$193.Metal1 v_a.$2507.Metal3 0.00483968f
Cred_1274 di_tg_ctrl.$193.Metal1 v_a.$2545.Metal3 0.00167907f
Cred_1275 di_tg_ctrl.$193.Metal1 v_a.$2567.Metal3 0.00483968f
Cred_1276 di_tg_ctrl.$193.Metal1 v_a.P24.nSD 0.0179198f
Cred_1277 di_tg_ctrl.$193.Metal1 v_b.$2691.Metal2 0.0015587f
Cred_1278 di_tg_ctrl.$193.Metal1 v_b.$2751.Metal2 0.0015466f
Cred_1279 di_tg_ctrl.$193.Metal1 v_b.P23.nSD 1.10493e-06f
Cred_1280 di_tg_ctrl.$193.Metal1 v_b.P25.nSD 0.00411517f
Cred_1281 di_tg_ctrl.$193.Metal1 v_b.P25.pSD 3.11001e-05f
Cred_1282 di_tg_ctrl.$193.Metal1 VSS 0.00227309f
Cred_1283 di_tg_ctrl.$193.Metal1 VSS.$153.Metal1 0.00529443f
Cred_1284 di_tg_ctrl.$193.Metal1 VSS.$163.Metal1 0.0231471f
Cred_1285 di_tg_ctrl.$193.Metal1 VSS.$17.Metal1 4.06896e-06f
Cred_1286 di_tg_ctrl.$193.Metal1 VSS.$301.Metal1 2.14948e-06f
Cred_1287 di_tg_ctrl.$193.Metal1 VSS.$470.Metal2 0.00016097f
Cred_1288 di_tg_ctrl.$193.Metal1 VSS.$478.Metal2 3.05201e-05f
Cred_1289 di_tg_ctrl.$193.Metal1 VSS.$606.Metal2 2.27118e-07f
Cred_1290 di_tg_ctrl.$193.Metal1 VSS.$692.Metal3 1.62457e-07f
Cred_1291 di_tg_ctrl.$193.Metal1 VSS.$760.Metal3 1.34382e-08f
Cred_1292 di_tg_ctrl.$193.Metal1 VSS.P0.pSD 0.000587064f
Cred_1293 di_tg_ctrl.$196.Metal1 VSS 0.0149315f
Cred_1294 di_tg_ctrl.$196.Metal1 v_a.$2507.Metal3 0.000211784f
Cred_1295 di_tg_ctrl.$196.Metal1 v_a.$2545.Metal3 7.34762e-05f
Cred_1296 di_tg_ctrl.$196.Metal1 v_a.$2567.Metal3 0.00210146f
Cred_1297 di_tg_ctrl.$196.Metal1 v_a.P24.nSD 2.86912e-05f
Cred_1298 di_tg_ctrl.$196.Metal1 v_a.P26.nSD 0.00243295f
Cred_1299 di_tg_ctrl.$196.Metal1 v_b.$2691.Metal2 0.00478088f
Cred_1300 di_tg_ctrl.$196.Metal1 v_b.$2751.Metal2 0.00478088f
Cred_1301 di_tg_ctrl.$196.Metal1 v_b.P25.nSD 0.0136013f
Cred_1302 di_tg_ctrl.$196.Metal1 v_b.P25.pSD 9.61372e-05f
Cred_1303 di_tg_ctrl.$196.Metal1 VSS 0.0190035f
Cred_1304 di_tg_ctrl.$196.Metal1 VSS.$153.Metal1 0.000125559f
Cred_1305 di_tg_ctrl.$196.Metal1 VSS.$163.Metal1 0.0132805f
Cred_1306 di_tg_ctrl.$196.Metal1 VSS.$17.Metal1 3.72324e-06f
Cred_1307 di_tg_ctrl.$196.Metal1 VSS.$177.Metal1 5.69082e-05f
Cred_1308 di_tg_ctrl.$196.Metal1 VSS.$301.Metal1 1.96685e-06f
Cred_1309 di_tg_ctrl.$196.Metal1 VSS.$470.Metal2 9.6839e-07f
Cred_1310 di_tg_ctrl.$196.Metal1 VSS.$478.Metal2 3.68702e-05f
Cred_1311 di_tg_ctrl.$196.Metal1 VSS.$482.Metal2 8.82256e-07f
Cred_1312 di_tg_ctrl.$196.Metal1 VSS.$486.Metal2 4.38881e-07f
Cred_1313 di_tg_ctrl.$196.Metal1 VSS.$606.Metal2 2.0782e-07f
Cred_1314 di_tg_ctrl.$196.Metal1 VSS.$760.Metal3 1.22965e-08f
Cred_1315 di_tg_ctrl.$196.Metal1 VSS.P0.pSD 0.000532223f
Cred_1316 di_tg_ctrl.$198.Metal1 VSS 0.0117335f
Cred_1317 di_tg_ctrl.$198.Metal1 v_a.$2567.Metal3 0.0111717f
Cred_1318 di_tg_ctrl.$198.Metal1 v_a.P26.nSD 0.0166576f
Cred_1319 di_tg_ctrl.$198.Metal1 v_b.$2691.Metal2 0.000262693f
Cred_1320 di_tg_ctrl.$198.Metal1 v_b.$2751.Metal2 0.000275088f
Cred_1321 di_tg_ctrl.$198.Metal1 v_b.P25.nSD 0.000496977f
Cred_1322 di_tg_ctrl.$198.Metal1 v_b.P25.pSD 5.28241e-06f
Cred_1323 di_tg_ctrl.$198.Metal1 v_b.P27.nSD 1.13204e-06f
Cred_1324 di_tg_ctrl.$198.Metal1 VSS 0.0176469f
Cred_1325 di_tg_ctrl.$198.Metal1 VSS.$163.Metal1 9.15451e-05f
Cred_1326 di_tg_ctrl.$198.Metal1 VSS.$177.Metal1 0.00366351f
Cred_1327 di_tg_ctrl.$198.Metal1 VSS.$478.Metal2 7.06005e-07f
Cred_1328 di_tg_ctrl.$198.Metal1 VSS.$482.Metal2 0.000107614f
Cred_1329 di_tg_ctrl.$198.Metal1 VSS.$486.Metal2 6.26645e-05f
Cred_1330 di_tg_ctrl.$198.Metal1 VSS.P0.pSD 1.80608e-05f
Cred_1331 di_tg_ctrl.$200.Metal1 VSS 0.00785311f
Cred_1332 di_tg_ctrl.$200.Metal1 v_a.$2567.Metal3 0.00134016f
Cred_1333 di_tg_ctrl.$200.Metal1 v_a.$2597.Metal3 0.000464745f
Cred_1334 di_tg_ctrl.$200.Metal1 v_a.P26.nSD 0.0020311f
Cred_1335 di_tg_ctrl.$200.Metal1 v_a.P28.nSD 0.000833909f
Cred_1336 di_tg_ctrl.$200.Metal1 v_b.$2751.Metal2 0.00889904f
Cred_1337 di_tg_ctrl.$200.Metal1 v_b.P27.nSD 0.0124468f
Cred_1338 di_tg_ctrl.$200.Metal1 VSS 0.0115182f
Cred_1339 di_tg_ctrl.$200.Metal1 VSS.$177.Metal1 0.0197371f
Cred_1340 di_tg_ctrl.$200.Metal1 VSS.$191.Metal1 9.17286e-05f
Cred_1341 di_tg_ctrl.$200.Metal1 VSS.$482.Metal2 8.49499e-05f
Cred_1342 di_tg_ctrl.$200.Metal1 VSS.$486.Metal2 0.000101655f
Cred_1343 di_tg_ctrl.$200.Metal1 VSS.$494.Metal2 1.42215e-06f
Cred_1344 di_tg_ctrl.$200.Metal1 VSS.$498.Metal2 7.07532e-07f
Cred_1345 di_tg_ctrl.$200.Metal1 VSS.P0.pSD 4.27146e-05f
Cred_1346 di_tg_ctrl.$204.Metal1 di_tg_ctrl_n.$86.GatPoly 4.74183e-05f
Cred_1347 di_tg_ctrl.$204.Metal1 VSS 0.0106802f
Cred_1348 di_tg_ctrl.$204.Metal1 v_a.$2597.Metal3 0.0112011f
Cred_1349 di_tg_ctrl.$204.Metal1 v_a.P28.nSD 0.0188259f
Cred_1350 di_tg_ctrl.$204.Metal1 v_b.$2751.Metal2 0.00300047f
Cred_1351 di_tg_ctrl.$204.Metal1 v_b.P27.nSD 0.00417154f
Cred_1352 di_tg_ctrl.$204.Metal1 VSS 0.00147309f
Cred_1353 di_tg_ctrl.$204.Metal1 VSS.$17.Metal1 6.76509e-08f
Cred_1354 di_tg_ctrl.$204.Metal1 VSS.$177.Metal1 0.0266661f
Cred_1355 di_tg_ctrl.$204.Metal1 VSS.$191.Metal1 0.00352647f
Cred_1356 di_tg_ctrl.$204.Metal1 VSS.$301.Metal1 9.5755e-08f
Cred_1357 di_tg_ctrl.$204.Metal1 VSS.$482.Metal2 4.70886e-06f
Cred_1358 di_tg_ctrl.$204.Metal1 VSS.$486.Metal2 1.61132e-05f
Cred_1359 di_tg_ctrl.$204.Metal1 VSS.$494.Metal2 5.4674e-05f
Cred_1360 di_tg_ctrl.$204.Metal1 VSS.$498.Metal2 2.72008e-05f
Cred_1361 di_tg_ctrl.$204.Metal1 VSS.$606.Metal2 1.01176e-08f
Cred_1362 di_tg_ctrl.$204.Metal1 VSS.$760.Metal3 5.98646e-10f
Cred_1363 di_tg_ctrl.$204.Metal1 VSS.P0.pSD 5.3103e-05f
Cred_1364 di_tg_ctrl.$206.Metal1 VSS 0.00782649f
Cred_1365 di_tg_ctrl.$206.Metal1 v_a.$2597.Metal3 0.00121536f
Cred_1366 di_tg_ctrl.$206.Metal1 v_a.$2635.Metal3 7.99612e-05f
Cred_1367 di_tg_ctrl.$206.Metal1 v_a.$2657.Metal3 0.000230476f
Cred_1368 di_tg_ctrl.$206.Metal1 v_a.P28.nSD 5.28632e-05f
Cred_1369 di_tg_ctrl.$206.Metal1 v_a.P30.nSD 0.000715323f
Cred_1370 di_tg_ctrl.$206.Metal1 v_b.$2751.Metal2 0.00438671f
Cred_1371 di_tg_ctrl.$206.Metal1 v_b.$2811.Metal2 0.00438671f
Cred_1372 di_tg_ctrl.$206.Metal1 v_b.P29.nSD 0.0122704f
Cred_1373 di_tg_ctrl.$206.Metal1 v_b.P29.pSD 8.8211e-05f
Cred_1374 di_tg_ctrl.$206.Metal1 VSS.$17.Metal1 6.14806e-06f
Cred_1375 di_tg_ctrl.$206.Metal1 VSS.$177.Metal1 0.0140484f
Cred_1376 di_tg_ctrl.$206.Metal1 VSS.$191.Metal1 0.0160098f
Cred_1377 di_tg_ctrl.$206.Metal1 VSS.$301.Metal1 9.6165e-06f
Cred_1378 di_tg_ctrl.$206.Metal1 VSS.$494.Metal2 9.98845e-05f
Cred_1379 di_tg_ctrl.$206.Metal1 VSS.$498.Metal2 0.000102124f
Cred_1380 di_tg_ctrl.$206.Metal1 VSS.$606.Metal2 1.01609e-06f
Cred_1381 di_tg_ctrl.$206.Metal1 VSS.$760.Metal3 6.01209e-08f
Cred_1382 di_tg_ctrl.$206.Metal1 VSS.P0.pSD 0.00155025f
Cred_1383 di_tg_ctrl.$209.Metal1 di_tg_ctrl_n.$86.GatPoly 6.39063e-05f
Cred_1384 di_tg_ctrl.$209.Metal1 VSS 0.0105784f
Cred_1385 di_tg_ctrl.$209.Metal1 v_a.$2597.Metal3 0.00487338f
Cred_1386 di_tg_ctrl.$209.Metal1 v_a.$2635.Metal3 0.00169077f
Cred_1387 di_tg_ctrl.$209.Metal1 v_a.$2657.Metal3 0.00487338f
Cred_1388 di_tg_ctrl.$209.Metal1 v_a.P30.nSD 0.0168898f
Cred_1389 di_tg_ctrl.$209.Metal1 v_b.$2751.Metal2 0.00149102f
Cred_1390 di_tg_ctrl.$209.Metal1 v_b.$2811.Metal2 0.00150336f
Cred_1391 di_tg_ctrl.$209.Metal1 v_b.P29.nSD 0.00453826f
Cred_1392 di_tg_ctrl.$209.Metal1 v_b.P29.pSD 2.99824e-05f
Cred_1393 di_tg_ctrl.$209.Metal1 v_b.P31.nSD 1.12721e-06f
Cred_1394 di_tg_ctrl.$209.Metal1 VSS.$17.Metal1 2.38365e-06f
Cred_1395 di_tg_ctrl.$209.Metal1 VSS.$177.Metal1 0.00420197f
Cred_1396 di_tg_ctrl.$209.Metal1 VSS.$191.Metal1 0.0250851f
Cred_1397 di_tg_ctrl.$209.Metal1 VSS.$205.Metal1 0.00130981f
Cred_1398 di_tg_ctrl.$209.Metal1 VSS.$301.Metal1 4.72305e-06f
Cred_1399 di_tg_ctrl.$209.Metal1 VSS.$494.Metal2 3.24048e-05f
Cred_1400 di_tg_ctrl.$209.Metal1 VSS.$498.Metal2 9.35366e-05f
Cred_1401 di_tg_ctrl.$209.Metal1 VSS.$506.Metal2 9.21478e-05f
Cred_1402 di_tg_ctrl.$209.Metal1 VSS.$510.Metal2 1.01009e-05f
Cred_1403 di_tg_ctrl.$209.Metal1 VSS.$606.Metal2 4.99045e-07f
Cred_1404 di_tg_ctrl.$209.Metal1 VSS.$706.Metal3 3.1297e-07f
Cred_1405 di_tg_ctrl.$209.Metal1 VSS.$760.Metal3 2.95278e-08f
Cred_1406 di_tg_ctrl.$209.Metal1 VSS.P0.pSD 0.000698253f
Cred_1407 di_tg_ctrl.$211.Metal1 VSS 0.00785673f
Cred_1408 di_tg_ctrl.$211.Metal1 v_a.$2597.Metal3 0.000585207f
Cred_1409 di_tg_ctrl.$211.Metal1 v_a.$2635.Metal3 0.000203031f
Cred_1410 di_tg_ctrl.$211.Metal1 v_a.$2657.Metal3 0.00100358f
Cred_1411 di_tg_ctrl.$211.Metal1 v_a.P30.nSD 0.00207799f
Cred_1412 di_tg_ctrl.$211.Metal1 v_a.P32.nSD 0.000682047f
Cred_1413 di_tg_ctrl.$211.Metal1 v_b.$2811.Metal2 0.00883713f
Cred_1414 di_tg_ctrl.$211.Metal1 v_b.P31.nSD 0.0123881f
Cred_1415 di_tg_ctrl.$211.Metal1 VSS.$191.Metal1 0.0198792f
Cred_1416 di_tg_ctrl.$211.Metal1 VSS.$205.Metal1 0.0113651f
Cred_1417 di_tg_ctrl.$211.Metal1 VSS.$498.Metal2 2.57057e-05f
Cred_1418 di_tg_ctrl.$211.Metal1 VSS.$506.Metal2 0.000154246f
Cred_1419 di_tg_ctrl.$211.Metal1 VSS.$510.Metal2 8.65695e-05f
Cred_1420 di_tg_ctrl.$211.Metal1 VSS.$706.Metal3 2.06102e-07f
Cred_1421 di_tg_ctrl.$211.Metal1 VSS.P0.pSD 7.32478e-05f
Cred_1422 di_tg_ctrl.$215.Metal1 di_tg_ctrl_n.$86.GatPoly 0.00026201f
Cred_1423 di_tg_ctrl.$215.Metal1 VSS 0.0119574f
Cred_1424 di_tg_ctrl.$215.Metal1 v_a.$2657.Metal3 0.0114374f
Cred_1425 di_tg_ctrl.$215.Metal1 v_a.P32.nSD 0.0186627f
Cred_1426 di_tg_ctrl.$215.Metal1 v_b.$2811.Metal2 0.00319516f
Cred_1427 di_tg_ctrl.$215.Metal1 v_b.$2871.Metal2 0.000106507f
Cred_1428 di_tg_ctrl.$215.Metal1 v_b.P31.nSD 0.0042539f
Cred_1429 di_tg_ctrl.$215.Metal1 v_b.P33.nSD 0.000202214f
Cred_1430 di_tg_ctrl.$215.Metal1 v_b.P33.pSD 2.14171e-06f
Cred_1431 di_tg_ctrl.$215.Metal1 VSS.$17.Metal1 3.92791e-08f
Cred_1432 di_tg_ctrl.$215.Metal1 VSS.$191.Metal1 0.00840983f
Cred_1433 di_tg_ctrl.$215.Metal1 VSS.$205.Metal1 0.0234212f
Cred_1434 di_tg_ctrl.$215.Metal1 VSS.$301.Metal1 1.53241e-07f
Cred_1435 di_tg_ctrl.$215.Metal1 VSS.$506.Metal2 6.48655e-05f
Cred_1436 di_tg_ctrl.$215.Metal1 VSS.$510.Metal2 0.000101767f
Cred_1437 di_tg_ctrl.$215.Metal1 VSS.$606.Metal2 1.61917e-08f
Cred_1438 di_tg_ctrl.$215.Metal1 VSS.$760.Metal3 9.58042e-10f
Cred_1439 di_tg_ctrl.$215.Metal1 VSS.P0.pSD 7.58169e-05f
Cred_1440 di_tg_ctrl.$216.Metal1 di_tg_ctrl_n.$103.GatPoly 2.84467e-05f
Cred_1441 di_tg_ctrl.$216.Metal1 di_tg_ctrl_n.$223.Metal1 4.92869e-05f
Cred_1442 di_tg_ctrl.$216.Metal1 di_tg_ctrl_n.$227.Metal1 7.66925e-06f
Cred_1443 di_tg_ctrl.$216.Metal1 di_tg_ctrl_n.$232.Metal1 4.57053e-06f
Cred_1444 di_tg_ctrl.$216.Metal1 di_tg_ctrl_n.$234.Metal1 7.92494e-06f
Cred_1445 di_tg_ctrl.$216.Metal1 di_tg_ctrl_n.$238.Metal1 3.32291e-06f
Cred_1446 di_tg_ctrl.$216.Metal1 di_tg_ctrl_n.$352.Metal2 0.000162043f
Cred_1447 di_tg_ctrl.$216.Metal1 di_tg_ctrl_n.$443.Metal3 2.46457e-05f
Cred_1448 di_tg_ctrl.$216.Metal1 di_tg_ctrl_n.$86.GatPoly 0.00181231f
Cred_1449 di_tg_ctrl.$216.Metal1 di_tg_ctrl_n.$89.GatPoly 0.000161963f
Cred_1450 di_tg_ctrl.$216.Metal1 di_tg_ctrl_n.$93.GatPoly 6.07952e-05f
Cred_1451 di_tg_ctrl.$216.Metal1 di_tg_ctrl_n.$95.GatPoly 6.10801e-05f
Cred_1452 di_tg_ctrl.$216.Metal1 di_tg_ctrl_n.$99.GatPoly 4.67686e-05f
Cred_1453 di_tg_ctrl.$216.Metal1 di_tg_ctrl_n.P1.GatPoly 1.01515e-05f
Cred_1454 di_tg_ctrl.$216.Metal1 di_tg_ctrl_n.P2.GatPoly 1.7149e-06f
Cred_1455 di_tg_ctrl.$216.Metal1 di_tg_ctrl_n.P3.GatPoly 1.33291e-06f
Cred_1456 di_tg_ctrl.$216.Metal1 di_tg_ctrl_n.P5.GatPoly 1.81636e-06f
Cred_1457 di_tg_ctrl.$216.Metal1 di_tg_ctrl_n.P6.GatPoly 6.96862e-07f
Cred_1458 di_tg_ctrl.$216.Metal1 di_tg_ctrl_n.P7.GatPoly 6.23682e-07f
Cred_1459 di_tg_ctrl.$216.Metal1 VSS 0.00742747f
Cred_1460 di_tg_ctrl.$216.Metal1 v_a.$2597.Metal3 4.7065e-07f
Cred_1461 di_tg_ctrl.$216.Metal1 v_a.$2635.Metal3 1.63287e-07f
Cred_1462 di_tg_ctrl.$216.Metal1 v_a.$2657.Metal3 0.00201118f
Cred_1463 di_tg_ctrl.$216.Metal1 v_a.P30.nSD 3.69469e-08f
Cred_1464 di_tg_ctrl.$216.Metal1 v_a.P32.nSD 8.23936e-05f
Cred_1465 di_tg_ctrl.$216.Metal1 v_a.P34.nSD 0.000698682f
Cred_1466 di_tg_ctrl.$216.Metal1 v_a.P34.pSD 1.41012e-05f
Cred_1467 di_tg_ctrl.$216.Metal1 v_b.$2811.Metal2 0.00389414f
Cred_1468 di_tg_ctrl.$216.Metal1 v_b.$2871.Metal2 0.0040147f
Cred_1469 di_tg_ctrl.$216.Metal1 v_b.P31.nSD 2.3726e-06f
Cred_1470 di_tg_ctrl.$216.Metal1 v_b.P33.nSD 0.00982679f
Cred_1471 di_tg_ctrl.$216.Metal1 v_b.P33.pSD 7.82163e-05f
Cred_1472 di_tg_ctrl.$216.Metal1 v_b.P35.nSD 0.000116201f
Cred_1473 di_tg_ctrl.$216.Metal1 VSS.$17.Metal1 2.67098e-06f
Cred_1474 di_tg_ctrl.$216.Metal1 VSS.$191.Metal1 0.000429353f
Cred_1475 di_tg_ctrl.$216.Metal1 VSS.$205.Metal1 0.0172929f
Cred_1476 di_tg_ctrl.$216.Metal1 VSS.$213.Metal1 0.00512294f
Cred_1477 di_tg_ctrl.$216.Metal1 VSS.$221.Metal1 3.7638e-06f
Cred_1478 di_tg_ctrl.$216.Metal1 VSS.$301.Metal1 1.04204e-05f
Cred_1479 di_tg_ctrl.$216.Metal1 VSS.$506.Metal2 3.41836e-06f
Cred_1480 di_tg_ctrl.$216.Metal1 VSS.$510.Metal2 0.000125009f
Cred_1481 di_tg_ctrl.$216.Metal1 VSS.$518.Metal2 0.00063296f
Cred_1482 di_tg_ctrl.$216.Metal1 VSS.$526.Metal2 0.000143683f
Cred_1483 di_tg_ctrl.$216.Metal1 VSS.$606.Metal2 1.10104e-06f
Cred_1484 di_tg_ctrl.$216.Metal1 VSS.$706.Metal3 1.3313e-05f
Cred_1485 di_tg_ctrl.$216.Metal1 VSS.$712.Metal3 7.63547e-05f
Cred_1486 di_tg_ctrl.$216.Metal1 VSS.$716.Metal3 5.86765e-05f
Cred_1487 di_tg_ctrl.$216.Metal1 VSS.$760.Metal3 6.51468e-08f
Cred_1488 di_tg_ctrl.$216.Metal1 VSS.P0.pSD 0.00104125f
Cred_1489 di_tg_ctrl.$219.Metal1 di_tg_ctrl_n.$103.GatPoly 0.000531415f
Cred_1490 di_tg_ctrl.$219.Metal1 di_tg_ctrl_n.$223.Metal1 0.00770814f
Cred_1491 di_tg_ctrl.$219.Metal1 di_tg_ctrl_n.$227.Metal1 0.00014327f
Cred_1492 di_tg_ctrl.$219.Metal1 di_tg_ctrl_n.$232.Metal1 8.53824e-05f
Cred_1493 di_tg_ctrl.$219.Metal1 di_tg_ctrl_n.$234.Metal1 0.000148046f
Cred_1494 di_tg_ctrl.$219.Metal1 di_tg_ctrl_n.$238.Metal1 6.20754e-05f
Cred_1495 di_tg_ctrl.$219.Metal1 di_tg_ctrl_n.$352.Metal2 0.000390734f
Cred_1496 di_tg_ctrl.$219.Metal1 di_tg_ctrl_n.$443.Metal3 4.13172e-05f
Cred_1497 di_tg_ctrl.$219.Metal1 di_tg_ctrl_n.$86.GatPoly 0.0310523f
Cred_1498 di_tg_ctrl.$219.Metal1 di_tg_ctrl_n.$89.GatPoly 0.00272394f
Cred_1499 di_tg_ctrl.$219.Metal1 di_tg_ctrl_n.$93.GatPoly 0.00113572f
Cred_1500 di_tg_ctrl.$219.Metal1 di_tg_ctrl_n.$95.GatPoly 0.00114104f
Cred_1501 di_tg_ctrl.$219.Metal1 di_tg_ctrl_n.$99.GatPoly 0.000873688f
Cred_1502 di_tg_ctrl.$219.Metal1 di_tg_ctrl_n.P1.GatPoly 0.000153068f
Cred_1503 di_tg_ctrl.$219.Metal1 di_tg_ctrl_n.P2.GatPoly 3.20361e-05f
Cred_1504 di_tg_ctrl.$219.Metal1 di_tg_ctrl_n.P3.GatPoly 2.49002e-05f
Cred_1505 di_tg_ctrl.$219.Metal1 di_tg_ctrl_n.P5.GatPoly 3.39315e-05f
Cred_1506 di_tg_ctrl.$219.Metal1 di_tg_ctrl_n.P6.GatPoly 1.30181e-05f
Cred_1507 di_tg_ctrl.$219.Metal1 di_tg_ctrl_n.P7.GatPoly 1.16511e-05f
Cred_1508 di_tg_ctrl.$219.Metal1 VSS 0.0476086f
Cred_1509 di_tg_ctrl.$219.Metal1 v_a.$2597.Metal3 6.99301e-07f
Cred_1510 di_tg_ctrl.$219.Metal1 v_a.$2635.Metal3 2.42615e-07f
Cred_1511 di_tg_ctrl.$219.Metal1 v_a.$2657.Metal3 0.0167219f
Cred_1512 di_tg_ctrl.$219.Metal1 v_a.P30.nSD 5.48964e-08f
Cred_1513 di_tg_ctrl.$219.Metal1 v_a.P32.nSD 3.33154e-05f
Cred_1514 di_tg_ctrl.$219.Metal1 v_a.P34.nSD 0.0234427f
Cred_1515 di_tg_ctrl.$219.Metal1 v_a.P34.pSD 0.000254629f
Cred_1516 di_tg_ctrl.$219.Metal1 v_b.$2811.Metal2 0.00366442f
Cred_1517 di_tg_ctrl.$219.Metal1 v_b.$2871.Metal2 0.00570295f
Cred_1518 di_tg_ctrl.$219.Metal1 v_b.P31.nSD 3.52525e-06f
Cred_1519 di_tg_ctrl.$219.Metal1 v_b.P33.nSD 0.00951141f
Cred_1520 di_tg_ctrl.$219.Metal1 v_b.P33.pSD 7.35533e-05f
Cred_1521 di_tg_ctrl.$219.Metal1 v_b.P35.nSD 0.00190182f
Cred_1522 di_tg_ctrl.$219.Metal1 VSS.$17.Metal1 2.42688e-06f
Cred_1523 di_tg_ctrl.$219.Metal1 VSS.$191.Metal1 1.88652e-06f
Cred_1524 di_tg_ctrl.$219.Metal1 VSS.$205.Metal1 0.0105412f
Cred_1525 di_tg_ctrl.$219.Metal1 VSS.$213.Metal1 0.0281798f
Cred_1526 di_tg_ctrl.$219.Metal1 VSS.$221.Metal1 0.00152467f
Cred_1527 di_tg_ctrl.$219.Metal1 VSS.$301.Metal1 1.33057e-05f
Cred_1528 di_tg_ctrl.$219.Metal1 VSS.$506.Metal2 1.73148e-07f
Cred_1529 di_tg_ctrl.$219.Metal1 VSS.$510.Metal2 0.00011435f
Cred_1530 di_tg_ctrl.$219.Metal1 VSS.$518.Metal2 0.00103915f
Cred_1531 di_tg_ctrl.$219.Metal1 VSS.$526.Metal2 0.000304139f
Cred_1532 di_tg_ctrl.$219.Metal1 VSS.$606.Metal2 1.4059e-06f
Cred_1533 di_tg_ctrl.$219.Metal1 VSS.$706.Metal3 1.97807e-05f
Cred_1534 di_tg_ctrl.$219.Metal1 VSS.$712.Metal3 0.000114299f
Cred_1535 di_tg_ctrl.$219.Metal1 VSS.$716.Metal3 9.2352e-05f
Cred_1536 di_tg_ctrl.$219.Metal1 VSS.$760.Metal3 8.31851e-08f
Cred_1537 di_tg_ctrl.$219.Metal1 VSS.P0.pSD 0.00113642f
Cred_1538 di_tg_ctrl.$22.GatPoly VSS 0.0419433f
Cred_1539 di_tg_ctrl.$22.GatPoly v_a.$2297.Metal3 0.00339653f
Cred_1540 di_tg_ctrl.$22.GatPoly v_a.P8.nSD 0.00456153f
Cred_1541 di_tg_ctrl.$22.GatPoly v_b.$2481.Metal2 0.00439206f
Cred_1542 di_tg_ctrl.$22.GatPoly v_b.P10.nSD 0.00407521f
Cred_1543 di_tg_ctrl.$22.GatPoly VSS.$17.Metal1 2.93935e-07f
Cred_1544 di_tg_ctrl.$22.GatPoly VSS.$301.Metal1 2.62089e-09f
Cred_1545 di_tg_ctrl.$22.GatPoly VSS.$394.Metal2 1.06325e-05f
Cred_1546 di_tg_ctrl.$22.GatPoly VSS.$606.Metal2 2.76927e-10f
Cred_1547 di_tg_ctrl.$22.GatPoly VSS.$69.Metal1 0.00181058f
Cred_1548 di_tg_ctrl.$22.GatPoly VSS.$760.Metal3 1.63854e-11f
Cred_1549 di_tg_ctrl.$22.GatPoly VSS.$79.Metal1 0.00337388f
Cred_1550 di_tg_ctrl.$22.GatPoly VSS.P0.pSD 8.81591e-06f
Cred_1551 di_tg_ctrl.$223.Metal1 di_tg_ctrl_n.$204.Metal1 1.45626e-05f
Cred_1552 di_tg_ctrl.$223.Metal1 di_tg_ctrl_n.$207.Metal1 7.45998e-05f
Cred_1553 di_tg_ctrl.$223.Metal1 di_tg_ctrl_n.$209.Metal1 4.30237e-05f
Cred_1554 di_tg_ctrl.$223.Metal1 di_tg_ctrl_n.$215.Metal1 9.36517e-05f
Cred_1555 di_tg_ctrl.$223.Metal1 di_tg_ctrl_n.$216.Metal1 0.000156085f
Cred_1556 di_tg_ctrl.$223.Metal1 di_tg_ctrl_n.$219.Metal1 0.0114729f
Cred_1557 di_tg_ctrl.$223.Metal1 di_tg_ctrl_n.$69.GatPoly 0.000312661f
Cred_1558 di_tg_ctrl.$223.Metal1 di_tg_ctrl_n.$72.GatPoly 0.000405013f
Cred_1559 di_tg_ctrl.$223.Metal1 di_tg_ctrl_n.$76.GatPoly 0.000561658f
Cred_1560 di_tg_ctrl.$223.Metal1 di_tg_ctrl_n.$79.GatPoly 0.000806971f
Cred_1561 di_tg_ctrl.$223.Metal1 di_tg_ctrl_n.$83.GatPoly 0.00969249f
Cred_1562 di_tg_ctrl.$223.Metal1 di_tg_ctrl_n.P47.GatPoly 2.07749e-06f
Cred_1563 di_tg_ctrl.$223.Metal1 di_tg_ctrl_n.P48.GatPoly 6.13771e-06f
Cred_1564 di_tg_ctrl.$223.Metal1 di_tg_ctrl_n.P51.GatPoly 1.30328e-05f
Cred_1565 di_tg_ctrl.$223.Metal1 di_tg_ctrl_n.P52.GatPoly 7.39263e-05f
Cred_1566 di_tg_ctrl.$223.Metal1 di_tg_ctrl_n.P53.GatPoly 0.000249946f
Cred_1567 di_tg_ctrl.$223.Metal1 VSS 0.00260527f
Cred_1568 di_tg_ctrl.$223.Metal1 v_b.$2871.Metal2 0.000292283f
Cred_1569 di_tg_ctrl.$223.Metal1 v_b.$2962.Metal2 0.00238973f
Cred_1570 di_tg_ctrl.$223.Metal1 v_b.$3779.Metal3 0.00874169f
Cred_1571 di_tg_ctrl.$223.Metal1 v_b.P35.pSD 0.00106022f
Cred_1572 di_tg_ctrl.$223.Metal1 v_b.P37.nSD 1.04514e-05f
Cred_1573 di_tg_ctrl.$223.Metal1 v_b.P37.pSD 0.0225029f
Cred_1574 di_tg_ctrl.$223.Metal1 v_b.P39.pSD 0.0118285f
Cred_1575 di_tg_ctrl.$223.Metal1 VDD.$238.Metal1 0.0278232f
Cred_1576 di_tg_ctrl.$223.Metal1 VDD.$247.Metal1 0.0324223f
Cred_1577 di_tg_ctrl.$223.Metal1 VDD.$251.Metal1 3.9248e-05f
Cred_1578 di_tg_ctrl.$223.Metal1 VDD.$568.Metal2 8.15173e-05f
Cred_1579 di_tg_ctrl.$223.Metal1 VDD.$576.Metal2 7.32127e-08f
Cred_1580 di_tg_ctrl.$223.Metal1 VDD.$758.Metal3 5.87003e-10f
Cred_1581 di_tg_ctrl.$223.Metal1 VDD.P0.nSD 2.68768e-05f
Cred_1582 di_tg_ctrl.$225.Metal1 VSS 0.000593363f
Cred_1583 di_tg_ctrl.$225.Metal1 v_b.$2962.Metal2 0.0027821f
Cred_1584 di_tg_ctrl.$225.Metal1 v_b.$3785.Metal3 0.000981669f
Cred_1585 di_tg_ctrl.$225.Metal1 v_b.P39.pSD 0.0124106f
Cred_1586 di_tg_ctrl.$225.Metal1 v_b.P41.pSD 0.000841476f
Cred_1587 di_tg_ctrl.$225.Metal1 VDD.$238.Metal1 2.4404e-05f
Cred_1588 di_tg_ctrl.$225.Metal1 VDD.$247.Metal1 0.0155979f
Cred_1589 di_tg_ctrl.$225.Metal1 VDD.$251.Metal1 0.0176659f
Cred_1590 di_tg_ctrl.$225.Metal1 VDD.$263.Metal1 2.78102e-07f
Cred_1591 di_tg_ctrl.$225.Metal1 VDD.$568.Metal2 1.14046e-06f
Cred_1592 di_tg_ctrl.$225.Metal1 VDD.$576.Metal2 9.95975e-06f
Cred_1593 di_tg_ctrl.$225.Metal1 VDD.$580.Metal2 2.09224e-09f
Cred_1594 di_tg_ctrl.$225.Metal1 VDD.$758.Metal3 7.63506e-09f
Cred_1595 di_tg_ctrl.$225.Metal1 VDD.P0.nSD 4.27147e-08f
Cred_1596 di_tg_ctrl.$227.Metal1 di_tg_ctrl_n.$219.Metal1 5.14986e-05f
Cred_1597 di_tg_ctrl.$227.Metal1 di_tg_ctrl_n.$83.GatPoly 0.000267291f
Cred_1598 di_tg_ctrl.$227.Metal1 di_tg_ctrl_n.P52.GatPoly 2.10368e-06f
Cred_1599 di_tg_ctrl.$227.Metal1 di_tg_ctrl_n.P53.GatPoly 2.89037e-06f
Cred_1600 di_tg_ctrl.$227.Metal1 VSS 0.000938236f
Cred_1601 di_tg_ctrl.$227.Metal1 v_b.$3056.Metal2 0.00160868f
Cred_1602 di_tg_ctrl.$227.Metal1 v_b.$3785.Metal3 0.00943244f
Cred_1603 di_tg_ctrl.$227.Metal1 v_b.P41.pSD 0.0228979f
Cred_1604 di_tg_ctrl.$227.Metal1 v_b.P43.pSD 0.00727625f
Cred_1605 di_tg_ctrl.$227.Metal1 VDD.$247.Metal1 5.58592e-08f
Cred_1606 di_tg_ctrl.$227.Metal1 VDD.$251.Metal1 0.0339997f
Cred_1607 di_tg_ctrl.$227.Metal1 VDD.$263.Metal1 0.013908f
Cred_1608 di_tg_ctrl.$227.Metal1 VDD.$568.Metal2 1.18621e-05f
Cred_1609 di_tg_ctrl.$227.Metal1 VDD.$576.Metal2 0.000285097f
Cred_1610 di_tg_ctrl.$227.Metal1 VDD.$580.Metal2 9.50655e-05f
Cred_1611 di_tg_ctrl.$227.Metal1 VDD.$758.Metal3 9.51077e-08f
Cred_1612 di_tg_ctrl.$227.Metal1 VDD.P0.nSD 5.64297e-05f
Cred_1613 di_tg_ctrl.$230.Metal1 di_tg_ctrl_n.$219.Metal1 0.000176247f
Cred_1614 di_tg_ctrl.$230.Metal1 di_tg_ctrl_n.$471.Metal4 0.000124128f
Cred_1615 di_tg_ctrl.$230.Metal1 di_tg_ctrl_n.$491.Metal4 0.000161621f
Cred_1616 di_tg_ctrl.$230.Metal1 di_tg_ctrl_n.$83.GatPoly 0.000914764f
Cred_1617 di_tg_ctrl.$230.Metal1 di_tg_ctrl_n.P52.GatPoly 7.19953e-06f
Cred_1618 di_tg_ctrl.$230.Metal1 di_tg_ctrl_n.P53.GatPoly 9.89188e-06f
Cred_1619 di_tg_ctrl.$230.Metal1 VSS 0.00164438f
Cred_1620 di_tg_ctrl.$230.Metal1 v_b.$3056.Metal2 0.00473345f
Cred_1621 di_tg_ctrl.$230.Metal1 v_b.$3785.Metal3 0.000434617f
Cred_1622 di_tg_ctrl.$230.Metal1 v_b.$3821.Metal3 0.00305459f
Cred_1623 di_tg_ctrl.$230.Metal1 v_b.P41.pSD 0.000205382f
Cred_1624 di_tg_ctrl.$230.Metal1 v_b.P43.pSD 0.0218804f
Cred_1625 di_tg_ctrl.$230.Metal1 v_b.P45.pSD 0.00702814f
Cred_1626 di_tg_ctrl.$230.Metal1 VDD.$251.Metal1 0.0123509f
Cred_1627 di_tg_ctrl.$230.Metal1 VDD.$263.Metal1 0.0355358f
Cred_1628 di_tg_ctrl.$230.Metal1 VDD.$269.Metal1 0.000102839f
Cred_1629 di_tg_ctrl.$230.Metal1 VDD.$576.Metal2 4.87702e-05f
Cred_1630 di_tg_ctrl.$230.Metal1 VDD.$580.Metal2 0.000123432f
Cred_1631 di_tg_ctrl.$230.Metal1 VDD.$584.Metal2 0.000132721f
Cred_1632 di_tg_ctrl.$230.Metal1 VDD.$588.Metal2 5.0277e-07f
Cred_1633 di_tg_ctrl.$230.Metal1 VDD.P0.nSD 5.10777e-05f
Cred_1634 di_tg_ctrl.$232.Metal1 di_tg_ctrl_n.$219.Metal1 0.000101646f
Cred_1635 di_tg_ctrl.$232.Metal1 di_tg_ctrl_n.$471.Metal4 7.1588e-05f
Cred_1636 di_tg_ctrl.$232.Metal1 di_tg_ctrl_n.$491.Metal4 9.32112e-05f
Cred_1637 di_tg_ctrl.$232.Metal1 di_tg_ctrl_n.$83.GatPoly 0.000527569f
Cred_1638 di_tg_ctrl.$232.Metal1 di_tg_ctrl_n.P52.GatPoly 4.15216e-06f
Cred_1639 di_tg_ctrl.$232.Metal1 di_tg_ctrl_n.P53.GatPoly 5.70491e-06f
Cred_1640 di_tg_ctrl.$232.Metal1 VSS 0.00150899f
Cred_1641 di_tg_ctrl.$232.Metal1 v_b.$3056.Metal2 0.000648193f
Cred_1642 di_tg_ctrl.$232.Metal1 v_b.$3821.Metal3 0.00960645f
Cred_1643 di_tg_ctrl.$232.Metal1 v_b.P43.pSD 0.0022671f
Cred_1644 di_tg_ctrl.$232.Metal1 v_b.P45.pSD 0.022055f
Cred_1645 di_tg_ctrl.$232.Metal1 VDD.$251.Metal1 5.69128e-05f
Cred_1646 di_tg_ctrl.$232.Metal1 VDD.$263.Metal1 0.024003f
Cred_1647 di_tg_ctrl.$232.Metal1 VDD.$269.Metal1 0.00849692f
Cred_1648 di_tg_ctrl.$232.Metal1 VDD.$576.Metal2 2.24732e-07f
Cred_1649 di_tg_ctrl.$232.Metal1 VDD.$580.Metal2 9.82937e-06f
Cred_1650 di_tg_ctrl.$232.Metal1 VDD.$584.Metal2 7.87913e-05f
Cred_1651 di_tg_ctrl.$232.Metal1 VDD.$588.Metal2 4.15405e-05f
Cred_1652 di_tg_ctrl.$232.Metal1 VDD.P0.nSD 1.44927e-05f
Cred_1653 di_tg_ctrl.$234.Metal1 VSS 0.000593363f
Cred_1654 di_tg_ctrl.$234.Metal1 v_b.$3153.Metal2 0.002331f
Cred_1655 di_tg_ctrl.$234.Metal1 v_b.$3821.Metal3 0.000913253f
Cred_1656 di_tg_ctrl.$234.Metal1 v_b.P45.pSD 0.0022502f
Cred_1657 di_tg_ctrl.$234.Metal1 v_b.P47.pSD 0.0118417f
Cred_1658 di_tg_ctrl.$234.Metal1 VDD.$263.Metal1 0.0076152f
Cred_1659 di_tg_ctrl.$234.Metal1 VDD.$269.Metal1 0.0240328f
Cred_1660 di_tg_ctrl.$234.Metal1 VDD.$273.Metal1 4.20503e-05f
Cred_1661 di_tg_ctrl.$234.Metal1 VDD.$584.Metal2 1.43192e-06f
Cred_1662 di_tg_ctrl.$234.Metal1 VDD.$588.Metal2 3.76751e-05f
Cred_1663 di_tg_ctrl.$234.Metal1 VDD.$596.Metal2 7.4518e-08f
Cred_1664 di_tg_ctrl.$234.Metal1 VDD.$768.Metal3 5.97469e-10f
Cred_1665 di_tg_ctrl.$234.Metal1 VDD.P0.nSD 1.28896e-05f
Cred_1666 di_tg_ctrl.$236.Metal1 VSS 0.000593363f
Cred_1667 di_tg_ctrl.$236.Metal1 v_b.$3153.Metal2 0.00265631f
Cred_1668 di_tg_ctrl.$236.Metal1 v_b.$3857.Metal3 0.000446196f
Cred_1669 di_tg_ctrl.$236.Metal1 v_b.$3890.Metal3 0.000468506f
Cred_1670 di_tg_ctrl.$236.Metal1 v_b.P47.pSD 0.0125669f
Cred_1671 di_tg_ctrl.$236.Metal1 v_b.P49.nSD 8.28493e-07f
Cred_1672 di_tg_ctrl.$236.Metal1 v_b.P49.pSD 0.000563099f
Cred_1673 di_tg_ctrl.$236.Metal1 VDD.$263.Metal1 2.43834e-05f
Cred_1674 di_tg_ctrl.$236.Metal1 VDD.$269.Metal1 0.0156456f
Cred_1675 di_tg_ctrl.$236.Metal1 VDD.$273.Metal1 0.0176809f
Cred_1676 di_tg_ctrl.$236.Metal1 VDD.$283.Metal1 9.73772e-08f
Cred_1677 di_tg_ctrl.$236.Metal1 VDD.$584.Metal2 4.58491e-09f
Cred_1678 di_tg_ctrl.$236.Metal1 VDD.$588.Metal2 7.87258e-07f
Cred_1679 di_tg_ctrl.$236.Metal1 VDD.$596.Metal2 3.59879e-06f
Cred_1680 di_tg_ctrl.$236.Metal1 VDD.$600.Metal2 7.14254e-10f
Cred_1681 di_tg_ctrl.$236.Metal1 VDD.$768.Metal3 4.76733e-09f
Cred_1682 di_tg_ctrl.$236.Metal1 VDD.P0.nSD 4.17674e-08f
Cred_1683 di_tg_ctrl.$238.Metal1 di_tg_ctrl_n.$219.Metal1 2.46436e-05f
Cred_1684 di_tg_ctrl.$238.Metal1 di_tg_ctrl_n.$83.GatPoly 0.000127906f
Cred_1685 di_tg_ctrl.$238.Metal1 di_tg_ctrl_n.P52.GatPoly 1.00667e-06f
Cred_1686 di_tg_ctrl.$238.Metal1 di_tg_ctrl_n.P53.GatPoly 1.38312e-06f
Cred_1687 di_tg_ctrl.$238.Metal1 VSS 0.000938236f
Cred_1688 di_tg_ctrl.$238.Metal1 v_b.$3247.Metal2 0.00164646f
Cred_1689 di_tg_ctrl.$238.Metal1 v_b.$3857.Metal3 0.00462105f
Cred_1690 di_tg_ctrl.$238.Metal1 v_b.$3890.Metal3 0.0048521f
Cred_1691 di_tg_ctrl.$238.Metal1 v_b.P49.nSD 8.58033e-06f
Cred_1692 di_tg_ctrl.$238.Metal1 v_b.P49.pSD 0.0229982f
Cred_1693 di_tg_ctrl.$238.Metal1 v_b.P51.pSD 0.0074074f
Cred_1694 di_tg_ctrl.$238.Metal1 VDD.$269.Metal1 5.47272e-08f
Cred_1695 di_tg_ctrl.$238.Metal1 VDD.$273.Metal1 0.0335538f
Cred_1696 di_tg_ctrl.$238.Metal1 VDD.$283.Metal1 0.0135275f
Cred_1697 di_tg_ctrl.$238.Metal1 VDD.$588.Metal2 1.22337e-05f
Cred_1698 di_tg_ctrl.$238.Metal1 VDD.$596.Metal2 0.000293427f
Cred_1699 di_tg_ctrl.$238.Metal1 VDD.$600.Metal2 9.15652e-05f
Cred_1700 di_tg_ctrl.$238.Metal1 VDD.$768.Metal3 9.80873e-08f
Cred_1701 di_tg_ctrl.$238.Metal1 VDD.P0.nSD 5.50651e-05f
Cred_1702 di_tg_ctrl.$24.GatPoly VSS 0.0389033f
Cred_1703 di_tg_ctrl.$24.GatPoly v_a.$2327.Metal3 0.00459452f
Cred_1704 di_tg_ctrl.$24.GatPoly v_a.P10.nSD 0.00617126f
Cred_1705 di_tg_ctrl.$24.GatPoly v_b.$2481.Metal2 0.00500303f
Cred_1706 di_tg_ctrl.$24.GatPoly v_b.$2541.Metal2 0.000237798f
Cred_1707 di_tg_ctrl.$24.GatPoly v_b.P10.nSD 0.00441242f
Cred_1708 di_tg_ctrl.$24.GatPoly v_b.P11.nSD 0.000451485f
Cred_1709 di_tg_ctrl.$24.GatPoly v_b.P11.pSD 4.78182e-06f
Cred_1710 di_tg_ctrl.$24.GatPoly VSS.$402.Metal2 9.78985e-06f
Cred_1711 di_tg_ctrl.$24.GatPoly VSS.$406.Metal2 4.87024e-06f
Cred_1712 di_tg_ctrl.$24.GatPoly VSS.$79.Metal1 0.00320021f
Cred_1713 di_tg_ctrl.$24.GatPoly VSS.$91.Metal1 0.000631428f
Cred_1714 di_tg_ctrl.$24.GatPoly VSS.P0.pSD 4.54103e-06f
Cred_1715 di_tg_ctrl.$241.Metal1 VSS 0.000486042f
Cred_1716 di_tg_ctrl.$241.Metal1 v_b.$3247.Metal2 0.00360503f
Cred_1717 di_tg_ctrl.$241.Metal1 v_b.$3857.Metal3 0.000211367f
Cred_1718 di_tg_ctrl.$241.Metal1 v_b.$3890.Metal3 0.000221936f
Cred_1719 di_tg_ctrl.$241.Metal1 v_b.$3903.Metal3 0.00102745f
Cred_1720 di_tg_ctrl.$241.Metal1 v_b.P49.nSD 3.92465e-07f
Cred_1721 di_tg_ctrl.$241.Metal1 v_b.P49.pSD 0.000206367f
Cred_1722 di_tg_ctrl.$241.Metal1 v_b.P51.pSD 0.0179523f
Cred_1723 di_tg_ctrl.$241.Metal1 v_b.P53.pSD 0.0024382f
Cred_1724 di_tg_ctrl.$241.Metal1 VDD.$273.Metal1 0.012107f
Cred_1725 di_tg_ctrl.$241.Metal1 VDD.$283.Metal1 0.0338925f
Cred_1726 di_tg_ctrl.$241.Metal1 VDD.$287.Metal1 1.42784e-05f
Cred_1727 di_tg_ctrl.$241.Metal1 VDD.$596.Metal2 5.00836e-05f
Cred_1728 di_tg_ctrl.$241.Metal1 VDD.$600.Metal2 0.000120823f
Cred_1729 di_tg_ctrl.$241.Metal1 VDD.$604.Metal2 0.000126488f
Cred_1730 di_tg_ctrl.$241.Metal1 VDD.P0.nSD 4.97959e-05f
Cred_1731 di_tg_ctrl.$243.Metal1 di_tg_ctrl_n.$219.Metal1 1.81562e-05f
Cred_1732 di_tg_ctrl.$243.Metal1 di_tg_ctrl_n.$83.GatPoly 0.000196112f
Cred_1733 di_tg_ctrl.$243.Metal1 di_tg_ctrl_n.P52.GatPoly 1.54348e-06f
Cred_1734 di_tg_ctrl.$243.Metal1 di_tg_ctrl_n.P53.GatPoly 1.01902e-06f
Cred_1735 di_tg_ctrl.$243.Metal1 VSS 0.00150899f
Cred_1736 di_tg_ctrl.$243.Metal1 v_b.$3344.Metal2 0.000646201f
Cred_1737 di_tg_ctrl.$243.Metal1 v_b.$3903.Metal3 0.00973591f
Cred_1738 di_tg_ctrl.$243.Metal1 v_b.P51.pSD 1.07171e-05f
Cred_1739 di_tg_ctrl.$243.Metal1 v_b.P53.pSD 0.0223438f
Cred_1740 di_tg_ctrl.$243.Metal1 v_b.P55.pSD 0.00225267f
Cred_1741 di_tg_ctrl.$243.Metal1 VDD.$283.Metal1 0.0150182f
Cred_1742 di_tg_ctrl.$243.Metal1 VDD.$287.Metal1 0.016735f
Cred_1743 di_tg_ctrl.$243.Metal1 VDD.$291.Metal1 0.000173676f
Cred_1744 di_tg_ctrl.$243.Metal1 VDD.$600.Metal2 9.89539e-06f
Cred_1745 di_tg_ctrl.$243.Metal1 VDD.$604.Metal2 8.38569e-05f
Cred_1746 di_tg_ctrl.$243.Metal1 VDD.$612.Metal2 4.04966e-07f
Cred_1747 di_tg_ctrl.$243.Metal1 VDD.$776.Metal3 3.24693e-09f
Cred_1748 di_tg_ctrl.$245.Metal1 di_tg_ctrl_n.$219.Metal1 3.14815e-05f
Cred_1749 di_tg_ctrl.$245.Metal1 di_tg_ctrl_n.$83.GatPoly 0.000340044f
Cred_1750 di_tg_ctrl.$245.Metal1 di_tg_ctrl_n.P52.GatPoly 2.67627e-06f
Cred_1751 di_tg_ctrl.$245.Metal1 di_tg_ctrl_n.P53.GatPoly 1.7669e-06f
Cred_1752 di_tg_ctrl.$245.Metal1 VSS 0.00164438f
Cred_1753 di_tg_ctrl.$245.Metal1 v_b.$3344.Metal2 0.00472549f
Cred_1754 di_tg_ctrl.$245.Metal1 v_b.$3903.Metal3 0.0032265f
Cred_1755 di_tg_ctrl.$245.Metal1 v_b.$3934.Metal3 0.00043466f
Cred_1756 di_tg_ctrl.$245.Metal1 v_b.P53.pSD 0.00749234f
Cred_1757 di_tg_ctrl.$245.Metal1 v_b.P55.pSD 0.021842f
Cred_1758 di_tg_ctrl.$245.Metal1 v_b.P57.pSD 0.000205402f
Cred_1759 di_tg_ctrl.$245.Metal1 VDD.$283.Metal1 0.000219573f
Cred_1760 di_tg_ctrl.$245.Metal1 VDD.$287.Metal1 0.015337f
Cred_1761 di_tg_ctrl.$245.Metal1 VDD.$291.Metal1 0.0236137f
Cred_1762 di_tg_ctrl.$245.Metal1 VDD.$295.Metal1 0.00820404f
Cred_1763 di_tg_ctrl.$245.Metal1 VDD.$604.Metal2 7.15668e-07f
Cred_1764 di_tg_ctrl.$245.Metal1 VDD.$612.Metal2 6.33094e-07f
Cred_1765 di_tg_ctrl.$245.Metal1 VDD.$776.Metal3 5.07601e-09f
Cred_1766 di_tg_ctrl.$249.Metal1 di_tg_ctrl_n.$219.Metal1 6.55177e-06f
Cred_1767 di_tg_ctrl.$249.Metal1 di_tg_ctrl_n.$83.GatPoly 7.07682e-05f
Cred_1768 di_tg_ctrl.$249.Metal1 di_tg_ctrl_n.P52.GatPoly 5.56972e-07f
Cred_1769 di_tg_ctrl.$249.Metal1 di_tg_ctrl_n.P53.GatPoly 3.67719e-07f
Cred_1770 di_tg_ctrl.$249.Metal1 VSS 0.000938236f
Cred_1771 di_tg_ctrl.$249.Metal1 v_b.$3344.Metal2 0.0016486f
Cred_1772 di_tg_ctrl.$249.Metal1 v_b.$3934.Metal3 0.00950282f
Cred_1773 di_tg_ctrl.$249.Metal1 v_b.P55.pSD 0.00741507f
Cred_1774 di_tg_ctrl.$249.Metal1 v_b.P57.pSD 0.0229771f
Cred_1775 di_tg_ctrl.$249.Metal1 VDD.$291.Metal1 0.00726835f
Cred_1776 di_tg_ctrl.$249.Metal1 VDD.$295.Metal1 0.0227551f
Cred_1777 di_tg_ctrl.$249.Metal1 VDD.$299.Metal1 0.0173154f
Cred_1778 di_tg_ctrl.$249.Metal1 VDD.$612.Metal2 0.00012514f
Cred_1779 di_tg_ctrl.$249.Metal1 VDD.$620.Metal2 0.000100477f
Cred_1780 di_tg_ctrl.$249.Metal1 VDD.$780.Metal3 8.05602e-07f
Cred_1781 di_tg_ctrl.$250.Metal1 VSS 0.000593363f
Cred_1782 di_tg_ctrl.$250.Metal1 v_b.$3438.Metal2 0.00265631f
Cred_1783 di_tg_ctrl.$250.Metal1 v_b.$3934.Metal3 0.000917567f
Cred_1784 di_tg_ctrl.$250.Metal1 v_b.P57.pSD 0.000561063f
Cred_1785 di_tg_ctrl.$250.Metal1 v_b.P59.pSD 0.0125669f
Cred_1786 di_tg_ctrl.$250.Metal1 VDD.$295.Metal1 3.56229e-05f
Cred_1787 di_tg_ctrl.$250.Metal1 VDD.$299.Metal1 0.0254622f
Cred_1788 di_tg_ctrl.$250.Metal1 VDD.$309.Metal1 0.00557295f
Cred_1789 di_tg_ctrl.$250.Metal1 VDD.$612.Metal2 1.93371e-06f
Cred_1790 di_tg_ctrl.$250.Metal1 VDD.$620.Metal2 6.46281e-05f
Cred_1791 di_tg_ctrl.$250.Metal1 VDD.$624.Metal2 3.24851e-05f
Cred_1792 di_tg_ctrl.$250.Metal1 VDD.$780.Metal3 1.25526e-08f
Cred_1793 di_tg_ctrl.$250.Metal1 VDD.P0.nSD 2.82883e-05f
Cred_1794 di_tg_ctrl.$252.Metal1 VSS 0.000593363f
Cred_1795 di_tg_ctrl.$252.Metal1 v_b.$2003.Metal1 1.34919e-05f
Cred_1796 di_tg_ctrl.$252.Metal1 v_b.$3438.Metal2 0.002331f
Cred_1797 di_tg_ctrl.$252.Metal1 v_b.$3507.Metal2 3.12859e-05f
Cred_1798 di_tg_ctrl.$252.Metal1 v_b.$3990.Metal3 0.00140973f
Cred_1799 di_tg_ctrl.$252.Metal1 v_b.P59.pSD 0.0118563f
Cred_1800 di_tg_ctrl.$252.Metal1 v_b.P61.pSD 0.00184459f
Cred_1801 di_tg_ctrl.$252.Metal1 VDD.$295.Metal1 6.39414e-06f
Cred_1802 di_tg_ctrl.$252.Metal1 VDD.$299.Metal1 0.0151614f
Cred_1803 di_tg_ctrl.$252.Metal1 VDD.$309.Metal1 0.0158019f
Cred_1804 di_tg_ctrl.$252.Metal1 VDD.$612.Metal2 1.37167e-08f
Cred_1805 di_tg_ctrl.$252.Metal1 VDD.$620.Metal2 9.97561e-05f
Cred_1806 di_tg_ctrl.$252.Metal1 VDD.$624.Metal2 0.000212367f
Cred_1807 di_tg_ctrl.$252.Metal1 VDD.$780.Metal3 1.09977e-10f
Cred_1808 di_tg_ctrl.$252.Metal1 VDD.P0.nSD 5.23204e-05f
Cred_1809 di_tg_ctrl.$254.Metal1 di_tg_ctrl_n.$219.Metal1 1.28437e-05f
Cred_1810 di_tg_ctrl.$254.Metal1 di_tg_ctrl_n.$83.GatPoly 0.00013873f
Cred_1811 di_tg_ctrl.$254.Metal1 di_tg_ctrl_n.P52.GatPoly 1.09185e-06f
Cred_1812 di_tg_ctrl.$254.Metal1 di_tg_ctrl_n.P53.GatPoly 7.20855e-07f
Cred_1813 di_tg_ctrl.$254.Metal1 VSS 0.00150899f
Cred_1814 di_tg_ctrl.$254.Metal1 v_b.$2003.Metal1 0.0092724f
Cred_1815 di_tg_ctrl.$254.Metal1 v_b.$3507.Metal2 0.0054127f
Cred_1816 di_tg_ctrl.$254.Metal1 v_b.$3535.Metal2 0.000646201f
Cred_1817 di_tg_ctrl.$254.Metal1 v_b.$3990.Metal3 0.0058838f
Cred_1818 di_tg_ctrl.$254.Metal1 v_b.P59.pSD 1.08327e-05f
Cred_1819 di_tg_ctrl.$254.Metal1 v_b.P61.pSD 0.0116049f
Cred_1820 di_tg_ctrl.$254.Metal1 v_b.P63.pSD 0.00225267f
Cred_1821 di_tg_ctrl.$254.Metal1 VDD.$299.Metal1 0.00496606f
Cred_1822 di_tg_ctrl.$254.Metal1 VDD.$309.Metal1 0.0266732f
Cred_1823 di_tg_ctrl.$254.Metal1 VDD.$313.Metal1 0.000187979f
Cred_1824 di_tg_ctrl.$254.Metal1 VDD.$620.Metal2 3.8641e-05f
Cred_1825 di_tg_ctrl.$254.Metal1 VDD.$624.Metal2 0.000148261f
Cred_1826 di_tg_ctrl.$254.Metal1 VDD.$632.Metal2 4.20784e-07f
Cred_1827 di_tg_ctrl.$254.Metal1 VDD.$786.Metal3 3.37375e-09f
Cred_1828 di_tg_ctrl.$254.Metal1 VDD.P0.nSD 2.52851e-05f
Cred_1829 di_tg_ctrl.$256.Metal1 di_tg_ctrl_n.$219.Metal1 2.227e-05f
Cred_1830 di_tg_ctrl.$256.Metal1 di_tg_ctrl_n.$83.GatPoly 0.000240547f
Cred_1831 di_tg_ctrl.$256.Metal1 di_tg_ctrl_n.P52.GatPoly 1.89319e-06f
Cred_1832 di_tg_ctrl.$256.Metal1 di_tg_ctrl_n.P53.GatPoly 1.24991e-06f
Cred_1833 di_tg_ctrl.$256.Metal1 VSS 0.00164438f
Cred_1834 di_tg_ctrl.$256.Metal1 v_b.$2003.Metal1 0.00272723f
Cred_1835 di_tg_ctrl.$256.Metal1 v_b.$3507.Metal2 0.00139632f
Cred_1836 di_tg_ctrl.$256.Metal1 v_b.$3535.Metal2 0.00472665f
Cred_1837 di_tg_ctrl.$256.Metal1 v_b.$3990.Metal3 0.0024426f
Cred_1838 di_tg_ctrl.$256.Metal1 v_b.$4009.Metal3 0.000434617f
Cred_1839 di_tg_ctrl.$256.Metal1 v_b.P61.pSD 0.00423084f
Cred_1840 di_tg_ctrl.$256.Metal1 v_b.P63.pSD 0.0218433f
Cred_1841 di_tg_ctrl.$256.Metal1 v_b.P65.pSD 0.000205382f
Cred_1842 di_tg_ctrl.$256.Metal1 VDD.$299.Metal1 7.34697e-05f
Cred_1843 di_tg_ctrl.$256.Metal1 VDD.$309.Metal1 0.0154959f
Cred_1844 di_tg_ctrl.$256.Metal1 VDD.$313.Metal1 0.0236429f
Cred_1845 di_tg_ctrl.$256.Metal1 VDD.$317.Metal1 0.00820323f
Cred_1846 di_tg_ctrl.$256.Metal1 VDD.$620.Metal2 4.14444e-07f
Cred_1847 di_tg_ctrl.$256.Metal1 VDD.$624.Metal2 1.67372e-06f
Cred_1848 di_tg_ctrl.$256.Metal1 VDD.$632.Metal2 6.8867e-07f
Cred_1849 di_tg_ctrl.$256.Metal1 VDD.$786.Metal3 5.5216e-09f
Cred_1850 di_tg_ctrl.$256.Metal1 VDD.P0.nSD 3.74077e-07f
Cred_1851 di_tg_ctrl.$260.Metal1 di_tg_ctrl_n.$219.Metal1 4.76539e-06f
Cred_1852 di_tg_ctrl.$260.Metal1 di_tg_ctrl_n.$83.GatPoly 5.14728e-05f
Cred_1853 di_tg_ctrl.$260.Metal1 di_tg_ctrl_n.P52.GatPoly 4.0511e-07f
Cred_1854 di_tg_ctrl.$260.Metal1 di_tg_ctrl_n.P53.GatPoly 2.67458e-07f
Cred_1855 di_tg_ctrl.$260.Metal1 VSS 0.000938236f
Cred_1856 di_tg_ctrl.$260.Metal1 v_b.$3535.Metal2 0.00164821f
Cred_1857 di_tg_ctrl.$260.Metal1 v_b.$4009.Metal3 0.00943563f
Cred_1858 di_tg_ctrl.$260.Metal1 v_b.P63.pSD 0.00741561f
Cred_1859 di_tg_ctrl.$260.Metal1 v_b.P65.pSD 0.0228764f
Cred_1860 di_tg_ctrl.$260.Metal1 VDD.$313.Metal1 0.00727664f
Cred_1861 di_tg_ctrl.$260.Metal1 VDD.$317.Metal1 0.022663f
Cred_1862 di_tg_ctrl.$260.Metal1 VDD.$321.Metal1 0.0171747f
Cred_1863 di_tg_ctrl.$260.Metal1 VDD.$632.Metal2 0.000121194f
Cred_1864 di_tg_ctrl.$260.Metal1 VDD.$640.Metal2 9.72796e-05f
Cred_1865 di_tg_ctrl.$260.Metal1 VDD.$790.Metal3 7.79966e-07f
Cred_1866 di_tg_ctrl.$261.Metal1 VSS 0.000553766f
Cred_1867 di_tg_ctrl.$261.Metal1 v_b.$2255.Metal1 0.00699215f
Cred_1868 di_tg_ctrl.$261.Metal1 v_b.$3629.Metal2 0.00500596f
Cred_1869 di_tg_ctrl.$261.Metal1 v_b.$3698.Metal2 0.00457505f
Cred_1870 di_tg_ctrl.$261.Metal1 v_b.$4009.Metal3 0.000983089f
Cred_1871 di_tg_ctrl.$261.Metal1 v_b.$4065.Metal3 0.00585248f
Cred_1872 di_tg_ctrl.$261.Metal1 v_b.P65.pSD 0.000842121f
Cred_1873 di_tg_ctrl.$261.Metal1 v_b.P67.pSD 0.0235798f
Cred_1874 di_tg_ctrl.$261.Metal1 v_b.P69.pSD 0.0106099f
Cred_1875 di_tg_ctrl.$261.Metal1 VDD.$317.Metal1 3.55147e-05f
Cred_1876 di_tg_ctrl.$261.Metal1 VDD.$321.Metal1 0.0481514f
Cred_1877 di_tg_ctrl.$261.Metal1 VDD.$332.Metal1 0.0377233f
Cred_1878 di_tg_ctrl.$261.Metal1 VDD.$340.Metal1 0.00336622f
Cred_1879 di_tg_ctrl.$261.Metal1 VDD.$388.Metal2 1.27292e-10f
Cred_1880 di_tg_ctrl.$261.Metal1 VDD.$42.Metal1 5.97691e-09f
Cred_1881 di_tg_ctrl.$261.Metal1 VDD.$632.Metal2 5.64836e-06f
Cred_1882 di_tg_ctrl.$261.Metal1 VDD.$640.Metal2 0.000248118f
Cred_1883 di_tg_ctrl.$261.Metal1 VDD.$644.Metal2 0.000725976f
Cred_1884 di_tg_ctrl.$261.Metal1 VDD.$666.Metal3 5.60406e-12f
Cred_1885 di_tg_ctrl.$261.Metal1 VDD.$790.Metal3 5.64454e-06f
Cred_1886 di_tg_ctrl.$261.Metal1 VDD.$794.Metal3 2.83272e-05f
Cred_1887 di_tg_ctrl.$261.Metal1 VDD.P0.nSD 0.00152101f
Cred_1888 di_tg_ctrl.$27.GatPoly VSS 0.041943f
Cred_1889 di_tg_ctrl.$27.GatPoly v_a.$2327.Metal3 0.00339618f
Cred_1890 di_tg_ctrl.$27.GatPoly v_a.P10.nSD 0.00456464f
Cred_1891 di_tg_ctrl.$27.GatPoly v_b.$2481.Metal2 0.002162f
Cred_1892 di_tg_ctrl.$27.GatPoly v_b.$2541.Metal2 0.002162f
Cred_1893 di_tg_ctrl.$27.GatPoly v_b.P11.nSD 0.00409542f
Cred_1894 di_tg_ctrl.$27.GatPoly v_b.P11.pSD 4.34751e-05f
Cred_1895 di_tg_ctrl.$27.GatPoly VSS.$402.Metal2 1.8039e-05f
Cred_1896 di_tg_ctrl.$27.GatPoly VSS.$406.Metal2 2.50909e-05f
Cred_1897 di_tg_ctrl.$27.GatPoly VSS.$79.Metal1 0.00233888f
Cred_1898 di_tg_ctrl.$27.GatPoly VSS.$91.Metal1 0.00377379f
Cred_1899 di_tg_ctrl.$27.GatPoly VSS.P0.pSD 1.34198e-05f
Cred_1900 di_tg_ctrl.$270.Metal2 VSS 0.0156326f
Cred_1901 di_tg_ctrl.$270.Metal2 v_a 0.0470656f
Cred_1902 di_tg_ctrl.$270.Metal2 v_a.$2215.Metal3 0.00479071f
Cred_1903 di_tg_ctrl.$270.Metal2 v_a.$2237.Metal3 0.0138999f
Cred_1904 di_tg_ctrl.$270.Metal2 v_a.P0.nSD 0.0120807f
Cred_1905 di_tg_ctrl.$270.Metal2 v_a.P2.nSD 0.014946f
Cred_1906 di_tg_ctrl.$270.Metal2 v_a.P4.nSD 2.69355e-06f
Cred_1907 di_tg_ctrl.$270.Metal2 v_b.$2361.Metal2 0.0280685f
Cred_1908 di_tg_ctrl.$270.Metal2 v_b.$2421.Metal2 0.000945266f
Cred_1909 di_tg_ctrl.$270.Metal2 v_b.P1.nSD 0.0102691f
Cred_1910 di_tg_ctrl.$270.Metal2 v_b.P3.nSD 0.00036202f
Cred_1911 di_tg_ctrl.$270.Metal2 v_b.P3.pSD 1.90081e-05f
Cred_1912 di_tg_ctrl.$270.Metal2 VSS.$17.Metal1 0.00427743f
Cred_1913 di_tg_ctrl.$270.Metal2 VSS.$366.Metal2 0.0568051f
Cred_1914 di_tg_ctrl.$270.Metal2 VSS.$370.Metal2 8.57724e-06f
Cred_1915 di_tg_ctrl.$270.Metal2 VSS.$39.Metal1 0.00955774f
Cred_1916 di_tg_ctrl.$270.Metal2 VSS.$51.Metal1 0.000453514f
Cred_1917 di_tg_ctrl.$270.Metal2 VSS.$636.Metal3 0.0137928f
Cred_1918 di_tg_ctrl.$270.Metal2 VSS.$642.Metal3 0.000633542f
Cred_1919 di_tg_ctrl.$270.Metal2 VSS.P0.pSD 6.30447e-05f
Cred_1920 di_tg_ctrl.$272.Metal2 VSS 0.00414727f
Cred_1921 di_tg_ctrl.$272.Metal2 v_a 0.00134527f
Cred_1922 di_tg_ctrl.$272.Metal2 v_a.$2215.Metal3 0.000151803f
Cred_1923 di_tg_ctrl.$272.Metal2 v_a.$2237.Metal3 0.011778f
Cred_1924 di_tg_ctrl.$272.Metal2 v_a.P0.nSD 9.36801e-05f
Cred_1925 di_tg_ctrl.$272.Metal2 v_a.P2.nSD 9.63877e-05f
Cred_1926 di_tg_ctrl.$272.Metal2 v_a.P4.nSD 0.0049269f
Cred_1927 di_tg_ctrl.$272.Metal2 v_b.$2361.Metal2 0.0129352f
Cred_1928 di_tg_ctrl.$272.Metal2 v_b.$2421.Metal2 0.0127896f
Cred_1929 di_tg_ctrl.$272.Metal2 v_b.P1.nSD 8.10541e-05f
Cred_1930 di_tg_ctrl.$272.Metal2 v_b.P3.nSD 0.0109854f
Cred_1931 di_tg_ctrl.$272.Metal2 v_b.P3.pSD 0.000257182f
Cred_1932 di_tg_ctrl.$272.Metal2 VSS.$17.Metal1 1.37543e-05f
Cred_1933 di_tg_ctrl.$272.Metal2 VSS.$366.Metal2 0.014131f
Cred_1934 di_tg_ctrl.$272.Metal2 VSS.$370.Metal2 0.0141153f
Cred_1935 di_tg_ctrl.$272.Metal2 VSS.$378.Metal2 0.00142047f
Cred_1936 di_tg_ctrl.$272.Metal2 VSS.$39.Metal1 0.00189393f
Cred_1937 di_tg_ctrl.$272.Metal2 VSS.$51.Metal1 0.00237281f
Cred_1938 di_tg_ctrl.$272.Metal2 VSS.$636.Metal3 0.00147325f
Cred_1939 di_tg_ctrl.$272.Metal2 VSS.$642.Metal3 0.000213505f
Cred_1940 di_tg_ctrl.$272.Metal2 VSS.P0.pSD 1.14083e-05f
Cred_1941 di_tg_ctrl.$276.Metal2 VSS 0.00384375f
Cred_1942 di_tg_ctrl.$276.Metal2 v_a.$2237.Metal3 0.0185133f
Cred_1943 di_tg_ctrl.$276.Metal2 v_a.$2275.Metal3 1.68723e-05f
Cred_1944 di_tg_ctrl.$276.Metal2 v_a.$2297.Metal3 4.86318e-05f
Cred_1945 di_tg_ctrl.$276.Metal2 v_a.P4.nSD 0.00866253f
Cred_1946 di_tg_ctrl.$276.Metal2 v_a.P6.nSD 8.0482e-06f
Cred_1947 di_tg_ctrl.$276.Metal2 v_b.$2361.Metal2 0.000530403f
Cred_1948 di_tg_ctrl.$276.Metal2 v_b.$2421.Metal2 0.0110064f
Cred_1949 di_tg_ctrl.$276.Metal2 v_b.P3.nSD 0.000104265f
Cred_1950 di_tg_ctrl.$276.Metal2 v_b.P3.pSD 1.06657e-05f
Cred_1951 di_tg_ctrl.$276.Metal2 v_b.P5.nSD 0.00437866f
Cred_1952 di_tg_ctrl.$276.Metal2 VSS.$17.Metal1 9.42701e-07f
Cred_1953 di_tg_ctrl.$276.Metal2 VSS.$301.Metal1 3.00186e-09f
Cred_1954 di_tg_ctrl.$276.Metal2 VSS.$366.Metal2 2.66262e-06f
Cred_1955 di_tg_ctrl.$276.Metal2 VSS.$370.Metal2 0.0149134f
Cred_1956 di_tg_ctrl.$276.Metal2 VSS.$378.Metal2 0.0139087f
Cred_1957 di_tg_ctrl.$276.Metal2 VSS.$39.Metal1 0.000345202f
Cred_1958 di_tg_ctrl.$276.Metal2 VSS.$51.Metal1 0.00404412f
Cred_1959 di_tg_ctrl.$276.Metal2 VSS.$606.Metal2 3.17181e-10f
Cred_1960 di_tg_ctrl.$276.Metal2 VSS.$61.Metal1 0.000598698f
Cred_1961 di_tg_ctrl.$276.Metal2 VSS.$642.Metal3 0.000347481f
Cred_1962 di_tg_ctrl.$276.Metal2 VSS.$646.Metal3 0.000131406f
Cred_1963 di_tg_ctrl.$276.Metal2 VSS.$760.Metal3 1.87672e-11f
Cred_1964 di_tg_ctrl.$276.Metal2 VSS.P0.pSD 1.46414e-05f
Cred_1965 di_tg_ctrl.$278.Metal2 VSS 0.00255445f
Cred_1966 di_tg_ctrl.$278.Metal2 v_a.$2237.Metal3 0.00158963f
Cred_1967 di_tg_ctrl.$278.Metal2 v_a.$2275.Metal3 0.000497988f
Cred_1968 di_tg_ctrl.$278.Metal2 v_a.$2297.Metal3 0.00143538f
Cred_1969 di_tg_ctrl.$278.Metal2 v_a.P4.nSD 1.07512e-05f
Cred_1970 di_tg_ctrl.$278.Metal2 v_a.P6.nSD 0.001682f
Cred_1971 di_tg_ctrl.$278.Metal2 v_b.$2421.Metal2 0.0179336f
Cred_1972 di_tg_ctrl.$278.Metal2 v_b.P5.nSD 0.00623612f
Cred_1973 di_tg_ctrl.$278.Metal2 VSS.$17.Metal1 2.31434e-08f
Cred_1974 di_tg_ctrl.$278.Metal2 VSS.$301.Metal1 1.0391e-10f
Cred_1975 di_tg_ctrl.$278.Metal2 VSS.$378.Metal2 0.0163318f
Cred_1976 di_tg_ctrl.$278.Metal2 VSS.$386.Metal2 0.00289504f
Cred_1977 di_tg_ctrl.$278.Metal2 VSS.$51.Metal1 0.00116259f
Cred_1978 di_tg_ctrl.$278.Metal2 VSS.$606.Metal2 1.09793e-11f
Cred_1979 di_tg_ctrl.$278.Metal2 VSS.$61.Metal1 0.00221019f
Cred_1980 di_tg_ctrl.$278.Metal2 VSS.$642.Metal3 0.000216941f
Cred_1981 di_tg_ctrl.$278.Metal2 VSS.$646.Metal3 0.000226682f
Cred_1982 di_tg_ctrl.$278.Metal2 VSS.$760.Metal3 6.49629e-13f
Cred_1983 di_tg_ctrl.$278.Metal2 VSS.P0.pSD 3.78345e-06f
Cred_1984 di_tg_ctrl.$280.Metal2 VSS 0.00253534f
Cred_1985 di_tg_ctrl.$280.Metal2 v_a.$2237.Metal3 0.0114989f
Cred_1986 di_tg_ctrl.$280.Metal2 v_a.$2275.Metal3 0.00398942f
Cred_1987 di_tg_ctrl.$280.Metal2 v_a.$2297.Metal3 0.0114989f
Cred_1988 di_tg_ctrl.$280.Metal2 v_a.P6.nSD 0.0122124f
Cred_1989 di_tg_ctrl.$280.Metal2 v_b.$2421.Metal2 0.000811044f
Cred_1990 di_tg_ctrl.$280.Metal2 v_b.$2481.Metal2 0.000811044f
Cred_1991 di_tg_ctrl.$280.Metal2 v_b.P7.nSD 0.000175745f
Cred_1992 di_tg_ctrl.$280.Metal2 v_b.P7.pSD 1.6309e-05f
Cred_1993 di_tg_ctrl.$280.Metal2 VSS.$378.Metal2 0.00666187f
Cred_1994 di_tg_ctrl.$280.Metal2 VSS.$386.Metal2 0.0125021f
Cred_1995 di_tg_ctrl.$280.Metal2 VSS.$51.Metal1 0.000152693f
Cred_1996 di_tg_ctrl.$280.Metal2 VSS.$61.Metal1 0.00267721f
Cred_1997 di_tg_ctrl.$280.Metal2 VSS.$646.Metal3 5.3404e-05f
Cred_1998 di_tg_ctrl.$280.Metal2 VSS.$69.Metal1 0.000646477f
Cred_1999 di_tg_ctrl.$280.Metal2 VSS.P0.pSD 3.52102e-06f
Cred_2000 di_tg_ctrl.$282.Metal2 VSS 0.00395693f
Cred_2001 di_tg_ctrl.$282.Metal2 v_a.$2237.Metal3 1.29062e-05f
Cred_2002 di_tg_ctrl.$282.Metal2 v_a.$2275.Metal3 4.47767e-06f
Cred_2003 di_tg_ctrl.$282.Metal2 v_a.$2297.Metal3 0.0117924f
Cred_2004 di_tg_ctrl.$282.Metal2 v_a.P6.nSD 1.03218e-05f
Cred_2005 di_tg_ctrl.$282.Metal2 v_a.P8.nSD 0.00512332f
Cred_2006 di_tg_ctrl.$282.Metal2 v_b.$2421.Metal2 0.0127757f
Cred_2007 di_tg_ctrl.$282.Metal2 v_b.$2481.Metal2 0.0127757f
Cred_2008 di_tg_ctrl.$282.Metal2 v_b.P7.nSD 0.0108133f
Cred_2009 di_tg_ctrl.$282.Metal2 v_b.P7.pSD 0.000256903f
Cred_2010 di_tg_ctrl.$282.Metal2 VSS.$386.Metal2 0.020269f
Cred_2011 di_tg_ctrl.$282.Metal2 VSS.$394.Metal2 0.00915472f
Cred_2012 di_tg_ctrl.$282.Metal2 VSS.$61.Metal1 0.000923125f
Cred_2013 di_tg_ctrl.$282.Metal2 VSS.$646.Metal3 0.000161087f
Cred_2014 di_tg_ctrl.$282.Metal2 VSS.$654.Metal3 9.00433e-05f
Cred_2015 di_tg_ctrl.$282.Metal2 VSS.$69.Metal1 0.00330728f
Cred_2016 di_tg_ctrl.$282.Metal2 VSS.$79.Metal1 0.000151507f
Cred_2017 di_tg_ctrl.$282.Metal2 VSS.P0.pSD 4.45823e-06f
Cred_2018 di_tg_ctrl.$286.Metal2 VSS 0.00383357f
Cred_2019 di_tg_ctrl.$286.Metal2 v_a.$2297.Metal3 0.0180304f
Cred_2020 di_tg_ctrl.$286.Metal2 v_a.$2327.Metal3 0.000121283f
Cred_2021 di_tg_ctrl.$286.Metal2 v_a.P10.nSD 8.12004e-06f
Cred_2022 di_tg_ctrl.$286.Metal2 v_a.P8.nSD 0.00845929f
Cred_2023 di_tg_ctrl.$286.Metal2 v_b.$2421.Metal2 0.000507832f
Cred_2024 di_tg_ctrl.$286.Metal2 v_b.$2481.Metal2 0.0119876f
Cred_2025 di_tg_ctrl.$286.Metal2 v_b.P10.nSD 0.00463348f
Cred_2026 di_tg_ctrl.$286.Metal2 v_b.P7.nSD 9.98284e-05f
Cred_2027 di_tg_ctrl.$286.Metal2 v_b.P7.pSD 1.02118e-05f
Cred_2028 di_tg_ctrl.$286.Metal2 VSS.$17.Metal1 5.70081e-07f
Cred_2029 di_tg_ctrl.$286.Metal2 VSS.$301.Metal1 5.08315e-09f
Cred_2030 di_tg_ctrl.$286.Metal2 VSS.$386.Metal2 0.00339439f
Cred_2031 di_tg_ctrl.$286.Metal2 VSS.$394.Metal2 0.0225577f
Cred_2032 di_tg_ctrl.$286.Metal2 VSS.$402.Metal2 0.00289525f
Cred_2033 di_tg_ctrl.$286.Metal2 VSS.$406.Metal2 1.0674e-07f
Cred_2034 di_tg_ctrl.$286.Metal2 VSS.$606.Metal2 5.37093e-10f
Cred_2035 di_tg_ctrl.$286.Metal2 VSS.$646.Metal3 6.35169e-05f
Cred_2036 di_tg_ctrl.$286.Metal2 VSS.$654.Metal3 0.000398134f
Cred_2037 di_tg_ctrl.$286.Metal2 VSS.$660.Metal3 1.33129e-05f
Cred_2038 di_tg_ctrl.$286.Metal2 VSS.$69.Metal1 0.00243287f
Cred_2039 di_tg_ctrl.$286.Metal2 VSS.$760.Metal3 3.17791e-11f
Cred_2040 di_tg_ctrl.$286.Metal2 VSS.$79.Metal1 0.0025322f
Cred_2041 di_tg_ctrl.$286.Metal2 VSS.P0.pSD 1.45102e-05f
Cred_2042 di_tg_ctrl.$288.Metal2 VSS 0.00257658f
Cred_2043 di_tg_ctrl.$288.Metal2 v_a.$2297.Metal3 0.00014292f
Cred_2044 di_tg_ctrl.$288.Metal2 v_a.$2327.Metal3 0.00365834f
Cred_2045 di_tg_ctrl.$288.Metal2 v_a.P10.nSD 0.00193165f
Cred_2046 di_tg_ctrl.$288.Metal2 v_a.P8.nSD 1.00725e-05f
Cred_2047 di_tg_ctrl.$288.Metal2 v_b.$2481.Metal2 0.0171346f
Cred_2048 di_tg_ctrl.$288.Metal2 v_b.P10.nSD 0.00602108f
Cred_2049 di_tg_ctrl.$288.Metal2 VSS.$17.Metal1 4.15364e-08f
Cred_2050 di_tg_ctrl.$288.Metal2 VSS.$301.Metal1 5.21728e-10f
Cred_2051 di_tg_ctrl.$288.Metal2 VSS.$386.Metal2 3.97323e-07f
Cred_2052 di_tg_ctrl.$288.Metal2 VSS.$394.Metal2 0.00666226f
Cred_2053 di_tg_ctrl.$288.Metal2 VSS.$402.Metal2 0.0125038f
Cred_2054 di_tg_ctrl.$288.Metal2 VSS.$406.Metal2 3.30845e-06f
Cred_2055 di_tg_ctrl.$288.Metal2 VSS.$606.Metal2 5.51265e-11f
Cred_2056 di_tg_ctrl.$288.Metal2 VSS.$646.Metal3 2.4827e-05f
Cred_2057 di_tg_ctrl.$288.Metal2 VSS.$654.Metal3 0.000427567f
Cred_2058 di_tg_ctrl.$288.Metal2 VSS.$660.Metal3 2.688e-05f
Cred_2059 di_tg_ctrl.$288.Metal2 VSS.$69.Metal1 9.91506e-05f
Cred_2060 di_tg_ctrl.$288.Metal2 VSS.$760.Metal3 3.26176e-12f
Cred_2061 di_tg_ctrl.$288.Metal2 VSS.$79.Metal1 0.0028985f
Cred_2062 di_tg_ctrl.$288.Metal2 VSS.$91.Metal1 0.000401f
Cred_2063 di_tg_ctrl.$288.Metal2 VSS.P0.pSD 5.12341e-06f
Cred_2064 di_tg_ctrl.$29.GatPoly VSS 0.0389033f
Cred_2065 di_tg_ctrl.$29.GatPoly v_a.$2327.Metal3 0.00194798f
Cred_2066 di_tg_ctrl.$29.GatPoly v_a.$2365.Metal3 0.000675829f
Cred_2067 di_tg_ctrl.$29.GatPoly v_a.$2387.Metal3 0.00194798f
Cred_2068 di_tg_ctrl.$29.GatPoly v_a.P12.nSD 0.00618186f
Cred_2069 di_tg_ctrl.$29.GatPoly v_b.$2481.Metal2 0.00234605f
Cred_2070 di_tg_ctrl.$29.GatPoly v_b.$2541.Metal2 0.00282906f
Cred_2071 di_tg_ctrl.$29.GatPoly v_b.P11.nSD 0.00443838f
Cred_2072 di_tg_ctrl.$29.GatPoly v_b.P11.pSD 4.7176e-05f
Cred_2073 di_tg_ctrl.$29.GatPoly v_b.P13.nSD 0.000448854f
Cred_2074 di_tg_ctrl.$29.GatPoly VSS.$101.Metal1 0.000477509f
Cred_2075 di_tg_ctrl.$29.GatPoly VSS.$414.Metal2 3.68242e-06f
Cred_2076 di_tg_ctrl.$29.GatPoly VSS.$91.Metal1 0.00311343f
Cred_2077 di_tg_ctrl.$29.GatPoly VSS.P0.pSD 1.28368e-06f
Cred_2078 di_tg_ctrl.$290.Metal2 VSS 0.00249762f
Cred_2079 di_tg_ctrl.$290.Metal2 v_a.$2327.Metal3 0.026769f
Cred_2080 di_tg_ctrl.$290.Metal2 v_a.P10.nSD 0.0118468f
Cred_2081 di_tg_ctrl.$290.Metal2 v_b.$2481.Metal2 0.00085805f
Cred_2082 di_tg_ctrl.$290.Metal2 v_b.$2541.Metal2 0.00085805f
Cred_2083 di_tg_ctrl.$290.Metal2 v_b.P11.nSD 0.000187509f
Cred_2084 di_tg_ctrl.$290.Metal2 v_b.P11.pSD 1.72543e-05f
Cred_2085 di_tg_ctrl.$290.Metal2 VSS.$402.Metal2 0.0134408f
Cred_2086 di_tg_ctrl.$290.Metal2 VSS.$406.Metal2 0.00584769f
Cred_2087 di_tg_ctrl.$290.Metal2 VSS.$79.Metal1 0.00194972f
Cred_2088 di_tg_ctrl.$290.Metal2 VSS.$91.Metal1 0.00145933f
Cred_2089 di_tg_ctrl.$290.Metal2 VSS.P0.pSD 9.03677e-06f
Cred_2090 di_tg_ctrl.$292.Metal2 VSS 0.00398514f
Cred_2091 di_tg_ctrl.$292.Metal2 v_a.$2327.Metal3 0.00522269f
Cred_2092 di_tg_ctrl.$292.Metal2 v_a.$2365.Metal3 0.00180172f
Cred_2093 di_tg_ctrl.$292.Metal2 v_a.$2387.Metal3 0.0051932f
Cred_2094 di_tg_ctrl.$292.Metal2 v_a.P10.nSD 1.07009e-05f
Cred_2095 di_tg_ctrl.$292.Metal2 v_a.P12.nSD 0.00536691f
Cred_2096 di_tg_ctrl.$292.Metal2 v_b.$2481.Metal2 0.0128652f
Cred_2097 di_tg_ctrl.$292.Metal2 v_b.$2541.Metal2 0.0128652f
Cred_2098 di_tg_ctrl.$292.Metal2 v_b.P11.nSD 0.0107268f
Cred_2099 di_tg_ctrl.$292.Metal2 v_b.P11.pSD 0.000258703f
Cred_2100 di_tg_ctrl.$292.Metal2 VSS.$101.Metal1 0.000130686f
Cred_2101 di_tg_ctrl.$292.Metal2 VSS.$402.Metal2 5.25161e-06f
Cred_2102 di_tg_ctrl.$292.Metal2 VSS.$406.Metal2 0.020296f
Cred_2103 di_tg_ctrl.$292.Metal2 VSS.$414.Metal2 0.009173f
Cred_2104 di_tg_ctrl.$292.Metal2 VSS.$654.Metal3 4.70486e-05f
Cred_2105 di_tg_ctrl.$292.Metal2 VSS.$660.Metal3 0.000206564f
Cred_2106 di_tg_ctrl.$292.Metal2 VSS.$79.Metal1 0.000631998f
Cred_2107 di_tg_ctrl.$292.Metal2 VSS.$91.Metal1 0.00356339f
Cred_2108 di_tg_ctrl.$292.Metal2 VSS.P0.pSD 6.65814e-06f
Cred_2109 di_tg_ctrl.$296.Metal2 VSS 0.00382328f
Cred_2110 di_tg_ctrl.$296.Metal2 v_a.$2327.Metal3 0.00747716f
Cred_2111 di_tg_ctrl.$296.Metal2 v_a.$2365.Metal3 0.00259412f
Cred_2112 di_tg_ctrl.$296.Metal2 v_a.$2387.Metal3 0.00760001f
Cred_2113 di_tg_ctrl.$296.Metal2 v_a.P12.nSD 0.00832388f
Cred_2114 di_tg_ctrl.$296.Metal2 v_a.P14.nSD 8.47902e-06f
Cred_2115 di_tg_ctrl.$296.Metal2 v_b.$2481.Metal2 0.000485261f
Cred_2116 di_tg_ctrl.$296.Metal2 v_b.$2541.Metal2 0.012977f
Cred_2117 di_tg_ctrl.$296.Metal2 v_b.P11.nSD 9.53914e-05f
Cred_2118 di_tg_ctrl.$296.Metal2 v_b.P11.pSD 9.75796e-06f
Cred_2119 di_tg_ctrl.$296.Metal2 v_b.P13.nSD 0.0048897f
Cred_2120 di_tg_ctrl.$296.Metal2 VSS.$101.Metal1 0.0025038f
Cred_2121 di_tg_ctrl.$296.Metal2 VSS.$17.Metal1 3.44296e-07f
Cred_2122 di_tg_ctrl.$296.Metal2 VSS.$301.Metal1 8.57661e-09f
Cred_2123 di_tg_ctrl.$296.Metal2 VSS.$406.Metal2 0.00341325f
Cred_2124 di_tg_ctrl.$296.Metal2 VSS.$414.Metal2 0.0225708f
Cred_2125 di_tg_ctrl.$296.Metal2 VSS.$422.Metal2 0.00289525f
Cred_2126 di_tg_ctrl.$296.Metal2 VSS.$426.Metal2 1.0674e-07f
Cred_2127 di_tg_ctrl.$296.Metal2 VSS.$606.Metal2 9.06218e-10f
Cred_2128 di_tg_ctrl.$296.Metal2 VSS.$660.Metal3 0.00012923f
Cred_2129 di_tg_ctrl.$296.Metal2 VSS.$664.Metal3 0.000334617f
Cred_2130 di_tg_ctrl.$296.Metal2 VSS.$670.Metal3 1.33129e-05f
Cred_2131 di_tg_ctrl.$296.Metal2 VSS.$760.Metal3 5.36197e-11f
Cred_2132 di_tg_ctrl.$296.Metal2 VSS.$91.Metal1 0.00242201f
Cred_2133 di_tg_ctrl.$296.Metal2 VSS.P0.pSD 1.47407e-05f
Cred_2134 di_tg_ctrl.$298.Metal2 VSS 0.00259864f
Cred_2135 di_tg_ctrl.$298.Metal2 v_a.$2327.Metal3 6.00088e-05f
Cred_2136 di_tg_ctrl.$298.Metal2 v_a.$2365.Metal3 2.08194e-05f
Cred_2137 di_tg_ctrl.$298.Metal2 v_a.$2387.Metal3 0.00398465f
Cred_2138 di_tg_ctrl.$298.Metal2 v_a.P12.nSD 1.02236e-05f
Cred_2139 di_tg_ctrl.$298.Metal2 v_a.P14.nSD 0.00219536f
Cred_2140 di_tg_ctrl.$298.Metal2 v_b.$2541.Metal2 0.0166043f
Cred_2141 di_tg_ctrl.$298.Metal2 v_b.P13.nSD 0.00587247f
Cred_2142 di_tg_ctrl.$298.Metal2 VSS.$101.Metal1 0.00288399f
Cred_2143 di_tg_ctrl.$298.Metal2 VSS.$113.Metal1 0.000406776f
Cred_2144 di_tg_ctrl.$298.Metal2 VSS.$17.Metal1 4.07737e-08f
Cred_2145 di_tg_ctrl.$298.Metal2 VSS.$301.Metal1 1.4299e-09f
Cred_2146 di_tg_ctrl.$298.Metal2 VSS.$414.Metal2 0.00666197f
Cred_2147 di_tg_ctrl.$298.Metal2 VSS.$422.Metal2 0.0125039f
Cred_2148 di_tg_ctrl.$298.Metal2 VSS.$426.Metal2 3.35296e-06f
Cred_2149 di_tg_ctrl.$298.Metal2 VSS.$606.Metal2 1.51085e-10f
Cred_2150 di_tg_ctrl.$298.Metal2 VSS.$660.Metal3 5.04502e-05f
Cred_2151 di_tg_ctrl.$298.Metal2 VSS.$664.Metal3 0.00040274f
Cred_2152 di_tg_ctrl.$298.Metal2 VSS.$670.Metal3 2.688e-05f
Cred_2153 di_tg_ctrl.$298.Metal2 VSS.$760.Metal3 8.93951e-12f
Cred_2154 di_tg_ctrl.$298.Metal2 VSS.$91.Metal1 0.000113029f
Cred_2155 di_tg_ctrl.$298.Metal2 VSS.P0.pSD 5.89331e-06f
Cred_2156 di_tg_ctrl.$3.GatPoly VSS 0.0780163f
Cred_2157 di_tg_ctrl.$3.GatPoly v_a 0.00620468f
Cred_2158 di_tg_ctrl.$3.GatPoly v_a.$2215.Metal3 0.000495445f
Cred_2159 di_tg_ctrl.$3.GatPoly v_a.$2237.Metal3 0.00142805f
Cred_2160 di_tg_ctrl.$3.GatPoly v_a.P0.nSD 0.00482332f
Cred_2161 di_tg_ctrl.$3.GatPoly v_a.P2.nSD 0.00515445f
Cred_2162 di_tg_ctrl.$3.GatPoly v_b.$2361.Metal2 0.00796533f
Cred_2163 di_tg_ctrl.$3.GatPoly v_b.$2421.Metal2 0.000198121f
Cred_2164 di_tg_ctrl.$3.GatPoly v_b.P0.nSD 0.00130189f
Cred_2165 di_tg_ctrl.$3.GatPoly v_b.P0.pSD 1.69718e-05f
Cred_2166 di_tg_ctrl.$3.GatPoly v_b.P1.nSD 0.00615072f
Cred_2167 di_tg_ctrl.$3.GatPoly v_b.P3.nSD 0.000376153f
Cred_2168 di_tg_ctrl.$3.GatPoly v_b.P3.pSD 3.98395e-06f
Cred_2169 di_tg_ctrl.$3.GatPoly VSS.$17.Metal1 0.00203737f
Cred_2170 di_tg_ctrl.$3.GatPoly VSS.$301.Metal1 4.26819e-10f
Cred_2171 di_tg_ctrl.$3.GatPoly VSS.$366.Metal2 9.40948e-05f
Cred_2172 di_tg_ctrl.$3.GatPoly VSS.$39.Metal1 0.00567996f
Cred_2173 di_tg_ctrl.$3.GatPoly VSS.$606.Metal2 4.50983e-11f
Cred_2174 di_tg_ctrl.$3.GatPoly VSS.$636.Metal3 1.04928e-05f
Cred_2175 di_tg_ctrl.$3.GatPoly VSS.$760.Metal3 2.66841e-12f
Cred_2176 di_tg_ctrl.$3.GatPoly VSS.P0.pSD 4.34863e-05f
Cred_2177 di_tg_ctrl.$300.Metal2 VSS 0.00245984f
Cred_2178 di_tg_ctrl.$300.Metal2 v_a.$2387.Metal3 0.0264469f
Cred_2179 di_tg_ctrl.$300.Metal2 v_a.P14.nSD 0.0115795f
Cred_2180 di_tg_ctrl.$300.Metal2 v_b.$2541.Metal2 0.000904872f
Cred_2181 di_tg_ctrl.$300.Metal2 v_b.$2601.Metal2 0.000904872f
Cred_2182 di_tg_ctrl.$300.Metal2 v_b.P15.nSD 0.000198914f
Cred_2183 di_tg_ctrl.$300.Metal2 v_b.P15.pSD 1.81958e-05f
Cred_2184 di_tg_ctrl.$300.Metal2 VSS.$101.Metal1 0.0012051f
Cred_2185 di_tg_ctrl.$300.Metal2 VSS.$113.Metal1 0.00123894f
Cred_2186 di_tg_ctrl.$300.Metal2 VSS.$422.Metal2 0.0144185f
Cred_2187 di_tg_ctrl.$300.Metal2 VSS.$426.Metal2 0.00584599f
Cred_2188 di_tg_ctrl.$300.Metal2 VSS.P0.pSD 7.07597e-06f
Cred_2189 di_tg_ctrl.$302.Metal2 VSS 0.00399294f
Cred_2190 di_tg_ctrl.$302.Metal2 v_a.$2387.Metal3 0.00576726f
Cred_2191 di_tg_ctrl.$302.Metal2 v_a.$2447.Metal3 0.00573878f
Cred_2192 di_tg_ctrl.$302.Metal2 v_a.P14.nSD 9.56055e-06f
Cred_2193 di_tg_ctrl.$302.Metal2 v_a.P16.nSD 0.00567812f
Cred_2194 di_tg_ctrl.$302.Metal2 v_a.P16.pSD 0.000127195f
Cred_2195 di_tg_ctrl.$302.Metal2 v_b.$2541.Metal2 0.0131091f
Cred_2196 di_tg_ctrl.$302.Metal2 v_b.$2601.Metal2 0.0131091f
Cred_2197 di_tg_ctrl.$302.Metal2 v_b.P15.nSD 0.0109018f
Cred_2198 di_tg_ctrl.$302.Metal2 v_b.P15.pSD 0.000263607f
Cred_2199 di_tg_ctrl.$302.Metal2 VSS.$101.Metal1 0.000653538f
Cred_2200 di_tg_ctrl.$302.Metal2 VSS.$113.Metal1 0.00351572f
Cred_2201 di_tg_ctrl.$302.Metal2 VSS.$123.Metal1 0.000110953f
Cred_2202 di_tg_ctrl.$302.Metal2 VSS.$422.Metal2 5.41784e-06f
Cred_2203 di_tg_ctrl.$302.Metal2 VSS.$426.Metal2 0.0203221f
Cred_2204 di_tg_ctrl.$302.Metal2 VSS.$434.Metal2 0.00919274f
Cred_2205 di_tg_ctrl.$302.Metal2 VSS.$664.Metal3 4.70486e-05f
Cred_2206 di_tg_ctrl.$302.Metal2 VSS.$670.Metal3 0.000206724f
Cred_2207 di_tg_ctrl.$302.Metal2 VSS.P0.pSD 6.66712e-06f
Cred_2208 di_tg_ctrl.$306.Metal2 VSS 0.00480121f
Cred_2209 di_tg_ctrl.$306.Metal2 v_a.$2387.Metal3 0.00770483f
Cred_2210 di_tg_ctrl.$306.Metal2 v_a.$2447.Metal3 0.00957333f
Cred_2211 di_tg_ctrl.$306.Metal2 v_a.P14.nSD 7.91167e-09f
Cred_2212 di_tg_ctrl.$306.Metal2 v_a.P16.nSD 0.00802875f
Cred_2213 di_tg_ctrl.$306.Metal2 v_a.P16.pSD 0.000170769f
Cred_2214 di_tg_ctrl.$306.Metal2 v_a.P18.nSD 0.00113331f
Cred_2215 di_tg_ctrl.$306.Metal2 v_b.$2541.Metal2 0.000462689f
Cred_2216 di_tg_ctrl.$306.Metal2 v_b.$2601.Metal2 0.0220471f
Cred_2217 di_tg_ctrl.$306.Metal2 v_b.P15.nSD 9.09543e-05f
Cred_2218 di_tg_ctrl.$306.Metal2 v_b.P15.pSD 9.30408e-06f
Cred_2219 di_tg_ctrl.$306.Metal2 v_b.P17.nSD 0.0079794f
Cred_2220 di_tg_ctrl.$306.Metal2 VSS.$113.Metal1 0.00247391f
Cred_2221 di_tg_ctrl.$306.Metal2 VSS.$123.Metal1 0.00388767f
Cred_2222 di_tg_ctrl.$306.Metal2 VSS.$135.Metal1 0.000201785f
Cred_2223 di_tg_ctrl.$306.Metal2 VSS.$17.Metal1 2.24158e-07f
Cred_2224 di_tg_ctrl.$306.Metal2 VSS.$301.Metal1 1.60249e-08f
Cred_2225 di_tg_ctrl.$306.Metal2 VSS.$426.Metal2 0.00343315f
Cred_2226 di_tg_ctrl.$306.Metal2 VSS.$434.Metal2 0.0258531f
Cred_2227 di_tg_ctrl.$306.Metal2 VSS.$442.Metal2 0.00902982f
Cred_2228 di_tg_ctrl.$306.Metal2 VSS.$446.Metal2 1.55633e-06f
Cred_2229 di_tg_ctrl.$306.Metal2 VSS.$606.Metal2 1.69322e-09f
Cred_2230 di_tg_ctrl.$306.Metal2 VSS.$670.Metal3 0.000104581f
Cred_2231 di_tg_ctrl.$306.Metal2 VSS.$674.Metal3 0.000187282f
Cred_2232 di_tg_ctrl.$306.Metal2 VSS.$760.Metal3 1.00185e-10f
Cred_2233 di_tg_ctrl.$306.Metal2 VSS.P0.pSD 1.80958e-05f
Cred_2234 di_tg_ctrl.$310.Metal2 VSS 0.00366527f
Cred_2235 di_tg_ctrl.$310.Metal2 v_a.$2447.Metal3 0.0260065f
Cred_2236 di_tg_ctrl.$310.Metal2 v_a.$2485.Metal3 8.41207e-09f
Cred_2237 di_tg_ctrl.$310.Metal2 v_a.$2507.Metal3 2.42466e-08f
Cred_2238 di_tg_ctrl.$310.Metal2 v_a.P18.nSD 0.0126366f
Cred_2239 di_tg_ctrl.$310.Metal2 v_a.P20.nSD 4.56504e-09f
Cred_2240 di_tg_ctrl.$310.Metal2 v_b.$2601.Metal2 0.00657f
Cred_2241 di_tg_ctrl.$310.Metal2 v_b.$2631.Metal2 0.00193329f
Cred_2242 di_tg_ctrl.$310.Metal2 v_b.P17.nSD 0.0024676f
Cred_2243 di_tg_ctrl.$310.Metal2 v_b.P19.nSD 0.000199886f
Cred_2244 di_tg_ctrl.$310.Metal2 VSS.$113.Metal1 6.12944e-05f
Cred_2245 di_tg_ctrl.$310.Metal2 VSS.$123.Metal1 0.00268686f
Cred_2246 di_tg_ctrl.$310.Metal2 VSS.$135.Metal1 0.00147405f
Cred_2247 di_tg_ctrl.$310.Metal2 VSS.$17.Metal1 1.62734e-08f
Cred_2248 di_tg_ctrl.$310.Metal2 VSS.$301.Metal1 1.58914e-09f
Cred_2249 di_tg_ctrl.$310.Metal2 VSS.$434.Metal2 0.00326849f
Cred_2250 di_tg_ctrl.$310.Metal2 VSS.$442.Metal2 0.0204731f
Cred_2251 di_tg_ctrl.$310.Metal2 VSS.$446.Metal2 0.00584851f
Cred_2252 di_tg_ctrl.$310.Metal2 VSS.$606.Metal2 1.67911e-10f
Cred_2253 di_tg_ctrl.$310.Metal2 VSS.$674.Metal3 0.000144008f
Cred_2254 di_tg_ctrl.$310.Metal2 VSS.$680.Metal3 8.91267e-05f
Cred_2255 di_tg_ctrl.$310.Metal2 VSS.$760.Metal3 9.93505e-12f
Cred_2256 di_tg_ctrl.$310.Metal2 VSS.P0.pSD 1.0613e-05f
Cred_2257 di_tg_ctrl.$312.Metal2 VSS 0.00398649f
Cred_2258 di_tg_ctrl.$312.Metal2 v_a.$2447.Metal3 0.00551273f
Cred_2259 di_tg_ctrl.$312.Metal2 v_a.$2485.Metal3 0.00191066f
Cred_2260 di_tg_ctrl.$312.Metal2 v_a.$2507.Metal3 0.00550721f
Cred_2261 di_tg_ctrl.$312.Metal2 v_a.P18.nSD 8.81791e-06f
Cred_2262 di_tg_ctrl.$312.Metal2 v_a.P20.nSD 0.00572881f
Cred_2263 di_tg_ctrl.$312.Metal2 v_b.$2631.Metal2 0.0265029f
Cred_2264 di_tg_ctrl.$312.Metal2 v_b.P19.nSD 0.0107199f
Cred_2265 di_tg_ctrl.$312.Metal2 VSS.$123.Metal1 0.00067445f
Cred_2266 di_tg_ctrl.$312.Metal2 VSS.$135.Metal1 0.00346293f
Cred_2267 di_tg_ctrl.$312.Metal2 VSS.$145.Metal1 9.21222e-05f
Cred_2268 di_tg_ctrl.$312.Metal2 VSS.$442.Metal2 5.20199e-06f
Cred_2269 di_tg_ctrl.$312.Metal2 VSS.$446.Metal2 0.0203472f
Cred_2270 di_tg_ctrl.$312.Metal2 VSS.$454.Metal2 0.00921246f
Cred_2271 di_tg_ctrl.$312.Metal2 VSS.$680.Metal3 5.08974e-05f
Cred_2272 di_tg_ctrl.$312.Metal2 VSS.P0.pSD 6.66151e-06f
Cred_2273 di_tg_ctrl.$316.Metal2 VSS 0.00508605f
Cred_2274 di_tg_ctrl.$316.Metal2 v_a.$2447.Metal3 0.00715111f
Cred_2275 di_tg_ctrl.$316.Metal2 v_a.$2485.Metal3 0.002481f
Cred_2276 di_tg_ctrl.$316.Metal2 v_a.$2507.Metal3 0.0110688f
Cred_2277 di_tg_ctrl.$316.Metal2 v_a.P20.nSD 0.00794405f
Cred_2278 di_tg_ctrl.$316.Metal2 v_a.P22.nSD 0.00150195f
Cred_2279 di_tg_ctrl.$316.Metal2 v_b.$2631.Metal2 0.0120707f
Cred_2280 di_tg_ctrl.$316.Metal2 v_b.$2691.Metal2 0.0111768f
Cred_2281 di_tg_ctrl.$316.Metal2 v_b.P19.nSD 8.16471e-05f
Cred_2282 di_tg_ctrl.$316.Metal2 v_b.P21.nSD 0.00839185f
Cred_2283 di_tg_ctrl.$316.Metal2 v_b.P21.pSD 0.00022475f
Cred_2284 di_tg_ctrl.$316.Metal2 VSS.$135.Metal1 0.0024686f
Cred_2285 di_tg_ctrl.$316.Metal2 VSS.$145.Metal1 0.00375847f
Cred_2286 di_tg_ctrl.$316.Metal2 VSS.$153.Metal1 0.000307342f
Cred_2287 di_tg_ctrl.$316.Metal2 VSS.$17.Metal1 1.38064e-07f
Cred_2288 di_tg_ctrl.$316.Metal2 VSS.$301.Metal1 2.75508e-08f
Cred_2289 di_tg_ctrl.$316.Metal2 VSS.$446.Metal2 0.00345302f
Cred_2290 di_tg_ctrl.$316.Metal2 VSS.$454.Metal2 0.0258669f
Cred_2291 di_tg_ctrl.$316.Metal2 VSS.$462.Metal2 0.00902909f
Cred_2292 di_tg_ctrl.$316.Metal2 VSS.$470.Metal2 4.60139e-10f
Cred_2293 di_tg_ctrl.$316.Metal2 VSS.$606.Metal2 2.91106e-09f
Cred_2294 di_tg_ctrl.$316.Metal2 VSS.$680.Metal3 0.000106142f
Cred_2295 di_tg_ctrl.$316.Metal2 VSS.$684.Metal3 0.000189292f
Cred_2296 di_tg_ctrl.$316.Metal2 VSS.$692.Metal3 2.87521e-08f
Cred_2297 di_tg_ctrl.$316.Metal2 VSS.$760.Metal3 1.72243e-10f
Cred_2298 di_tg_ctrl.$316.Metal2 VSS.P0.pSD 1.77213e-05f
Cred_2299 di_tg_ctrl.$32.GatPoly VSS 0.0419432f
Cred_2300 di_tg_ctrl.$32.GatPoly v_a.$2327.Metal3 0.00142588f
Cred_2301 di_tg_ctrl.$32.GatPoly v_a.$2365.Metal3 0.000494693f
Cred_2302 di_tg_ctrl.$32.GatPoly v_a.$2387.Metal3 0.00142588f
Cred_2303 di_tg_ctrl.$32.GatPoly v_a.P12.nSD 0.00452371f
Cred_2304 di_tg_ctrl.$32.GatPoly v_b.$2541.Metal2 0.00439204f
Cred_2305 di_tg_ctrl.$32.GatPoly v_b.P13.nSD 0.00407452f
Cred_2306 di_tg_ctrl.$32.GatPoly VSS.$101.Metal1 0.00332265f
Cred_2307 di_tg_ctrl.$32.GatPoly VSS.$17.Metal1 1.8218e-07f
Cred_2308 di_tg_ctrl.$32.GatPoly VSS.$301.Metal1 4.53819e-09f
Cred_2309 di_tg_ctrl.$32.GatPoly VSS.$414.Metal2 1.08968e-05f
Cred_2310 di_tg_ctrl.$32.GatPoly VSS.$606.Metal2 4.79512e-10f
Cred_2311 di_tg_ctrl.$32.GatPoly VSS.$760.Metal3 2.83721e-11f
Cred_2312 di_tg_ctrl.$32.GatPoly VSS.$91.Metal1 0.00187946f
Cred_2313 di_tg_ctrl.$32.GatPoly VSS.P0.pSD 9.27605e-06f
Cred_2314 di_tg_ctrl.$320.Metal2 di_tg_ctrl_n.$354.Metal2 5.66512e-11f
Cred_2315 di_tg_ctrl.$320.Metal2 di_tg_ctrl_n.$443.Metal3 1.21833e-08f
Cred_2316 di_tg_ctrl.$320.Metal2 di_tg_ctrl_n.$447.Metal3 5.96325e-09f
Cred_2317 di_tg_ctrl.$320.Metal2 di_tg_ctrl_n.$488.Metal4 1.56923e-07f
Cred_2318 di_tg_ctrl.$320.Metal2 VSS 0.00371345f
Cred_2319 di_tg_ctrl.$320.Metal2 v_a.$2507.Metal3 0.0265101f
Cred_2320 di_tg_ctrl.$320.Metal2 v_a.$2545.Metal3 2.26662e-06f
Cred_2321 di_tg_ctrl.$320.Metal2 v_a.$2567.Metal3 6.53319e-06f
Cred_2322 di_tg_ctrl.$320.Metal2 v_a.P22.nSD 0.0122379f
Cred_2323 di_tg_ctrl.$320.Metal2 v_a.P24.nSD 5.12867e-07f
Cred_2324 di_tg_ctrl.$320.Metal2 v_b.$2631.Metal2 0.00299101f
Cred_2325 di_tg_ctrl.$320.Metal2 v_b.$2691.Metal2 0.00506938f
Cred_2326 di_tg_ctrl.$320.Metal2 v_b.P21.nSD 0.00237593f
Cred_2327 di_tg_ctrl.$320.Metal2 v_b.P21.pSD 6.01454e-05f
Cred_2328 di_tg_ctrl.$320.Metal2 v_b.P23.nSD 0.000239065f
Cred_2329 di_tg_ctrl.$320.Metal2 VSS.$135.Metal1 6.61594e-05f
Cred_2330 di_tg_ctrl.$320.Metal2 VSS.$145.Metal1 0.00200883f
Cred_2331 di_tg_ctrl.$320.Metal2 VSS.$153.Metal1 0.00228999f
Cred_2332 di_tg_ctrl.$320.Metal2 VSS.$163.Metal1 5.66751e-06f
Cred_2333 di_tg_ctrl.$320.Metal2 VSS.$17.Metal1 1.22192e-08f
Cred_2334 di_tg_ctrl.$320.Metal2 VSS.$301.Metal1 3.3018e-09f
Cred_2335 di_tg_ctrl.$320.Metal2 VSS.$454.Metal2 0.00326854f
Cred_2336 di_tg_ctrl.$320.Metal2 VSS.$462.Metal2 0.0232835f
Cred_2337 di_tg_ctrl.$320.Metal2 VSS.$470.Metal2 0.00289771f
Cred_2338 di_tg_ctrl.$320.Metal2 VSS.$606.Metal2 3.48874e-10f
Cred_2339 di_tg_ctrl.$320.Metal2 VSS.$684.Metal3 0.000277426f
Cred_2340 di_tg_ctrl.$320.Metal2 VSS.$692.Metal3 0.000174135f
Cred_2341 di_tg_ctrl.$320.Metal2 VSS.$760.Metal3 2.06424e-11f
Cred_2342 di_tg_ctrl.$320.Metal2 VSS.P0.pSD 5.86554e-06f
Cred_2343 di_tg_ctrl.$322.Metal2 di_tg_ctrl_n.$354.Metal2 1.15465e-10f
Cred_2344 di_tg_ctrl.$322.Metal2 di_tg_ctrl_n.$443.Metal3 2.48318e-08f
Cred_2345 di_tg_ctrl.$322.Metal2 di_tg_ctrl_n.$447.Metal3 1.21542e-08f
Cred_2346 di_tg_ctrl.$322.Metal2 di_tg_ctrl_n.$488.Metal4 3.19837e-07f
Cred_2347 di_tg_ctrl.$322.Metal2 VSS 0.00404134f
Cred_2348 di_tg_ctrl.$322.Metal2 v_a.$2507.Metal3 0.00589109f
Cred_2349 di_tg_ctrl.$322.Metal2 v_a.$2545.Metal3 0.00193859f
Cred_2350 di_tg_ctrl.$322.Metal2 v_a.$2567.Metal3 0.0055877f
Cred_2351 di_tg_ctrl.$322.Metal2 v_a.P22.nSD 3.00275e-05f
Cred_2352 di_tg_ctrl.$322.Metal2 v_a.P24.nSD 0.00586169f
Cred_2353 di_tg_ctrl.$322.Metal2 v_b.$2691.Metal2 0.0260119f
Cred_2354 di_tg_ctrl.$322.Metal2 v_b.P23.nSD 0.0105889f
Cred_2355 di_tg_ctrl.$322.Metal2 VSS.$145.Metal1 1.59672e-05f
Cred_2356 di_tg_ctrl.$322.Metal2 VSS.$153.Metal1 0.00309721f
Cred_2357 di_tg_ctrl.$322.Metal2 VSS.$163.Metal1 0.00111511f
Cred_2358 di_tg_ctrl.$322.Metal2 VSS.$462.Metal2 0.00694515f
Cred_2359 di_tg_ctrl.$322.Metal2 VSS.$470.Metal2 0.0212108f
Cred_2360 di_tg_ctrl.$322.Metal2 VSS.$478.Metal2 0.00142045f
Cred_2361 di_tg_ctrl.$322.Metal2 VSS.$684.Metal3 0.000231746f
Cred_2362 di_tg_ctrl.$322.Metal2 VSS.$692.Metal3 0.000235657f
Cred_2363 di_tg_ctrl.$322.Metal2 VSS.P0.pSD 3.94684e-06f
Cred_2364 di_tg_ctrl.$326.Metal2 VSS 0.00383383f
Cred_2365 di_tg_ctrl.$326.Metal2 v_a.$2507.Metal3 0.00713119f
Cred_2366 di_tg_ctrl.$326.Metal2 v_a.$2545.Metal3 0.00247409f
Cred_2367 di_tg_ctrl.$326.Metal2 v_a.$2567.Metal3 0.00727411f
Cred_2368 di_tg_ctrl.$326.Metal2 v_a.P24.nSD 0.00780684f
Cred_2369 di_tg_ctrl.$326.Metal2 v_a.P26.nSD 1.00725e-05f
Cred_2370 di_tg_ctrl.$326.Metal2 v_b.$2691.Metal2 0.00931088f
Cred_2371 di_tg_ctrl.$326.Metal2 v_b.$2751.Metal2 0.00846277f
Cred_2372 di_tg_ctrl.$326.Metal2 v_b.P23.nSD 7.74598e-05f
Cred_2373 di_tg_ctrl.$326.Metal2 v_b.P25.nSD 0.00618861f
Cred_2374 di_tg_ctrl.$326.Metal2 v_b.P25.pSD 0.000170175f
Cred_2375 di_tg_ctrl.$326.Metal2 VSS 0.000764788f
Cred_2376 di_tg_ctrl.$326.Metal2 VSS.$153.Metal1 0.000582165f
Cred_2377 di_tg_ctrl.$326.Metal2 VSS.$163.Metal1 0.00347565f
Cred_2378 di_tg_ctrl.$326.Metal2 VSS.$17.Metal1 7.69658e-08f
Cred_2379 di_tg_ctrl.$326.Metal2 VSS.$301.Metal1 4.06582e-08f
Cred_2380 di_tg_ctrl.$326.Metal2 VSS.$470.Metal2 0.0150586f
Cred_2381 di_tg_ctrl.$326.Metal2 VSS.$478.Metal2 0.0138938f
Cred_2382 di_tg_ctrl.$326.Metal2 VSS.$482.Metal2 1.05139e-06f
Cred_2383 di_tg_ctrl.$326.Metal2 VSS.$486.Metal2 5.23598e-07f
Cred_2384 di_tg_ctrl.$326.Metal2 VSS.$606.Metal2 4.29601e-09f
Cred_2385 di_tg_ctrl.$326.Metal2 VSS.$692.Metal3 0.000431762f
Cred_2386 di_tg_ctrl.$326.Metal2 VSS.$700.Metal3 6.53047e-05f
Cred_2387 di_tg_ctrl.$326.Metal2 VSS.$760.Metal3 2.54189e-10f
Cred_2388 di_tg_ctrl.$326.Metal2 VSS.P0.pSD 1.39083e-05f
Cred_2389 di_tg_ctrl.$328.Metal2 VSS 0.00380111f
Cred_2390 di_tg_ctrl.$328.Metal2 v_a.$2507.Metal3 5.14793e-05f
Cred_2391 di_tg_ctrl.$328.Metal2 v_a.$2545.Metal3 1.78602e-05f
Cred_2392 di_tg_ctrl.$328.Metal2 v_a.$2567.Metal3 0.0195073f
Cred_2393 di_tg_ctrl.$328.Metal2 v_a.P24.nSD 8.58432e-06f
Cred_2394 di_tg_ctrl.$328.Metal2 v_a.P26.nSD 0.00852519f
Cred_2395 di_tg_ctrl.$328.Metal2 v_b.$2691.Metal2 0.00562771f
Cred_2396 di_tg_ctrl.$328.Metal2 v_b.$2751.Metal2 0.0066592f
Cred_2397 di_tg_ctrl.$328.Metal2 v_b.P25.nSD 0.00462298f
Cred_2398 di_tg_ctrl.$328.Metal2 v_b.P25.pSD 0.000113166f
Cred_2399 di_tg_ctrl.$328.Metal2 v_b.P27.nSD 9.4209e-05f
Cred_2400 di_tg_ctrl.$328.Metal2 VSS 0.00364296f
Cred_2401 di_tg_ctrl.$328.Metal2 VSS.$163.Metal1 0.000641758f
Cred_2402 di_tg_ctrl.$328.Metal2 VSS.$177.Metal1 0.000452515f
Cred_2403 di_tg_ctrl.$328.Metal2 VSS.$478.Metal2 0.0134328f
Cred_2404 di_tg_ctrl.$328.Metal2 VSS.$482.Metal2 0.0127305f
Cred_2405 di_tg_ctrl.$328.Metal2 VSS.$486.Metal2 0.00286801f
Cred_2406 di_tg_ctrl.$328.Metal2 VSS.$692.Metal3 0.0003298f
Cred_2407 di_tg_ctrl.$328.Metal2 VSS.$700.Metal3 0.00010142f
Cred_2408 di_tg_ctrl.$328.Metal2 VSS.P0.pSD 3.23502e-06f
Cred_2409 di_tg_ctrl.$332.Metal2 VSS 0.00395693f
Cred_2410 di_tg_ctrl.$332.Metal2 v_a.$2567.Metal3 0.0103979f
Cred_2411 di_tg_ctrl.$332.Metal2 v_a.$2597.Metal3 3.04065e-05f
Cred_2412 di_tg_ctrl.$332.Metal2 v_a.P26.nSD 0.00504915f
Cred_2413 di_tg_ctrl.$332.Metal2 v_a.P28.nSD 1.02054e-05f
Cred_2414 di_tg_ctrl.$332.Metal2 v_b.$2751.Metal2 0.0259491f
Cred_2415 di_tg_ctrl.$332.Metal2 v_b.P27.nSD 0.0106789f
Cred_2416 di_tg_ctrl.$332.Metal2 VSS 0.0018333f
Cred_2417 di_tg_ctrl.$332.Metal2 VSS.$177.Metal1 0.00248809f
Cred_2418 di_tg_ctrl.$332.Metal2 VSS.$191.Metal1 1.04105e-06f
Cred_2419 di_tg_ctrl.$332.Metal2 VSS.$478.Metal2 2.8813e-07f
Cred_2420 di_tg_ctrl.$332.Metal2 VSS.$482.Metal2 0.00689587f
Cred_2421 di_tg_ctrl.$332.Metal2 VSS.$486.Metal2 0.0197737f
Cred_2422 di_tg_ctrl.$332.Metal2 VSS.$494.Metal2 0.00289505f
Cred_2423 di_tg_ctrl.$332.Metal2 VSS.$498.Metal2 8.02992e-09f
Cred_2424 di_tg_ctrl.$332.Metal2 VSS.$692.Metal3 3.59364e-05f
Cred_2425 di_tg_ctrl.$332.Metal2 VSS.$700.Metal3 0.000193687f
Cred_2426 di_tg_ctrl.$332.Metal2 VSS.P0.pSD 6.85483e-06f
Cred_2427 di_tg_ctrl.$334.Metal2 VSS 0.00253534f
Cred_2428 di_tg_ctrl.$334.Metal2 v_a.$2597.Metal3 0.027091f
Cred_2429 di_tg_ctrl.$334.Metal2 v_a.P28.nSD 0.0121087f
Cred_2430 di_tg_ctrl.$334.Metal2 v_b.$2751.Metal2 0.00164737f
Cred_2431 di_tg_ctrl.$334.Metal2 v_b.P27.nSD 0.000166771f
Cred_2432 di_tg_ctrl.$334.Metal2 VSS 6.43017e-06f
Cred_2433 di_tg_ctrl.$334.Metal2 VSS.$177.Metal1 0.00310122f
Cred_2434 di_tg_ctrl.$334.Metal2 VSS.$191.Metal1 0.000366763f
Cred_2435 di_tg_ctrl.$334.Metal2 VSS.$482.Metal2 2.05546e-08f
Cred_2436 di_tg_ctrl.$334.Metal2 VSS.$486.Metal2 0.0066322f
Cred_2437 di_tg_ctrl.$334.Metal2 VSS.$494.Metal2 0.0124743f
Cred_2438 di_tg_ctrl.$334.Metal2 VSS.$498.Metal2 2.82896e-06f
Cred_2439 di_tg_ctrl.$334.Metal2 VSS.$700.Metal3 5.31749e-05f
Cred_2440 di_tg_ctrl.$334.Metal2 VSS.P0.pSD 3.24975e-06f
Cred_2441 di_tg_ctrl.$336.Metal2 di_tg_ctrl_n.$354.Metal2 1.14e-08f
Cred_2442 di_tg_ctrl.$336.Metal2 di_tg_ctrl_n.$443.Metal3 2.45166e-06f
Cred_2443 di_tg_ctrl.$336.Metal2 di_tg_ctrl_n.$447.Metal3 1.19999e-06f
Cred_2444 di_tg_ctrl.$336.Metal2 di_tg_ctrl_n.$488.Metal4 3.15778e-05f
Cred_2445 di_tg_ctrl.$336.Metal2 VSS 0.00255445f
Cred_2446 di_tg_ctrl.$336.Metal2 v_a.$2597.Metal3 0.00344716f
Cred_2447 di_tg_ctrl.$336.Metal2 v_a.$2635.Metal3 2.27151e-05f
Cred_2448 di_tg_ctrl.$336.Metal2 v_a.$2657.Metal3 6.54728e-05f
Cred_2449 di_tg_ctrl.$336.Metal2 v_a.P28.nSD 0.00166906f
Cred_2450 di_tg_ctrl.$336.Metal2 v_a.P30.nSD 1.13417e-05f
Cred_2451 di_tg_ctrl.$336.Metal2 v_b.$2751.Metal2 0.00882896f
Cred_2452 di_tg_ctrl.$336.Metal2 v_b.$2811.Metal2 0.00882896f
Cred_2453 di_tg_ctrl.$336.Metal2 v_b.P29.nSD 0.00633372f
Cred_2454 di_tg_ctrl.$336.Metal2 v_b.P29.pSD 0.000177539f
Cred_2455 di_tg_ctrl.$336.Metal2 VSS.$17.Metal1 1.31901e-09f
Cred_2456 di_tg_ctrl.$336.Metal2 VSS.$177.Metal1 0.00188225f
Cred_2457 di_tg_ctrl.$336.Metal2 VSS.$191.Metal1 0.00144561f
Cred_2458 di_tg_ctrl.$336.Metal2 VSS.$301.Metal1 1.86697e-09f
Cred_2459 di_tg_ctrl.$336.Metal2 VSS.$494.Metal2 0.0133852f
Cred_2460 di_tg_ctrl.$336.Metal2 VSS.$498.Metal2 0.00584913f
Cred_2461 di_tg_ctrl.$336.Metal2 VSS.$606.Metal2 1.97267e-10f
Cred_2462 di_tg_ctrl.$336.Metal2 VSS.$700.Metal3 0.000197811f
Cred_2463 di_tg_ctrl.$336.Metal2 VSS.$706.Metal3 0.000228022f
Cred_2464 di_tg_ctrl.$336.Metal2 VSS.$760.Metal3 1.1672e-11f
Cred_2465 di_tg_ctrl.$336.Metal2 VSS.P0.pSD 9.04098e-06f
Cred_2466 di_tg_ctrl.$338.Metal2 di_tg_ctrl_n.$354.Metal2 5.6461e-09f
Cred_2467 di_tg_ctrl.$338.Metal2 di_tg_ctrl_n.$443.Metal3 1.21424e-06f
Cred_2468 di_tg_ctrl.$338.Metal2 di_tg_ctrl_n.$447.Metal3 5.94322e-07f
Cred_2469 di_tg_ctrl.$338.Metal2 di_tg_ctrl_n.$488.Metal4 1.56396e-05f
Cred_2470 di_tg_ctrl.$338.Metal2 VSS 0.00384375f
Cred_2471 di_tg_ctrl.$338.Metal2 v_a.$2597.Metal3 0.0085477f
Cred_2472 di_tg_ctrl.$338.Metal2 v_a.$2635.Metal3 0.00292578f
Cred_2473 di_tg_ctrl.$338.Metal2 v_a.$2657.Metal3 0.00843313f
Cred_2474 di_tg_ctrl.$338.Metal2 v_a.P28.nSD 7.6096e-06f
Cred_2475 di_tg_ctrl.$338.Metal2 v_a.P30.nSD 0.00881392f
Cred_2476 di_tg_ctrl.$338.Metal2 v_b.$2751.Metal2 0.0051567f
Cred_2477 di_tg_ctrl.$338.Metal2 v_b.$2811.Metal2 0.00623404f
Cred_2478 di_tg_ctrl.$338.Metal2 v_b.P29.nSD 0.00443407f
Cred_2479 di_tg_ctrl.$338.Metal2 v_b.P29.pSD 0.000103694f
Cred_2480 di_tg_ctrl.$338.Metal2 v_b.P31.nSD 9.83962e-05f
Cred_2481 di_tg_ctrl.$338.Metal2 VSS.$17.Metal1 3.8151e-08f
Cred_2482 di_tg_ctrl.$338.Metal2 VSS.$177.Metal1 0.000852696f
Cred_2483 di_tg_ctrl.$338.Metal2 VSS.$191.Metal1 0.00394266f
Cred_2484 di_tg_ctrl.$338.Metal2 VSS.$205.Metal1 0.000167041f
Cred_2485 di_tg_ctrl.$338.Metal2 VSS.$301.Metal1 7.55938e-08f
Cred_2486 di_tg_ctrl.$338.Metal2 VSS.$494.Metal2 7.75421e-06f
Cred_2487 di_tg_ctrl.$338.Metal2 VSS.$498.Metal2 0.0197371f
Cred_2488 di_tg_ctrl.$338.Metal2 VSS.$506.Metal2 0.00916873f
Cred_2489 di_tg_ctrl.$338.Metal2 VSS.$510.Metal2 1.28817e-06f
Cred_2490 di_tg_ctrl.$338.Metal2 VSS.$606.Metal2 7.98736e-09f
Cred_2491 di_tg_ctrl.$338.Metal2 VSS.$700.Metal3 0.00014697f
Cred_2492 di_tg_ctrl.$338.Metal2 VSS.$706.Metal3 0.000323367f
Cred_2493 di_tg_ctrl.$338.Metal2 VSS.$760.Metal3 4.72601e-10f
Cred_2494 di_tg_ctrl.$338.Metal2 VSS.P0.pSD 1.93854e-05f
Cred_2495 di_tg_ctrl.$34.GatPoly VSS 0.0389033f
Cred_2496 di_tg_ctrl.$34.GatPoly v_a.$2387.Metal3 0.00443311f
Cred_2497 di_tg_ctrl.$34.GatPoly v_a.P14.nSD 0.00595342f
Cred_2498 di_tg_ctrl.$34.GatPoly v_b.$2541.Metal2 0.00500303f
Cred_2499 di_tg_ctrl.$34.GatPoly v_b.$2601.Metal2 0.000237798f
Cred_2500 di_tg_ctrl.$34.GatPoly v_b.P13.nSD 0.00441242f
Cred_2501 di_tg_ctrl.$34.GatPoly v_b.P15.nSD 0.000451485f
Cred_2502 di_tg_ctrl.$34.GatPoly v_b.P15.pSD 4.78182e-06f
Cred_2503 di_tg_ctrl.$34.GatPoly VSS.$101.Metal1 0.00327306f
Cred_2504 di_tg_ctrl.$34.GatPoly VSS.$113.Metal1 0.000631439f
Cred_2505 di_tg_ctrl.$34.GatPoly VSS.$422.Metal2 9.78995e-06f
Cred_2506 di_tg_ctrl.$34.GatPoly VSS.$426.Metal2 4.87025e-06f
Cred_2507 di_tg_ctrl.$34.GatPoly VSS.P0.pSD 4.54104e-06f
Cred_2508 di_tg_ctrl.$342.Metal2 di_tg_ctrl_n.$223.Metal1 2.07467e-07f
Cred_2509 di_tg_ctrl.$342.Metal2 di_tg_ctrl_n.$352.Metal2 1.10244e-05f
Cred_2510 di_tg_ctrl.$342.Metal2 di_tg_ctrl_n.$443.Metal3 0.000171277f
Cred_2511 di_tg_ctrl.$342.Metal2 di_tg_ctrl_n.$86.GatPoly 1.11575e-09f
Cred_2512 di_tg_ctrl.$342.Metal2 VSS 0.00405618f
Cred_2513 di_tg_ctrl.$342.Metal2 v_a.$2597.Metal3 0.00423969f
Cred_2514 di_tg_ctrl.$342.Metal2 v_a.$2635.Metal3 0.00147091f
Cred_2515 di_tg_ctrl.$342.Metal2 v_a.$2657.Metal3 0.0061618f
Cred_2516 di_tg_ctrl.$342.Metal2 v_a.P30.nSD 0.00489258f
Cred_2517 di_tg_ctrl.$342.Metal2 v_a.P32.nSD 9.24412e-05f
Cred_2518 di_tg_ctrl.$342.Metal2 v_a.P34.nSD 9.86066e-05f
Cred_2519 di_tg_ctrl.$342.Metal2 v_a.P34.pSD 1.15331e-05f
Cred_2520 di_tg_ctrl.$342.Metal2 v_b.$2811.Metal2 0.0260492f
Cred_2521 di_tg_ctrl.$342.Metal2 v_b.$2871.Metal2 7.16975e-05f
Cred_2522 di_tg_ctrl.$342.Metal2 v_b.P31.nSD 0.0108486f
Cred_2523 di_tg_ctrl.$342.Metal2 v_b.P33.nSD 8.18475e-05f
Cred_2524 di_tg_ctrl.$342.Metal2 v_b.P33.pSD 1.44174e-06f
Cred_2525 di_tg_ctrl.$342.Metal2 VSS.$191.Metal1 0.00294755f
Cred_2526 di_tg_ctrl.$342.Metal2 VSS.$205.Metal1 0.00133028f
Cred_2527 di_tg_ctrl.$342.Metal2 VSS.$213.Metal1 1.79455e-05f
Cred_2528 di_tg_ctrl.$342.Metal2 VSS.$221.Metal1 1.62971e-07f
Cred_2529 di_tg_ctrl.$342.Metal2 VSS.$498.Metal2 0.00340739f
Cred_2530 di_tg_ctrl.$342.Metal2 VSS.$506.Metal2 0.0203716f
Cred_2531 di_tg_ctrl.$342.Metal2 VSS.$510.Metal2 0.00585329f
Cred_2532 di_tg_ctrl.$342.Metal2 VSS.$518.Metal2 2.67327e-05f
Cred_2533 di_tg_ctrl.$342.Metal2 VSS.$526.Metal2 7.00236e-06f
Cred_2534 di_tg_ctrl.$342.Metal2 VSS.$706.Metal3 0.000342725f
Cred_2535 di_tg_ctrl.$342.Metal2 VSS.$712.Metal3 0.000913674f
Cred_2536 di_tg_ctrl.$342.Metal2 VSS.$716.Metal3 0.000463805f
Cred_2537 di_tg_ctrl.$342.Metal2 VSS.P0.pSD 1.00191e-05f
Cred_2538 di_tg_ctrl.$344.Metal2 di_tg_ctrl_n.$223.Metal1 0.000160145f
Cred_2539 di_tg_ctrl.$344.Metal2 di_tg_ctrl_n.$352.Metal2 0.00850976f
Cred_2540 di_tg_ctrl.$344.Metal2 di_tg_ctrl_n.$443.Metal3 0.00163684f
Cred_2541 di_tg_ctrl.$344.Metal2 di_tg_ctrl_n.$86.GatPoly 8.61252e-07f
Cred_2542 di_tg_ctrl.$344.Metal2 VSS 0.00983061f
Cred_2543 di_tg_ctrl.$344.Metal2 v_a.$2597.Metal3 3.87655e-05f
Cred_2544 di_tg_ctrl.$344.Metal2 v_a.$2635.Metal3 1.34492e-05f
Cred_2545 di_tg_ctrl.$344.Metal2 v_a.$2657.Metal3 0.0652095f
Cred_2546 di_tg_ctrl.$344.Metal2 v_a.P30.nSD 3.04316e-06f
Cred_2547 di_tg_ctrl.$344.Metal2 v_a.P32.nSD 0.0148215f
Cred_2548 di_tg_ctrl.$344.Metal2 v_a.P34.nSD 0.0122658f
Cred_2549 di_tg_ctrl.$344.Metal2 v_a.P34.pSD 0.000433415f
Cred_2550 di_tg_ctrl.$344.Metal2 v_b.$2811.Metal2 0.0152733f
Cred_2551 di_tg_ctrl.$344.Metal2 v_b.$2871.Metal2 0.0133534f
Cred_2552 di_tg_ctrl.$344.Metal2 v_b.P31.nSD 0.000351558f
Cred_2553 di_tg_ctrl.$344.Metal2 v_b.P33.nSD 0.0104168f
Cred_2554 di_tg_ctrl.$344.Metal2 v_b.P33.pSD 0.000268519f
Cred_2555 di_tg_ctrl.$344.Metal2 VSS.$191.Metal1 0.000871724f
Cred_2556 di_tg_ctrl.$344.Metal2 VSS.$205.Metal1 0.00585953f
Cred_2557 di_tg_ctrl.$344.Metal2 VSS.$213.Metal1 0.0035103f
Cred_2558 di_tg_ctrl.$344.Metal2 VSS.$221.Metal1 0.000175498f
Cred_2559 di_tg_ctrl.$344.Metal2 VSS.$506.Metal2 1.55154e-05f
Cred_2560 di_tg_ctrl.$344.Metal2 VSS.$510.Metal2 0.0224963f
Cred_2561 di_tg_ctrl.$344.Metal2 VSS.$518.Metal2 0.0342269f
Cred_2562 di_tg_ctrl.$344.Metal2 VSS.$526.Metal2 0.00754058f
Cred_2563 di_tg_ctrl.$344.Metal2 VSS.$706.Metal3 0.00109654f
Cred_2564 di_tg_ctrl.$344.Metal2 VSS.$712.Metal3 0.00568752f
Cred_2565 di_tg_ctrl.$344.Metal2 VSS.$716.Metal3 0.00401015f
Cred_2566 di_tg_ctrl.$344.Metal2 VSS.P0.pSD 1.34031e-05f
Cred_2567 di_tg_ctrl.$350.Metal2 di_tg_ctrl_n.$204.Metal1 2.95292e-07f
Cred_2568 di_tg_ctrl.$350.Metal2 di_tg_ctrl_n.$207.Metal1 6.72977e-07f
Cred_2569 di_tg_ctrl.$350.Metal2 di_tg_ctrl_n.$209.Metal1 3.88124e-07f
Cred_2570 di_tg_ctrl.$350.Metal2 di_tg_ctrl_n.$215.Metal1 8.44848e-07f
Cred_2571 di_tg_ctrl.$350.Metal2 di_tg_ctrl_n.$216.Metal1 0.000169892f
Cred_2572 di_tg_ctrl.$350.Metal2 di_tg_ctrl_n.$219.Metal1 0.000446061f
Cred_2573 di_tg_ctrl.$350.Metal2 di_tg_ctrl_n.$320.Metal2 2.8194e-10f
Cred_2574 di_tg_ctrl.$350.Metal2 di_tg_ctrl_n.$322.Metal2 5.74644e-10f
Cred_2575 di_tg_ctrl.$350.Metal2 di_tg_ctrl_n.$336.Metal2 7.50206e-08f
Cred_2576 di_tg_ctrl.$350.Metal2 di_tg_ctrl_n.$338.Metal2 3.71556e-08f
Cred_2577 di_tg_ctrl.$350.Metal2 di_tg_ctrl_n.$342.Metal2 1.42637e-05f
Cred_2578 di_tg_ctrl.$350.Metal2 di_tg_ctrl_n.$344.Metal2 0.00885457f
Cred_2579 di_tg_ctrl.$350.Metal2 di_tg_ctrl_n.$423.Metal3 1.4769e-08f
Cred_2580 di_tg_ctrl.$350.Metal2 di_tg_ctrl_n.$429.Metal3 3.01019e-08f
Cred_2581 di_tg_ctrl.$350.Metal2 di_tg_ctrl_n.$434.Metal3 3.92985e-06f
Cred_2582 di_tg_ctrl.$350.Metal2 di_tg_ctrl_n.$437.Metal3 0.000749131f
Cred_2583 di_tg_ctrl.$350.Metal2 di_tg_ctrl_n.$483.Metal4 2.44053e-06f
Cred_2584 di_tg_ctrl.$350.Metal2 di_tg_ctrl_n.$69.GatPoly 3.23381e-06f
Cred_2585 di_tg_ctrl.$350.Metal2 di_tg_ctrl_n.$72.GatPoly 3.9618e-06f
Cred_2586 di_tg_ctrl.$350.Metal2 di_tg_ctrl_n.$76.GatPoly 5.06681e-06f
Cred_2587 di_tg_ctrl.$350.Metal2 di_tg_ctrl_n.$79.GatPoly 7.27982e-06f
Cred_2588 di_tg_ctrl.$350.Metal2 di_tg_ctrl_n.$83.GatPoly 8.74376e-05f
Cred_2589 di_tg_ctrl.$350.Metal2 di_tg_ctrl_n.P47.GatPoly 2.11663e-08f
Cred_2590 di_tg_ctrl.$350.Metal2 di_tg_ctrl_n.P48.GatPoly 5.53693e-08f
Cred_2591 di_tg_ctrl.$350.Metal2 di_tg_ctrl_n.P51.GatPoly 1.17571e-07f
Cred_2592 di_tg_ctrl.$350.Metal2 di_tg_ctrl_n.P52.GatPoly 6.66901e-07f
Cred_2593 di_tg_ctrl.$350.Metal2 di_tg_ctrl_n.P53.GatPoly 2.25481e-06f
Cred_2594 di_tg_ctrl.$350.Metal2 VSS 3.68122e-05f
Cred_2595 di_tg_ctrl.$350.Metal2 v_a.$2657.Metal3 1.28009e-06f
Cred_2596 di_tg_ctrl.$350.Metal2 v_a.P34.nSD 8.41745e-09f
Cred_2597 di_tg_ctrl.$350.Metal2 v_a.P34.pSD 9.82783e-07f
Cred_2598 di_tg_ctrl.$350.Metal2 v_b.$2871.Metal2 2.63673e-06f
Cred_2599 di_tg_ctrl.$350.Metal2 v_b.$2962.Metal2 6.94028e-05f
Cred_2600 di_tg_ctrl.$350.Metal2 v_b.$3779.Metal3 0.0166923f
Cred_2601 di_tg_ctrl.$350.Metal2 v_b.$3785.Metal3 4.13021e-05f
Cred_2602 di_tg_ctrl.$350.Metal2 v_b.P35.pSD 9.5644e-06f
Cred_2603 di_tg_ctrl.$350.Metal2 v_b.P37.nSD 1.99569e-05f
Cred_2604 di_tg_ctrl.$350.Metal2 v_b.P37.pSD 0.0222508f
Cred_2605 di_tg_ctrl.$350.Metal2 v_b.P39.pSD 0.00262552f
Cred_2606 di_tg_ctrl.$350.Metal2 v_b.P41.pSD 2.46714e-05f
Cred_2607 di_tg_ctrl.$350.Metal2 VDD.$238.Metal1 0.00323274f
Cred_2608 di_tg_ctrl.$350.Metal2 VDD.$247.Metal1 0.0018819f
Cred_2609 di_tg_ctrl.$350.Metal2 VDD.$560.Metal2 0.00469044f
Cred_2610 di_tg_ctrl.$350.Metal2 VDD.$568.Metal2 0.0270168f
Cred_2611 di_tg_ctrl.$350.Metal2 VDD.$750.Metal3 0.000428689f
Cred_2612 di_tg_ctrl.$350.Metal2 VDD.$758.Metal3 0.00132997f
Cred_2613 di_tg_ctrl.$350.Metal2 VDD.P0.nSD 3.1557e-06f
Cred_2614 di_tg_ctrl.$352.Metal2 di_tg_ctrl_n.$204.Metal1 1.10323e-07f
Cred_2615 di_tg_ctrl.$352.Metal2 di_tg_ctrl_n.$216.Metal1 3.77631e-07f
Cred_2616 di_tg_ctrl.$352.Metal2 di_tg_ctrl_n.$219.Metal1 5.941e-07f
Cred_2617 di_tg_ctrl.$352.Metal2 di_tg_ctrl_n.$320.Metal2 1.676e-10f
Cred_2618 di_tg_ctrl.$352.Metal2 di_tg_ctrl_n.$322.Metal2 3.41598e-10f
Cred_2619 di_tg_ctrl.$352.Metal2 di_tg_ctrl_n.$336.Metal2 4.45961e-08f
Cred_2620 di_tg_ctrl.$352.Metal2 di_tg_ctrl_n.$338.Metal2 2.20872e-08f
Cred_2621 di_tg_ctrl.$352.Metal2 di_tg_ctrl_n.$342.Metal2 2.98939e-06f
Cred_2622 di_tg_ctrl.$352.Metal2 di_tg_ctrl_n.$344.Metal2 2.58175e-05f
Cred_2623 di_tg_ctrl.$352.Metal2 di_tg_ctrl_n.$423.Metal3 8.77948e-09f
Cred_2624 di_tg_ctrl.$352.Metal2 di_tg_ctrl_n.$429.Metal3 1.78942e-08f
Cred_2625 di_tg_ctrl.$352.Metal2 di_tg_ctrl_n.$434.Metal3 2.33611e-06f
Cred_2626 di_tg_ctrl.$352.Metal2 di_tg_ctrl_n.$437.Metal3 0.000157752f
Cred_2627 di_tg_ctrl.$352.Metal2 di_tg_ctrl_n.$483.Metal4 1.45078e-06f
Cred_2628 di_tg_ctrl.$352.Metal2 di_tg_ctrl_n.$69.GatPoly 2.78125e-07f
Cred_2629 di_tg_ctrl.$352.Metal2 di_tg_ctrl_n.$72.GatPoly 2.0737e-07f
Cred_2630 di_tg_ctrl.$352.Metal2 di_tg_ctrl_n.P47.GatPoly 1.63208e-09f
Cred_2631 di_tg_ctrl.$352.Metal2 VSS 1.16869e-05f
Cred_2632 di_tg_ctrl.$352.Metal2 v_a.$2657.Metal3 8.61539e-07f
Cred_2633 di_tg_ctrl.$352.Metal2 v_a.P34.nSD 5.6652e-09f
Cred_2634 di_tg_ctrl.$352.Metal2 v_a.P34.pSD 6.61442e-07f
Cred_2635 di_tg_ctrl.$352.Metal2 v_b.$2962.Metal2 0.00947963f
Cred_2636 di_tg_ctrl.$352.Metal2 v_b.$3779.Metal3 0.000498409f
Cred_2637 di_tg_ctrl.$352.Metal2 v_b.$3785.Metal3 0.00897083f
Cred_2638 di_tg_ctrl.$352.Metal2 v_b.P37.nSD 5.95887e-07f
Cred_2639 di_tg_ctrl.$352.Metal2 v_b.P37.pSD 0.000368923f
Cred_2640 di_tg_ctrl.$352.Metal2 v_b.P39.pSD 0.024892f
Cred_2641 di_tg_ctrl.$352.Metal2 v_b.P41.pSD 0.0118236f
Cred_2642 di_tg_ctrl.$352.Metal2 VDD.$238.Metal1 1.10055e-05f
Cred_2643 di_tg_ctrl.$352.Metal2 VDD.$247.Metal1 0.00299793f
Cred_2644 di_tg_ctrl.$352.Metal2 VDD.$251.Metal1 0.00308086f
Cred_2645 di_tg_ctrl.$352.Metal2 VDD.$263.Metal1 0.000330483f
Cred_2646 di_tg_ctrl.$352.Metal2 VDD.$560.Metal2 3.3337e-06f
Cred_2647 di_tg_ctrl.$352.Metal2 VDD.$568.Metal2 0.0141391f
Cred_2648 di_tg_ctrl.$352.Metal2 VDD.$576.Metal2 0.0221646f
Cred_2649 di_tg_ctrl.$352.Metal2 VDD.$580.Metal2 2.48632e-06f
Cred_2650 di_tg_ctrl.$352.Metal2 VDD.$750.Metal3 0.000208309f
Cred_2651 di_tg_ctrl.$352.Metal2 VDD.$758.Metal3 0.000991868f
Cred_2652 di_tg_ctrl.$352.Metal2 VDD.P0.nSD 1.70085e-06f
Cred_2653 di_tg_ctrl.$356.Metal2 VSS 1.64856e-06f
Cred_2654 di_tg_ctrl.$356.Metal2 v_b.$3056.Metal2 0.00879487f
Cred_2655 di_tg_ctrl.$356.Metal2 v_b.$3785.Metal3 0.010214f
Cred_2656 di_tg_ctrl.$356.Metal2 v_b.$3821.Metal3 0.00430844f
Cred_2657 di_tg_ctrl.$356.Metal2 v_b.P41.pSD 0.0124113f
Cred_2658 di_tg_ctrl.$356.Metal2 v_b.P43.pSD 0.0242604f
Cred_2659 di_tg_ctrl.$356.Metal2 v_b.P45.pSD 0.00516489f
Cred_2660 di_tg_ctrl.$356.Metal2 VDD.$247.Metal1 3.06371e-06f
Cred_2661 di_tg_ctrl.$356.Metal2 VDD.$251.Metal1 0.00371483f
Cred_2662 di_tg_ctrl.$356.Metal2 VDD.$263.Metal1 0.00453041f
Cred_2663 di_tg_ctrl.$356.Metal2 VDD.$568.Metal2 0.000650601f
Cred_2664 di_tg_ctrl.$356.Metal2 VDD.$576.Metal2 0.014036f
Cred_2665 di_tg_ctrl.$356.Metal2 VDD.$580.Metal2 0.0231407f
Cred_2666 di_tg_ctrl.$356.Metal2 VDD.$584.Metal2 0.0110309f
Cred_2667 di_tg_ctrl.$356.Metal2 VDD.$588.Metal2 9.2798e-10f
Cred_2668 di_tg_ctrl.$356.Metal2 VDD.$758.Metal3 1.89285e-05f
Cred_2669 di_tg_ctrl.$356.Metal2 VDD.$762.Metal3 0.000249215f
Cred_2670 di_tg_ctrl.$356.Metal2 VDD.$768.Metal3 1.1574e-07f
Cred_2671 di_tg_ctrl.$356.Metal2 VDD.P0.nSD 9.23013e-06f
Cred_2672 di_tg_ctrl.$360.Metal2 di_tg_ctrl_n.$471.Metal4 1.12617e-07f
Cred_2673 di_tg_ctrl.$360.Metal2 di_tg_ctrl_n.$491.Metal4 5.89377e-07f
Cred_2674 di_tg_ctrl.$360.Metal2 VSS 1.80272e-06f
Cred_2675 di_tg_ctrl.$360.Metal2 v_b.$3056.Metal2 0.000285075f
Cred_2676 di_tg_ctrl.$360.Metal2 v_b.$3153.Metal2 2.35539e-05f
Cred_2677 di_tg_ctrl.$360.Metal2 v_b.$3821.Metal3 0.0153761f
Cred_2678 di_tg_ctrl.$360.Metal2 v_b.$3857.Metal3 1.00222e-05f
Cred_2679 di_tg_ctrl.$360.Metal2 v_b.$3890.Metal3 1.05233e-05f
Cred_2680 di_tg_ctrl.$360.Metal2 v_b.P43.pSD 0.00206479f
Cred_2681 di_tg_ctrl.$360.Metal2 v_b.P45.pSD 0.0180129f
Cred_2682 di_tg_ctrl.$360.Metal2 v_b.P47.pSD 0.00280942f
Cred_2683 di_tg_ctrl.$360.Metal2 v_b.P49.nSD 1.86091e-08f
Cred_2684 di_tg_ctrl.$360.Metal2 v_b.P49.pSD 1.23064e-05f
Cred_2685 di_tg_ctrl.$360.Metal2 VDD.$263.Metal1 0.00351188f
Cred_2686 di_tg_ctrl.$360.Metal2 VDD.$269.Metal1 0.00177932f
Cred_2687 di_tg_ctrl.$360.Metal2 VDD.$580.Metal2 0.00131167f
Cred_2688 di_tg_ctrl.$360.Metal2 VDD.$584.Metal2 0.0137055f
Cred_2689 di_tg_ctrl.$360.Metal2 VDD.$588.Metal2 0.0224499f
Cred_2690 di_tg_ctrl.$360.Metal2 VDD.$596.Metal2 3.21375e-09f
Cred_2691 di_tg_ctrl.$360.Metal2 VDD.$600.Metal2 2.12829e-09f
Cred_2692 di_tg_ctrl.$360.Metal2 VDD.$604.Metal2 1.0599e-09f
Cred_2693 di_tg_ctrl.$360.Metal2 VDD.$762.Metal3 0.00013063f
Cred_2694 di_tg_ctrl.$360.Metal2 VDD.$768.Metal3 0.000378739f
Cred_2695 di_tg_ctrl.$360.Metal2 VDD.$776.Metal3 1.32193e-07f
Cred_2696 di_tg_ctrl.$360.Metal2 VDD.P0.nSD 3.00415e-06f
Cred_2697 di_tg_ctrl.$362.Metal2 di_tg_ctrl_n.$471.Metal4 2.29534e-07f
Cred_2698 di_tg_ctrl.$362.Metal2 di_tg_ctrl_n.$491.Metal4 1.20126e-06f
Cred_2699 di_tg_ctrl.$362.Metal2 VSS 3.67426e-06f
Cred_2700 di_tg_ctrl.$362.Metal2 v_b.$3153.Metal2 0.00895384f
Cred_2701 di_tg_ctrl.$362.Metal2 v_b.$3821.Metal3 0.000134903f
Cred_2702 di_tg_ctrl.$362.Metal2 v_b.$3857.Metal3 0.00514707f
Cred_2703 di_tg_ctrl.$362.Metal2 v_b.$3890.Metal3 0.00540443f
Cred_2704 di_tg_ctrl.$362.Metal2 v_b.P45.pSD 8.05828e-05f
Cred_2705 di_tg_ctrl.$362.Metal2 v_b.P47.pSD 0.0233348f
Cred_2706 di_tg_ctrl.$362.Metal2 v_b.P49.nSD 9.55705e-06f
Cred_2707 di_tg_ctrl.$362.Metal2 v_b.P49.pSD 0.0125564f
Cred_2708 di_tg_ctrl.$362.Metal2 VDD.$263.Metal1 3.88049e-06f
Cred_2709 di_tg_ctrl.$362.Metal2 VDD.$269.Metal1 0.00287476f
Cred_2710 di_tg_ctrl.$362.Metal2 VDD.$273.Metal1 0.00316431f
Cred_2711 di_tg_ctrl.$362.Metal2 VDD.$283.Metal1 0.000346965f
Cred_2712 di_tg_ctrl.$362.Metal2 VDD.$584.Metal2 5.87374e-07f
Cred_2713 di_tg_ctrl.$362.Metal2 VDD.$588.Metal2 0.0140805f
Cred_2714 di_tg_ctrl.$362.Metal2 VDD.$596.Metal2 0.0221105f
Cred_2715 di_tg_ctrl.$362.Metal2 VDD.$600.Metal2 2.5493e-06f
Cred_2716 di_tg_ctrl.$362.Metal2 VDD.$604.Metal2 2.16026e-09f
Cred_2717 di_tg_ctrl.$362.Metal2 VDD.$762.Metal3 7.3168e-05f
Cred_2718 di_tg_ctrl.$362.Metal2 VDD.$768.Metal3 0.000531697f
Cred_2719 di_tg_ctrl.$362.Metal2 VDD.$776.Metal3 2.69434e-07f
Cred_2720 di_tg_ctrl.$362.Metal2 VDD.P0.nSD 1.77275e-06f
Cred_2721 di_tg_ctrl.$366.Metal2 v_b.$3247.Metal2 0.00886749f
Cred_2722 di_tg_ctrl.$366.Metal2 v_b.$3857.Metal3 0.00524847f
Cred_2723 di_tg_ctrl.$366.Metal2 v_b.$3890.Metal3 0.0055109f
Cred_2724 di_tg_ctrl.$366.Metal2 v_b.$3903.Metal3 0.00587155f
Cred_2725 di_tg_ctrl.$366.Metal2 v_b.P49.nSD 9.74533e-06f
Cred_2726 di_tg_ctrl.$366.Metal2 v_b.P49.pSD 0.012655f
Cred_2727 di_tg_ctrl.$366.Metal2 v_b.P51.pSD 0.0244234f
Cred_2728 di_tg_ctrl.$366.Metal2 v_b.P53.pSD 0.00631635f
Cred_2729 di_tg_ctrl.$366.Metal2 VDD.$269.Metal1 2.91043e-06f
Cred_2730 di_tg_ctrl.$366.Metal2 VDD.$273.Metal1 0.00365533f
Cred_2731 di_tg_ctrl.$366.Metal2 VDD.$283.Metal1 0.00457428f
Cred_2732 di_tg_ctrl.$366.Metal2 VDD.$588.Metal2 0.000650598f
Cred_2733 di_tg_ctrl.$366.Metal2 VDD.$596.Metal2 0.0140373f
Cred_2734 di_tg_ctrl.$366.Metal2 VDD.$600.Metal2 0.0231429f
Cred_2735 di_tg_ctrl.$366.Metal2 VDD.$604.Metal2 0.0110348f
Cred_2736 di_tg_ctrl.$366.Metal2 VDD.$768.Metal3 0.00013885f
Cred_2737 di_tg_ctrl.$366.Metal2 VDD.$776.Metal3 0.000119817f
Cred_2738 di_tg_ctrl.$366.Metal2 VDD.P0.nSD 9.29591e-06f
Cred_2739 di_tg_ctrl.$37.GatPoly VSS 0.0419431f
Cred_2740 di_tg_ctrl.$37.GatPoly v_a.$2387.Metal3 0.00324421f
Cred_2741 di_tg_ctrl.$37.GatPoly v_a.P14.nSD 0.00435827f
Cred_2742 di_tg_ctrl.$37.GatPoly v_b.$2541.Metal2 0.00216199f
Cred_2743 di_tg_ctrl.$37.GatPoly v_b.$2601.Metal2 0.00216199f
Cred_2744 di_tg_ctrl.$37.GatPoly v_b.P15.nSD 0.0040954f
Cred_2745 di_tg_ctrl.$37.GatPoly v_b.P15.pSD 4.34748e-05f
Cred_2746 di_tg_ctrl.$37.GatPoly VSS.$101.Metal1 0.00233985f
Cred_2747 di_tg_ctrl.$37.GatPoly VSS.$113.Metal1 0.00375458f
Cred_2748 di_tg_ctrl.$37.GatPoly VSS.$422.Metal2 1.80468e-05f
Cred_2749 di_tg_ctrl.$37.GatPoly VSS.$426.Metal2 2.50933e-05f
Cred_2750 di_tg_ctrl.$37.GatPoly VSS.P0.pSD 1.34223e-05f
Cred_2751 di_tg_ctrl.$370.Metal2 v_b.$3344.Metal2 2.33663e-05f
Cred_2752 di_tg_ctrl.$370.Metal2 v_b.$3903.Metal3 0.0155141f
Cred_2753 di_tg_ctrl.$370.Metal2 v_b.$3934.Metal3 2.49082e-05f
Cred_2754 di_tg_ctrl.$370.Metal2 v_b.P51.pSD 0.00142059f
Cred_2755 di_tg_ctrl.$370.Metal2 v_b.P53.pSD 0.0176474f
Cred_2756 di_tg_ctrl.$370.Metal2 v_b.P55.pSD 0.00298106f
Cred_2757 di_tg_ctrl.$370.Metal2 v_b.P57.pSD 1.48786e-05f
Cred_2758 di_tg_ctrl.$370.Metal2 VDD.$283.Metal1 0.00173629f
Cred_2759 di_tg_ctrl.$370.Metal2 VDD.$287.Metal1 0.00351835f
Cred_2760 di_tg_ctrl.$370.Metal2 VDD.$291.Metal1 2.37262e-05f
Cred_2761 di_tg_ctrl.$370.Metal2 VDD.$596.Metal2 7.2227e-08f
Cred_2762 di_tg_ctrl.$370.Metal2 VDD.$600.Metal2 0.00131182f
Cred_2763 di_tg_ctrl.$370.Metal2 VDD.$604.Metal2 0.0249005f
Cred_2764 di_tg_ctrl.$370.Metal2 VDD.$612.Metal2 0.0111937f
Cred_2765 di_tg_ctrl.$370.Metal2 VDD.$768.Metal3 9.00836e-06f
Cred_2766 di_tg_ctrl.$370.Metal2 VDD.$776.Metal3 0.000515543f
Cred_2767 di_tg_ctrl.$370.Metal2 VDD.$780.Metal3 7.83306e-05f
Cred_2768 di_tg_ctrl.$372.Metal2 v_b.$3344.Metal2 0.00881948f
Cred_2769 di_tg_ctrl.$372.Metal2 v_b.$3903.Metal3 0.000125312f
Cred_2770 di_tg_ctrl.$372.Metal2 v_b.$3934.Metal3 0.0108054f
Cred_2771 di_tg_ctrl.$372.Metal2 v_b.P53.pSD 7.48538e-05f
Cred_2772 di_tg_ctrl.$372.Metal2 v_b.P55.pSD 0.0229106f
Cred_2773 di_tg_ctrl.$372.Metal2 v_b.P57.pSD 0.0126384f
Cred_2774 di_tg_ctrl.$372.Metal2 VDD.$287.Metal1 1.55508e-05f
Cred_2775 di_tg_ctrl.$372.Metal2 VDD.$291.Metal1 0.0028161f
Cred_2776 di_tg_ctrl.$372.Metal2 VDD.$295.Metal1 0.00262328f
Cred_2777 di_tg_ctrl.$372.Metal2 VDD.$299.Metal1 0.00113079f
Cred_2778 di_tg_ctrl.$372.Metal2 VDD.$596.Metal2 3.57721e-08f
Cred_2779 di_tg_ctrl.$372.Metal2 VDD.$600.Metal2 7.1831e-08f
Cred_2780 di_tg_ctrl.$372.Metal2 VDD.$604.Metal2 0.00132614f
Cred_2781 di_tg_ctrl.$372.Metal2 VDD.$612.Metal2 0.029728f
Cred_2782 di_tg_ctrl.$372.Metal2 VDD.$620.Metal2 0.00530817f
Cred_2783 di_tg_ctrl.$372.Metal2 VDD.$768.Metal3 4.46159e-06f
Cred_2784 di_tg_ctrl.$372.Metal2 VDD.$776.Metal3 0.000368622f
Cred_2785 di_tg_ctrl.$372.Metal2 VDD.$780.Metal3 0.000200716f
Cred_2786 di_tg_ctrl.$376.Metal2 v_b.$2003.Metal1 0.00123826f
Cred_2787 di_tg_ctrl.$376.Metal2 v_b.$3438.Metal2 0.00875506f
Cred_2788 di_tg_ctrl.$376.Metal2 v_b.$3507.Metal2 0.00287134f
Cred_2789 di_tg_ctrl.$376.Metal2 v_b.$3934.Metal3 0.0105729f
Cred_2790 di_tg_ctrl.$376.Metal2 v_b.$3990.Metal3 0.0059574f
Cred_2791 di_tg_ctrl.$376.Metal2 v_b.P57.pSD 0.0125261f
Cred_2792 di_tg_ctrl.$376.Metal2 v_b.P59.pSD 0.0242073f
Cred_2793 di_tg_ctrl.$376.Metal2 v_b.P61.pSD 0.00238246f
Cred_2794 di_tg_ctrl.$376.Metal2 VDD.$295.Metal1 0.00096703f
Cred_2795 di_tg_ctrl.$376.Metal2 VDD.$299.Metal1 0.00493401f
Cred_2796 di_tg_ctrl.$376.Metal2 VDD.$309.Metal1 0.00214743f
Cred_2797 di_tg_ctrl.$376.Metal2 VDD.$612.Metal2 0.00794582f
Cred_2798 di_tg_ctrl.$376.Metal2 VDD.$620.Metal2 0.0297729f
Cred_2799 di_tg_ctrl.$376.Metal2 VDD.$624.Metal2 0.01105f
Cred_2800 di_tg_ctrl.$376.Metal2 VDD.$780.Metal3 0.000232794f
Cred_2801 di_tg_ctrl.$376.Metal2 VDD.$786.Metal3 7.5627e-05f
Cred_2802 di_tg_ctrl.$376.Metal2 VDD.P0.nSD 7.99376e-06f
Cred_2803 di_tg_ctrl.$380.Metal2 v_b.$2003.Metal1 0.00312684f
Cred_2804 di_tg_ctrl.$380.Metal2 v_b.$3507.Metal2 0.00725987f
Cred_2805 di_tg_ctrl.$380.Metal2 v_b.$3535.Metal2 0.000603418f
Cred_2806 di_tg_ctrl.$380.Metal2 v_b.$3990.Metal3 0.0150148f
Cred_2807 di_tg_ctrl.$380.Metal2 v_b.$4009.Metal3 2.98898e-05f
Cred_2808 di_tg_ctrl.$380.Metal2 v_b.P59.pSD 0.00133703f
Cred_2809 di_tg_ctrl.$380.Metal2 v_b.P61.pSD 0.00674643f
Cred_2810 di_tg_ctrl.$380.Metal2 v_b.P63.pSD 0.00429249f
Cred_2811 di_tg_ctrl.$380.Metal2 v_b.P65.pSD 1.78544e-05f
Cred_2812 di_tg_ctrl.$380.Metal2 VDD.$299.Metal1 0.000573407f
Cred_2813 di_tg_ctrl.$380.Metal2 VDD.$309.Metal1 0.0045623f
Cred_2814 di_tg_ctrl.$380.Metal2 VDD.$313.Metal1 2.64793e-05f
Cred_2815 di_tg_ctrl.$380.Metal2 VDD.$620.Metal2 0.00131501f
Cred_2816 di_tg_ctrl.$380.Metal2 VDD.$624.Metal2 0.0249607f
Cred_2817 di_tg_ctrl.$380.Metal2 VDD.$632.Metal2 0.0112443f
Cred_2818 di_tg_ctrl.$380.Metal2 VDD.$780.Metal3 1.21232e-05f
Cred_2819 di_tg_ctrl.$380.Metal2 VDD.$786.Metal3 0.000513451f
Cred_2820 di_tg_ctrl.$380.Metal2 VDD.$790.Metal3 7.83306e-05f
Cred_2821 di_tg_ctrl.$380.Metal2 VDD.P0.nSD 2.91955e-06f
Cred_2822 di_tg_ctrl.$382.Metal2 v_b.$2003.Metal1 7.89857e-06f
Cred_2823 di_tg_ctrl.$382.Metal2 v_b.$3507.Metal2 2.28605e-05f
Cred_2824 di_tg_ctrl.$382.Metal2 v_b.$3535.Metal2 0.00818087f
Cred_2825 di_tg_ctrl.$382.Metal2 v_b.$3990.Metal3 0.000158328f
Cred_2826 di_tg_ctrl.$382.Metal2 v_b.$4009.Metal3 0.0110224f
Cred_2827 di_tg_ctrl.$382.Metal2 v_b.P61.pSD 5.58424e-06f
Cred_2828 di_tg_ctrl.$382.Metal2 v_b.P63.pSD 0.0214687f
Cred_2829 di_tg_ctrl.$382.Metal2 v_b.P65.pSD 0.0126526f
Cred_2830 di_tg_ctrl.$382.Metal2 VDD.$309.Metal1 1.50032e-05f
Cred_2831 di_tg_ctrl.$382.Metal2 VDD.$313.Metal1 0.00271301f
Cred_2832 di_tg_ctrl.$382.Metal2 VDD.$317.Metal1 0.00267869f
Cred_2833 di_tg_ctrl.$382.Metal2 VDD.$321.Metal1 0.00118627f
Cred_2834 di_tg_ctrl.$382.Metal2 VDD.$620.Metal2 4.81411e-08f
Cred_2835 di_tg_ctrl.$382.Metal2 VDD.$624.Metal2 0.00132613f
Cred_2836 di_tg_ctrl.$382.Metal2 VDD.$632.Metal2 0.0297219f
Cred_2837 di_tg_ctrl.$382.Metal2 VDD.$640.Metal2 0.00530819f
Cred_2838 di_tg_ctrl.$382.Metal2 VDD.$780.Metal3 6.00429e-06f
Cred_2839 di_tg_ctrl.$382.Metal2 VDD.$786.Metal3 0.000367385f
Cred_2840 di_tg_ctrl.$382.Metal2 VDD.$790.Metal3 0.000200717f
Cred_2841 di_tg_ctrl.$386.Metal2 VSS 0.00384613f
Cred_2842 di_tg_ctrl.$386.Metal2 v_b.$2255.Metal1 0.00457724f
Cred_2843 di_tg_ctrl.$386.Metal2 v_b.$3629.Metal2 0.00915717f
Cred_2844 di_tg_ctrl.$386.Metal2 v_b.$3698.Metal2 0.0102927f
Cred_2845 di_tg_ctrl.$386.Metal2 v_b.$4009.Metal3 0.00980741f
Cred_2846 di_tg_ctrl.$386.Metal2 v_b.$4065.Metal3 0.0198949f
Cred_2847 di_tg_ctrl.$386.Metal2 v_b.P65.pSD 0.0120816f
Cred_2848 di_tg_ctrl.$386.Metal2 v_b.P67.pSD 0.026694f
Cred_2849 di_tg_ctrl.$386.Metal2 v_b.P69.pSD 0.00730555f
Cred_2850 di_tg_ctrl.$386.Metal2 VDD.$317.Metal1 0.000915478f
Cred_2851 di_tg_ctrl.$386.Metal2 VDD.$321.Metal1 0.00659829f
Cred_2852 di_tg_ctrl.$386.Metal2 VDD.$332.Metal1 0.00525622f
Cred_2853 di_tg_ctrl.$386.Metal2 VDD.$340.Metal1 0.000152031f
Cred_2854 di_tg_ctrl.$386.Metal2 VDD.$388.Metal2 4.19334e-12f
Cred_2855 di_tg_ctrl.$386.Metal2 VDD.$42.Metal1 1.96896e-10f
Cred_2856 di_tg_ctrl.$386.Metal2 VDD.$632.Metal2 0.00794585f
Cred_2857 di_tg_ctrl.$386.Metal2 VDD.$640.Metal2 0.0310537f
Cred_2858 di_tg_ctrl.$386.Metal2 VDD.$644.Metal2 0.0282024f
Cred_2859 di_tg_ctrl.$386.Metal2 VDD.$666.Metal3 1.84613e-13f
Cred_2860 di_tg_ctrl.$386.Metal2 VDD.$790.Metal3 0.000667843f
Cred_2861 di_tg_ctrl.$386.Metal2 VDD.$794.Metal3 0.0024613f
Cred_2862 di_tg_ctrl.$386.Metal2 VDD.P0.nSD 6.42558e-05f
Cred_2863 di_tg_ctrl.$39.GatPoly VSS 0.0389033f
Cred_2864 di_tg_ctrl.$39.GatPoly v_a.$2387.Metal3 0.0021603f
Cred_2865 di_tg_ctrl.$39.GatPoly v_a.$2447.Metal3 0.0021603f
Cred_2866 di_tg_ctrl.$39.GatPoly v_a.P16.nSD 0.00591196f
Cred_2867 di_tg_ctrl.$39.GatPoly v_a.P16.pSD 4.78812e-05f
Cred_2868 di_tg_ctrl.$39.GatPoly v_b.$2541.Metal2 0.00234605f
Cred_2869 di_tg_ctrl.$39.GatPoly v_b.$2601.Metal2 0.00280842f
Cred_2870 di_tg_ctrl.$39.GatPoly v_b.P15.nSD 0.00443838f
Cred_2871 di_tg_ctrl.$39.GatPoly v_b.P15.pSD 4.7176e-05f
Cred_2872 di_tg_ctrl.$39.GatPoly v_b.P17.nSD 0.000429599f
Cred_2873 di_tg_ctrl.$39.GatPoly VSS.$113.Metal1 0.00309932f
Cred_2874 di_tg_ctrl.$39.GatPoly VSS.$123.Metal1 0.000489429f
Cred_2875 di_tg_ctrl.$39.GatPoly VSS.$434.Metal2 3.77429e-06f
Cred_2876 di_tg_ctrl.$39.GatPoly VSS.P0.pSD 1.34013e-06f
Cred_2877 di_tg_ctrl.$394.Metal3 VSS 0.0158766f
Cred_2878 di_tg_ctrl.$394.Metal3 v_a 0.0703411f
Cred_2879 di_tg_ctrl.$394.Metal3 v_a.$2215.Metal3 0.00791816f
Cred_2880 di_tg_ctrl.$394.Metal3 v_a.$2237.Metal3 0.0854729f
Cred_2881 di_tg_ctrl.$394.Metal3 v_a.$2275.Metal3 0.00088383f
Cred_2882 di_tg_ctrl.$394.Metal3 v_a.$2297.Metal3 0.00254751f
Cred_2883 di_tg_ctrl.$394.Metal3 v_a.P0.nSD 0.0049073f
Cred_2884 di_tg_ctrl.$394.Metal3 v_a.P2.nSD 0.00462197f
Cred_2885 di_tg_ctrl.$394.Metal3 v_a.P4.nSD 0.00441241f
Cred_2886 di_tg_ctrl.$394.Metal3 v_a.P6.nSD 0.000421594f
Cred_2887 di_tg_ctrl.$394.Metal3 v_b.$2361.Metal2 0.0112748f
Cred_2888 di_tg_ctrl.$394.Metal3 v_b.$2421.Metal2 0.00695511f
Cred_2889 di_tg_ctrl.$394.Metal3 v_b.P1.nSD 0.00424591f
Cred_2890 di_tg_ctrl.$394.Metal3 v_b.P3.nSD 0.00396992f
Cred_2891 di_tg_ctrl.$394.Metal3 v_b.P3.pSD 7.33188e-05f
Cred_2892 di_tg_ctrl.$394.Metal3 v_b.P5.nSD 0.00215043f
Cred_2893 di_tg_ctrl.$394.Metal3 VSS.$17.Metal1 0.000720499f
Cred_2894 di_tg_ctrl.$394.Metal3 VSS.$366.Metal2 0.00367167f
Cred_2895 di_tg_ctrl.$394.Metal3 VSS.$370.Metal2 0.000331636f
Cred_2896 di_tg_ctrl.$394.Metal3 VSS.$378.Metal2 6.55411e-05f
Cred_2897 di_tg_ctrl.$394.Metal3 VSS.$39.Metal1 0.00187682f
Cred_2898 di_tg_ctrl.$394.Metal3 VSS.$51.Metal1 0.00210972f
Cred_2899 di_tg_ctrl.$394.Metal3 VSS.$61.Metal1 2.43601e-05f
Cred_2900 di_tg_ctrl.$394.Metal3 VSS.$636.Metal3 0.0821504f
Cred_2901 di_tg_ctrl.$394.Metal3 VSS.$642.Metal3 0.0419002f
Cred_2902 di_tg_ctrl.$394.Metal3 VSS.$646.Metal3 0.00688352f
Cred_2903 di_tg_ctrl.$394.Metal3 VSS.P0.pSD 1.7114e-05f
Cred_2904 di_tg_ctrl.$397.Metal3 VSS 0.00435747f
Cred_2905 di_tg_ctrl.$397.Metal3 v_a.$2237.Metal3 0.0342569f
Cred_2906 di_tg_ctrl.$397.Metal3 v_a.$2275.Metal3 0.00908171f
Cred_2907 di_tg_ctrl.$397.Metal3 v_a.$2297.Metal3 0.027207f
Cred_2908 di_tg_ctrl.$397.Metal3 v_a.P4.nSD 0.000563186f
Cred_2909 di_tg_ctrl.$397.Metal3 v_a.P6.nSD 0.00474991f
Cred_2910 di_tg_ctrl.$397.Metal3 v_a.P8.nSD 3.03864e-05f
Cred_2911 di_tg_ctrl.$397.Metal3 v_b.$2421.Metal2 0.00630693f
Cred_2912 di_tg_ctrl.$397.Metal3 v_b.$2481.Metal2 0.00194622f
Cred_2913 di_tg_ctrl.$397.Metal3 v_b.P5.nSD 0.00233164f
Cred_2914 di_tg_ctrl.$397.Metal3 v_b.P7.nSD 0.00220406f
Cred_2915 di_tg_ctrl.$397.Metal3 v_b.P7.pSD 3.9136e-05f
Cred_2916 di_tg_ctrl.$397.Metal3 VSS.$378.Metal2 5.13189e-05f
Cred_2917 di_tg_ctrl.$397.Metal3 VSS.$386.Metal2 0.000137453f
Cred_2918 di_tg_ctrl.$397.Metal3 VSS.$394.Metal2 8.02021e-05f
Cred_2919 di_tg_ctrl.$397.Metal3 VSS.$51.Metal1 0.000319344f
Cred_2920 di_tg_ctrl.$397.Metal3 VSS.$61.Metal1 0.000198089f
Cred_2921 di_tg_ctrl.$397.Metal3 VSS.$642.Metal3 0.0113642f
Cred_2922 di_tg_ctrl.$397.Metal3 VSS.$646.Metal3 0.0389588f
Cred_2923 di_tg_ctrl.$397.Metal3 VSS.$654.Metal3 0.00501148f
Cred_2924 di_tg_ctrl.$397.Metal3 VSS.$69.Metal1 0.000425664f
Cred_2925 di_tg_ctrl.$397.Metal3 VSS.P0.pSD 8.23576e-07f
Cred_2926 di_tg_ctrl.$399.Metal3 VSS 0.00440963f
Cred_2927 di_tg_ctrl.$399.Metal3 v_a.$2237.Metal3 0.000558799f
Cred_2928 di_tg_ctrl.$399.Metal3 v_a.$2275.Metal3 0.000193869f
Cred_2929 di_tg_ctrl.$399.Metal3 v_a.$2297.Metal3 0.0598629f
Cred_2930 di_tg_ctrl.$399.Metal3 v_a.$2327.Metal3 0.00635325f
Cred_2931 di_tg_ctrl.$399.Metal3 v_a.P10.nSD 0.000425357f
Cred_2932 di_tg_ctrl.$399.Metal3 v_a.P6.nSD 4.38668e-05f
Cred_2933 di_tg_ctrl.$399.Metal3 v_a.P8.nSD 0.00446015f
Cred_2934 di_tg_ctrl.$399.Metal3 v_b.$2421.Metal2 0.00195592f
Cred_2935 di_tg_ctrl.$399.Metal3 v_b.$2481.Metal2 0.00493871f
Cred_2936 di_tg_ctrl.$399.Metal3 v_b.P10.nSD 0.00209423f
Cred_2937 di_tg_ctrl.$399.Metal3 v_b.P7.nSD 0.00220596f
Cred_2938 di_tg_ctrl.$399.Metal3 v_b.P7.pSD 3.9331e-05f
Cred_2939 di_tg_ctrl.$399.Metal3 VSS.$386.Metal2 0.000337113f
Cred_2940 di_tg_ctrl.$399.Metal3 VSS.$394.Metal2 0.000430332f
Cred_2941 di_tg_ctrl.$399.Metal3 VSS.$402.Metal2 1.12277e-05f
Cred_2942 di_tg_ctrl.$399.Metal3 VSS.$406.Metal2 5.59144e-06f
Cred_2943 di_tg_ctrl.$399.Metal3 VSS.$61.Metal1 0.000186024f
Cred_2944 di_tg_ctrl.$399.Metal3 VSS.$646.Metal3 0.0187843f
Cred_2945 di_tg_ctrl.$399.Metal3 VSS.$654.Metal3 0.0346153f
Cred_2946 di_tg_ctrl.$399.Metal3 VSS.$660.Metal3 0.00069738f
Cred_2947 di_tg_ctrl.$399.Metal3 VSS.$69.Metal1 0.00155214f
Cred_2948 di_tg_ctrl.$399.Metal3 VSS.$79.Metal1 0.000138113f
Cred_2949 di_tg_ctrl.$399.Metal3 VSS.P0.pSD 1.54886e-06f
Cred_2950 di_tg_ctrl.$402.Metal3 VSS 0.00436928f
Cred_2951 di_tg_ctrl.$402.Metal3 v_a.$2297.Metal3 0.00748668f
Cred_2952 di_tg_ctrl.$402.Metal3 v_a.$2327.Metal3 0.062016f
Cred_2953 di_tg_ctrl.$402.Metal3 v_a.$2365.Metal3 0.000160153f
Cred_2954 di_tg_ctrl.$402.Metal3 v_a.$2387.Metal3 0.000461616f
Cred_2955 di_tg_ctrl.$402.Metal3 v_a.P10.nSD 0.00450761f
Cred_2956 di_tg_ctrl.$402.Metal3 v_a.P12.nSD 3.62378e-05f
Cred_2957 di_tg_ctrl.$402.Metal3 v_a.P8.nSD 0.000527631f
Cred_2958 di_tg_ctrl.$402.Metal3 v_b.$2481.Metal2 0.00539011f
Cred_2959 di_tg_ctrl.$402.Metal3 v_b.$2541.Metal2 0.0019974f
Cred_2960 di_tg_ctrl.$402.Metal3 v_b.P10.nSD 0.00216486f
Cred_2961 di_tg_ctrl.$402.Metal3 v_b.P11.nSD 0.00231637f
Cred_2962 di_tg_ctrl.$402.Metal3 v_b.P11.pSD 4.01652e-05f
Cred_2963 di_tg_ctrl.$402.Metal3 VSS.$386.Metal2 2.08132e-05f
Cred_2964 di_tg_ctrl.$402.Metal3 VSS.$394.Metal2 4.20023e-05f
Cred_2965 di_tg_ctrl.$402.Metal3 VSS.$402.Metal2 0.000145694f
Cred_2966 di_tg_ctrl.$402.Metal3 VSS.$406.Metal2 0.000131961f
Cred_2967 di_tg_ctrl.$402.Metal3 VSS.$646.Metal3 0.00130053f
Cred_2968 di_tg_ctrl.$402.Metal3 VSS.$654.Metal3 0.0343473f
Cred_2969 di_tg_ctrl.$402.Metal3 VSS.$660.Metal3 0.018936f
Cred_2970 di_tg_ctrl.$402.Metal3 VSS.$69.Metal1 8.32716e-08f
Cred_2971 di_tg_ctrl.$402.Metal3 VSS.$79.Metal1 0.000620257f
Cred_2972 di_tg_ctrl.$402.Metal3 VSS.$91.Metal1 0.000998582f
Cred_2973 di_tg_ctrl.$402.Metal3 VSS.P0.pSD 4.13931e-06f
Cred_2974 di_tg_ctrl.$404.Metal3 VSS 0.00439743f
Cred_2975 di_tg_ctrl.$404.Metal3 v_a.$2327.Metal3 0.0271614f
Cred_2976 di_tg_ctrl.$404.Metal3 v_a.$2365.Metal3 0.00898646f
Cred_2977 di_tg_ctrl.$404.Metal3 v_a.$2387.Metal3 0.0323378f
Cred_2978 di_tg_ctrl.$404.Metal3 v_a.P10.nSD 3.7139e-05f
Cred_2979 di_tg_ctrl.$404.Metal3 v_a.P12.nSD 0.00479623f
Cred_2980 di_tg_ctrl.$404.Metal3 v_a.P14.nSD 0.000444162f
Cred_2981 di_tg_ctrl.$404.Metal3 v_b.$2481.Metal2 0.00200667f
Cred_2982 di_tg_ctrl.$404.Metal3 v_b.$2541.Metal2 0.00509193f
Cred_2983 di_tg_ctrl.$404.Metal3 v_b.P11.nSD 0.00231819f
Cred_2984 di_tg_ctrl.$404.Metal3 v_b.P11.pSD 4.03515e-05f
Cred_2985 di_tg_ctrl.$404.Metal3 v_b.P13.nSD 0.00211189f
Cred_2986 di_tg_ctrl.$404.Metal3 VSS.$101.Metal1 0.000119155f
Cred_2987 di_tg_ctrl.$404.Metal3 VSS.$402.Metal2 2.07469e-05f
Cred_2988 di_tg_ctrl.$404.Metal3 VSS.$406.Metal2 0.000106821f
Cred_2989 di_tg_ctrl.$404.Metal3 VSS.$414.Metal2 0.000189505f
Cred_2990 di_tg_ctrl.$404.Metal3 VSS.$422.Metal2 1.12277e-05f
Cred_2991 di_tg_ctrl.$404.Metal3 VSS.$426.Metal2 5.59144e-06f
Cred_2992 di_tg_ctrl.$404.Metal3 VSS.$654.Metal3 0.00246457f
Cred_2993 di_tg_ctrl.$404.Metal3 VSS.$660.Metal3 0.0318725f
Cred_2994 di_tg_ctrl.$404.Metal3 VSS.$664.Metal3 0.0195525f
Cred_2995 di_tg_ctrl.$404.Metal3 VSS.$670.Metal3 0.00069738f
Cred_2996 di_tg_ctrl.$404.Metal3 VSS.$79.Metal1 0.000127904f
Cred_2997 di_tg_ctrl.$404.Metal3 VSS.$91.Metal1 0.00158927f
Cred_2998 di_tg_ctrl.$404.Metal3 VSS.P0.pSD 1.92394e-06f
Cred_2999 di_tg_ctrl.$407.Metal3 VSS 0.00437116f
Cred_3000 di_tg_ctrl.$407.Metal3 v_a.$2327.Metal3 0.00314348f
Cred_3001 di_tg_ctrl.$407.Metal3 v_a.$2365.Metal3 0.00109059f
Cred_3002 di_tg_ctrl.$407.Metal3 v_a.$2387.Metal3 0.0637814f
Cred_3003 di_tg_ctrl.$407.Metal3 v_a.$2447.Metal3 0.000563607f
Cred_3004 di_tg_ctrl.$407.Metal3 v_a.P12.nSD 0.00053555f
Cred_3005 di_tg_ctrl.$407.Metal3 v_a.P14.nSD 0.00442297f
Cred_3006 di_tg_ctrl.$407.Metal3 v_a.P16.nSD 3.88457e-05f
Cred_3007 di_tg_ctrl.$407.Metal3 v_a.P16.pSD 1.24919e-05f
Cred_3008 di_tg_ctrl.$407.Metal3 v_b.$2541.Metal2 0.00519607f
Cred_3009 di_tg_ctrl.$407.Metal3 v_b.$2601.Metal2 0.00190585f
Cred_3010 di_tg_ctrl.$407.Metal3 v_b.P13.nSD 0.0021472f
Cred_3011 di_tg_ctrl.$407.Metal3 v_b.P15.nSD 0.00228331f
Cred_3012 di_tg_ctrl.$407.Metal3 v_b.P15.pSD 3.83241e-05f
Cred_3013 di_tg_ctrl.$407.Metal3 VSS.$101.Metal1 0.000651308f
Cred_3014 di_tg_ctrl.$407.Metal3 VSS.$113.Metal1 0.00100344f
Cred_3015 di_tg_ctrl.$407.Metal3 VSS.$414.Metal2 2.11891e-05f
Cred_3016 di_tg_ctrl.$407.Metal3 VSS.$422.Metal2 0.00014574f
Cred_3017 di_tg_ctrl.$407.Metal3 VSS.$426.Metal2 0.000132017f
Cred_3018 di_tg_ctrl.$407.Metal3 VSS.$660.Metal3 0.00264276f
Cred_3019 di_tg_ctrl.$407.Metal3 VSS.$664.Metal3 0.0330226f
Cred_3020 di_tg_ctrl.$407.Metal3 VSS.$670.Metal3 0.0189239f
Cred_3021 di_tg_ctrl.$407.Metal3 VSS.P0.pSD 4.27292e-06f
Cred_3022 di_tg_ctrl.$409.Metal3 VSS 0.0038914f
Cred_3023 di_tg_ctrl.$409.Metal3 v_a.$2387.Metal3 0.0292477f
Cred_3024 di_tg_ctrl.$409.Metal3 v_a.$2447.Metal3 0.0280293f
Cred_3025 di_tg_ctrl.$409.Metal3 v_a.P14.nSD 3.66942e-05f
Cred_3026 di_tg_ctrl.$409.Metal3 v_a.P16.nSD 0.00451704f
Cred_3027 di_tg_ctrl.$409.Metal3 v_a.P16.pSD 0.000621247f
Cred_3028 di_tg_ctrl.$409.Metal3 v_b.$2541.Metal2 0.00191468f
Cred_3029 di_tg_ctrl.$409.Metal3 v_b.$2601.Metal2 0.00350896f
Cred_3030 di_tg_ctrl.$409.Metal3 v_b.P15.nSD 0.00228505f
Cred_3031 di_tg_ctrl.$409.Metal3 v_b.P15.pSD 3.85017e-05f
Cred_3032 di_tg_ctrl.$409.Metal3 v_b.P17.nSD 0.00106505f
Cred_3033 di_tg_ctrl.$409.Metal3 VSS.$101.Metal1 0.000132823f
Cred_3034 di_tg_ctrl.$409.Metal3 VSS.$113.Metal1 0.0015653f
Cred_3035 di_tg_ctrl.$409.Metal3 VSS.$123.Metal1 0.000101103f
Cred_3036 di_tg_ctrl.$409.Metal3 VSS.$422.Metal2 2.07848e-05f
Cred_3037 di_tg_ctrl.$409.Metal3 VSS.$426.Metal2 0.000107277f
Cred_3038 di_tg_ctrl.$409.Metal3 VSS.$434.Metal2 0.000179534f
Cred_3039 di_tg_ctrl.$409.Metal3 VSS.$664.Metal3 0.00246457f
Cred_3040 di_tg_ctrl.$409.Metal3 VSS.$670.Metal3 0.030726f
Cred_3041 di_tg_ctrl.$409.Metal3 VSS.$674.Metal3 0.0105126f
Cred_3042 di_tg_ctrl.$409.Metal3 VSS.P0.pSD 1.85743e-06f
Cred_3043 di_tg_ctrl.$413.Metal3 VSS 0.00368309f
Cred_3044 di_tg_ctrl.$413.Metal3 v_a.$2387.Metal3 0.00509467f
Cred_3045 di_tg_ctrl.$413.Metal3 v_a.$2447.Metal3 0.0482312f
Cred_3046 di_tg_ctrl.$413.Metal3 v_a.$2485.Metal3 1.95642e-06f
Cred_3047 di_tg_ctrl.$413.Metal3 v_a.$2507.Metal3 5.63909e-06f
Cred_3048 di_tg_ctrl.$413.Metal3 v_a.P14.nSD 4.14442e-07f
Cred_3049 di_tg_ctrl.$413.Metal3 v_a.P16.nSD 0.000758319f
Cred_3050 di_tg_ctrl.$413.Metal3 v_a.P16.pSD 0.000112799f
Cred_3051 di_tg_ctrl.$413.Metal3 v_a.P18.nSD 0.0031465f
Cred_3052 di_tg_ctrl.$413.Metal3 v_a.P20.nSD 1.06171e-06f
Cred_3053 di_tg_ctrl.$413.Metal3 v_b.$2601.Metal2 0.00496803f
Cred_3054 di_tg_ctrl.$413.Metal3 v_b.$2631.Metal2 2.14252e-05f
Cred_3055 di_tg_ctrl.$413.Metal3 v_b.P17.nSD 0.00328217f
Cred_3056 di_tg_ctrl.$413.Metal3 v_b.P19.nSD 8.99084e-06f
Cred_3057 di_tg_ctrl.$413.Metal3 VSS.$113.Metal1 1.17011e-06f
Cred_3058 di_tg_ctrl.$413.Metal3 VSS.$123.Metal1 0.000294472f
Cred_3059 di_tg_ctrl.$413.Metal3 VSS.$135.Metal1 0.00026707f
Cred_3060 di_tg_ctrl.$413.Metal3 VSS.$17.Metal1 3.10659e-10f
Cred_3061 di_tg_ctrl.$413.Metal3 VSS.$301.Metal1 3.03366e-11f
Cred_3062 di_tg_ctrl.$413.Metal3 VSS.$434.Metal2 9.46581e-05f
Cred_3063 di_tg_ctrl.$413.Metal3 VSS.$442.Metal2 0.000203335f
Cred_3064 di_tg_ctrl.$413.Metal3 VSS.$446.Metal2 5.68486e-05f
Cred_3065 di_tg_ctrl.$413.Metal3 VSS.$606.Metal2 3.20541e-12f
Cred_3066 di_tg_ctrl.$413.Metal3 VSS.$670.Metal3 0.00403642f
Cred_3067 di_tg_ctrl.$413.Metal3 VSS.$674.Metal3 0.0350812f
Cred_3068 di_tg_ctrl.$413.Metal3 VSS.$680.Metal3 0.0068334f
Cred_3069 di_tg_ctrl.$413.Metal3 VSS.$760.Metal3 1.8966e-13f
Cred_3070 di_tg_ctrl.$413.Metal3 VSS.P0.pSD 1.60316e-06f
Cred_3071 di_tg_ctrl.$417.Metal3 VSS 0.00306272f
Cred_3072 di_tg_ctrl.$417.Metal3 v_a.$2447.Metal3 0.0255145f
Cred_3073 di_tg_ctrl.$417.Metal3 v_a.$2485.Metal3 0.000358139f
Cred_3074 di_tg_ctrl.$417.Metal3 v_a.$2507.Metal3 0.00103228f
Cred_3075 di_tg_ctrl.$417.Metal3 v_a.P18.nSD 0.00174191f
Cred_3076 di_tg_ctrl.$417.Metal3 v_a.P20.nSD 8.12697e-05f
Cred_3077 di_tg_ctrl.$417.Metal3 v_b.$2631.Metal2 0.00787239f
Cred_3078 di_tg_ctrl.$417.Metal3 v_b.P19.nSD 0.00459125f
Cred_3079 di_tg_ctrl.$417.Metal3 VSS.$123.Metal1 0.000545674f
Cred_3080 di_tg_ctrl.$417.Metal3 VSS.$135.Metal1 0.0012149f
Cred_3081 di_tg_ctrl.$417.Metal3 VSS.$442.Metal2 9.47818e-05f
Cred_3082 di_tg_ctrl.$417.Metal3 VSS.$446.Metal2 0.000126258f
Cred_3083 di_tg_ctrl.$417.Metal3 VSS.$674.Metal3 0.0113096f
Cred_3084 di_tg_ctrl.$417.Metal3 VSS.$680.Metal3 0.0214622f
Cred_3085 di_tg_ctrl.$417.Metal3 VSS.P0.pSD 4.08869e-06f
Cred_3086 di_tg_ctrl.$419.Metal3 VSS 0.0027636f
Cred_3087 di_tg_ctrl.$419.Metal3 v_a.$2447.Metal3 0.0237926f
Cred_3088 di_tg_ctrl.$419.Metal3 v_a.$2485.Metal3 0.00825458f
Cred_3089 di_tg_ctrl.$419.Metal3 v_a.$2507.Metal3 0.0238377f
Cred_3090 di_tg_ctrl.$419.Metal3 v_a.P20.nSD 0.00448436f
Cred_3091 di_tg_ctrl.$419.Metal3 v_b.$2631.Metal2 0.00090471f
Cred_3092 di_tg_ctrl.$419.Metal3 v_b.$2691.Metal2 0.000887645f
Cred_3093 di_tg_ctrl.$419.Metal3 v_b.P19.nSD 1.55864e-06f
Cred_3094 di_tg_ctrl.$419.Metal3 v_b.P21.nSD 0.00113698f
Cred_3095 di_tg_ctrl.$419.Metal3 v_b.P21.pSD 1.78494e-05f
Cred_3096 di_tg_ctrl.$419.Metal3 VSS.$135.Metal1 0.00106906f
Cred_3097 di_tg_ctrl.$419.Metal3 VSS.$145.Metal1 8.3951e-05f
Cred_3098 di_tg_ctrl.$419.Metal3 VSS.$153.Metal1 1.61541e-10f
Cred_3099 di_tg_ctrl.$419.Metal3 VSS.$446.Metal2 6.59181e-05f
Cred_3100 di_tg_ctrl.$419.Metal3 VSS.$454.Metal2 0.000180244f
Cred_3101 di_tg_ctrl.$419.Metal3 VSS.$462.Metal2 8.14814e-08f
Cred_3102 di_tg_ctrl.$419.Metal3 VSS.$470.Metal2 4.03761e-08f
Cred_3103 di_tg_ctrl.$419.Metal3 VSS.$680.Metal3 0.0232672f
Cred_3104 di_tg_ctrl.$419.Metal3 VSS.$684.Metal3 0.0106048f
Cred_3105 di_tg_ctrl.$419.Metal3 VSS.$692.Metal3 2.52293e-06f
Cred_3106 di_tg_ctrl.$419.Metal3 VSS.P0.pSD 5.28125e-07f
Cred_3107 di_tg_ctrl.$42.GatPoly VSS 0.0419427f
Cred_3108 di_tg_ctrl.$42.GatPoly v_a.$2387.Metal3 0.00159706f
Cred_3109 di_tg_ctrl.$42.GatPoly v_a.$2447.Metal3 0.00159706f
Cred_3110 di_tg_ctrl.$42.GatPoly v_a.P16.nSD 0.00436903f
Cred_3111 di_tg_ctrl.$42.GatPoly v_a.P16.pSD 3.53976e-05f
Cred_3112 di_tg_ctrl.$42.GatPoly v_b.$2601.Metal2 0.00424469f
Cred_3113 di_tg_ctrl.$42.GatPoly v_b.P17.nSD 0.00393405f
Cred_3114 di_tg_ctrl.$42.GatPoly VSS.$113.Metal1 0.00205496f
Cred_3115 di_tg_ctrl.$42.GatPoly VSS.$123.Metal1 0.00337803f
Cred_3116 di_tg_ctrl.$42.GatPoly VSS.$17.Metal1 1.12964e-07f
Cred_3117 di_tg_ctrl.$42.GatPoly VSS.$301.Metal1 7.84436e-09f
Cred_3118 di_tg_ctrl.$42.GatPoly VSS.$434.Metal2 1.19834e-05f
Cred_3119 di_tg_ctrl.$42.GatPoly VSS.$606.Metal2 8.28847e-10f
Cred_3120 di_tg_ctrl.$42.GatPoly VSS.$760.Metal3 4.90418e-11f
Cred_3121 di_tg_ctrl.$42.GatPoly VSS.P0.pSD 9.98695e-06f
Cred_3122 di_tg_ctrl.$423.Metal3 di_tg_ctrl_n.$354.Metal2 2.9676e-09f
Cred_3123 di_tg_ctrl.$423.Metal3 di_tg_ctrl_n.$443.Metal3 6.38206e-07f
Cred_3124 di_tg_ctrl.$423.Metal3 di_tg_ctrl_n.$447.Metal3 3.12376e-07f
Cred_3125 di_tg_ctrl.$423.Metal3 di_tg_ctrl_n.$488.Metal4 8.22019e-06f
Cred_3126 di_tg_ctrl.$423.Metal3 VSS 0.00477842f
Cred_3127 di_tg_ctrl.$423.Metal3 v_a.$2447.Metal3 0.00419301f
Cred_3128 di_tg_ctrl.$423.Metal3 v_a.$2485.Metal3 0.00145472f
Cred_3129 di_tg_ctrl.$423.Metal3 v_a.$2507.Metal3 0.0571248f
Cred_3130 di_tg_ctrl.$423.Metal3 v_a.$2545.Metal3 0.000118733f
Cred_3131 di_tg_ctrl.$423.Metal3 v_a.$2567.Metal3 0.000342232f
Cred_3132 di_tg_ctrl.$423.Metal3 v_a.P20.nSD 0.0007085f
Cred_3133 di_tg_ctrl.$423.Metal3 v_a.P22.nSD 0.00380963f
Cred_3134 di_tg_ctrl.$423.Metal3 v_a.P24.nSD 2.68658e-05f
Cred_3135 di_tg_ctrl.$423.Metal3 v_b.$2631.Metal2 0.00240855f
Cred_3136 di_tg_ctrl.$423.Metal3 v_b.$2691.Metal2 0.00503945f
Cred_3137 di_tg_ctrl.$423.Metal3 v_b.P21.nSD 0.00333913f
Cred_3138 di_tg_ctrl.$423.Metal3 v_b.P21.pSD 4.84328e-05f
Cred_3139 di_tg_ctrl.$423.Metal3 v_b.P23.nSD 0.00148771f
Cred_3140 di_tg_ctrl.$423.Metal3 VSS.$135.Metal1 1.26298e-06f
Cred_3141 di_tg_ctrl.$423.Metal3 VSS.$145.Metal1 0.000219655f
Cred_3142 di_tg_ctrl.$423.Metal3 VSS.$153.Metal1 0.000874179f
Cred_3143 di_tg_ctrl.$423.Metal3 VSS.$163.Metal1 5.7176e-05f
Cred_3144 di_tg_ctrl.$423.Metal3 VSS.$17.Metal1 2.33264e-10f
Cred_3145 di_tg_ctrl.$423.Metal3 VSS.$301.Metal1 6.30313e-11f
Cred_3146 di_tg_ctrl.$423.Metal3 VSS.$454.Metal2 9.54353e-05f
Cred_3147 di_tg_ctrl.$423.Metal3 VSS.$462.Metal2 0.00033089f
Cred_3148 di_tg_ctrl.$423.Metal3 VSS.$470.Metal2 0.000154266f
Cred_3149 di_tg_ctrl.$423.Metal3 VSS.$606.Metal2 6.65998e-12f
Cred_3150 di_tg_ctrl.$423.Metal3 VSS.$680.Metal3 0.00413277f
Cred_3151 di_tg_ctrl.$423.Metal3 VSS.$684.Metal3 0.0415804f
Cred_3152 di_tg_ctrl.$423.Metal3 VSS.$692.Metal3 0.0101246f
Cred_3153 di_tg_ctrl.$423.Metal3 VSS.$760.Metal3 3.94062e-13f
Cred_3154 di_tg_ctrl.$423.Metal3 VSS.P0.pSD 1.19739e-06f
Cred_3155 di_tg_ctrl.$429.Metal3 di_tg_ctrl_n.$354.Metal2 6.04849e-09f
Cred_3156 di_tg_ctrl.$429.Metal3 di_tg_ctrl_n.$443.Metal3 1.30078e-06f
Cred_3157 di_tg_ctrl.$429.Metal3 di_tg_ctrl_n.$447.Metal3 6.36679e-07f
Cred_3158 di_tg_ctrl.$429.Metal3 di_tg_ctrl_n.$488.Metal4 1.67542e-05f
Cred_3159 di_tg_ctrl.$429.Metal3 VSS 0.00531323f
Cred_3160 di_tg_ctrl.$429.Metal3 v_a.$2507.Metal3 0.0420028f
Cred_3161 di_tg_ctrl.$429.Metal3 v_a.$2545.Metal3 0.00915756f
Cred_3162 di_tg_ctrl.$429.Metal3 v_a.$2567.Metal3 0.033882f
Cred_3163 di_tg_ctrl.$429.Metal3 v_a.P22.nSD 0.0011214f
Cred_3164 di_tg_ctrl.$429.Metal3 v_a.P24.nSD 0.00486768f
Cred_3165 di_tg_ctrl.$429.Metal3 v_a.P26.nSD 0.000527631f
Cred_3166 di_tg_ctrl.$429.Metal3 v_b.$2691.Metal2 0.00704875f
Cred_3167 di_tg_ctrl.$429.Metal3 v_b.$2751.Metal2 0.00167032f
Cred_3168 di_tg_ctrl.$429.Metal3 v_b.P23.nSD 0.0030337f
Cred_3169 di_tg_ctrl.$429.Metal3 v_b.P25.nSD 0.00218334f
Cred_3170 di_tg_ctrl.$429.Metal3 v_b.P25.pSD 3.35879e-05f
Cred_3171 di_tg_ctrl.$429.Metal3 VSS.$145.Metal1 9.55662e-05f
Cred_3172 di_tg_ctrl.$429.Metal3 VSS.$153.Metal1 0.00143237f
Cred_3173 di_tg_ctrl.$429.Metal3 VSS.$163.Metal1 0.000740417f
Cred_3174 di_tg_ctrl.$429.Metal3 VSS.$462.Metal2 0.000216267f
Cred_3175 di_tg_ctrl.$429.Metal3 VSS.$470.Metal2 0.000443044f
Cred_3176 di_tg_ctrl.$429.Metal3 VSS.$478.Metal2 9.33276e-05f
Cred_3177 di_tg_ctrl.$429.Metal3 VSS.$482.Metal2 5.50758e-05f
Cred_3178 di_tg_ctrl.$429.Metal3 VSS.$486.Metal2 2.7428e-05f
Cred_3179 di_tg_ctrl.$429.Metal3 VSS.$684.Metal3 0.014708f
Cred_3180 di_tg_ctrl.$429.Metal3 VSS.$692.Metal3 0.048192f
Cred_3181 di_tg_ctrl.$429.Metal3 VSS.$700.Metal3 0.00342089f
Cred_3182 di_tg_ctrl.$429.Metal3 VSS.P0.pSD 2.50902e-06f
Cred_3183 di_tg_ctrl.$432.Metal3 VSS 0.00440963f
Cred_3184 di_tg_ctrl.$432.Metal3 v_a.$2507.Metal3 0.00269667f
Cred_3185 di_tg_ctrl.$432.Metal3 v_a.$2545.Metal3 0.00093558f
Cred_3186 di_tg_ctrl.$432.Metal3 v_a.$2567.Metal3 0.061973f
Cred_3187 di_tg_ctrl.$432.Metal3 v_a.$2597.Metal3 0.00131651f
Cred_3188 di_tg_ctrl.$432.Metal3 v_a.P24.nSD 0.000449678f
Cred_3189 di_tg_ctrl.$432.Metal3 v_a.P26.nSD 0.00445863f
Cred_3190 di_tg_ctrl.$432.Metal3 v_a.P28.nSD 3.88271e-05f
Cred_3191 di_tg_ctrl.$432.Metal3 v_b.$2691.Metal2 0.00146851f
Cred_3192 di_tg_ctrl.$432.Metal3 v_b.$2751.Metal2 0.00544103f
Cred_3193 di_tg_ctrl.$432.Metal3 v_b.P25.nSD 0.00211048f
Cred_3194 di_tg_ctrl.$432.Metal3 v_b.P25.pSD 2.95297e-05f
Cred_3195 di_tg_ctrl.$432.Metal3 v_b.P27.nSD 0.00218427f
Cred_3196 di_tg_ctrl.$432.Metal3 VSS 0.00102299f
Cred_3197 di_tg_ctrl.$432.Metal3 VSS.$177.Metal1 0.000825658f
Cred_3198 di_tg_ctrl.$432.Metal3 VSS.$478.Metal2 0.000184547f
Cred_3199 di_tg_ctrl.$432.Metal3 VSS.$482.Metal2 0.000400284f
Cred_3200 di_tg_ctrl.$432.Metal3 VSS.$486.Metal2 0.000248864f
Cred_3201 di_tg_ctrl.$432.Metal3 VSS.$692.Metal3 0.0284539f
Cred_3202 di_tg_ctrl.$432.Metal3 VSS.$700.Metal3 0.0267781f
Cred_3203 di_tg_ctrl.$432.Metal3 VSS.P0.pSD 2.99797e-06f
Cred_3204 di_tg_ctrl.$434.Metal3 di_tg_ctrl_n.$354.Metal2 5.97172e-07f
Cred_3205 di_tg_ctrl.$434.Metal3 di_tg_ctrl_n.$443.Metal3 0.000128427f
Cred_3206 di_tg_ctrl.$434.Metal3 di_tg_ctrl_n.$447.Metal3 6.28598e-05f
Cred_3207 di_tg_ctrl.$434.Metal3 di_tg_ctrl_n.$488.Metal4 0.00165416f
Cred_3208 di_tg_ctrl.$434.Metal3 VSS 0.00435747f
Cred_3209 di_tg_ctrl.$434.Metal3 v_a.$2567.Metal3 0.00103031f
Cred_3210 di_tg_ctrl.$434.Metal3 v_a.$2597.Metal3 0.0651001f
Cred_3211 di_tg_ctrl.$434.Metal3 v_a.$2635.Metal3 0.0011899f
Cred_3212 di_tg_ctrl.$434.Metal3 v_a.$2657.Metal3 0.0034297f
Cred_3213 di_tg_ctrl.$434.Metal3 v_a.P26.nSD 3.03864e-05f
Cred_3214 di_tg_ctrl.$434.Metal3 v_a.P28.nSD 0.00451377f
Cred_3215 di_tg_ctrl.$434.Metal3 v_a.P30.nSD 0.000594117f
Cred_3216 di_tg_ctrl.$434.Metal3 v_b.$2751.Metal2 0.00609972f
Cred_3217 di_tg_ctrl.$434.Metal3 v_b.$2811.Metal2 0.00214689f
Cred_3218 di_tg_ctrl.$434.Metal3 v_b.P27.nSD 0.00218247f
Cred_3219 di_tg_ctrl.$434.Metal3 v_b.P29.nSD 0.00235539f
Cred_3220 di_tg_ctrl.$434.Metal3 v_b.P29.pSD 4.31712e-05f
Cred_3221 di_tg_ctrl.$434.Metal3 VSS 0.000196479f
Cred_3222 di_tg_ctrl.$434.Metal3 VSS.$177.Metal1 0.00046382f
Cred_3223 di_tg_ctrl.$434.Metal3 VSS.$191.Metal1 0.000279361f
Cred_3224 di_tg_ctrl.$434.Metal3 VSS.$478.Metal2 1.50933e-05f
Cred_3225 di_tg_ctrl.$434.Metal3 VSS.$482.Metal2 3.09357e-05f
Cred_3226 di_tg_ctrl.$434.Metal3 VSS.$486.Metal2 4.79141e-05f
Cred_3227 di_tg_ctrl.$434.Metal3 VSS.$494.Metal2 0.000118015f
Cred_3228 di_tg_ctrl.$434.Metal3 VSS.$498.Metal2 9.68016e-05f
Cred_3229 di_tg_ctrl.$434.Metal3 VSS.$692.Metal3 0.00188248f
Cred_3230 di_tg_ctrl.$434.Metal3 VSS.$700.Metal3 0.0403278f
Cred_3231 di_tg_ctrl.$434.Metal3 VSS.$706.Metal3 0.0140902f
Cred_3232 di_tg_ctrl.$434.Metal3 VSS.P0.pSD 1.51799e-06f
Cred_3233 di_tg_ctrl.$437.Metal3 di_tg_ctrl_n.$223.Metal1 1.08679e-05f
Cred_3234 di_tg_ctrl.$437.Metal3 di_tg_ctrl_n.$352.Metal2 0.000577495f
Cred_3235 di_tg_ctrl.$437.Metal3 di_tg_ctrl_n.$354.Metal2 2.95763e-07f
Cred_3236 di_tg_ctrl.$437.Metal3 di_tg_ctrl_n.$443.Metal3 0.00903571f
Cred_3237 di_tg_ctrl.$437.Metal3 di_tg_ctrl_n.$447.Metal3 3.11327e-05f
Cred_3238 di_tg_ctrl.$437.Metal3 di_tg_ctrl_n.$488.Metal4 0.000819259f
Cred_3239 di_tg_ctrl.$437.Metal3 di_tg_ctrl_n.$86.GatPoly 5.84469e-08f
Cred_3240 di_tg_ctrl.$437.Metal3 VSS 0.0111048f
Cred_3241 di_tg_ctrl.$437.Metal3 v_a.$2597.Metal3 0.0315015f
Cred_3242 di_tg_ctrl.$437.Metal3 v_a.$2635.Metal3 0.00884683f
Cred_3243 di_tg_ctrl.$437.Metal3 v_a.$2657.Metal3 0.125925f
Cred_3244 di_tg_ctrl.$437.Metal3 v_a.P28.nSD 0.000398618f
Cred_3245 di_tg_ctrl.$437.Metal3 v_a.P30.nSD 0.00464096f
Cred_3246 di_tg_ctrl.$437.Metal3 v_a.P32.nSD 0.00441612f
Cred_3247 di_tg_ctrl.$437.Metal3 v_a.P34.nSD 0.00516537f
Cred_3248 di_tg_ctrl.$437.Metal3 v_a.P34.pSD 0.000604143f
Cred_3249 di_tg_ctrl.$437.Metal3 v_b.$2751.Metal2 0.0016291f
Cred_3250 di_tg_ctrl.$437.Metal3 v_b.$2811.Metal2 0.0127906f
Cred_3251 di_tg_ctrl.$437.Metal3 v_b.$2871.Metal2 0.00375577f
Cred_3252 di_tg_ctrl.$437.Metal3 v_b.P29.nSD 0.00216846f
Cred_3253 di_tg_ctrl.$437.Metal3 v_b.P29.pSD 3.27591e-05f
Cred_3254 di_tg_ctrl.$437.Metal3 v_b.P31.nSD 0.00392954f
Cred_3255 di_tg_ctrl.$437.Metal3 v_b.P33.nSD 0.00428747f
Cred_3256 di_tg_ctrl.$437.Metal3 v_b.P33.pSD 7.55237e-05f
Cred_3257 di_tg_ctrl.$437.Metal3 VSS.$177.Metal1 0.000101991f
Cred_3258 di_tg_ctrl.$437.Metal3 VSS.$191.Metal1 0.0023442f
Cred_3259 di_tg_ctrl.$437.Metal3 VSS.$205.Metal1 0.000956447f
Cred_3260 di_tg_ctrl.$437.Metal3 VSS.$213.Metal1 0.000940052f
Cred_3261 di_tg_ctrl.$437.Metal3 VSS.$221.Metal1 8.53703e-06f
Cred_3262 di_tg_ctrl.$437.Metal3 VSS.$494.Metal2 6.25138e-05f
Cred_3263 di_tg_ctrl.$437.Metal3 VSS.$498.Metal2 0.000146988f
Cred_3264 di_tg_ctrl.$437.Metal3 VSS.$506.Metal2 0.00029427f
Cred_3265 di_tg_ctrl.$437.Metal3 VSS.$510.Metal2 0.000367334f
Cred_3266 di_tg_ctrl.$437.Metal3 VSS.$518.Metal2 0.00140036f
Cred_3267 di_tg_ctrl.$437.Metal3 VSS.$526.Metal2 0.000366809f
Cred_3268 di_tg_ctrl.$437.Metal3 VSS.$700.Metal3 0.00769879f
Cred_3269 di_tg_ctrl.$437.Metal3 VSS.$706.Metal3 0.0507544f
Cred_3270 di_tg_ctrl.$437.Metal3 VSS.$712.Metal3 0.0500072f
Cred_3271 di_tg_ctrl.$437.Metal3 VSS.$716.Metal3 0.0242958f
Cred_3272 di_tg_ctrl.$437.Metal3 VSS.P0.pSD 7.37592e-06f
Cred_3273 di_tg_ctrl.$44.GatPoly VSS 0.0389033f
Cred_3274 di_tg_ctrl.$44.GatPoly v_a.$2447.Metal3 0.00438796f
Cred_3275 di_tg_ctrl.$44.GatPoly v_a.P18.nSD 0.00589247f
Cred_3276 di_tg_ctrl.$44.GatPoly v_b.$2601.Metal2 0.00458478f
Cred_3277 di_tg_ctrl.$44.GatPoly v_b.$2631.Metal2 0.00048301f
Cred_3278 di_tg_ctrl.$44.GatPoly v_b.P17.nSD 0.00424405f
Cred_3279 di_tg_ctrl.$44.GatPoly v_b.P19.nSD 0.000448854f
Cred_3280 di_tg_ctrl.$44.GatPoly VSS.$123.Metal1 0.00334591f
Cred_3281 di_tg_ctrl.$44.GatPoly VSS.$135.Metal1 0.00063145f
Cred_3282 di_tg_ctrl.$44.GatPoly VSS.$442.Metal2 9.79003e-06f
Cred_3283 di_tg_ctrl.$44.GatPoly VSS.$446.Metal2 4.87025e-06f
Cred_3284 di_tg_ctrl.$44.GatPoly VSS.P0.pSD 4.54105e-06f
Cred_3285 di_tg_ctrl.$446.Metal3 di_tg_ctrl_n.$204.Metal1 5.77911e-06f
Cred_3286 di_tg_ctrl.$446.Metal3 di_tg_ctrl_n.$216.Metal1 1.97817e-05f
Cred_3287 di_tg_ctrl.$446.Metal3 di_tg_ctrl_n.$219.Metal1 3.11211e-05f
Cred_3288 di_tg_ctrl.$446.Metal3 di_tg_ctrl_n.$320.Metal2 8.77948e-09f
Cred_3289 di_tg_ctrl.$446.Metal3 di_tg_ctrl_n.$322.Metal2 1.78942e-08f
Cred_3290 di_tg_ctrl.$446.Metal3 di_tg_ctrl_n.$336.Metal2 2.33611e-06f
Cred_3291 di_tg_ctrl.$446.Metal3 di_tg_ctrl_n.$338.Metal2 1.15701e-06f
Cred_3292 di_tg_ctrl.$446.Metal3 di_tg_ctrl_n.$342.Metal2 0.000156595f
Cred_3293 di_tg_ctrl.$446.Metal3 di_tg_ctrl_n.$344.Metal2 0.00135242f
Cred_3294 di_tg_ctrl.$446.Metal3 di_tg_ctrl_n.$423.Metal3 4.599e-07f
Cred_3295 di_tg_ctrl.$446.Metal3 di_tg_ctrl_n.$429.Metal3 9.3736e-07f
Cred_3296 di_tg_ctrl.$446.Metal3 di_tg_ctrl_n.$434.Metal3 0.000122374f
Cred_3297 di_tg_ctrl.$446.Metal3 di_tg_ctrl_n.$437.Metal3 0.00826363f
Cred_3298 di_tg_ctrl.$446.Metal3 di_tg_ctrl_n.$483.Metal4 7.59968e-05f
Cred_3299 di_tg_ctrl.$446.Metal3 di_tg_ctrl_n.$69.GatPoly 1.45692e-05f
Cred_3300 di_tg_ctrl.$446.Metal3 di_tg_ctrl_n.$72.GatPoly 1.08628e-05f
Cred_3301 di_tg_ctrl.$446.Metal3 di_tg_ctrl_n.P47.GatPoly 8.5494e-08f
Cred_3302 di_tg_ctrl.$446.Metal3 VSS 0.000721703f
Cred_3303 di_tg_ctrl.$446.Metal3 v_a.$2657.Metal3 4.51305e-05f
Cred_3304 di_tg_ctrl.$446.Metal3 v_a.P34.nSD 2.96763e-07f
Cred_3305 di_tg_ctrl.$446.Metal3 v_a.P34.pSD 3.46487e-05f
Cred_3306 di_tg_ctrl.$446.Metal3 v_b.$2962.Metal2 0.00370389f
Cred_3307 di_tg_ctrl.$446.Metal3 v_b.$3056.Metal2 0.00179451f
Cred_3308 di_tg_ctrl.$446.Metal3 v_b.$3779.Metal3 0.0261085f
Cred_3309 di_tg_ctrl.$446.Metal3 v_b.$3785.Metal3 0.0395676f
Cred_3310 di_tg_ctrl.$446.Metal3 v_b.$3821.Metal3 4.0399e-05f
Cred_3311 di_tg_ctrl.$446.Metal3 v_b.P37.nSD 3.12147e-05f
Cred_3312 di_tg_ctrl.$446.Metal3 v_b.P37.pSD 0.0193255f
Cred_3313 di_tg_ctrl.$446.Metal3 v_b.P39.pSD 0.0107543f
Cred_3314 di_tg_ctrl.$446.Metal3 v_b.P41.pSD 0.0237587f
Cred_3315 di_tg_ctrl.$446.Metal3 v_b.P43.pSD 0.00413408f
Cred_3316 di_tg_ctrl.$446.Metal3 v_b.P45.pSD 2.10443e-05f
Cred_3317 di_tg_ctrl.$446.Metal3 VDD.$238.Metal1 0.000576506f
Cred_3318 di_tg_ctrl.$446.Metal3 VDD.$247.Metal1 0.00156173f
Cred_3319 di_tg_ctrl.$446.Metal3 VDD.$251.Metal1 0.000198204f
Cred_3320 di_tg_ctrl.$446.Metal3 VDD.$263.Metal1 0.000338548f
Cred_3321 di_tg_ctrl.$446.Metal3 VDD.$560.Metal2 0.000174631f
Cred_3322 di_tg_ctrl.$446.Metal3 VDD.$568.Metal2 0.000292281f
Cred_3323 di_tg_ctrl.$446.Metal3 VDD.$576.Metal2 0.000327264f
Cred_3324 di_tg_ctrl.$446.Metal3 VDD.$580.Metal2 1.98173e-06f
Cred_3325 di_tg_ctrl.$446.Metal3 VDD.$584.Metal2 1.11159e-07f
Cred_3326 di_tg_ctrl.$446.Metal3 VDD.$588.Metal2 5.53575e-08f
Cred_3327 di_tg_ctrl.$446.Metal3 VDD.$750.Metal3 0.010912f
Cred_3328 di_tg_ctrl.$446.Metal3 VDD.$758.Metal3 0.0637795f
Cred_3329 di_tg_ctrl.$446.Metal3 VDD.$762.Metal3 0.0260444f
Cred_3330 di_tg_ctrl.$446.Metal3 VDD.$768.Metal3 6.90434e-06f
Cred_3331 di_tg_ctrl.$446.Metal3 VDD.P0.nSD 1.84907e-06f
Cred_3332 di_tg_ctrl.$450.Metal3 di_tg_ctrl_n.$471.Metal4 5.89929e-06f
Cred_3333 di_tg_ctrl.$450.Metal3 di_tg_ctrl_n.$491.Metal4 3.08737e-05f
Cred_3334 di_tg_ctrl.$450.Metal3 VSS 0.000349127f
Cred_3335 di_tg_ctrl.$450.Metal3 v_b.$3056.Metal2 0.0018172f
Cred_3336 di_tg_ctrl.$450.Metal3 v_b.$3153.Metal2 0.00123384f
Cred_3337 di_tg_ctrl.$450.Metal3 v_b.$3785.Metal3 0.00236413f
Cred_3338 di_tg_ctrl.$450.Metal3 v_b.$3821.Metal3 0.0342609f
Cred_3339 di_tg_ctrl.$450.Metal3 v_b.$3857.Metal3 0.000524997f
Cred_3340 di_tg_ctrl.$450.Metal3 v_b.$3890.Metal3 0.000551247f
Cred_3341 di_tg_ctrl.$450.Metal3 v_b.P41.pSD 0.00141219f
Cred_3342 di_tg_ctrl.$450.Metal3 v_b.P43.pSD 0.00686379f
Cred_3343 di_tg_ctrl.$450.Metal3 v_b.P45.pSD 0.0205013f
Cred_3344 di_tg_ctrl.$450.Metal3 v_b.P47.pSD 0.00442341f
Cred_3345 di_tg_ctrl.$450.Metal3 v_b.P49.nSD 9.7481e-07f
Cred_3346 di_tg_ctrl.$450.Metal3 v_b.P49.pSD 0.000644653f
Cred_3347 di_tg_ctrl.$450.Metal3 VDD.$251.Metal1 0.000165375f
Cred_3348 di_tg_ctrl.$450.Metal3 VDD.$263.Metal1 0.00206542f
Cred_3349 di_tg_ctrl.$450.Metal3 VDD.$269.Metal1 0.000737621f
Cred_3350 di_tg_ctrl.$450.Metal3 VDD.$576.Metal2 6.423e-06f
Cred_3351 di_tg_ctrl.$450.Metal3 VDD.$580.Metal2 2.69742e-05f
Cred_3352 di_tg_ctrl.$450.Metal3 VDD.$584.Metal2 0.000397559f
Cred_3353 di_tg_ctrl.$450.Metal3 VDD.$588.Metal2 0.000162745f
Cred_3354 di_tg_ctrl.$450.Metal3 VDD.$596.Metal2 1.68348e-07f
Cred_3355 di_tg_ctrl.$450.Metal3 VDD.$600.Metal2 1.11487e-07f
Cred_3356 di_tg_ctrl.$450.Metal3 VDD.$604.Metal2 5.55211e-08f
Cred_3357 di_tg_ctrl.$450.Metal3 VDD.$758.Metal3 0.000719648f
Cred_3358 di_tg_ctrl.$450.Metal3 VDD.$762.Metal3 0.0393282f
Cred_3359 di_tg_ctrl.$450.Metal3 VDD.$768.Metal3 0.0280409f
Cred_3360 di_tg_ctrl.$450.Metal3 VDD.$776.Metal3 6.92475e-06f
Cred_3361 di_tg_ctrl.$450.Metal3 VDD.P0.nSD 1.54375e-06f
Cred_3362 di_tg_ctrl.$456.Metal3 di_tg_ctrl_n.$471.Metal4 4.14561e-05f
Cred_3363 di_tg_ctrl.$456.Metal3 di_tg_ctrl_n.$491.Metal4 0.000216959f
Cred_3364 di_tg_ctrl.$456.Metal3 VSS 0.000629929f
Cred_3365 di_tg_ctrl.$456.Metal3 v_b.$3153.Metal2 0.00256249f
Cred_3366 di_tg_ctrl.$456.Metal3 v_b.$3247.Metal2 0.00186517f
Cred_3367 di_tg_ctrl.$456.Metal3 v_b.$3821.Metal3 0.00706913f
Cred_3368 di_tg_ctrl.$456.Metal3 v_b.$3857.Metal3 0.0194272f
Cred_3369 di_tg_ctrl.$456.Metal3 v_b.$3890.Metal3 0.0203986f
Cred_3370 di_tg_ctrl.$456.Metal3 v_b.P45.pSD 0.00422267f
Cred_3371 di_tg_ctrl.$456.Metal3 v_b.P47.pSD 0.00666681f
Cred_3372 di_tg_ctrl.$456.Metal3 v_b.P49.nSD 3.60723e-05f
Cred_3373 di_tg_ctrl.$456.Metal3 v_b.P49.pSD 0.0240518f
Cred_3374 di_tg_ctrl.$456.Metal3 v_b.P51.pSD 0.00422838f
Cred_3375 di_tg_ctrl.$456.Metal3 VDD.$263.Metal1 0.000203344f
Cred_3376 di_tg_ctrl.$456.Metal3 VDD.$269.Metal1 0.00086336f
Cred_3377 di_tg_ctrl.$456.Metal3 VDD.$273.Metal1 0.000205518f
Cred_3378 di_tg_ctrl.$456.Metal3 VDD.$283.Metal1 0.000354325f
Cred_3379 di_tg_ctrl.$456.Metal3 VDD.$584.Metal2 3.07794e-05f
Cred_3380 di_tg_ctrl.$456.Metal3 VDD.$588.Metal2 6.76788e-05f
Cred_3381 di_tg_ctrl.$456.Metal3 VDD.$596.Metal2 0.000426052f
Cred_3382 di_tg_ctrl.$456.Metal3 VDD.$600.Metal2 0.000204113f
Cred_3383 di_tg_ctrl.$456.Metal3 VDD.$604.Metal2 0.0001006f
Cred_3384 di_tg_ctrl.$456.Metal3 VDD.$762.Metal3 0.00383412f
Cred_3385 di_tg_ctrl.$456.Metal3 VDD.$768.Metal3 0.0520789f
Cred_3386 di_tg_ctrl.$456.Metal3 VDD.$776.Metal3 0.0125471f
Cred_3387 di_tg_ctrl.$456.Metal3 VDD.P0.nSD 1.25963e-06f
Cred_3388 di_tg_ctrl.$459.Metal3 v_b.$3247.Metal2 0.00186517f
Cred_3389 di_tg_ctrl.$459.Metal3 v_b.$3344.Metal2 0.00122401f
Cred_3390 di_tg_ctrl.$459.Metal3 v_b.$3857.Metal3 0.000966847f
Cred_3391 di_tg_ctrl.$459.Metal3 v_b.$3890.Metal3 0.00101519f
Cred_3392 di_tg_ctrl.$459.Metal3 v_b.$3903.Metal3 0.0353579f
Cred_3393 di_tg_ctrl.$459.Metal3 v_b.$3934.Metal3 0.00130478f
Cred_3394 di_tg_ctrl.$459.Metal3 v_b.P49.nSD 1.79523e-06f
Cred_3395 di_tg_ctrl.$459.Metal3 v_b.P49.pSD 0.00119207f
Cred_3396 di_tg_ctrl.$459.Metal3 v_b.P51.pSD 0.00687351f
Cred_3397 di_tg_ctrl.$459.Metal3 v_b.P53.pSD 0.0211743f
Cred_3398 di_tg_ctrl.$459.Metal3 v_b.P55.pSD 0.00449292f
Cred_3399 di_tg_ctrl.$459.Metal3 v_b.P57.pSD 0.000779396f
Cred_3400 di_tg_ctrl.$459.Metal3 VDD.$273.Metal1 0.000173068f
Cred_3401 di_tg_ctrl.$459.Metal3 VDD.$283.Metal1 0.0016666f
Cred_3402 di_tg_ctrl.$459.Metal3 VDD.$287.Metal1 0.000818956f
Cred_3403 di_tg_ctrl.$459.Metal3 VDD.$596.Metal2 0.000119486f
Cred_3404 di_tg_ctrl.$459.Metal3 VDD.$600.Metal2 0.000253938f
Cred_3405 di_tg_ctrl.$459.Metal3 VDD.$604.Metal2 0.000427379f
Cred_3406 di_tg_ctrl.$459.Metal3 VDD.$612.Metal2 3.28989e-05f
Cred_3407 di_tg_ctrl.$459.Metal3 VDD.$768.Metal3 0.0148134f
Cred_3408 di_tg_ctrl.$459.Metal3 VDD.$776.Metal3 0.0479069f
Cred_3409 di_tg_ctrl.$459.Metal3 VDD.$780.Metal3 0.00410324f
Cred_3410 di_tg_ctrl.$459.Metal3 VDD.P0.nSD 8.8173e-07f
Cred_3411 di_tg_ctrl.$462.Metal3 v_b.$3344.Metal2 0.00247138f
Cred_3412 di_tg_ctrl.$462.Metal3 v_b.$3438.Metal2 0.0019034f
Cred_3413 di_tg_ctrl.$462.Metal3 v_b.$3903.Metal3 0.00656429f
Cred_3414 di_tg_ctrl.$462.Metal3 v_b.$3934.Metal3 0.0398394f
Cred_3415 di_tg_ctrl.$462.Metal3 v_b.P53.pSD 0.00392111f
Cred_3416 di_tg_ctrl.$462.Metal3 v_b.P55.pSD 0.0064536f
Cred_3417 di_tg_ctrl.$462.Metal3 v_b.P57.pSD 0.0239182f
Cred_3418 di_tg_ctrl.$462.Metal3 v_b.P59.pSD 0.00436475f
Cred_3419 di_tg_ctrl.$462.Metal3 VDD.$287.Metal1 0.000405607f
Cred_3420 di_tg_ctrl.$462.Metal3 VDD.$295.Metal1 1.8395e-05f
Cred_3421 di_tg_ctrl.$462.Metal3 VDD.$299.Metal1 0.000381429f
Cred_3422 di_tg_ctrl.$462.Metal3 VDD.$309.Metal1 0.00017932f
Cred_3423 di_tg_ctrl.$462.Metal3 VDD.$596.Metal2 1.87387e-06f
Cred_3424 di_tg_ctrl.$462.Metal3 VDD.$600.Metal2 3.76276e-06f
Cred_3425 di_tg_ctrl.$462.Metal3 VDD.$604.Metal2 5.68183e-06f
Cred_3426 di_tg_ctrl.$462.Metal3 VDD.$612.Metal2 0.000204513f
Cred_3427 di_tg_ctrl.$462.Metal3 VDD.$620.Metal2 0.000167144f
Cred_3428 di_tg_ctrl.$462.Metal3 VDD.$624.Metal2 3.28086e-05f
Cred_3429 di_tg_ctrl.$462.Metal3 VDD.$768.Metal3 0.000233714f
Cred_3430 di_tg_ctrl.$462.Metal3 VDD.$776.Metal3 0.0202141f
Cred_3431 di_tg_ctrl.$462.Metal3 VDD.$780.Metal3 0.0445054f
Cred_3432 di_tg_ctrl.$462.Metal3 VDD.$786.Metal3 0.00396161f
Cred_3433 di_tg_ctrl.$462.Metal3 VDD.P0.nSD 9.12989e-07f
Cred_3434 di_tg_ctrl.$464.Metal3 v_b.$2003.Metal1 0.00231193f
Cred_3435 di_tg_ctrl.$464.Metal3 v_b.$3438.Metal2 0.0019034f
Cred_3436 di_tg_ctrl.$464.Metal3 v_b.$3507.Metal2 0.00667771f
Cred_3437 di_tg_ctrl.$464.Metal3 v_b.$3535.Metal2 0.00117383f
Cred_3438 di_tg_ctrl.$464.Metal3 v_b.$3934.Metal3 0.00159059f
Cred_3439 di_tg_ctrl.$464.Metal3 v_b.$3990.Metal3 0.0459829f
Cred_3440 di_tg_ctrl.$464.Metal3 v_b.$4009.Metal3 0.00156573f
Cred_3441 di_tg_ctrl.$464.Metal3 v_b.P57.pSD 0.000950125f
Cred_3442 di_tg_ctrl.$464.Metal3 v_b.P59.pSD 0.00685428f
Cred_3443 di_tg_ctrl.$464.Metal3 v_b.P61.pSD 0.00166329f
Cred_3444 di_tg_ctrl.$464.Metal3 v_b.P63.pSD 0.00441405f
Cred_3445 di_tg_ctrl.$464.Metal3 v_b.P65.pSD 0.000935276f
Cred_3446 di_tg_ctrl.$464.Metal3 VDD.$299.Metal1 0.000795213f
Cred_3447 di_tg_ctrl.$464.Metal3 VDD.$309.Metal1 0.00184723f
Cred_3448 di_tg_ctrl.$464.Metal3 VDD.$620.Metal2 0.000177612f
Cred_3449 di_tg_ctrl.$464.Metal3 VDD.$624.Metal2 0.000394355f
Cred_3450 di_tg_ctrl.$464.Metal3 VDD.$632.Metal2 3.28989e-05f
Cred_3451 di_tg_ctrl.$464.Metal3 VDD.$780.Metal3 0.019923f
Cred_3452 di_tg_ctrl.$464.Metal3 VDD.$786.Metal3 0.0430401f
Cred_3453 di_tg_ctrl.$464.Metal3 VDD.$790.Metal3 0.00410324f
Cred_3454 di_tg_ctrl.$464.Metal3 VDD.P0.nSD 3.12971e-06f
Cred_3455 di_tg_ctrl.$467.Metal3 VSS 0.00387385f
Cred_3456 di_tg_ctrl.$467.Metal3 v_b.$2003.Metal1 0.000413755f
Cred_3457 di_tg_ctrl.$467.Metal3 v_b.$2255.Metal1 0.00200031f
Cred_3458 di_tg_ctrl.$467.Metal3 v_b.$3507.Metal2 0.00119752f
Cred_3459 di_tg_ctrl.$467.Metal3 v_b.$3535.Metal2 0.00237007f
Cred_3460 di_tg_ctrl.$467.Metal3 v_b.$3629.Metal2 0.00370504f
Cred_3461 di_tg_ctrl.$467.Metal3 v_b.$3698.Metal2 0.0057375f
Cred_3462 di_tg_ctrl.$467.Metal3 v_b.$3990.Metal3 0.00829381f
Cred_3463 di_tg_ctrl.$467.Metal3 v_b.$4009.Metal3 0.0400874f
Cred_3464 di_tg_ctrl.$467.Metal3 v_b.$4065.Metal3 0.0388121f
Cred_3465 di_tg_ctrl.$467.Metal3 v_b.P61.pSD 0.000292522f
Cred_3466 di_tg_ctrl.$467.Metal3 v_b.P63.pSD 0.00629436f
Cred_3467 di_tg_ctrl.$467.Metal3 v_b.P65.pSD 0.0240646f
Cred_3468 di_tg_ctrl.$467.Metal3 v_b.P67.pSD 0.0108765f
Cred_3469 di_tg_ctrl.$467.Metal3 v_b.P69.pSD 0.00148713f
Cred_3470 di_tg_ctrl.$467.Metal3 VDD.$309.Metal1 0.000393314f
Cred_3471 di_tg_ctrl.$467.Metal3 VDD.$317.Metal1 1.74168e-05f
Cred_3472 di_tg_ctrl.$467.Metal3 VDD.$321.Metal1 0.00129623f
Cred_3473 di_tg_ctrl.$467.Metal3 VDD.$332.Metal1 0.00112698f
Cred_3474 di_tg_ctrl.$467.Metal3 VDD.$340.Metal1 4.55685e-06f
Cred_3475 di_tg_ctrl.$467.Metal3 VDD.$388.Metal2 6.42999e-14f
Cred_3476 di_tg_ctrl.$467.Metal3 VDD.$42.Metal1 3.01917e-12f
Cred_3477 di_tg_ctrl.$467.Metal3 VDD.$620.Metal2 2.5218e-06f
Cred_3478 di_tg_ctrl.$467.Metal3 VDD.$624.Metal2 5.06382e-06f
Cred_3479 di_tg_ctrl.$467.Metal3 VDD.$632.Metal2 0.000204514f
Cred_3480 di_tg_ctrl.$467.Metal3 VDD.$640.Metal2 0.000259572f
Cred_3481 di_tg_ctrl.$467.Metal3 VDD.$644.Metal2 0.000610995f
Cred_3482 di_tg_ctrl.$467.Metal3 VDD.$666.Metal3 2.83083e-15f
Cred_3483 di_tg_ctrl.$467.Metal3 VDD.$780.Metal3 0.000314526f
Cred_3484 di_tg_ctrl.$467.Metal3 VDD.$786.Metal3 0.0201493f
Cred_3485 di_tg_ctrl.$467.Metal3 VDD.$790.Metal3 0.0509318f
Cred_3486 di_tg_ctrl.$467.Metal3 VDD.$794.Metal3 0.0462801f
Cred_3487 di_tg_ctrl.$467.Metal3 VDD.P0.nSD 5.94076e-06f
Cred_3488 di_tg_ctrl.$47.GatPoly VSS 0.0419432f
Cred_3489 di_tg_ctrl.$47.GatPoly v_a.$2447.Metal3 0.00324459f
Cred_3490 di_tg_ctrl.$47.GatPoly v_a.P18.nSD 0.00435882f
Cred_3491 di_tg_ctrl.$47.GatPoly v_b.$2631.Metal2 0.00439135f
Cred_3492 di_tg_ctrl.$47.GatPoly v_b.P19.nSD 0.00407145f
Cred_3493 di_tg_ctrl.$47.GatPoly VSS.$123.Metal1 0.0023422f
Cred_3494 di_tg_ctrl.$47.GatPoly VSS.$135.Metal1 0.00373821f
Cred_3495 di_tg_ctrl.$47.GatPoly VSS.$442.Metal2 1.80653e-05f
Cred_3496 di_tg_ctrl.$47.GatPoly VSS.$446.Metal2 2.51108e-05f
Cred_3497 di_tg_ctrl.$47.GatPoly VSS.P0.pSD 1.34346e-05f
Cred_3498 di_tg_ctrl.$471.Metal4 di_tg_ctrl_n.$354.Metal2 3.71639e-07f
Cred_3499 di_tg_ctrl.$471.Metal4 di_tg_ctrl_n.$443.Metal3 6.41897e-05f
Cred_3500 di_tg_ctrl.$471.Metal4 di_tg_ctrl_n.$447.Metal3 4.10388e-05f
Cred_3501 di_tg_ctrl.$471.Metal4 di_tg_ctrl_n.$471.Metal4 0.0565003f
Cred_3502 di_tg_ctrl.$471.Metal4 di_tg_ctrl_n.$488.Metal4 0.00112997f
Cred_3503 di_tg_ctrl.$471.Metal4 di_tg_ctrl_n.$491.Metal4 0.067393f
Cred_3504 di_tg_ctrl.$471.Metal4 di_tg_ctrl_n.P0.GatPoly 0.000460121f
Cred_3505 di_tg_ctrl.$471.Metal4 di_tg_ctrl_n.P2.GatPoly 0.000174232f
Cred_3506 di_tg_ctrl.$471.Metal4 di_tg_ctrl_n.P35.GatPoly 0.00245886f
Cred_3507 di_tg_ctrl.$471.Metal4 di_tg_ctrl_n.P36.GatPoly 0.0024545f
Cred_3508 di_tg_ctrl.$471.Metal4 di_tg_ctrl_n.P37.GatPoly 0.00126754f
Cred_3509 di_tg_ctrl.$471.Metal4 di_tg_ctrl_n.P38.GatPoly 0.00126754f
Cred_3510 di_tg_ctrl.$471.Metal4 di_tg_ctrl_n.P39.GatPoly 0.000750272f
Cred_3511 di_tg_ctrl.$471.Metal4 di_tg_ctrl_n.P40.GatPoly 0.000750272f
Cred_3512 di_tg_ctrl.$471.Metal4 di_tg_ctrl_n.P41.GatPoly 0.000750272f
Cred_3513 di_tg_ctrl.$471.Metal4 di_tg_ctrl_n.P42.GatPoly 0.000750272f
Cred_3514 di_tg_ctrl.$471.Metal4 di_tg_ctrl_n.P43.GatPoly 0.000750272f
Cred_3515 di_tg_ctrl.$471.Metal4 di_tg_ctrl_n.P44.GatPoly 0.000750272f
Cred_3516 di_tg_ctrl.$471.Metal4 di_tg_ctrl_n.P45.GatPoly 0.000750272f
Cred_3517 di_tg_ctrl.$471.Metal4 di_tg_ctrl_n.P47.GatPoly 0.000530397f
Cred_3518 di_tg_ctrl.$471.Metal4 di_tg_ctrl_n.P48.GatPoly 0.000700311f
Cred_3519 di_tg_ctrl.$471.Metal4 di_tg_ctrl_n.P49.GatPoly 0.000720968f
Cred_3520 di_tg_ctrl.$471.Metal4 di_tg_ctrl_n.P50.GatPoly 0.000738147f
Cred_3521 di_tg_ctrl.$471.Metal4 di_tg_ctrl_n.P51.GatPoly 0.00076017f
Cred_3522 di_tg_ctrl.$471.Metal4 di_tg_ctrl_n.P52.GatPoly 0.000776847f
Cred_3523 di_tg_ctrl.$471.Metal4 di_tg_ctrl_n.P53.GatPoly 0.000795448f
Cred_3524 di_tg_ctrl.$471.Metal4 VSS 0.0729336f
Cred_3525 di_tg_ctrl.$471.Metal4 v_a.$1047.Metal1 1.57197e-07f
Cred_3526 di_tg_ctrl.$471.Metal4 v_a.$1964.Metal2 5.82515e-06f
Cred_3527 di_tg_ctrl.$471.Metal4 v_a.$2080.Metal2 4.11481e-06f
Cred_3528 di_tg_ctrl.$471.Metal4 v_a.$2297.Metal3 0.0958116f
Cred_3529 di_tg_ctrl.$471.Metal4 v_a.$2327.Metal3 0.00195359f
Cred_3530 di_tg_ctrl.$471.Metal4 v_a.$2365.Metal3 0.000314278f
Cred_3531 di_tg_ctrl.$471.Metal4 v_a.$2387.Metal3 0.143121f
Cred_3532 di_tg_ctrl.$471.Metal4 v_a.$2447.Metal3 0.349598f
Cred_3533 di_tg_ctrl.$471.Metal4 v_a.$2458.Metal3 0.0140926f
Cred_3534 di_tg_ctrl.$471.Metal4 v_a.$2485.Metal3 0.00707751f
Cred_3535 di_tg_ctrl.$471.Metal4 v_a.$2488.Metal3 0.0103743f
Cred_3536 di_tg_ctrl.$471.Metal4 v_a.$2507.Metal3 0.0600971f
Cred_3537 di_tg_ctrl.$471.Metal4 v_a.$2518.Metal3 0.0104273f
Cred_3538 di_tg_ctrl.$471.Metal4 v_a.$2545.Metal3 0.00398687f
Cred_3539 di_tg_ctrl.$471.Metal4 v_a.$2548.Metal3 0.010445f
Cred_3540 di_tg_ctrl.$471.Metal4 v_a.$2567.Metal3 0.110788f
Cred_3541 di_tg_ctrl.$471.Metal4 v_a.$2578.Metal3 0.010472f
Cred_3542 di_tg_ctrl.$471.Metal4 v_a.$2597.Metal3 0.0318247f
Cred_3543 di_tg_ctrl.$471.Metal4 v_a.$2608.Metal3 0.00756547f
Cred_3544 di_tg_ctrl.$471.Metal4 v_a.$2635.Metal3 0.00268633f
Cred_3545 di_tg_ctrl.$471.Metal4 v_a.$2638.Metal3 0.00749734f
Cred_3546 di_tg_ctrl.$471.Metal4 v_a.$2657.Metal3 0.0493274f
Cred_3547 di_tg_ctrl.$471.Metal4 v_a.$2668.Metal3 0.0077283f
Cred_3548 di_tg_ctrl.$471.Metal4 v_a.$921.Metal1 2.22537e-07f
Cred_3549 di_tg_ctrl.$471.Metal4 v_a.P10.nSD 3.09003e-05f
Cred_3550 di_tg_ctrl.$471.Metal4 v_a.P12.nSD 7.11118e-05f
Cred_3551 di_tg_ctrl.$471.Metal4 v_a.P14.nSD 0.00153121f
Cred_3552 di_tg_ctrl.$471.Metal4 v_a.P16.nSD 0.0107493f
Cred_3553 di_tg_ctrl.$471.Metal4 v_a.P16.pSD 0.00339934f
Cred_3554 di_tg_ctrl.$471.Metal4 v_a.P18.nSD 0.00825132f
Cred_3555 di_tg_ctrl.$471.Metal4 v_a.P20.nSD 0.00183825f
Cred_3556 di_tg_ctrl.$471.Metal4 v_a.P22.nSD 0.000526834f
Cred_3557 di_tg_ctrl.$471.Metal4 v_a.P24.nSD 0.000598765f
Cred_3558 di_tg_ctrl.$471.Metal4 v_a.P26.nSD 0.000629543f
Cred_3559 di_tg_ctrl.$471.Metal4 v_a.P28.nSD 0.000328308f
Cred_3560 di_tg_ctrl.$471.Metal4 v_a.P28.pSD 5.45832e-09f
Cred_3561 di_tg_ctrl.$471.Metal4 v_a.P30.nSD 0.00039814f
Cred_3562 di_tg_ctrl.$471.Metal4 v_a.P32.nSD 0.000328308f
Cred_3563 di_tg_ctrl.$471.Metal4 v_a.P32.pSD 3.85568e-09f
Cred_3564 di_tg_ctrl.$471.Metal4 v_a.P34.nSD 0.000747751f
Cred_3565 di_tg_ctrl.$471.Metal4 v_a.P34.pSD 0.00281963f
Cred_3566 di_tg_ctrl.$471.Metal4 v_a.P8.nSD 0.000165218f
Cred_3567 di_tg_ctrl.$471.Metal4 v_b.$2481.Metal2 0.000453959f
Cred_3568 di_tg_ctrl.$471.Metal4 v_b.$2541.Metal2 0.00491244f
Cred_3569 di_tg_ctrl.$471.Metal4 v_b.$2601.Metal2 0.0702306f
Cred_3570 di_tg_ctrl.$471.Metal4 v_b.$2631.Metal2 0.013639f
Cred_3571 di_tg_ctrl.$471.Metal4 v_b.$2691.Metal2 0.00958266f
Cred_3572 di_tg_ctrl.$471.Metal4 v_b.$2751.Metal2 0.0073662f
Cred_3573 di_tg_ctrl.$471.Metal4 v_b.$2811.Metal2 0.0057055f
Cred_3574 di_tg_ctrl.$471.Metal4 v_b.$2871.Metal2 0.0107204f
Cred_3575 di_tg_ctrl.$471.Metal4 v_b.$2962.Metal2 0.005516f
Cred_3576 di_tg_ctrl.$471.Metal4 v_b.$3053.Metal2 0.00044443f
Cred_3577 di_tg_ctrl.$471.Metal4 v_b.$3056.Metal2 0.00159596f
Cred_3578 di_tg_ctrl.$471.Metal4 v_b.$3089.Metal2 2.632e-06f
Cred_3579 di_tg_ctrl.$471.Metal4 v_b.$3153.Metal2 0.000189871f
Cred_3580 di_tg_ctrl.$471.Metal4 v_b.$3435.Metal2 4.94859e-06f
Cred_3581 di_tg_ctrl.$471.Metal4 v_b.$3438.Metal2 1.15283e-05f
Cred_3582 di_tg_ctrl.$471.Metal4 v_b.$3529.Metal2 3.09296e-06f
Cred_3583 di_tg_ctrl.$471.Metal4 v_b.$3779.Metal3 0.0415245f
Cred_3584 di_tg_ctrl.$471.Metal4 v_b.$3785.Metal3 0.053656f
Cred_3585 di_tg_ctrl.$471.Metal4 v_b.$3821.Metal3 0.0213862f
Cred_3586 di_tg_ctrl.$471.Metal4 v_b.$3934.Metal3 0.00160669f
Cred_3587 di_tg_ctrl.$471.Metal4 v_b.$3970.Metal3 0.00249543f
Cred_3588 di_tg_ctrl.$471.Metal4 v_b.P10.nSD 0.00128801f
Cred_3589 di_tg_ctrl.$471.Metal4 v_b.P11.nSD 0.00163662f
Cred_3590 di_tg_ctrl.$471.Metal4 v_b.P11.pSD 9.12852e-06f
Cred_3591 di_tg_ctrl.$471.Metal4 v_b.P13.nSD 0.00192821f
Cred_3592 di_tg_ctrl.$471.Metal4 v_b.P15.nSD 0.00295606f
Cred_3593 di_tg_ctrl.$471.Metal4 v_b.P15.pSD 6.0071e-05f
Cred_3594 di_tg_ctrl.$471.Metal4 v_b.P17.nSD 0.0126709f
Cred_3595 di_tg_ctrl.$471.Metal4 v_b.P17.pSD 0.00748161f
Cred_3596 di_tg_ctrl.$471.Metal4 v_b.P19.nSD 0.00493983f
Cred_3597 di_tg_ctrl.$471.Metal4 v_b.P19.pSD 0.0030217f
Cred_3598 di_tg_ctrl.$471.Metal4 v_b.P21.nSD 0.00360253f
Cred_3599 di_tg_ctrl.$471.Metal4 v_b.P21.pSD 0.00308115f
Cred_3600 di_tg_ctrl.$471.Metal4 v_b.P23.nSD 0.00327766f
Cred_3601 di_tg_ctrl.$471.Metal4 v_b.P23.pSD 0.00305778f
Cred_3602 di_tg_ctrl.$471.Metal4 v_b.P25.nSD 0.00295817f
Cred_3603 di_tg_ctrl.$471.Metal4 v_b.P25.pSD 0.00314941f
Cred_3604 di_tg_ctrl.$471.Metal4 v_b.P27.nSD 0.00270527f
Cred_3605 di_tg_ctrl.$471.Metal4 v_b.P27.pSD 0.00316857f
Cred_3606 di_tg_ctrl.$471.Metal4 v_b.P29.nSD 0.00118877f
Cred_3607 di_tg_ctrl.$471.Metal4 v_b.P29.pSD 0.00243485f
Cred_3608 di_tg_ctrl.$471.Metal4 v_b.P31.nSD 0.00117335f
Cred_3609 di_tg_ctrl.$471.Metal4 v_b.P31.pSD 0.00249089f
Cred_3610 di_tg_ctrl.$471.Metal4 v_b.P33.nSD 0.00118976f
Cred_3611 di_tg_ctrl.$471.Metal4 v_b.P33.pSD 0.00263696f
Cred_3612 di_tg_ctrl.$471.Metal4 v_b.P35.nSD 0.00125056f
Cred_3613 di_tg_ctrl.$471.Metal4 v_b.P35.pSD 0.00281718f
Cred_3614 di_tg_ctrl.$471.Metal4 v_b.P37.nSD 0.000569975f
Cred_3615 di_tg_ctrl.$471.Metal4 v_b.P37.pSD 0.00561908f
Cred_3616 di_tg_ctrl.$471.Metal4 v_b.P39.nSD 0.00117335f
Cred_3617 di_tg_ctrl.$471.Metal4 v_b.P39.pSD 0.00361674f
Cred_3618 di_tg_ctrl.$471.Metal4 v_b.P41.nSD 0.000469064f
Cred_3619 di_tg_ctrl.$471.Metal4 v_b.P41.pSD 0.00620282f
Cred_3620 di_tg_ctrl.$471.Metal4 v_b.P43.pSD 0.00149443f
Cred_3621 di_tg_ctrl.$471.Metal4 v_b.P45.pSD 0.00225938f
Cred_3622 di_tg_ctrl.$471.Metal4 v_b.P47.pSD 0.000350889f
Cred_3623 di_tg_ctrl.$471.Metal4 v_b.P7.nSD 0.00105494f
Cred_3624 di_tg_ctrl.$471.Metal4 VDD.$340.Metal1 1.70545e-06f
Cred_3625 di_tg_ctrl.$471.Metal4 VDD.$388.Metal2 1.77165e-09f
Cred_3626 di_tg_ctrl.$471.Metal4 VDD.$42.Metal1 8.31867e-08f
Cred_3627 di_tg_ctrl.$471.Metal4 VDD.$666.Metal3 7.79974e-11f
Cred_3628 di_tg_ctrl.$471.Metal4 VDD.P0.nSD 0.000283762f
Cred_3629 di_tg_ctrl.$471.Metal4 VSS.$123.Metal1 2.48323e-06f
Cred_3630 di_tg_ctrl.$471.Metal4 VSS.$135.Metal1 2.44293e-06f
Cred_3631 di_tg_ctrl.$471.Metal4 VSS.$17.Metal1 1.91769e-05f
Cred_3632 di_tg_ctrl.$471.Metal4 VSS.$301.Metal1 1.57927e-06f
Cred_3633 di_tg_ctrl.$471.Metal4 VSS.$434.Metal2 2.08035e-05f
Cred_3634 di_tg_ctrl.$471.Metal4 VSS.$442.Metal2 2.02255e-05f
Cred_3635 di_tg_ctrl.$471.Metal4 VSS.$446.Metal2 1.55839e-05f
Cred_3636 di_tg_ctrl.$471.Metal4 VSS.$606.Metal2 1.66869e-07f
Cred_3637 di_tg_ctrl.$471.Metal4 VSS.$670.Metal3 0.00533466f
Cred_3638 di_tg_ctrl.$471.Metal4 VSS.$674.Metal3 0.00918469f
Cred_3639 di_tg_ctrl.$471.Metal4 VSS.$680.Metal3 0.00194131f
Cred_3640 di_tg_ctrl.$471.Metal4 VSS.$760.Metal3 9.87339e-09f
Cred_3641 di_tg_ctrl.$471.Metal4 VSS.P0.pSD 0.0010579f
Cred_3642 di_tg_ctrl.$483.Metal4 di_tg_ctrl_n.$354.Metal2 4.90384e-07f
Cred_3643 di_tg_ctrl.$483.Metal4 di_tg_ctrl_n.$443.Metal3 0.000105461f
Cred_3644 di_tg_ctrl.$483.Metal4 di_tg_ctrl_n.$447.Metal3 5.1619e-05f
Cred_3645 di_tg_ctrl.$483.Metal4 di_tg_ctrl_n.$488.Metal4 0.00135836f
Cred_3646 di_tg_ctrl.$483.Metal4 VSS 0.0292222f
Cred_3647 di_tg_ctrl.$483.Metal4 v_a.$2447.Metal3 0.00182798f
Cred_3648 di_tg_ctrl.$483.Metal4 v_a.$2485.Metal3 0.000634198f
Cred_3649 di_tg_ctrl.$483.Metal4 v_a.$2507.Metal3 0.0212047f
Cred_3650 di_tg_ctrl.$483.Metal4 v_a.$2545.Metal3 6.79985e-06f
Cred_3651 di_tg_ctrl.$483.Metal4 v_a.$2567.Metal3 1.95996e-05f
Cred_3652 di_tg_ctrl.$483.Metal4 v_a.P20.nSD 2.18023e-05f
Cred_3653 di_tg_ctrl.$483.Metal4 v_a.P22.nSD 6.33945e-05f
Cred_3654 di_tg_ctrl.$483.Metal4 v_a.P24.nSD 1.5386e-06f
Cred_3655 di_tg_ctrl.$483.Metal4 v_b.$2631.Metal2 0.00147339f
Cred_3656 di_tg_ctrl.$483.Metal4 v_b.$2691.Metal2 0.0072023f
Cred_3657 di_tg_ctrl.$483.Metal4 v_b.P21.nSD 0.00202283f
Cred_3658 di_tg_ctrl.$483.Metal4 v_b.P21.pSD 2.96279e-05f
Cred_3659 di_tg_ctrl.$483.Metal4 v_b.P23.nSD 0.0031957f
Cred_3660 di_tg_ctrl.$483.Metal4 VSS.$145.Metal1 5.50789e-06f
Cred_3661 di_tg_ctrl.$483.Metal4 VSS.$153.Metal1 3.45038e-05f
Cred_3662 di_tg_ctrl.$483.Metal4 VSS.$163.Metal1 3.27446e-06f
Cred_3663 di_tg_ctrl.$483.Metal4 VSS.$454.Metal2 7.10116e-06f
Cred_3664 di_tg_ctrl.$483.Metal4 VSS.$462.Metal2 8.34953e-05f
Cred_3665 di_tg_ctrl.$483.Metal4 VSS.$470.Metal2 6.39977e-05f
Cred_3666 di_tg_ctrl.$483.Metal4 VSS.$680.Metal3 0.00120299f
Cred_3667 di_tg_ctrl.$483.Metal4 VSS.$684.Metal3 0.0105484f
Cred_3668 di_tg_ctrl.$483.Metal4 VSS.$692.Metal3 0.00402673f
Cred_3669 di_tg_ctrl.$483.Metal4 VSS.P0.pSD 4.12791e-08f
Cred_3670 di_tg_ctrl.$487.Metal4 di_tg_ctrl_n.$204.Metal1 0.000180418f
Cred_3671 di_tg_ctrl.$487.Metal4 di_tg_ctrl_n.$216.Metal1 1.09417e-06f
Cred_3672 di_tg_ctrl.$487.Metal4 di_tg_ctrl_n.$219.Metal1 0.00011539f
Cred_3673 di_tg_ctrl.$487.Metal4 di_tg_ctrl_n.$320.Metal2 1.76629e-07f
Cred_3674 di_tg_ctrl.$487.Metal4 di_tg_ctrl_n.$322.Metal2 3.60002e-07f
Cred_3675 di_tg_ctrl.$487.Metal4 di_tg_ctrl_n.$336.Metal2 4.69988e-05f
Cred_3676 di_tg_ctrl.$487.Metal4 di_tg_ctrl_n.$338.Metal2 2.32772e-05f
Cred_3677 di_tg_ctrl.$487.Metal4 di_tg_ctrl_n.$342.Metal2 8.66168e-06f
Cred_3678 di_tg_ctrl.$487.Metal4 di_tg_ctrl_n.$344.Metal2 7.48055e-05f
Cred_3679 di_tg_ctrl.$487.Metal4 di_tg_ctrl_n.$354.Metal2 1.86506e-06f
Cred_3680 di_tg_ctrl.$487.Metal4 di_tg_ctrl_n.$423.Metal3 9.25248e-06f
Cred_3681 di_tg_ctrl.$487.Metal4 di_tg_ctrl_n.$429.Metal3 1.88582e-05f
Cred_3682 di_tg_ctrl.$487.Metal4 di_tg_ctrl_n.$434.Metal3 0.00246197f
Cred_3683 di_tg_ctrl.$487.Metal4 di_tg_ctrl_n.$437.Metal3 0.00167307f
Cred_3684 di_tg_ctrl.$487.Metal4 di_tg_ctrl_n.$443.Metal3 0.000322134f
Cred_3685 di_tg_ctrl.$487.Metal4 di_tg_ctrl_n.$447.Metal3 0.000205952f
Cred_3686 di_tg_ctrl.$487.Metal4 di_tg_ctrl_n.$471.Metal4 0.128534f
Cred_3687 di_tg_ctrl.$487.Metal4 di_tg_ctrl_n.$483.Metal4 0.00152894f
Cred_3688 di_tg_ctrl.$487.Metal4 di_tg_ctrl_n.$488.Metal4 0.00567072f
Cred_3689 di_tg_ctrl.$487.Metal4 di_tg_ctrl_n.$491.Metal4 0.271969f
Cred_3690 di_tg_ctrl.$487.Metal4 di_tg_ctrl_n.$69.GatPoly 0.000454836f
Cred_3691 di_tg_ctrl.$487.Metal4 di_tg_ctrl_n.$72.GatPoly 0.000339125f
Cred_3692 di_tg_ctrl.$487.Metal4 di_tg_ctrl_n.$83.GatPoly 0.00122778f
Cred_3693 di_tg_ctrl.$487.Metal4 di_tg_ctrl_n.P0.GatPoly 0.000562569f
Cred_3694 di_tg_ctrl.$487.Metal4 di_tg_ctrl_n.P2.GatPoly 0.000874378f
Cred_3695 di_tg_ctrl.$487.Metal4 di_tg_ctrl_n.P35.GatPoly 0.000572087f
Cred_3696 di_tg_ctrl.$487.Metal4 di_tg_ctrl_n.P36.GatPoly 0.000576451f
Cred_3697 di_tg_ctrl.$487.Metal4 di_tg_ctrl_n.P37.GatPoly 0.000724124f
Cred_3698 di_tg_ctrl.$487.Metal4 di_tg_ctrl_n.P38.GatPoly 0.000724124f
Cred_3699 di_tg_ctrl.$487.Metal4 di_tg_ctrl_n.P39.GatPoly 0.000428618f
Cred_3700 di_tg_ctrl.$487.Metal4 di_tg_ctrl_n.P40.GatPoly 0.000428618f
Cred_3701 di_tg_ctrl.$487.Metal4 di_tg_ctrl_n.P41.GatPoly 0.000428618f
Cred_3702 di_tg_ctrl.$487.Metal4 di_tg_ctrl_n.P42.GatPoly 0.000428618f
Cred_3703 di_tg_ctrl.$487.Metal4 di_tg_ctrl_n.P43.GatPoly 0.000428618f
Cred_3704 di_tg_ctrl.$487.Metal4 di_tg_ctrl_n.P44.GatPoly 0.000428618f
Cred_3705 di_tg_ctrl.$487.Metal4 di_tg_ctrl_n.P45.GatPoly 0.000428618f
Cred_3706 di_tg_ctrl.$487.Metal4 di_tg_ctrl_n.P47.GatPoly 0.000651162f
Cred_3707 di_tg_ctrl.$487.Metal4 di_tg_ctrl_n.P48.GatPoly 0.00152147f
Cred_3708 di_tg_ctrl.$487.Metal4 di_tg_ctrl_n.P49.GatPoly 0.0016276f
Cred_3709 di_tg_ctrl.$487.Metal4 di_tg_ctrl_n.P50.GatPoly 0.00171586f
Cred_3710 di_tg_ctrl.$487.Metal4 di_tg_ctrl_n.P51.GatPoly 0.00182901f
Cred_3711 di_tg_ctrl.$487.Metal4 di_tg_ctrl_n.P52.GatPoly 0.00294301f
Cred_3712 di_tg_ctrl.$487.Metal4 di_tg_ctrl_n.P53.GatPoly 0.00312454f
Cred_3713 di_tg_ctrl.$487.Metal4 VSS 0.056286f
Cred_3714 di_tg_ctrl.$487.Metal4 v_a.$1047.Metal1 8.07639e-07f
Cred_3715 di_tg_ctrl.$487.Metal4 v_a.$1964.Metal2 2.99282e-05f
Cred_3716 di_tg_ctrl.$487.Metal4 v_a.$2080.Metal2 2.11408e-05f
Cred_3717 di_tg_ctrl.$487.Metal4 v_a.$2297.Metal3 0.015046f
Cred_3718 di_tg_ctrl.$487.Metal4 v_a.$2327.Metal3 0.00016204f
Cred_3719 di_tg_ctrl.$487.Metal4 v_a.$2365.Metal3 2.60677e-05f
Cred_3720 di_tg_ctrl.$487.Metal4 v_a.$2387.Metal3 0.00526846f
Cred_3721 di_tg_ctrl.$487.Metal4 v_a.$2447.Metal3 0.0286706f
Cred_3722 di_tg_ctrl.$487.Metal4 v_a.$2458.Metal3 0.00624919f
Cred_3723 di_tg_ctrl.$487.Metal4 v_a.$2485.Metal3 0.00228939f
Cred_3724 di_tg_ctrl.$487.Metal4 v_a.$2488.Metal3 0.00592665f
Cred_3725 di_tg_ctrl.$487.Metal4 v_a.$2507.Metal3 0.0280277f
Cred_3726 di_tg_ctrl.$487.Metal4 v_a.$2518.Metal3 0.00595693f
Cred_3727 di_tg_ctrl.$487.Metal4 v_a.$2545.Metal3 0.00220273f
Cred_3728 di_tg_ctrl.$487.Metal4 v_a.$2548.Metal3 0.00596704f
Cred_3729 di_tg_ctrl.$487.Metal4 v_a.$2567.Metal3 0.0272393f
Cred_3730 di_tg_ctrl.$487.Metal4 v_a.$2578.Metal3 0.00598249f
Cred_3731 di_tg_ctrl.$487.Metal4 v_a.$2597.Metal3 0.0534028f
Cred_3732 di_tg_ctrl.$487.Metal4 v_a.$2608.Metal3 0.00975858f
Cred_3733 di_tg_ctrl.$487.Metal4 v_a.$2635.Metal3 0.00328446f
Cred_3734 di_tg_ctrl.$487.Metal4 v_a.$2638.Metal3 0.00916666f
Cred_3735 di_tg_ctrl.$487.Metal4 v_a.$2657.Metal3 0.0949304f
Cred_3736 di_tg_ctrl.$487.Metal4 v_a.$2668.Metal3 0.00980833f
Cred_3737 di_tg_ctrl.$487.Metal4 v_a.$921.Metal1 1.14334e-06f
Cred_3738 di_tg_ctrl.$487.Metal4 v_a.P10.nSD 2.56302e-06f
Cred_3739 di_tg_ctrl.$487.Metal4 v_a.P12.nSD 5.89835e-06f
Cred_3740 di_tg_ctrl.$487.Metal4 v_a.P14.nSD 2.35753e-05f
Cred_3741 di_tg_ctrl.$487.Metal4 v_a.P16.nSD 0.000183742f
Cred_3742 di_tg_ctrl.$487.Metal4 v_a.P16.pSD 0.000303184f
Cred_3743 di_tg_ctrl.$487.Metal4 v_a.P18.nSD 0.00033863f
Cred_3744 di_tg_ctrl.$487.Metal4 v_a.P20.nSD 0.000348134f
Cred_3745 di_tg_ctrl.$487.Metal4 v_a.P22.nSD 0.000270487f
Cred_3746 di_tg_ctrl.$487.Metal4 v_a.P24.nSD 0.000325117f
Cred_3747 di_tg_ctrl.$487.Metal4 v_a.P26.nSD 0.000279006f
Cred_3748 di_tg_ctrl.$487.Metal4 v_a.P28.nSD 0.000401408f
Cred_3749 di_tg_ctrl.$487.Metal4 v_a.P28.pSD 2.80435e-08f
Cred_3750 di_tg_ctrl.$487.Metal4 v_a.P30.nSD 0.000486788f
Cred_3751 di_tg_ctrl.$487.Metal4 v_a.P32.nSD 0.000401408f
Cred_3752 di_tg_ctrl.$487.Metal4 v_a.P32.pSD 1.98095e-08f
Cred_3753 di_tg_ctrl.$487.Metal4 v_a.P34.nSD 0.0011379f
Cred_3754 di_tg_ctrl.$487.Metal4 v_a.P34.pSD 0.0231691f
Cred_3755 di_tg_ctrl.$487.Metal4 v_a.P8.nSD 1.3704e-05f
Cred_3756 di_tg_ctrl.$487.Metal4 v_b.$2481.Metal2 3.76535e-05f
Cred_3757 di_tg_ctrl.$487.Metal4 v_b.$2541.Metal2 0.000268485f
Cred_3758 di_tg_ctrl.$487.Metal4 v_b.$2601.Metal2 0.00344009f
Cred_3759 di_tg_ctrl.$487.Metal4 v_b.$2631.Metal2 0.0036927f
Cred_3760 di_tg_ctrl.$487.Metal4 v_b.$2691.Metal2 0.00467405f
Cred_3761 di_tg_ctrl.$487.Metal4 v_b.$2751.Metal2 0.0051156f
Cred_3762 di_tg_ctrl.$487.Metal4 v_b.$2811.Metal2 0.0073274f
Cred_3763 di_tg_ctrl.$487.Metal4 v_b.$2871.Metal2 0.018009f
Cred_3764 di_tg_ctrl.$487.Metal4 v_b.$2962.Metal2 0.0257432f
Cred_3765 di_tg_ctrl.$487.Metal4 v_b.$3053.Metal2 0.00227846f
Cred_3766 di_tg_ctrl.$487.Metal4 v_b.$3056.Metal2 0.0152167f
Cred_3767 di_tg_ctrl.$487.Metal4 v_b.$3089.Metal2 1.08875e-05f
Cred_3768 di_tg_ctrl.$487.Metal4 v_b.$3153.Metal2 0.000975509f
Cred_3769 di_tg_ctrl.$487.Metal4 v_b.$3435.Metal2 6.14169e-06f
Cred_3770 di_tg_ctrl.$487.Metal4 v_b.$3438.Metal2 1.43078e-05f
Cred_3771 di_tg_ctrl.$487.Metal4 v_b.$3529.Metal2 3.83867e-06f
Cred_3772 di_tg_ctrl.$487.Metal4 v_b.$3779.Metal3 0.189482f
Cred_3773 di_tg_ctrl.$487.Metal4 v_b.$3785.Metal3 0.442398f
Cred_3774 di_tg_ctrl.$487.Metal4 v_b.$3821.Metal3 0.150425f
Cred_3775 di_tg_ctrl.$487.Metal4 v_b.$3857.Metal3 0.00460994f
Cred_3776 di_tg_ctrl.$487.Metal4 v_b.$3890.Metal3 0.00484044f
Cred_3777 di_tg_ctrl.$487.Metal4 v_b.$3934.Metal3 0.00199405f
Cred_3778 di_tg_ctrl.$487.Metal4 v_b.$3970.Metal3 0.00309708f
Cred_3779 di_tg_ctrl.$487.Metal4 v_b.P11.nSD 7.40184e-06f
Cred_3780 di_tg_ctrl.$487.Metal4 v_b.P11.pSD 7.57163e-07f
Cred_3781 di_tg_ctrl.$487.Metal4 v_b.P13.nSD 1.11449e-05f
Cred_3782 di_tg_ctrl.$487.Metal4 v_b.P15.nSD 2.13888e-05f
Cred_3783 di_tg_ctrl.$487.Metal4 v_b.P15.pSD 2.18795e-06f
Cred_3784 di_tg_ctrl.$487.Metal4 v_b.P17.nSD 0.000288794f
Cred_3785 di_tg_ctrl.$487.Metal4 v_b.P17.pSD 0.00201916f
Cred_3786 di_tg_ctrl.$487.Metal4 v_b.P19.nSD 0.000968338f
Cred_3787 di_tg_ctrl.$487.Metal4 v_b.P19.pSD 0.00172625f
Cred_3788 di_tg_ctrl.$487.Metal4 v_b.P21.nSD 0.00097241f
Cred_3789 di_tg_ctrl.$487.Metal4 v_b.P21.pSD 0.00175313f
Cred_3790 di_tg_ctrl.$487.Metal4 v_b.P23.nSD 0.00095515f
Cred_3791 di_tg_ctrl.$487.Metal4 v_b.P23.pSD 0.00415369f
Cred_3792 di_tg_ctrl.$487.Metal4 v_b.P25.nSD 0.000960653f
Cred_3793 di_tg_ctrl.$487.Metal4 v_b.P25.pSD 0.00483026f
Cred_3794 di_tg_ctrl.$487.Metal4 v_b.P27.nSD 0.000948196f
Cred_3795 di_tg_ctrl.$487.Metal4 v_b.P27.pSD 0.00551679f
Cred_3796 di_tg_ctrl.$487.Metal4 v_b.P29.nSD 0.00145345f
Cred_3797 di_tg_ctrl.$487.Metal4 v_b.P29.pSD 0.00725729f
Cred_3798 di_tg_ctrl.$487.Metal4 v_b.P31.nSD 0.00143461f
Cred_3799 di_tg_ctrl.$487.Metal4 v_b.P31.pSD 0.00823678f
Cred_3800 di_tg_ctrl.$487.Metal4 v_b.P33.nSD 0.00145856f
Cred_3801 di_tg_ctrl.$487.Metal4 v_b.P33.pSD 0.00948043f
Cred_3802 di_tg_ctrl.$487.Metal4 v_b.P35.nSD 0.00152901f
Cred_3803 di_tg_ctrl.$487.Metal4 v_b.P35.pSD 0.010595f
Cred_3804 di_tg_ctrl.$487.Metal4 v_b.P37.nSD 0.000836533f
Cred_3805 di_tg_ctrl.$487.Metal4 v_b.P37.pSD 0.0647654f
Cred_3806 di_tg_ctrl.$487.Metal4 v_b.P39.nSD 0.00143461f
Cred_3807 di_tg_ctrl.$487.Metal4 v_b.P39.pSD 0.0386018f
Cred_3808 di_tg_ctrl.$487.Metal4 v_b.P41.nSD 0.00122934f
Cred_3809 di_tg_ctrl.$487.Metal4 v_b.P41.pSD 0.139949f
Cred_3810 di_tg_ctrl.$487.Metal4 v_b.P43.pSD 0.0271706f
Cred_3811 di_tg_ctrl.$487.Metal4 v_b.P45.pSD 0.0413842f
Cred_3812 di_tg_ctrl.$487.Metal4 v_b.P47.pSD 0.00602569f
Cred_3813 di_tg_ctrl.$487.Metal4 v_b.P49.nSD 8.5597e-06f
Cred_3814 di_tg_ctrl.$487.Metal4 v_b.P49.pSD 0.00508446f
Cred_3815 di_tg_ctrl.$487.Metal4 v_b.P51.pSD 0.00355888f
Cred_3816 di_tg_ctrl.$487.Metal4 v_b.P55.pSD 0.00300207f
Cred_3817 di_tg_ctrl.$487.Metal4 v_b.P59.pSD 0.00247182f
Cred_3818 di_tg_ctrl.$487.Metal4 v_b.P63.pSD 0.0020187f
Cred_3819 di_tg_ctrl.$487.Metal4 v_b.P67.pSD 0.00165145f
Cred_3820 di_tg_ctrl.$487.Metal4 v_b.P71.pSD 0.00105041f
Cred_3821 di_tg_ctrl.$487.Metal4 VDD.$238.Metal1 3.19694e-05f
Cred_3822 di_tg_ctrl.$487.Metal4 VDD.$247.Metal1 6.72229e-05f
Cred_3823 di_tg_ctrl.$487.Metal4 VDD.$251.Metal1 2.01794e-06f
Cred_3824 di_tg_ctrl.$487.Metal4 VDD.$263.Metal1 4.05449e-06f
Cred_3825 di_tg_ctrl.$487.Metal4 VDD.$340.Metal1 8.76217e-06f
Cred_3826 di_tg_ctrl.$487.Metal4 VDD.$388.Metal2 9.10228e-09f
Cred_3827 di_tg_ctrl.$487.Metal4 VDD.$42.Metal1 4.27392e-07f
Cred_3828 di_tg_ctrl.$487.Metal4 VDD.$560.Metal2 3.0011e-05f
Cred_3829 di_tg_ctrl.$487.Metal4 VDD.$568.Metal2 5.65508e-05f
Cred_3830 di_tg_ctrl.$487.Metal4 VDD.$576.Metal2 2.25147e-05f
Cred_3831 di_tg_ctrl.$487.Metal4 VDD.$580.Metal2 2.36049e-08f
Cred_3832 di_tg_ctrl.$487.Metal4 VDD.$584.Metal2 9.69853e-06f
Cred_3833 di_tg_ctrl.$487.Metal4 VDD.$588.Metal2 4.8299e-06f
Cred_3834 di_tg_ctrl.$487.Metal4 VDD.$666.Metal3 4.00731e-10f
Cred_3835 di_tg_ctrl.$487.Metal4 VDD.$750.Metal3 0.00187526f
Cred_3836 di_tg_ctrl.$487.Metal4 VDD.$758.Metal3 0.0143894f
Cred_3837 di_tg_ctrl.$487.Metal4 VDD.$762.Metal3 0.00785466f
Cred_3838 di_tg_ctrl.$487.Metal4 VDD.$768.Metal3 0.000602399f
Cred_3839 di_tg_ctrl.$487.Metal4 VDD.P0.nSD 0.00145796f
Cred_3840 di_tg_ctrl.$49.GatPoly VSS 0.0389033f
Cred_3841 di_tg_ctrl.$49.GatPoly v_a.$2447.Metal3 0.00186469f
Cred_3842 di_tg_ctrl.$49.GatPoly v_a.$2485.Metal3 0.000646932f
Cred_3843 di_tg_ctrl.$49.GatPoly v_a.$2507.Metal3 0.00186469f
Cred_3844 di_tg_ctrl.$49.GatPoly v_a.P20.nSD 0.00591626f
Cred_3845 di_tg_ctrl.$49.GatPoly v_b.$2631.Metal2 0.00500303f
Cred_3846 di_tg_ctrl.$49.GatPoly v_b.$2691.Metal2 0.000237798f
Cred_3847 di_tg_ctrl.$49.GatPoly v_b.P19.nSD 0.00441242f
Cred_3848 di_tg_ctrl.$49.GatPoly v_b.P21.nSD 0.000451485f
Cred_3849 di_tg_ctrl.$49.GatPoly v_b.P21.pSD 4.78182e-06f
Cred_3850 di_tg_ctrl.$49.GatPoly VSS.$135.Metal1 0.00301478f
Cred_3851 di_tg_ctrl.$49.GatPoly VSS.$145.Metal1 0.000430915f
Cred_3852 di_tg_ctrl.$49.GatPoly VSS.$454.Metal2 3.32316e-06f
Cred_3853 di_tg_ctrl.$49.GatPoly VSS.P0.pSD 1.15844e-06f
Cred_3854 di_tg_ctrl.$495.Metal4 di_tg_ctrl_n.$471.Metal4 0.000974836f
Cred_3855 di_tg_ctrl.$495.Metal4 di_tg_ctrl_n.$491.Metal4 0.00510176f
Cred_3856 di_tg_ctrl.$495.Metal4 VSS 0.033007f
Cred_3857 di_tg_ctrl.$495.Metal4 v_b.$3056.Metal2 0.00104745f
Cred_3858 di_tg_ctrl.$495.Metal4 v_b.$3153.Metal2 0.00257028f
Cred_3859 di_tg_ctrl.$495.Metal4 v_b.$3785.Metal3 1.53528e-05f
Cred_3860 di_tg_ctrl.$495.Metal4 v_b.$3821.Metal3 0.0147696f
Cred_3861 di_tg_ctrl.$495.Metal4 v_b.$3857.Metal3 0.00494522f
Cred_3862 di_tg_ctrl.$495.Metal4 v_b.$3890.Metal3 0.00519248f
Cred_3863 di_tg_ctrl.$495.Metal4 v_b.P41.pSD 9.17084e-06f
Cred_3864 di_tg_ctrl.$495.Metal4 v_b.P43.pSD 0.00419757f
Cred_3865 di_tg_ctrl.$495.Metal4 v_b.P45.pSD 0.00712071f
Cred_3866 di_tg_ctrl.$495.Metal4 v_b.P47.pSD 0.00852739f
Cred_3867 di_tg_ctrl.$495.Metal4 v_b.P49.nSD 9.18224e-06f
Cred_3868 di_tg_ctrl.$495.Metal4 v_b.P49.pSD 0.00566115f
Cred_3869 di_tg_ctrl.$495.Metal4 VDD.$251.Metal1 1.07396e-06f
Cred_3870 di_tg_ctrl.$495.Metal4 VDD.$263.Metal1 1.38047e-05f
Cred_3871 di_tg_ctrl.$495.Metal4 VDD.$269.Metal1 2.99555e-05f
Cred_3872 di_tg_ctrl.$495.Metal4 VDD.$576.Metal2 5.7523e-07f
Cred_3873 di_tg_ctrl.$495.Metal4 VDD.$580.Metal2 1.25626e-08f
Cred_3874 di_tg_ctrl.$495.Metal4 VDD.$584.Metal2 3.71986e-05f
Cred_3875 di_tg_ctrl.$495.Metal4 VDD.$588.Metal2 4.36206e-05f
Cred_3876 di_tg_ctrl.$495.Metal4 VDD.$596.Metal2 2.78188e-05f
Cred_3877 di_tg_ctrl.$495.Metal4 VDD.$600.Metal2 1.84229e-05f
Cred_3878 di_tg_ctrl.$495.Metal4 VDD.$604.Metal2 9.17466e-06f
Cred_3879 di_tg_ctrl.$495.Metal4 VDD.$758.Metal3 7.12154e-05f
Cred_3880 di_tg_ctrl.$495.Metal4 VDD.$762.Metal3 0.00675302f
Cred_3881 di_tg_ctrl.$495.Metal4 VDD.$768.Metal3 0.0149123f
Cred_3882 di_tg_ctrl.$495.Metal4 VDD.$776.Metal3 0.00114429f
Cred_3883 di_tg_ctrl.$495.Metal4 VDD.P0.nSD 2.51855e-08f
Cred_3884 di_tg_ctrl.$52.GatPoly VSS 0.041943f
Cred_3885 di_tg_ctrl.$52.GatPoly v_a.$2447.Metal3 0.00139261f
Cred_3886 di_tg_ctrl.$52.GatPoly v_a.$2485.Metal3 0.00048315f
Cred_3887 di_tg_ctrl.$52.GatPoly v_a.$2507.Metal3 0.00139261f
Cred_3888 di_tg_ctrl.$52.GatPoly v_a.P20.nSD 0.00441662f
Cred_3889 di_tg_ctrl.$52.GatPoly v_b.$2631.Metal2 0.0021623f
Cred_3890 di_tg_ctrl.$52.GatPoly v_b.$2691.Metal2 0.0021623f
Cred_3891 di_tg_ctrl.$52.GatPoly v_b.P21.nSD 0.00409447f
Cred_3892 di_tg_ctrl.$52.GatPoly v_b.P21.pSD 4.3481e-05f
Cred_3893 di_tg_ctrl.$52.GatPoly VSS.$135.Metal1 0.00201965f
Cred_3894 di_tg_ctrl.$52.GatPoly VSS.$145.Metal1 0.00322251f
Cred_3895 di_tg_ctrl.$52.GatPoly VSS.$17.Metal1 7.02779e-08f
Cred_3896 di_tg_ctrl.$52.GatPoly VSS.$301.Metal1 1.35418e-08f
Cred_3897 di_tg_ctrl.$52.GatPoly VSS.$454.Metal2 1.14324e-05f
Cred_3898 di_tg_ctrl.$52.GatPoly VSS.$606.Metal2 1.43085e-09f
Cred_3899 di_tg_ctrl.$52.GatPoly VSS.$760.Metal3 8.46615e-11f
Cred_3900 di_tg_ctrl.$52.GatPoly VSS.P0.pSD 9.95017e-06f
Cred_3901 di_tg_ctrl.$54.GatPoly VSS 0.0389033f
Cred_3902 di_tg_ctrl.$54.GatPoly v_a.$2507.Metal3 0.00454936f
Cred_3903 di_tg_ctrl.$54.GatPoly v_a.P22.nSD 0.00611032f
Cred_3904 di_tg_ctrl.$54.GatPoly v_b.$2631.Metal2 0.00234605f
Cred_3905 di_tg_ctrl.$54.GatPoly v_b.$2691.Metal2 0.00282906f
Cred_3906 di_tg_ctrl.$54.GatPoly v_b.P21.nSD 0.00443838f
Cred_3907 di_tg_ctrl.$54.GatPoly v_b.P21.pSD 4.7176e-05f
Cred_3908 di_tg_ctrl.$54.GatPoly v_b.P23.nSD 0.000448854f
Cred_3909 di_tg_ctrl.$54.GatPoly VSS.$145.Metal1 0.00310464f
Cred_3910 di_tg_ctrl.$54.GatPoly VSS.$153.Metal1 0.000955135f
Cred_3911 di_tg_ctrl.$54.GatPoly VSS.$462.Metal2 7.36725e-06f
Cred_3912 di_tg_ctrl.$54.GatPoly VSS.P0.pSD 2.28199e-06f
Cred_3913 di_tg_ctrl.$57.GatPoly VSS 0.0419432f
Cred_3914 di_tg_ctrl.$57.GatPoly v_a.$2507.Metal3 0.00339733f
Cred_3915 di_tg_ctrl.$57.GatPoly v_a.P22.nSD 0.00456497f
Cred_3916 di_tg_ctrl.$57.GatPoly v_b.$2691.Metal2 0.00439132f
Cred_3917 di_tg_ctrl.$57.GatPoly v_b.P23.nSD 0.00407143f
Cred_3918 di_tg_ctrl.$57.GatPoly VSS.$145.Metal1 0.000723491f
Cred_3919 di_tg_ctrl.$57.GatPoly VSS.$153.Metal1 0.00515496f
Cred_3920 di_tg_ctrl.$57.GatPoly VSS.$163.Metal1 0.000230178f
Cred_3921 di_tg_ctrl.$57.GatPoly VSS.$462.Metal2 5.58033e-06f
Cred_3922 di_tg_ctrl.$57.GatPoly VSS.$470.Metal2 1.77509e-06f
Cred_3923 di_tg_ctrl.$57.GatPoly VSS.P0.pSD 2.36058e-06f
Cred_3924 di_tg_ctrl.$59.GatPoly VSS 0.0389033f
Cred_3925 di_tg_ctrl.$59.GatPoly v_a.$2507.Metal3 0.00195017f
Cred_3926 di_tg_ctrl.$59.GatPoly v_a.$2545.Metal3 0.000676589f
Cred_3927 di_tg_ctrl.$59.GatPoly v_a.$2567.Metal3 0.00195017f
Cred_3928 di_tg_ctrl.$59.GatPoly v_a.P24.nSD 0.00618885f
Cred_3929 di_tg_ctrl.$59.GatPoly v_b.$2691.Metal2 0.00500303f
Cred_3930 di_tg_ctrl.$59.GatPoly v_b.$2751.Metal2 0.000237798f
Cred_3931 di_tg_ctrl.$59.GatPoly v_b.P23.nSD 0.00441242f
Cred_3932 di_tg_ctrl.$59.GatPoly v_b.P25.nSD 0.000451485f
Cred_3933 di_tg_ctrl.$59.GatPoly v_b.P25.pSD 4.78182e-06f
Cred_3934 di_tg_ctrl.$59.GatPoly VSS.$153.Metal1 0.00127235f
Cred_3935 di_tg_ctrl.$59.GatPoly VSS.$163.Metal1 0.00209198f
Cred_3936 di_tg_ctrl.$59.GatPoly VSS.$470.Metal2 9.81323e-06f
Cred_3937 di_tg_ctrl.$59.GatPoly VSS.P0.pSD 3.16697e-06f
Cred_3938 di_tg_ctrl.$62.GatPoly VSS 0.0553151f
Cred_3939 di_tg_ctrl.$62.GatPoly v_a.$2507.Metal3 0.00144148f
Cred_3940 di_tg_ctrl.$62.GatPoly v_a.$2545.Metal3 0.000500105f
Cred_3941 di_tg_ctrl.$62.GatPoly v_a.$2567.Metal3 0.00295501f
Cred_3942 di_tg_ctrl.$62.GatPoly v_a.P24.nSD 0.00456689f
Cred_3943 di_tg_ctrl.$62.GatPoly v_a.P26.nSD 0.00203294f
Cred_3944 di_tg_ctrl.$62.GatPoly v_b.$2691.Metal2 0.00302351f
Cred_3945 di_tg_ctrl.$62.GatPoly v_b.$2751.Metal2 0.00302351f
Cred_3946 di_tg_ctrl.$62.GatPoly v_b.P25.nSD 0.00572279f
Cred_3947 di_tg_ctrl.$62.GatPoly v_b.P25.pSD 6.07988e-05f
Cred_3948 di_tg_ctrl.$62.GatPoly VSS 0.00207588f
Cred_3949 di_tg_ctrl.$62.GatPoly VSS.$153.Metal1 0.000285091f
Cred_3950 di_tg_ctrl.$62.GatPoly VSS.$163.Metal1 0.00423646f
Cred_3951 di_tg_ctrl.$62.GatPoly VSS.$17.Metal1 4.4206e-08f
Cred_3952 di_tg_ctrl.$62.GatPoly VSS.$177.Metal1 0.000107599f
Cred_3953 di_tg_ctrl.$62.GatPoly VSS.$301.Metal1 2.33524e-08f
Cred_3954 di_tg_ctrl.$62.GatPoly VSS.$470.Metal2 2.19881e-06f
Cred_3955 di_tg_ctrl.$62.GatPoly VSS.$478.Metal2 7.01305e-06f
Cred_3956 di_tg_ctrl.$62.GatPoly VSS.$482.Metal2 1.66813e-06f
Cred_3957 di_tg_ctrl.$62.GatPoly VSS.$486.Metal2 8.29817e-07f
Cred_3958 di_tg_ctrl.$62.GatPoly VSS.$606.Metal2 2.46745e-09f
Cred_3959 di_tg_ctrl.$62.GatPoly VSS.$760.Metal3 1.45996e-10f
Cred_3960 di_tg_ctrl.$62.GatPoly VSS.P0.pSD 8.85982e-06f
Cred_3961 di_tg_ctrl.$66.GatPoly VSS 0.04671f
Cred_3962 di_tg_ctrl.$66.GatPoly v_a.$2567.Metal3 0.00528687f
Cred_3963 di_tg_ctrl.$66.GatPoly v_a.P26.nSD 0.00710121f
Cred_3964 di_tg_ctrl.$66.GatPoly v_b.$2691.Metal2 0.000662251f
Cred_3965 di_tg_ctrl.$66.GatPoly v_b.$2751.Metal2 0.00542748f
Cred_3966 di_tg_ctrl.$66.GatPoly v_b.P25.nSD 0.00125288f
Cred_3967 di_tg_ctrl.$66.GatPoly v_b.P25.pSD 1.3317e-05f
Cred_3968 di_tg_ctrl.$66.GatPoly v_b.P27.nSD 0.00441242f
Cred_3969 di_tg_ctrl.$66.GatPoly VSS 0.0031294f
Cred_3970 di_tg_ctrl.$66.GatPoly VSS.$163.Metal1 0.000230786f
Cred_3971 di_tg_ctrl.$66.GatPoly VSS.$177.Metal1 0.00166959f
Cred_3972 di_tg_ctrl.$66.GatPoly VSS.$478.Metal2 1.77984e-06f
Cred_3973 di_tg_ctrl.$66.GatPoly VSS.$482.Metal2 8.74266e-06f
Cred_3974 di_tg_ctrl.$66.GatPoly VSS.$486.Metal2 1.2876e-05f
Cred_3975 di_tg_ctrl.$66.GatPoly VSS.P0.pSD 5.76672e-06f
Cred_3976 di_tg_ctrl.$68.GatPoly di_tg_ctrl_n.$86.GatPoly 0.000859506f
Cred_3977 di_tg_ctrl.$68.GatPoly VSS 0.041943f
Cred_3978 di_tg_ctrl.$68.GatPoly v_a.$2597.Metal3 0.00339569f
Cred_3979 di_tg_ctrl.$68.GatPoly v_a.P28.nSD 0.00456352f
Cred_3980 di_tg_ctrl.$68.GatPoly v_b.$2751.Metal2 0.00439039f
Cred_3981 di_tg_ctrl.$68.GatPoly v_b.P27.nSD 0.00407055f
Cred_3982 di_tg_ctrl.$68.GatPoly VSS 0.000679629f
Cred_3983 di_tg_ctrl.$68.GatPoly VSS.$177.Metal1 0.00439143f
Cred_3984 di_tg_ctrl.$68.GatPoly VSS.$191.Metal1 0.000188573f
Cred_3985 di_tg_ctrl.$68.GatPoly VSS.$482.Metal2 2.17249e-06f
Cred_3986 di_tg_ctrl.$68.GatPoly VSS.$486.Metal2 7.43403e-06f
Cred_3987 di_tg_ctrl.$68.GatPoly VSS.$494.Metal2 2.92361e-06f
Cred_3988 di_tg_ctrl.$68.GatPoly VSS.$498.Metal2 1.45452e-06f
Cred_3989 di_tg_ctrl.$68.GatPoly VSS.P0.pSD 4.07389e-06f
Cred_3990 di_tg_ctrl.$7.GatPoly VSS 0.0442418f
Cred_3991 di_tg_ctrl.$7.GatPoly v_a 0.00189408f
Cred_3992 di_tg_ctrl.$7.GatPoly v_a.$2215.Metal3 0.000496069f
Cred_3993 di_tg_ctrl.$7.GatPoly v_a.$2237.Metal3 0.00142985f
Cred_3994 di_tg_ctrl.$7.GatPoly v_a.P2.nSD 0.00516259f
Cred_3995 di_tg_ctrl.$7.GatPoly v_b.$2361.Metal2 0.00258695f
Cred_3996 di_tg_ctrl.$7.GatPoly v_b.$2421.Metal2 0.00218453f
Cred_3997 di_tg_ctrl.$7.GatPoly v_b.P1.nSD 0.000373961f
Cred_3998 di_tg_ctrl.$7.GatPoly v_b.P3.nSD 0.00413818f
Cred_3999 di_tg_ctrl.$7.GatPoly v_b.P3.pSD 4.3928e-05f
Cred_4000 di_tg_ctrl.$7.GatPoly VSS.$366.Metal2 2.28412e-05f
Cred_4001 di_tg_ctrl.$7.GatPoly VSS.$370.Metal2 1.35108e-05f
Cred_4002 di_tg_ctrl.$7.GatPoly VSS.$39.Metal1 0.00458913f
Cred_4003 di_tg_ctrl.$7.GatPoly VSS.$51.Metal1 0.00175185f
Cred_4004 di_tg_ctrl.$7.GatPoly VSS.P0.pSD 1.13208e-05f
Cred_4005 di_tg_ctrl.$71.GatPoly di_tg_ctrl_n.$86.GatPoly 0.00132029f
Cred_4006 di_tg_ctrl.$71.GatPoly VSS 0.0389033f
Cred_4007 di_tg_ctrl.$71.GatPoly v_a.$2597.Metal3 0.00459452f
Cred_4008 di_tg_ctrl.$71.GatPoly v_a.P28.nSD 0.00617126f
Cred_4009 di_tg_ctrl.$71.GatPoly v_b.$2751.Metal2 0.00282906f
Cred_4010 di_tg_ctrl.$71.GatPoly v_b.$2811.Metal2 0.00234605f
Cred_4011 di_tg_ctrl.$71.GatPoly v_b.P27.nSD 0.000448854f
Cred_4012 di_tg_ctrl.$71.GatPoly v_b.P29.nSD 0.00443838f
Cred_4013 di_tg_ctrl.$71.GatPoly v_b.P29.pSD 4.7176e-05f
Cred_4014 di_tg_ctrl.$71.GatPoly VSS.$177.Metal1 0.00251046f
Cred_4015 di_tg_ctrl.$71.GatPoly VSS.$191.Metal1 0.000841109f
Cred_4016 di_tg_ctrl.$71.GatPoly VSS.$494.Metal2 1.30405e-05f
Cred_4017 di_tg_ctrl.$71.GatPoly VSS.$498.Metal2 6.48774e-06f
Cred_4018 di_tg_ctrl.$71.GatPoly VSS.P0.pSD 6.21811e-06f
Cred_4019 di_tg_ctrl.$73.GatPoly di_tg_ctrl_n.$86.GatPoly 0.00115837f
Cred_4020 di_tg_ctrl.$73.GatPoly VSS 0.0419433f
Cred_4021 di_tg_ctrl.$73.GatPoly v_a.$2597.Metal3 0.00144671f
Cred_4022 di_tg_ctrl.$73.GatPoly v_a.$2635.Metal3 0.000501918f
Cred_4023 di_tg_ctrl.$73.GatPoly v_a.$2657.Metal3 0.00144671f
Cred_4024 di_tg_ctrl.$73.GatPoly v_a.P30.nSD 0.00459076f
Cred_4025 di_tg_ctrl.$73.GatPoly v_b.$2751.Metal2 0.00216166f
Cred_4026 di_tg_ctrl.$73.GatPoly v_b.$2811.Metal2 0.00216166f
Cred_4027 di_tg_ctrl.$73.GatPoly v_b.P29.nSD 0.00409863f
Cred_4028 di_tg_ctrl.$73.GatPoly v_b.P29.pSD 4.34683e-05f
Cred_4029 di_tg_ctrl.$73.GatPoly VSS.$17.Metal1 1.91802e-08f
Cred_4030 di_tg_ctrl.$73.GatPoly VSS.$177.Metal1 0.00168643f
Cred_4031 di_tg_ctrl.$73.GatPoly VSS.$191.Metal1 0.00437645f
Cred_4032 di_tg_ctrl.$73.GatPoly VSS.$301.Metal1 3.80045e-08f
Cred_4033 di_tg_ctrl.$73.GatPoly VSS.$494.Metal2 1.30054e-05f
Cred_4034 di_tg_ctrl.$73.GatPoly VSS.$498.Metal2 2.25761e-05f
Cred_4035 di_tg_ctrl.$73.GatPoly VSS.$606.Metal2 4.01561e-09f
Cred_4036 di_tg_ctrl.$73.GatPoly VSS.$760.Metal3 2.37598e-10f
Cred_4037 di_tg_ctrl.$73.GatPoly VSS.P0.pSD 1.64485e-05f
Cred_4038 di_tg_ctrl.$76.GatPoly di_tg_ctrl_n.$86.GatPoly 0.00186701f
Cred_4039 di_tg_ctrl.$76.GatPoly VSS 0.0389033f
Cred_4040 di_tg_ctrl.$76.GatPoly v_a.$2597.Metal3 0.00195695f
Cred_4041 di_tg_ctrl.$76.GatPoly v_a.$2635.Metal3 0.000678942f
Cred_4042 di_tg_ctrl.$76.GatPoly v_a.$2657.Metal3 0.00195695f
Cred_4043 di_tg_ctrl.$76.GatPoly v_a.P30.nSD 0.00621015f
Cred_4044 di_tg_ctrl.$76.GatPoly v_b.$2751.Metal2 0.000237798f
Cred_4045 di_tg_ctrl.$76.GatPoly v_b.$2811.Metal2 0.00500303f
Cred_4046 di_tg_ctrl.$76.GatPoly v_b.P29.nSD 0.000451485f
Cred_4047 di_tg_ctrl.$76.GatPoly v_b.P29.pSD 4.78182e-06f
Cred_4048 di_tg_ctrl.$76.GatPoly v_b.P31.nSD 0.00441242f
Cred_4049 di_tg_ctrl.$76.GatPoly VSS.$191.Metal1 0.00334084f
Cred_4050 di_tg_ctrl.$76.GatPoly VSS.$205.Metal1 0.000706882f
Cred_4051 di_tg_ctrl.$76.GatPoly VSS.$506.Metal2 1.09594e-05f
Cred_4052 di_tg_ctrl.$76.GatPoly VSS.$510.Metal2 5.45129e-06f
Cred_4053 di_tg_ctrl.$76.GatPoly VSS.P0.pSD 5.29535e-06f
Cred_4054 di_tg_ctrl.$78.GatPoly di_tg_ctrl_n.$86.GatPoly 0.00208177f
Cred_4055 di_tg_ctrl.$78.GatPoly VSS 0.0442418f
Cred_4056 di_tg_ctrl.$78.GatPoly v_a.$2657.Metal3 0.00383289f
Cred_4057 di_tg_ctrl.$78.GatPoly v_a.P32.nSD 0.0051497f
Cred_4058 di_tg_ctrl.$78.GatPoly v_b.$2811.Metal2 0.00463528f
Cred_4059 di_tg_ctrl.$78.GatPoly v_b.$2871.Metal2 0.000198121f
Cred_4060 di_tg_ctrl.$78.GatPoly v_b.P31.nSD 0.00411401f
Cred_4061 di_tg_ctrl.$78.GatPoly v_b.P33.nSD 0.000376153f
Cred_4062 di_tg_ctrl.$78.GatPoly v_b.P33.pSD 3.98395e-06f
Cred_4063 di_tg_ctrl.$78.GatPoly VSS.$191.Metal1 0.00215786f
Cred_4064 di_tg_ctrl.$78.GatPoly VSS.$205.Metal1 0.00320453f
Cred_4065 di_tg_ctrl.$78.GatPoly VSS.$506.Metal2 1.66437e-05f
Cred_4066 di_tg_ctrl.$78.GatPoly VSS.$510.Metal2 2.00362e-05f
Cred_4067 di_tg_ctrl.$78.GatPoly VSS.P0.pSD 1.21619e-05f
Cred_4068 di_tg_ctrl.$82.GatPoly di_tg_ctrl_n.$103.GatPoly 0.000294658f
Cred_4069 di_tg_ctrl.$82.GatPoly di_tg_ctrl_n.$223.Metal1 0.000478942f
Cred_4070 di_tg_ctrl.$82.GatPoly di_tg_ctrl_n.$227.Metal1 7.944e-05f
Cred_4071 di_tg_ctrl.$82.GatPoly di_tg_ctrl_n.$232.Metal1 4.73427e-05f
Cred_4072 di_tg_ctrl.$82.GatPoly di_tg_ctrl_n.$234.Metal1 8.20886e-05f
Cred_4073 di_tg_ctrl.$82.GatPoly di_tg_ctrl_n.$238.Metal1 3.44195e-05f
Cred_4074 di_tg_ctrl.$82.GatPoly di_tg_ctrl_n.$352.Metal2 1.75179e-07f
Cred_4075 di_tg_ctrl.$82.GatPoly di_tg_ctrl_n.$443.Metal3 3.28151e-09f
Cred_4076 di_tg_ctrl.$82.GatPoly di_tg_ctrl_n.$86.GatPoly 0.0214396f
Cred_4077 di_tg_ctrl.$82.GatPoly di_tg_ctrl_n.$89.GatPoly 0.00167766f
Cred_4078 di_tg_ctrl.$82.GatPoly di_tg_ctrl_n.$93.GatPoly 0.000629732f
Cred_4079 di_tg_ctrl.$82.GatPoly di_tg_ctrl_n.$95.GatPoly 0.000632683f
Cred_4080 di_tg_ctrl.$82.GatPoly di_tg_ctrl_n.$99.GatPoly 0.000484441f
Cred_4081 di_tg_ctrl.$82.GatPoly di_tg_ctrl_n.P1.GatPoly 0.000105152f
Cred_4082 di_tg_ctrl.$82.GatPoly di_tg_ctrl_n.P2.GatPoly 1.77633e-05f
Cred_4083 di_tg_ctrl.$82.GatPoly di_tg_ctrl_n.P3.GatPoly 1.38066e-05f
Cred_4084 di_tg_ctrl.$82.GatPoly di_tg_ctrl_n.P5.GatPoly 1.88143e-05f
Cred_4085 di_tg_ctrl.$82.GatPoly di_tg_ctrl_n.P6.GatPoly 7.21827e-06f
Cred_4086 di_tg_ctrl.$82.GatPoly di_tg_ctrl_n.P7.GatPoly 6.46026e-06f
Cred_4087 di_tg_ctrl.$82.GatPoly VSS 0.0709493f
Cred_4088 di_tg_ctrl.$82.GatPoly v_a.$2657.Metal3 0.00804833f
Cred_4089 di_tg_ctrl.$82.GatPoly v_a.P32.nSD 0.00514157f
Cred_4090 di_tg_ctrl.$82.GatPoly v_a.P34.nSD 0.00485107f
Cred_4091 di_tg_ctrl.$82.GatPoly v_a.P34.pSD 6.49658e-05f
Cred_4092 di_tg_ctrl.$82.GatPoly v_b.$2811.Metal2 0.00368461f
Cred_4093 di_tg_ctrl.$82.GatPoly v_b.$2871.Metal2 0.00457719f
Cred_4094 di_tg_ctrl.$82.GatPoly v_b.P31.nSD 0.000373961f
Cred_4095 di_tg_ctrl.$82.GatPoly v_b.P33.nSD 0.00620292f
Cred_4096 di_tg_ctrl.$82.GatPoly v_b.P33.pSD 6.60007e-05f
Cred_4097 di_tg_ctrl.$82.GatPoly v_b.P35.nSD 0.00120364f
Cred_4098 di_tg_ctrl.$82.GatPoly VSS.$17.Metal1 4.66361e-10f
Cred_4099 di_tg_ctrl.$82.GatPoly VSS.$191.Metal1 0.000237397f
Cred_4100 di_tg_ctrl.$82.GatPoly VSS.$205.Metal1 0.00470519f
Cred_4101 di_tg_ctrl.$82.GatPoly VSS.$213.Metal1 0.00269481f
Cred_4102 di_tg_ctrl.$82.GatPoly VSS.$221.Metal1 4.34879e-06f
Cred_4103 di_tg_ctrl.$82.GatPoly VSS.$301.Metal1 1.81944e-09f
Cred_4104 di_tg_ctrl.$82.GatPoly VSS.$506.Metal2 1.83106e-06f
Cred_4105 di_tg_ctrl.$82.GatPoly VSS.$510.Metal2 3.68033e-06f
Cred_4106 di_tg_ctrl.$82.GatPoly VSS.$518.Metal2 8.10197e-06f
Cred_4107 di_tg_ctrl.$82.GatPoly VSS.$526.Metal2 3.35362e-08f
Cred_4108 di_tg_ctrl.$82.GatPoly VSS.$606.Metal2 1.92244e-10f
Cred_4109 di_tg_ctrl.$82.GatPoly VSS.$760.Metal3 1.13748e-11f
Cred_4110 di_tg_ctrl.$82.GatPoly VSS.P0.pSD 4.57609e-06f
Cred_4111 di_tg_ctrl.$87.GatPoly di_tg_ctrl_n.$182.Metal1 5.69108e-05f
Cred_4112 di_tg_ctrl.$87.GatPoly di_tg_ctrl_n.$185.Metal1 0.00026596f
Cred_4113 di_tg_ctrl.$87.GatPoly di_tg_ctrl_n.$187.Metal1 0.000153386f
Cred_4114 di_tg_ctrl.$87.GatPoly di_tg_ctrl_n.$193.Metal1 8.0359e-05f
Cred_4115 di_tg_ctrl.$87.GatPoly di_tg_ctrl_n.$196.Metal1 0.000386049f
Cred_4116 di_tg_ctrl.$87.GatPoly di_tg_ctrl_n.$198.Metal1 0.000222645f
Cred_4117 di_tg_ctrl.$87.GatPoly di_tg_ctrl_n.$204.Metal1 0.000165863f
Cred_4118 di_tg_ctrl.$87.GatPoly di_tg_ctrl_n.$207.Metal1 0.000848558f
Cred_4119 di_tg_ctrl.$87.GatPoly di_tg_ctrl_n.$209.Metal1 0.000489387f
Cred_4120 di_tg_ctrl.$87.GatPoly di_tg_ctrl_n.$215.Metal1 0.00107182f
Cred_4121 di_tg_ctrl.$87.GatPoly di_tg_ctrl_n.$216.Metal1 0.00178635f
Cred_4122 di_tg_ctrl.$87.GatPoly di_tg_ctrl_n.$219.Metal1 0.0194056f
Cred_4123 di_tg_ctrl.$87.GatPoly di_tg_ctrl_n.$471.Metal4 0.00126648f
Cred_4124 di_tg_ctrl.$87.GatPoly di_tg_ctrl_n.$49.GatPoly 0.000143473f
Cred_4125 di_tg_ctrl.$87.GatPoly di_tg_ctrl_n.$491.Metal4 0.00164901f
Cred_4126 di_tg_ctrl.$87.GatPoly di_tg_ctrl_n.$52.GatPoly 0.00153443f
Cred_4127 di_tg_ctrl.$87.GatPoly di_tg_ctrl_n.$56.GatPoly 0.00186027f
Cred_4128 di_tg_ctrl.$87.GatPoly di_tg_ctrl_n.$59.GatPoly 0.00180261f
Cred_4129 di_tg_ctrl.$87.GatPoly di_tg_ctrl_n.$62.GatPoly 0.00218652f
Cred_4130 di_tg_ctrl.$87.GatPoly di_tg_ctrl_n.$66.GatPoly 0.00271619f
Cred_4131 di_tg_ctrl.$87.GatPoly di_tg_ctrl_n.$69.GatPoly 0.00356238f
Cred_4132 di_tg_ctrl.$87.GatPoly di_tg_ctrl_n.$72.GatPoly 0.00461086f
Cred_4133 di_tg_ctrl.$87.GatPoly di_tg_ctrl_n.$76.GatPoly 0.00638162f
Cred_4134 di_tg_ctrl.$87.GatPoly di_tg_ctrl_n.$79.GatPoly 0.00927533f
Cred_4135 di_tg_ctrl.$87.GatPoly di_tg_ctrl_n.$83.GatPoly 0.0994309f
Cred_4136 di_tg_ctrl.$87.GatPoly di_tg_ctrl_n.P39.GatPoly 8.11882e-06f
Cred_4137 di_tg_ctrl.$87.GatPoly di_tg_ctrl_n.P40.GatPoly 2.18819e-05f
Cred_4138 di_tg_ctrl.$87.GatPoly di_tg_ctrl_n.P43.GatPoly 1.14639e-05f
Cred_4139 di_tg_ctrl.$87.GatPoly di_tg_ctrl_n.P44.GatPoly 3.17622e-05f
Cred_4140 di_tg_ctrl.$87.GatPoly di_tg_ctrl_n.P47.GatPoly 2.36618e-05f
Cred_4141 di_tg_ctrl.$87.GatPoly di_tg_ctrl_n.P48.GatPoly 6.98153e-05f
Cred_4142 di_tg_ctrl.$87.GatPoly di_tg_ctrl_n.P51.GatPoly 0.000149157f
Cred_4143 di_tg_ctrl.$87.GatPoly di_tg_ctrl_n.P52.GatPoly 0.00075558f
Cred_4144 di_tg_ctrl.$87.GatPoly di_tg_ctrl_n.P53.GatPoly 0.00108583f
Cred_4145 di_tg_ctrl.$87.GatPoly VSS 0.00966593f
Cred_4146 di_tg_ctrl.$87.GatPoly v_b.$2871.Metal2 0.00475694f
Cred_4147 di_tg_ctrl.$87.GatPoly v_b.$2962.Metal2 0.00567102f
Cred_4148 di_tg_ctrl.$87.GatPoly v_b.$3779.Metal3 0.0231079f
Cred_4149 di_tg_ctrl.$87.GatPoly v_b.P35.pSD 0.016789f
Cred_4150 di_tg_ctrl.$87.GatPoly v_b.P37.nSD 2.76273e-05f
Cred_4151 di_tg_ctrl.$87.GatPoly v_b.P37.pSD 0.0485382f
Cred_4152 di_tg_ctrl.$87.GatPoly v_b.P39.pSD 0.0197238f
Cred_4153 di_tg_ctrl.$87.GatPoly VDD.$238.Metal1 0.00550554f
Cred_4154 di_tg_ctrl.$87.GatPoly VDD.$247.Metal1 0.00284414f
Cred_4155 di_tg_ctrl.$87.GatPoly VDD.$251.Metal1 0.000296834f
Cred_4156 di_tg_ctrl.$87.GatPoly VDD.$568.Metal2 1.28403e-05f
Cred_4157 di_tg_ctrl.$87.GatPoly VDD.$576.Metal2 5.5371e-07f
Cred_4158 di_tg_ctrl.$87.GatPoly VDD.$758.Metal3 4.43952e-09f
Cred_4159 di_tg_ctrl.$87.GatPoly VDD.P0.nSD 2.73581e-06f
Cred_4160 di_tg_ctrl.$9.GatPoly VSS 0.0389033f
Cred_4161 di_tg_ctrl.$9.GatPoly v_a.$2237.Metal3 0.00461049f
Cred_4162 di_tg_ctrl.$9.GatPoly v_a.P4.nSD 0.0061925f
Cred_4163 di_tg_ctrl.$9.GatPoly v_b.$2361.Metal2 0.00234605f
Cred_4164 di_tg_ctrl.$9.GatPoly v_b.$2421.Metal2 0.00282906f
Cred_4165 di_tg_ctrl.$9.GatPoly v_b.P3.nSD 0.00443838f
Cred_4166 di_tg_ctrl.$9.GatPoly v_b.P3.pSD 4.7176e-05f
Cred_4167 di_tg_ctrl.$9.GatPoly v_b.P5.nSD 0.000448854f
Cred_4168 di_tg_ctrl.$9.GatPoly VSS.$366.Metal2 6.81842e-06f
Cred_4169 di_tg_ctrl.$9.GatPoly VSS.$370.Metal2 1.37057e-05f
Cred_4170 di_tg_ctrl.$9.GatPoly VSS.$39.Metal1 0.000883991f
Cred_4171 di_tg_ctrl.$9.GatPoly VSS.$51.Metal1 0.00283076f
Cred_4172 di_tg_ctrl.$9.GatPoly VSS.P0.pSD 6.3576e-06f
Cred_4173 di_tg_ctrl.$90.GatPoly di_tg_ctrl_n.$219.Metal1 0.00167215f
Cred_4174 di_tg_ctrl.$90.GatPoly di_tg_ctrl_n.$83.GatPoly 0.00867889f
Cred_4175 di_tg_ctrl.$90.GatPoly di_tg_ctrl_n.P52.GatPoly 6.83061e-05f
Cred_4176 di_tg_ctrl.$90.GatPoly di_tg_ctrl_n.P53.GatPoly 9.38499e-05f
Cred_4177 di_tg_ctrl.$90.GatPoly VSS 0.00685292f
Cred_4178 di_tg_ctrl.$90.GatPoly v_b.$2962.Metal2 0.00567102f
Cred_4179 di_tg_ctrl.$90.GatPoly v_b.$3056.Metal2 0.00079298f
Cred_4180 di_tg_ctrl.$90.GatPoly v_b.$3785.Metal3 0.0109872f
Cred_4181 di_tg_ctrl.$90.GatPoly v_b.P39.pSD 0.0197238f
Cred_4182 di_tg_ctrl.$90.GatPoly v_b.P41.pSD 0.0248383f
Cred_4183 di_tg_ctrl.$90.GatPoly v_b.P43.pSD 0.00281168f
Cred_4184 di_tg_ctrl.$90.GatPoly VDD.$238.Metal1 0.000184568f
Cred_4185 di_tg_ctrl.$90.GatPoly VDD.$247.Metal1 0.00262487f
Cred_4186 di_tg_ctrl.$90.GatPoly VDD.$251.Metal1 0.00360508f
Cred_4187 di_tg_ctrl.$90.GatPoly VDD.$263.Metal1 0.000506462f
Cred_4188 di_tg_ctrl.$90.GatPoly VDD.$568.Metal2 4.48472e-06f
Cred_4189 di_tg_ctrl.$90.GatPoly VDD.$576.Metal2 1.08164e-05f
Cred_4190 di_tg_ctrl.$90.GatPoly VDD.$580.Metal2 3.81025e-06f
Cred_4191 di_tg_ctrl.$90.GatPoly VDD.$758.Metal3 2.45456e-08f
Cred_4192 di_tg_ctrl.$90.GatPoly VDD.P0.nSD 2.89037e-06f
Cred_4193 di_tg_ctrl.$93.GatPoly di_tg_ctrl_n.$219.Metal1 0.00126671f
Cred_4194 di_tg_ctrl.$93.GatPoly di_tg_ctrl_n.$471.Metal4 0.000234696f
Cred_4195 di_tg_ctrl.$93.GatPoly di_tg_ctrl_n.$491.Metal4 0.000305586f
Cred_4196 di_tg_ctrl.$93.GatPoly di_tg_ctrl_n.$83.GatPoly 0.00657452f
Cred_4197 di_tg_ctrl.$93.GatPoly di_tg_ctrl_n.P52.GatPoly 5.17439e-05f
Cred_4198 di_tg_ctrl.$93.GatPoly di_tg_ctrl_n.P53.GatPoly 7.10942e-05f
Cred_4199 di_tg_ctrl.$93.GatPoly VSS 0.00995367f
Cred_4200 di_tg_ctrl.$93.GatPoly v_b.$3056.Metal2 0.00831273f
Cred_4201 di_tg_ctrl.$93.GatPoly v_b.$3785.Metal3 0.00658155f
Cred_4202 di_tg_ctrl.$93.GatPoly v_b.$3821.Metal3 0.00380615f
Cred_4203 di_tg_ctrl.$93.GatPoly v_b.P41.pSD 0.0148356f
Cred_4204 di_tg_ctrl.$93.GatPoly v_b.P43.pSD 0.0290018f
Cred_4205 di_tg_ctrl.$93.GatPoly v_b.P45.pSD 0.00860614f
Cred_4206 di_tg_ctrl.$93.GatPoly VDD.$251.Metal1 0.003253f
Cred_4207 di_tg_ctrl.$93.GatPoly VDD.$263.Metal1 0.00482968f
Cred_4208 di_tg_ctrl.$93.GatPoly VDD.$269.Metal1 0.000194444f
Cred_4209 di_tg_ctrl.$93.GatPoly VDD.$576.Metal2 1.28452e-05f
Cred_4210 di_tg_ctrl.$93.GatPoly VDD.$580.Metal2 2.33261e-05f
Cred_4211 di_tg_ctrl.$93.GatPoly VDD.$584.Metal2 3.223e-07f
Cred_4212 di_tg_ctrl.$93.GatPoly VDD.$588.Metal2 9.50615e-07f
Cred_4213 di_tg_ctrl.$93.GatPoly VDD.P0.nSD 9.80645e-06f
Cred_4214 di_tg_ctrl.$97.GatPoly di_tg_ctrl_n.$219.Metal1 0.000982616f
Cred_4215 di_tg_ctrl.$97.GatPoly di_tg_ctrl_n.$471.Metal4 0.000801572f
Cred_4216 di_tg_ctrl.$97.GatPoly di_tg_ctrl_n.$491.Metal4 0.00104369f
Cred_4217 di_tg_ctrl.$97.GatPoly di_tg_ctrl_n.$83.GatPoly 0.00510002f
Cred_4218 di_tg_ctrl.$97.GatPoly di_tg_ctrl_n.P52.GatPoly 4.01391e-05f
Cred_4219 di_tg_ctrl.$97.GatPoly di_tg_ctrl_n.P53.GatPoly 5.51495e-05f
Cred_4220 di_tg_ctrl.$97.GatPoly VSS 0.00829178f
Cred_4221 di_tg_ctrl.$97.GatPoly v_b.$3056.Metal2 0.00162908f
Cred_4222 di_tg_ctrl.$97.GatPoly v_b.$3153.Metal2 0.0074146f
Cred_4223 di_tg_ctrl.$97.GatPoly v_b.$3821.Metal3 0.0108324f
Cred_4224 di_tg_ctrl.$97.GatPoly v_b.P43.pSD 0.005679f
Cred_4225 di_tg_ctrl.$97.GatPoly v_b.P45.pSD 0.0244491f
Cred_4226 di_tg_ctrl.$97.GatPoly v_b.P47.pSD 0.0260318f
Cred_4227 di_tg_ctrl.$97.GatPoly VDD.$251.Metal1 0.000143478f
Cred_4228 di_tg_ctrl.$97.GatPoly VDD.$263.Metal1 0.00357117f
Cred_4229 di_tg_ctrl.$97.GatPoly VDD.$269.Metal1 0.00266238f
Cred_4230 di_tg_ctrl.$97.GatPoly VDD.$273.Metal1 0.000318027f
Cred_4231 di_tg_ctrl.$97.GatPoly VDD.$576.Metal2 5.66552e-07f
Cred_4232 di_tg_ctrl.$97.GatPoly VDD.$580.Metal2 1.67833e-06f
Cred_4233 di_tg_ctrl.$97.GatPoly VDD.$584.Metal2 6.29554e-07f
Cred_4234 di_tg_ctrl.$97.GatPoly VDD.$588.Metal2 1.16103e-05f
Cred_4235 di_tg_ctrl.$97.GatPoly VDD.$596.Metal2 5.63582e-07f
Cred_4236 di_tg_ctrl.$97.GatPoly VDD.$768.Metal3 4.51867e-09f
Cred_4237 di_tg_ctrl.$97.GatPoly VDD.P0.nSD 3.00601e-06f
Cred_4238 di_tg_ctrl.P0.GatPoly VSS 0.0216709f
Cred_4239 di_tg_ctrl.P0.GatPoly v_a 0.0156249f
Cred_4240 di_tg_ctrl.P0.GatPoly v_a.P0.nSD 0.0205003f
Cred_4241 di_tg_ctrl.P0.GatPoly v_b.$2361.Metal2 0.0207106f
Cred_4242 di_tg_ctrl.P0.GatPoly v_b.P0.nSD 0.0159865f
Cred_4243 di_tg_ctrl.P0.GatPoly v_b.P0.pSD 0.000312151f
Cred_4244 di_tg_ctrl.P0.GatPoly v_b.P1.nSD 0.000145663f
Cred_4245 di_tg_ctrl.P0.GatPoly VSS.$17.Metal1 0.00528272f
Cred_4246 di_tg_ctrl.P0.GatPoly VSS.$301.Metal1 4.47029e-07f
Cred_4247 di_tg_ctrl.P0.GatPoly VSS.$366.Metal2 0.00258094f
Cred_4248 di_tg_ctrl.P0.GatPoly VSS.$39.Metal1 0.00397858f
Cred_4249 di_tg_ctrl.P0.GatPoly VSS.$606.Metal2 4.72338e-08f
Cred_4250 di_tg_ctrl.P0.GatPoly VSS.$636.Metal3 0.00161719f
Cred_4251 di_tg_ctrl.P0.GatPoly VSS.$760.Metal3 2.79476e-09f
Cred_4252 di_tg_ctrl.P0.GatPoly VSS.P0.pSD 0.00246488f
Cred_4253 di_tg_ctrl.P1.GatPoly VSS 0.0164384f
Cred_4254 di_tg_ctrl.P1.GatPoly v_a 0.0215139f
Cred_4255 di_tg_ctrl.P1.GatPoly v_a.P0.nSD 0.0165399f
Cred_4256 di_tg_ctrl.P1.GatPoly v_b.$2361.Metal2 0.0220662f
Cred_4257 di_tg_ctrl.P1.GatPoly v_b.P0.nSD 0.000157782f
Cred_4258 di_tg_ctrl.P1.GatPoly v_b.P0.pSD 2.05688e-06f
Cred_4259 di_tg_ctrl.P1.GatPoly v_b.P1.nSD 0.0133147f
Cred_4260 di_tg_ctrl.P1.GatPoly VSS.$17.Metal1 0.000617033f
Cred_4261 di_tg_ctrl.P1.GatPoly VSS.$301.Metal1 5.09146e-07f
Cred_4262 di_tg_ctrl.P1.GatPoly VSS.$366.Metal2 6.53669e-06f
Cred_4263 di_tg_ctrl.P1.GatPoly VSS.$39.Metal1 0.000206775f
Cred_4264 di_tg_ctrl.P1.GatPoly VSS.$606.Metal2 5.37971e-08f
Cred_4265 di_tg_ctrl.P1.GatPoly VSS.$636.Metal3 7.59492e-07f
Cred_4266 di_tg_ctrl.P1.GatPoly VSS.$760.Metal3 3.1831e-09f
Cred_4267 di_tg_ctrl.P1.GatPoly VSS.P0.pSD 0.00254363f
Cred_4268 di_tg_ctrl.P10.GatPoly VSS 0.0123426f
Cred_4269 di_tg_ctrl.P10.GatPoly v_a.$2327.Metal3 0.0213687f
Cred_4270 di_tg_ctrl.P10.GatPoly v_a.P10.nSD 0.0152022f
Cred_4271 di_tg_ctrl.P10.GatPoly v_b.$2481.Metal2 0.0215942f
Cred_4272 di_tg_ctrl.P10.GatPoly v_b.P10.nSD 0.0130565f
Cred_4273 di_tg_ctrl.P10.GatPoly VSS.$17.Metal1 0.000128448f
Cred_4274 di_tg_ctrl.P10.GatPoly VSS.$301.Metal1 1.6134e-06f
Cred_4275 di_tg_ctrl.P10.GatPoly VSS.$606.Metal2 1.70474e-07f
Cred_4276 di_tg_ctrl.P10.GatPoly VSS.$760.Metal3 1.00867e-08f
Cred_4277 di_tg_ctrl.P10.GatPoly VSS.P0.pSD 0.00269852f
Cred_4278 di_tg_ctrl.P11.GatPoly VSS 0.0127329f
Cred_4279 di_tg_ctrl.P11.GatPoly v_a.$2327.Metal3 0.021443f
Cred_4280 di_tg_ctrl.P11.GatPoly v_a.P10.nSD 0.015302f
Cred_4281 di_tg_ctrl.P11.GatPoly v_b.$2481.Metal2 0.0108163f
Cred_4282 di_tg_ctrl.P11.GatPoly v_b.$2541.Metal2 0.0108163f
Cred_4283 di_tg_ctrl.P11.GatPoly v_b.P11.nSD 0.0132743f
Cred_4284 di_tg_ctrl.P11.GatPoly v_b.P11.pSD 0.000217501f
Cred_4285 di_tg_ctrl.P11.GatPoly VSS.$17.Metal1 0.000117924f
Cred_4286 di_tg_ctrl.P11.GatPoly VSS.$301.Metal1 1.7579e-06f
Cred_4287 di_tg_ctrl.P11.GatPoly VSS.$402.Metal2 1.58375e-07f
Cred_4288 di_tg_ctrl.P11.GatPoly VSS.$406.Metal2 7.8788e-08f
Cred_4289 di_tg_ctrl.P11.GatPoly VSS.$606.Metal2 1.85742e-07f
Cred_4290 di_tg_ctrl.P11.GatPoly VSS.$760.Metal3 1.09901e-08f
Cred_4291 di_tg_ctrl.P11.GatPoly VSS.$79.Metal1 2.05344e-05f
Cred_4292 di_tg_ctrl.P11.GatPoly VSS.$91.Metal1 1.02149e-05f
Cred_4293 di_tg_ctrl.P11.GatPoly VSS.P0.pSD 0.00270895f
Cred_4294 di_tg_ctrl.P12.GatPoly VSS 0.0123426f
Cred_4295 di_tg_ctrl.P12.GatPoly v_a.$2327.Metal3 0.00907007f
Cred_4296 di_tg_ctrl.P12.GatPoly v_a.$2365.Metal3 0.00314676f
Cred_4297 di_tg_ctrl.P12.GatPoly v_a.$2387.Metal3 0.00907007f
Cred_4298 di_tg_ctrl.P12.GatPoly v_a.P12.nSD 0.015284f
Cred_4299 di_tg_ctrl.P12.GatPoly v_b.$2481.Metal2 0.0102826f
Cred_4300 di_tg_ctrl.P12.GatPoly v_b.$2541.Metal2 0.0102826f
Cred_4301 di_tg_ctrl.P12.GatPoly v_b.P11.nSD 0.0131056f
Cred_4302 di_tg_ctrl.P12.GatPoly v_b.P11.pSD 0.00020677f
Cred_4303 di_tg_ctrl.P12.GatPoly VSS.$17.Metal1 9.94007e-05f
Cred_4304 di_tg_ctrl.P12.GatPoly VSS.$301.Metal1 2.08672e-06f
Cred_4305 di_tg_ctrl.P12.GatPoly VSS.$606.Metal2 2.20486e-07f
Cred_4306 di_tg_ctrl.P12.GatPoly VSS.$760.Metal3 1.30459e-08f
Cred_4307 di_tg_ctrl.P12.GatPoly VSS.P0.pSD 0.00272704f
Cred_4308 di_tg_ctrl.P13.GatPoly VSS 0.0127329f
Cred_4309 di_tg_ctrl.P13.GatPoly v_a.$2327.Metal3 0.00885417f
Cred_4310 di_tg_ctrl.P13.GatPoly v_a.$2365.Metal3 0.00307185f
Cred_4311 di_tg_ctrl.P13.GatPoly v_a.$2387.Metal3 0.00885417f
Cred_4312 di_tg_ctrl.P13.GatPoly v_a.P12.nSD 0.0153636f
Cred_4313 di_tg_ctrl.P13.GatPoly v_b.$2541.Metal2 0.0224439f
Cred_4314 di_tg_ctrl.P13.GatPoly v_b.P13.nSD 0.0131979f
Cred_4315 di_tg_ctrl.P13.GatPoly VSS.$101.Metal1 7.72487e-06f
Cred_4316 di_tg_ctrl.P13.GatPoly VSS.$17.Metal1 9.12649e-05f
Cred_4317 di_tg_ctrl.P13.GatPoly VSS.$301.Metal1 2.27346e-06f
Cred_4318 di_tg_ctrl.P13.GatPoly VSS.$414.Metal2 5.95722e-08f
Cred_4319 di_tg_ctrl.P13.GatPoly VSS.$606.Metal2 2.40217e-07f
Cred_4320 di_tg_ctrl.P13.GatPoly VSS.$760.Metal3 1.42133e-08f
Cred_4321 di_tg_ctrl.P13.GatPoly VSS.$91.Metal1 1.79518e-05f
Cred_4322 di_tg_ctrl.P13.GatPoly VSS.P0.pSD 0.00273499f
Cred_4323 di_tg_ctrl.P14.GatPoly VSS 0.0123426f
Cred_4324 di_tg_ctrl.P14.GatPoly v_a.$2387.Metal3 0.0195611f
Cred_4325 di_tg_ctrl.P14.GatPoly v_a.P14.nSD 0.0151488f
Cred_4326 di_tg_ctrl.P14.GatPoly v_b.$2541.Metal2 0.0215942f
Cred_4327 di_tg_ctrl.P14.GatPoly v_b.P13.nSD 0.0130565f
Cred_4328 di_tg_ctrl.P14.GatPoly VSS.$17.Metal1 7.69464e-05f
Cred_4329 di_tg_ctrl.P14.GatPoly VSS.$301.Metal1 2.69844e-06f
Cred_4330 di_tg_ctrl.P14.GatPoly VSS.$606.Metal2 2.85121e-07f
Cred_4331 di_tg_ctrl.P14.GatPoly VSS.$760.Metal3 1.68703e-08f
Cred_4332 di_tg_ctrl.P14.GatPoly VSS.P0.pSD 0.00274881f
Cred_4333 di_tg_ctrl.P15.GatPoly VSS 0.0127329f
Cred_4334 di_tg_ctrl.P15.GatPoly v_a.$2387.Metal3 0.0188215f
Cred_4335 di_tg_ctrl.P15.GatPoly v_a.P14.nSD 0.0152203f
Cred_4336 di_tg_ctrl.P15.GatPoly v_b.$2541.Metal2 0.010678f
Cred_4337 di_tg_ctrl.P15.GatPoly v_b.$2601.Metal2 0.010678f
Cred_4338 di_tg_ctrl.P15.GatPoly v_b.P15.nSD 0.0132471f
Cred_4339 di_tg_ctrl.P15.GatPoly v_b.P15.pSD 0.00021472f
Cred_4340 di_tg_ctrl.P15.GatPoly VSS.$101.Metal1 2.05342e-05f
Cred_4341 di_tg_ctrl.P15.GatPoly VSS.$113.Metal1 1.02151e-05f
Cred_4342 di_tg_ctrl.P15.GatPoly VSS.$17.Metal1 7.06586e-05f
Cred_4343 di_tg_ctrl.P15.GatPoly VSS.$301.Metal1 2.9398e-06f
Cred_4344 di_tg_ctrl.P15.GatPoly VSS.$422.Metal2 1.58376e-07f
Cred_4345 di_tg_ctrl.P15.GatPoly VSS.$426.Metal2 7.87882e-08f
Cred_4346 di_tg_ctrl.P15.GatPoly VSS.$606.Metal2 3.10624e-07f
Cred_4347 di_tg_ctrl.P15.GatPoly VSS.$760.Metal3 1.83792e-08f
Cred_4348 di_tg_ctrl.P15.GatPoly VSS.P0.pSD 0.00275491f
Cred_4349 di_tg_ctrl.P16.GatPoly VSS 0.0123426f
Cred_4350 di_tg_ctrl.P16.GatPoly v_a.$2387.Metal3 0.00899464f
Cred_4351 di_tg_ctrl.P16.GatPoly v_a.$2447.Metal3 0.00899464f
Cred_4352 di_tg_ctrl.P16.GatPoly v_a.P16.nSD 0.0151919f
Cred_4353 di_tg_ctrl.P16.GatPoly v_a.P16.pSD 0.000199359f
Cred_4354 di_tg_ctrl.P16.GatPoly v_b.$2541.Metal2 0.0102826f
Cred_4355 di_tg_ctrl.P16.GatPoly v_b.$2601.Metal2 0.0102826f
Cred_4356 di_tg_ctrl.P16.GatPoly v_b.P15.nSD 0.0131056f
Cred_4357 di_tg_ctrl.P16.GatPoly v_b.P15.pSD 0.00020677f
Cred_4358 di_tg_ctrl.P16.GatPoly VSS.$17.Metal1 5.95953e-05f
Cred_4359 di_tg_ctrl.P16.GatPoly VSS.$301.Metal1 3.48913e-06f
Cred_4360 di_tg_ctrl.P16.GatPoly VSS.$606.Metal2 3.68667e-07f
Cred_4361 di_tg_ctrl.P16.GatPoly VSS.$760.Metal3 2.18135e-08f
Cred_4362 di_tg_ctrl.P16.GatPoly VSS.P0.pSD 0.00276529f
Cred_4363 di_tg_ctrl.P17.GatPoly VSS 0.0127329f
Cred_4364 di_tg_ctrl.P17.GatPoly v_a.$2387.Metal3 0.00891714f
Cred_4365 di_tg_ctrl.P17.GatPoly v_a.$2447.Metal3 0.00891714f
Cred_4366 di_tg_ctrl.P17.GatPoly v_a.P16.nSD 0.0152798f
Cred_4367 di_tg_ctrl.P17.GatPoly v_a.P16.pSD 0.000197641f
Cred_4368 di_tg_ctrl.P17.GatPoly v_b.$2601.Metal2 0.0216671f
Cred_4369 di_tg_ctrl.P17.GatPoly v_b.P17.nSD 0.0131242f
Cred_4370 di_tg_ctrl.P17.GatPoly VSS.$113.Metal1 1.89023e-05f
Cred_4371 di_tg_ctrl.P17.GatPoly VSS.$123.Metal1 7.91771e-06f
Cred_4372 di_tg_ctrl.P17.GatPoly VSS.$17.Metal1 7.07971e-05f
Cred_4373 di_tg_ctrl.P17.GatPoly VSS.$301.Metal1 4.91624e-06f
Cred_4374 di_tg_ctrl.P17.GatPoly VSS.$434.Metal2 6.10584e-08f
Cred_4375 di_tg_ctrl.P17.GatPoly VSS.$606.Metal2 5.19458e-07f
Cred_4376 di_tg_ctrl.P17.GatPoly VSS.$760.Metal3 3.07356e-08f
Cred_4377 di_tg_ctrl.P17.GatPoly VSS.P0.pSD 0.00358238f
Cred_4378 di_tg_ctrl.P18.GatPoly VSS 0.0123426f
Cred_4379 di_tg_ctrl.P18.GatPoly v_a.$2447.Metal3 0.0180414f
Cred_4380 di_tg_ctrl.P18.GatPoly v_a.P18.nSD 0.015104f
Cred_4381 di_tg_ctrl.P18.GatPoly v_b.$2601.Metal2 0.0215942f
Cred_4382 di_tg_ctrl.P18.GatPoly v_b.P17.nSD 0.0130565f
Cred_4383 di_tg_ctrl.P18.GatPoly VSS.$17.Metal1 5.70388e-05f
Cred_4384 di_tg_ctrl.P18.GatPoly VSS.$301.Metal1 5.56997e-06f
Cred_4385 di_tg_ctrl.P18.GatPoly VSS.$606.Metal2 5.88531e-07f
Cred_4386 di_tg_ctrl.P18.GatPoly VSS.$760.Metal3 3.48226e-08f
Cred_4387 di_tg_ctrl.P18.GatPoly VSS.P0.pSD 0.00342941f
Cred_4388 di_tg_ctrl.P19.GatPoly VSS 0.0127329f
Cred_4389 di_tg_ctrl.P19.GatPoly v_a.$2447.Metal3 0.0186945f
Cred_4390 di_tg_ctrl.P19.GatPoly v_a.P18.nSD 0.0152165f
Cred_4391 di_tg_ctrl.P19.GatPoly v_b.$2631.Metal2 0.0216888f
Cred_4392 di_tg_ctrl.P19.GatPoly v_b.P19.nSD 0.0131289f
Cred_4393 di_tg_ctrl.P19.GatPoly VSS.$123.Metal1 2.0534e-05f
Cred_4394 di_tg_ctrl.P19.GatPoly VSS.$135.Metal1 1.02152e-05f
Cred_4395 di_tg_ctrl.P19.GatPoly VSS.$17.Metal1 4.24491e-05f
Cred_4396 di_tg_ctrl.P19.GatPoly VSS.$301.Metal1 4.91455e-06f
Cred_4397 di_tg_ctrl.P19.GatPoly VSS.$442.Metal2 1.58378e-07f
Cred_4398 di_tg_ctrl.P19.GatPoly VSS.$446.Metal2 7.87882e-08f
Cred_4399 di_tg_ctrl.P19.GatPoly VSS.$606.Metal2 5.19279e-07f
Cred_4400 di_tg_ctrl.P19.GatPoly VSS.$760.Metal3 3.0725e-08f
Cred_4401 di_tg_ctrl.P19.GatPoly VSS.P0.pSD 0.00278092f
Cred_4402 di_tg_ctrl.P2.GatPoly VSS 0.0127833f
Cred_4403 di_tg_ctrl.P2.GatPoly v_a 0.0106011f
Cred_4404 di_tg_ctrl.P2.GatPoly v_a.$2215.Metal3 0.00277649f
Cred_4405 di_tg_ctrl.P2.GatPoly v_a.$2237.Metal3 0.00800282f
Cred_4406 di_tg_ctrl.P2.GatPoly v_a.P2.nSD 0.0153871f
Cred_4407 di_tg_ctrl.P2.GatPoly v_b.$2361.Metal2 0.0209673f
Cred_4408 di_tg_ctrl.P2.GatPoly v_b.$2421.Metal2 4.34372e-06f
Cred_4409 di_tg_ctrl.P2.GatPoly v_b.P1.nSD 0.0130635f
Cred_4410 di_tg_ctrl.P2.GatPoly v_b.P3.nSD 8.247e-06f
Cred_4411 di_tg_ctrl.P2.GatPoly v_b.P3.pSD 8.73465e-08f
Cred_4412 di_tg_ctrl.P2.GatPoly VSS.$17.Metal1 0.000358606f
Cred_4413 di_tg_ctrl.P2.GatPoly VSS.$301.Metal1 5.73385e-07f
Cred_4414 di_tg_ctrl.P2.GatPoly VSS.$39.Metal1 3.50706e-05f
Cred_4415 di_tg_ctrl.P2.GatPoly VSS.$606.Metal2 6.05847e-08f
Cred_4416 di_tg_ctrl.P2.GatPoly VSS.$760.Metal3 3.58472e-09f
Cred_4417 di_tg_ctrl.P2.GatPoly VSS.P0.pSD 0.00246952f
Cred_4418 di_tg_ctrl.P20.GatPoly VSS 0.0123426f
Cred_4419 di_tg_ctrl.P20.GatPoly v_a.$2447.Metal3 0.008425f
Cred_4420 di_tg_ctrl.P20.GatPoly v_a.$2485.Metal3 0.00292296f
Cred_4421 di_tg_ctrl.P20.GatPoly v_a.$2507.Metal3 0.008425f
Cred_4422 di_tg_ctrl.P20.GatPoly v_a.P20.nSD 0.0152333f
Cred_4423 di_tg_ctrl.P20.GatPoly v_b.$2631.Metal2 0.0208858f
Cred_4424 di_tg_ctrl.P20.GatPoly v_b.P19.nSD 0.0129918f
Cred_4425 di_tg_ctrl.P20.GatPoly VSS.$17.Metal1 3.58623e-05f
Cred_4426 di_tg_ctrl.P20.GatPoly VSS.$301.Metal1 5.83253e-06f
Cred_4427 di_tg_ctrl.P20.GatPoly VSS.$606.Metal2 6.16274e-07f
Cred_4428 di_tg_ctrl.P20.GatPoly VSS.$760.Metal3 3.64641e-08f
Cred_4429 di_tg_ctrl.P20.GatPoly VSS.P0.pSD 0.00278641f
Cred_4430 di_tg_ctrl.P21.GatPoly di_tg_ctrl_n.P0.GatPoly 0.00192974f
Cred_4431 di_tg_ctrl.P21.GatPoly VSS 0.0127329f
Cred_4432 di_tg_ctrl.P21.GatPoly v_a.$2447.Metal3 0.00870257f
Cred_4433 di_tg_ctrl.P21.GatPoly v_a.$2485.Metal3 0.00301926f
Cred_4434 di_tg_ctrl.P21.GatPoly v_a.$2507.Metal3 0.00870257f
Cred_4435 di_tg_ctrl.P21.GatPoly v_a.P20.nSD 0.0153494f
Cred_4436 di_tg_ctrl.P21.GatPoly v_b.$2631.Metal2 0.0110497f
Cred_4437 di_tg_ctrl.P21.GatPoly v_b.$2691.Metal2 0.0110497f
Cred_4438 di_tg_ctrl.P21.GatPoly v_b.P21.nSD 0.0133202f
Cred_4439 di_tg_ctrl.P21.GatPoly v_b.P21.pSD 0.000222195f
Cred_4440 di_tg_ctrl.P21.GatPoly VSS.$135.Metal1 1.87134e-05f
Cred_4441 di_tg_ctrl.P21.GatPoly VSS.$145.Metal1 6.9711e-06f
Cred_4442 di_tg_ctrl.P21.GatPoly VSS.$17.Metal1 3.29749e-05f
Cred_4443 di_tg_ctrl.P21.GatPoly VSS.$301.Metal1 6.35392e-06f
Cred_4444 di_tg_ctrl.P21.GatPoly VSS.$454.Metal2 5.37602e-08f
Cred_4445 di_tg_ctrl.P21.GatPoly VSS.$606.Metal2 6.71365e-07f
Cred_4446 di_tg_ctrl.P21.GatPoly VSS.$760.Metal3 3.97238e-08f
Cred_4447 di_tg_ctrl.P21.GatPoly VSS.P0.pSD 0.00278874f
Cred_4448 di_tg_ctrl.P22.GatPoly di_tg_ctrl_n.P0.GatPoly 0.0020709f
Cred_4449 di_tg_ctrl.P22.GatPoly VSS 0.0123426f
Cred_4450 di_tg_ctrl.P22.GatPoly v_a.$2507.Metal3 0.0204311f
Cred_4451 di_tg_ctrl.P22.GatPoly v_a.P22.nSD 0.0151745f
Cred_4452 di_tg_ctrl.P22.GatPoly v_b.$2631.Metal2 0.0106314f
Cred_4453 di_tg_ctrl.P22.GatPoly v_b.$2691.Metal2 0.0106314f
Cred_4454 di_tg_ctrl.P22.GatPoly v_b.P21.nSD 0.0131741f
Cred_4455 di_tg_ctrl.P22.GatPoly v_b.P21.pSD 0.000213783f
Cred_4456 di_tg_ctrl.P22.GatPoly VSS.$17.Metal1 2.79062e-05f
Cred_4457 di_tg_ctrl.P22.GatPoly VSS.$301.Metal1 7.54066e-06f
Cred_4458 di_tg_ctrl.P22.GatPoly VSS.$606.Metal2 7.96758e-07f
Cred_4459 di_tg_ctrl.P22.GatPoly VSS.$760.Metal3 4.71431e-08f
Cred_4460 di_tg_ctrl.P22.GatPoly VSS.P0.pSD 0.00279247f
Cred_4461 di_tg_ctrl.P23.GatPoly di_tg_ctrl_n.P0.GatPoly 0.00223435f
Cred_4462 di_tg_ctrl.P23.GatPoly VSS 0.0127329f
Cred_4463 di_tg_ctrl.P23.GatPoly v_a.$2507.Metal3 0.0205054f
Cred_4464 di_tg_ctrl.P23.GatPoly v_a.P22.nSD 0.0152743f
Cred_4465 di_tg_ctrl.P23.GatPoly v_b.$2691.Metal2 0.0216888f
Cred_4466 di_tg_ctrl.P23.GatPoly v_b.P23.nSD 0.0131289f
Cred_4467 di_tg_ctrl.P23.GatPoly VSS.$145.Metal1 1.54522e-05f
Cred_4468 di_tg_ctrl.P23.GatPoly VSS.$153.Metal1 1.54516e-05f
Cred_4469 di_tg_ctrl.P23.GatPoly VSS.$17.Metal1 2.56877e-05f
Cred_4470 di_tg_ctrl.P23.GatPoly VSS.$301.Metal1 8.21471e-06f
Cred_4471 di_tg_ctrl.P23.GatPoly VSS.$462.Metal2 1.19183e-07f
Cred_4472 di_tg_ctrl.P23.GatPoly VSS.$606.Metal2 8.67978e-07f
Cred_4473 di_tg_ctrl.P23.GatPoly VSS.$760.Metal3 5.13571e-08f
Cred_4474 di_tg_ctrl.P23.GatPoly VSS.P0.pSD 0.00279398f
Cred_4475 di_tg_ctrl.P24.GatPoly di_tg_ctrl_n.P0.GatPoly 0.0024258f
Cred_4476 di_tg_ctrl.P24.GatPoly VSS 0.0123426f
Cred_4477 di_tg_ctrl.P24.GatPoly v_a.$2507.Metal3 0.0086721f
Cred_4478 di_tg_ctrl.P24.GatPoly v_a.$2545.Metal3 0.00300869f
Cred_4479 di_tg_ctrl.P24.GatPoly v_a.$2567.Metal3 0.0086721f
Cred_4480 di_tg_ctrl.P24.GatPoly v_a.P24.nSD 0.0152527f
Cred_4481 di_tg_ctrl.P24.GatPoly v_b.$2691.Metal2 0.0208858f
Cred_4482 di_tg_ctrl.P24.GatPoly v_b.P23.nSD 0.0129918f
Cred_4483 di_tg_ctrl.P24.GatPoly VSS.$17.Metal1 2.1801e-05f
Cred_4484 di_tg_ctrl.P24.GatPoly VSS.$301.Metal1 9.74891e-06f
Cred_4485 di_tg_ctrl.P24.GatPoly VSS.$606.Metal2 1.03008e-06f
Cred_4486 di_tg_ctrl.P24.GatPoly VSS.$760.Metal3 6.09487e-08f
Cred_4487 di_tg_ctrl.P24.GatPoly VSS.P0.pSD 0.00279612f
Cred_4488 di_tg_ctrl.P25.GatPoly di_tg_ctrl_n.P0.GatPoly 0.00265313f
Cred_4489 di_tg_ctrl.P25.GatPoly VSS 0.0127329f
Cred_4490 di_tg_ctrl.P25.GatPoly v_a.$2507.Metal3 0.00870365f
Cred_4491 di_tg_ctrl.P25.GatPoly v_a.$2545.Metal3 0.00301963f
Cred_4492 di_tg_ctrl.P25.GatPoly v_a.$2567.Metal3 0.00870365f
Cred_4493 di_tg_ctrl.P25.GatPoly v_a.P24.nSD 0.0153528f
Cred_4494 di_tg_ctrl.P25.GatPoly v_b.$2691.Metal2 0.0110957f
Cred_4495 di_tg_ctrl.P25.GatPoly v_b.$2751.Metal2 0.0110957f
Cred_4496 di_tg_ctrl.P25.GatPoly v_b.P25.nSD 0.0133292f
Cred_4497 di_tg_ctrl.P25.GatPoly v_b.P25.pSD 0.00022312f
Cred_4498 di_tg_ctrl.P25.GatPoly VSS.$153.Metal1 6.21782e-06f
Cred_4499 di_tg_ctrl.P25.GatPoly VSS.$163.Metal1 1.94758e-05f
Cred_4500 di_tg_ctrl.P25.GatPoly VSS.$17.Metal1 2.01042e-05f
Cred_4501 di_tg_ctrl.P25.GatPoly VSS.$301.Metal1 1.06203e-05f
Cred_4502 di_tg_ctrl.P25.GatPoly VSS.$470.Metal2 4.79559e-08f
Cred_4503 di_tg_ctrl.P25.GatPoly VSS.$606.Metal2 1.12216e-06f
Cred_4504 di_tg_ctrl.P25.GatPoly VSS.$760.Metal3 6.63966e-08f
Cred_4505 di_tg_ctrl.P25.GatPoly VSS.P0.pSD 0.00279686f
Cred_4506 di_tg_ctrl.P26.GatPoly di_tg_ctrl_n.P0.GatPoly 0.00292748f
Cred_4507 di_tg_ctrl.P26.GatPoly VSS 0.0139636f
Cred_4508 di_tg_ctrl.P26.GatPoly v_a.$2567.Metal3 0.0206146f
Cred_4509 di_tg_ctrl.P26.GatPoly v_a.P26.nSD 0.0154209f
Cred_4510 di_tg_ctrl.P26.GatPoly v_b.$2691.Metal2 0.0107358f
Cred_4511 di_tg_ctrl.P26.GatPoly v_b.$2751.Metal2 0.0107358f
Cred_4512 di_tg_ctrl.P26.GatPoly v_b.P25.nSD 0.0133716f
Cred_4513 di_tg_ctrl.P26.GatPoly v_b.P25.pSD 0.000215882f
Cred_4514 di_tg_ctrl.P26.GatPoly VSS 0.00012543f
Cred_4515 di_tg_ctrl.P26.GatPoly VSS.$163.Metal1 3.63806e-05f
Cred_4516 di_tg_ctrl.P26.GatPoly VSS.$17.Metal1 1.85549e-05f
Cred_4517 di_tg_ctrl.P26.GatPoly VSS.$177.Metal1 1.30431e-05f
Cred_4518 di_tg_ctrl.P26.GatPoly VSS.$301.Metal1 1.15696e-05f
Cred_4519 di_tg_ctrl.P26.GatPoly VSS.$478.Metal2 2.80571e-07f
Cred_4520 di_tg_ctrl.P26.GatPoly VSS.$482.Metal2 2.02209e-07f
Cred_4521 di_tg_ctrl.P26.GatPoly VSS.$486.Metal2 1.00589e-07f
Cred_4522 di_tg_ctrl.P26.GatPoly VSS.$606.Metal2 1.22246e-06f
Cred_4523 di_tg_ctrl.P26.GatPoly VSS.$760.Metal3 7.23314e-08f
Cred_4524 di_tg_ctrl.P26.GatPoly VSS.P0.pSD 0.00279746f
Cred_4525 di_tg_ctrl.P27.GatPoly di_tg_ctrl_n.P0.GatPoly 0.00326512f
Cred_4526 di_tg_ctrl.P27.GatPoly VSS 0.0123426f
Cred_4527 di_tg_ctrl.P27.GatPoly v_a.$2567.Metal3 0.0204311f
Cred_4528 di_tg_ctrl.P27.GatPoly v_a.P26.nSD 0.0151745f
Cred_4529 di_tg_ctrl.P27.GatPoly v_b.$2751.Metal2 0.0216127f
Cred_4530 di_tg_ctrl.P27.GatPoly v_b.P27.nSD 0.0130582f
Cred_4531 di_tg_ctrl.P27.GatPoly VSS.$17.Metal1 1.58115e-05f
Cred_4532 di_tg_ctrl.P27.GatPoly VSS.$301.Metal1 1.3577e-05f
Cred_4533 di_tg_ctrl.P27.GatPoly VSS.$606.Metal2 1.43457e-06f
Cred_4534 di_tg_ctrl.P27.GatPoly VSS.$760.Metal3 8.48816e-08f
Cred_4535 di_tg_ctrl.P27.GatPoly VSS.P0.pSD 0.00279785f
Cred_4536 di_tg_ctrl.P28.GatPoly di_tg_ctrl_n.$86.GatPoly 1.88443e-05f
Cred_4537 di_tg_ctrl.P28.GatPoly di_tg_ctrl_n.P0.GatPoly 0.00369078f
Cred_4538 di_tg_ctrl.P28.GatPoly VSS 0.0127329f
Cred_4539 di_tg_ctrl.P28.GatPoly v_a.$2597.Metal3 0.0205054f
Cred_4540 di_tg_ctrl.P28.GatPoly v_a.P28.nSD 0.0152743f
Cred_4541 di_tg_ctrl.P28.GatPoly v_b.$2751.Metal2 0.0209619f
Cred_4542 di_tg_ctrl.P28.GatPoly v_b.P27.nSD 0.0130626f
Cred_4543 di_tg_ctrl.P28.GatPoly VSS.$17.Metal1 1.33233e-05f
Cred_4544 di_tg_ctrl.P28.GatPoly VSS.$177.Metal1 2.15208e-05f
Cred_4545 di_tg_ctrl.P28.GatPoly VSS.$191.Metal1 4.11038e-06f
Cred_4546 di_tg_ctrl.P28.GatPoly VSS.$301.Metal1 1.59523e-05f
Cred_4547 di_tg_ctrl.P28.GatPoly VSS.$494.Metal2 6.37269e-08f
Cred_4548 di_tg_ctrl.P28.GatPoly VSS.$498.Metal2 3.17047e-08f
Cred_4549 di_tg_ctrl.P28.GatPoly VSS.$606.Metal2 1.68555e-06f
Cred_4550 di_tg_ctrl.P28.GatPoly VSS.$760.Metal3 9.97315e-08f
Cred_4551 di_tg_ctrl.P28.GatPoly VSS.P0.pSD 0.00279773f
Cred_4552 di_tg_ctrl.P29.GatPoly di_tg_ctrl_n.P0.GatPoly 0.00424407f
Cred_4553 di_tg_ctrl.P29.GatPoly VSS 0.0123426f
Cred_4554 di_tg_ctrl.P29.GatPoly v_a.$2597.Metal3 0.0204311f
Cred_4555 di_tg_ctrl.P29.GatPoly v_a.P28.nSD 0.0151745f
Cred_4556 di_tg_ctrl.P29.GatPoly v_b.$2751.Metal2 0.0107555f
Cred_4557 di_tg_ctrl.P29.GatPoly v_b.$2811.Metal2 0.0107555f
Cred_4558 di_tg_ctrl.P29.GatPoly v_b.P29.nSD 0.0131985f
Cred_4559 di_tg_ctrl.P29.GatPoly v_b.P29.pSD 0.000216279f
Cred_4560 di_tg_ctrl.P29.GatPoly VSS.$17.Metal1 1.22301e-05f
Cred_4561 di_tg_ctrl.P29.GatPoly VSS.$301.Metal1 1.73109e-05f
Cred_4562 di_tg_ctrl.P29.GatPoly VSS.$606.Metal2 1.82909e-06f
Cred_4563 di_tg_ctrl.P29.GatPoly VSS.$760.Metal3 1.08225e-07f
Cred_4564 di_tg_ctrl.P29.GatPoly VSS.P0.pSD 0.00279728f
Cred_4565 di_tg_ctrl.P3.GatPoly VSS 0.0127833f
Cred_4566 di_tg_ctrl.P3.GatPoly v_a 0.0106011f
Cred_4567 di_tg_ctrl.P3.GatPoly v_a.$2215.Metal3 0.00277649f
Cred_4568 di_tg_ctrl.P3.GatPoly v_a.$2237.Metal3 0.00800282f
Cred_4569 di_tg_ctrl.P3.GatPoly v_a.P2.nSD 0.0153871f
Cred_4570 di_tg_ctrl.P3.GatPoly v_b.$2361.Metal2 0.0106873f
Cred_4571 di_tg_ctrl.P3.GatPoly v_b.$2421.Metal2 0.0106785f
Cred_4572 di_tg_ctrl.P3.GatPoly v_b.P1.nSD 8.19894e-06f
Cred_4573 di_tg_ctrl.P3.GatPoly v_b.P3.nSD 0.013248f
Cred_4574 di_tg_ctrl.P3.GatPoly v_b.P3.pSD 0.00021473f
Cred_4575 di_tg_ctrl.P3.GatPoly VSS.$17.Metal1 0.000329189f
Cred_4576 di_tg_ctrl.P3.GatPoly VSS.$301.Metal1 6.25452e-07f
Cred_4577 di_tg_ctrl.P3.GatPoly VSS.$39.Metal1 3.50706e-05f
Cred_4578 di_tg_ctrl.P3.GatPoly VSS.$606.Metal2 6.60863e-08f
Cred_4579 di_tg_ctrl.P3.GatPoly VSS.$760.Metal3 3.91024e-09f
Cred_4580 di_tg_ctrl.P3.GatPoly VSS.P0.pSD 0.00249888f
Cred_4581 di_tg_ctrl.P30.GatPoly di_tg_ctrl_n.$86.GatPoly 2.53968e-05f
Cred_4582 di_tg_ctrl.P30.GatPoly di_tg_ctrl_n.P0.GatPoly 0.00499251f
Cred_4583 di_tg_ctrl.P30.GatPoly VSS 0.0127329f
Cred_4584 di_tg_ctrl.P30.GatPoly v_a.$2597.Metal3 0.00870376f
Cred_4585 di_tg_ctrl.P30.GatPoly v_a.$2635.Metal3 0.00301967f
Cred_4586 di_tg_ctrl.P30.GatPoly v_a.$2657.Metal3 0.00870376f
Cred_4587 di_tg_ctrl.P30.GatPoly v_a.P30.nSD 0.0153532f
Cred_4588 di_tg_ctrl.P30.GatPoly v_b.$2751.Metal2 0.0103201f
Cred_4589 di_tg_ctrl.P30.GatPoly v_b.$2811.Metal2 0.0103201f
Cred_4590 di_tg_ctrl.P30.GatPoly v_b.P29.nSD 0.0131768f
Cred_4591 di_tg_ctrl.P30.GatPoly v_b.P29.pSD 0.000207524f
Cred_4592 di_tg_ctrl.P30.GatPoly VSS.$17.Metal1 1.03055e-05f
Cred_4593 di_tg_ctrl.P30.GatPoly VSS.$191.Metal1 3.10599e-05f
Cred_4594 di_tg_ctrl.P30.GatPoly VSS.$301.Metal1 2.04197e-05f
Cred_4595 di_tg_ctrl.P30.GatPoly VSS.$606.Metal2 2.15758e-06f
Cred_4596 di_tg_ctrl.P30.GatPoly VSS.$760.Metal3 1.27661e-07f
Cred_4597 di_tg_ctrl.P30.GatPoly VSS.P0.pSD 0.00279575f
Cred_4598 di_tg_ctrl.P31.GatPoly di_tg_ctrl_n.P0.GatPoly 0.00606144f
Cred_4599 di_tg_ctrl.P31.GatPoly VSS 0.0123426f
Cred_4600 di_tg_ctrl.P31.GatPoly v_a.$2597.Metal3 0.0086721f
Cred_4601 di_tg_ctrl.P31.GatPoly v_a.$2635.Metal3 0.00300869f
Cred_4602 di_tg_ctrl.P31.GatPoly v_a.$2657.Metal3 0.0086721f
Cred_4603 di_tg_ctrl.P31.GatPoly v_a.P30.nSD 0.0152527f
Cred_4604 di_tg_ctrl.P31.GatPoly v_b.$2811.Metal2 0.0216127f
Cred_4605 di_tg_ctrl.P31.GatPoly v_b.P31.nSD 0.0130582f
Cred_4606 di_tg_ctrl.P31.GatPoly VSS.$17.Metal1 9.45993e-06f
Cred_4607 di_tg_ctrl.P31.GatPoly VSS.$301.Metal1 2.21928e-05f
Cred_4608 di_tg_ctrl.P31.GatPoly VSS.$606.Metal2 2.34493e-06f
Cred_4609 di_tg_ctrl.P31.GatPoly VSS.$760.Metal3 1.38746e-07f
Cred_4610 di_tg_ctrl.P31.GatPoly VSS.P0.pSD 0.00279462f
Cred_4611 di_tg_ctrl.P32.GatPoly di_tg_ctrl_n.$86.GatPoly 4.5642e-05f
Cred_4612 di_tg_ctrl.P32.GatPoly di_tg_ctrl_n.P0.GatPoly 0.00771279f
Cred_4613 di_tg_ctrl.P32.GatPoly VSS 0.0127833f
Cred_4614 di_tg_ctrl.P32.GatPoly v_a.$2657.Metal3 0.020515f
Cred_4615 di_tg_ctrl.P32.GatPoly v_a.P32.nSD 0.0152872f
Cred_4616 di_tg_ctrl.P32.GatPoly v_b.$2811.Metal2 0.0209673f
Cred_4617 di_tg_ctrl.P32.GatPoly v_b.$2871.Metal2 4.34372e-06f
Cred_4618 di_tg_ctrl.P32.GatPoly v_b.P31.nSD 0.0130635f
Cred_4619 di_tg_ctrl.P32.GatPoly v_b.P33.nSD 8.247e-06f
Cred_4620 di_tg_ctrl.P32.GatPoly v_b.P33.pSD 8.73465e-08f
Cred_4621 di_tg_ctrl.P32.GatPoly VSS.$17.Metal1 7.9712e-06f
Cred_4622 di_tg_ctrl.P32.GatPoly VSS.$191.Metal1 5.2032e-06f
Cred_4623 di_tg_ctrl.P32.GatPoly VSS.$205.Metal1 2.37183e-05f
Cred_4624 di_tg_ctrl.P32.GatPoly VSS.$301.Metal1 2.62414e-05f
Cred_4625 di_tg_ctrl.P32.GatPoly VSS.$506.Metal2 4.01326e-08f
Cred_4626 di_tg_ctrl.P32.GatPoly VSS.$510.Metal2 8.06644e-08f
Cred_4627 di_tg_ctrl.P32.GatPoly VSS.$606.Metal2 2.77271e-06f
Cred_4628 di_tg_ctrl.P32.GatPoly VSS.$760.Metal3 1.64058e-07f
Cred_4629 di_tg_ctrl.P32.GatPoly VSS.P0.pSD 0.00279165f
Cred_4630 di_tg_ctrl.P33.GatPoly di_tg_ctrl_n.$86.GatPoly 5.84824e-05f
Cred_4631 di_tg_ctrl.P33.GatPoly di_tg_ctrl_n.P0.GatPoly 0.0117077f
Cred_4632 di_tg_ctrl.P33.GatPoly VSS 0.0127833f
Cred_4633 di_tg_ctrl.P33.GatPoly v_a.$2657.Metal3 0.0208799f
Cred_4634 di_tg_ctrl.P33.GatPoly v_a.P32.nSD 0.015298f
Cred_4635 di_tg_ctrl.P33.GatPoly v_b.$2811.Metal2 0.01071f
Cred_4636 di_tg_ctrl.P33.GatPoly v_b.$2871.Metal2 0.0107012f
Cred_4637 di_tg_ctrl.P33.GatPoly v_b.P31.nSD 8.19894e-06f
Cred_4638 di_tg_ctrl.P33.GatPoly v_b.P33.nSD 0.0132525f
Cred_4639 di_tg_ctrl.P33.GatPoly v_b.P33.pSD 0.000215186f
Cred_4640 di_tg_ctrl.P33.GatPoly VSS.$17.Metal1 7.31713e-06f
Cred_4641 di_tg_ctrl.P33.GatPoly VSS.$191.Metal1 5.2032e-06f
Cred_4642 di_tg_ctrl.P33.GatPoly VSS.$205.Metal1 2.37183e-05f
Cred_4643 di_tg_ctrl.P33.GatPoly VSS.$301.Metal1 2.85466e-05f
Cred_4644 di_tg_ctrl.P33.GatPoly VSS.$506.Metal2 4.01326e-08f
Cred_4645 di_tg_ctrl.P33.GatPoly VSS.$510.Metal2 8.06644e-08f
Cred_4646 di_tg_ctrl.P33.GatPoly VSS.$606.Metal2 3.01628e-06f
Cred_4647 di_tg_ctrl.P33.GatPoly VSS.$760.Metal3 1.78469e-07f
Cred_4648 di_tg_ctrl.P33.GatPoly VSS.P0.pSD 0.00278974f
Cred_4649 di_tg_ctrl.P34.GatPoly di_tg_ctrl_n.$103.GatPoly 3.57108e-05f
Cred_4650 di_tg_ctrl.P34.GatPoly di_tg_ctrl_n.$223.Metal1 5.80448e-05f
Cred_4651 di_tg_ctrl.P34.GatPoly di_tg_ctrl_n.$227.Metal1 9.62765e-06f
Cred_4652 di_tg_ctrl.P34.GatPoly di_tg_ctrl_n.$232.Metal1 5.73765e-06f
Cred_4653 di_tg_ctrl.P34.GatPoly di_tg_ctrl_n.$234.Metal1 9.94864e-06f
Cred_4654 di_tg_ctrl.P34.GatPoly di_tg_ctrl_n.$238.Metal1 4.17143e-06f
Cred_4655 di_tg_ctrl.P34.GatPoly di_tg_ctrl_n.$352.Metal2 2.12306e-08f
Cred_4656 di_tg_ctrl.P34.GatPoly di_tg_ctrl_n.$443.Metal3 3.97699e-10f
Cred_4657 di_tg_ctrl.P34.GatPoly di_tg_ctrl_n.$86.GatPoly 0.00227507f
Cred_4658 di_tg_ctrl.P34.GatPoly di_tg_ctrl_n.$89.GatPoly 0.000203322f
Cred_4659 di_tg_ctrl.P34.GatPoly di_tg_ctrl_n.$93.GatPoly 7.63198e-05f
Cred_4660 di_tg_ctrl.P34.GatPoly di_tg_ctrl_n.$95.GatPoly 7.66773e-05f
Cred_4661 di_tg_ctrl.P34.GatPoly di_tg_ctrl_n.$99.GatPoly 5.87113e-05f
Cred_4662 di_tg_ctrl.P34.GatPoly di_tg_ctrl_n.P0.GatPoly 0.0181069f
Cred_4663 di_tg_ctrl.P34.GatPoly di_tg_ctrl_n.P1.GatPoly 1.27438e-05f
Cred_4664 di_tg_ctrl.P34.GatPoly di_tg_ctrl_n.P2.GatPoly 2.15281e-06f
Cred_4665 di_tg_ctrl.P34.GatPoly di_tg_ctrl_n.P3.GatPoly 1.67328e-06f
Cred_4666 di_tg_ctrl.P34.GatPoly di_tg_ctrl_n.P5.GatPoly 2.28018e-06f
Cred_4667 di_tg_ctrl.P34.GatPoly di_tg_ctrl_n.P6.GatPoly 8.74811e-07f
Cred_4668 di_tg_ctrl.P34.GatPoly di_tg_ctrl_n.P7.GatPoly 7.82944e-07f
Cred_4669 di_tg_ctrl.P34.GatPoly VSS 0.0155819f
Cred_4670 di_tg_ctrl.P34.GatPoly v_a.$2657.Metal3 0.0198204f
Cred_4671 di_tg_ctrl.P34.GatPoly v_a.P34.nSD 0.0165873f
Cred_4672 di_tg_ctrl.P34.GatPoly v_a.P34.pSD 0.000305112f
Cred_4673 di_tg_ctrl.P34.GatPoly v_b.$2811.Metal2 0.0104176f
Cred_4674 di_tg_ctrl.P34.GatPoly v_b.$2871.Metal2 0.0105745f
Cred_4675 di_tg_ctrl.P34.GatPoly v_b.P33.nSD 0.0133613f
Cred_4676 di_tg_ctrl.P34.GatPoly v_b.P33.pSD 0.000209484f
Cred_4677 di_tg_ctrl.P34.GatPoly v_b.P35.nSD 0.000145874f
Cred_4678 di_tg_ctrl.P34.GatPoly VSS.$17.Metal1 6.16557e-06f
Cred_4679 di_tg_ctrl.P34.GatPoly VSS.$205.Metal1 8.23414e-05f
Cred_4680 di_tg_ctrl.P34.GatPoly VSS.$213.Metal1 0.000281313f
Cred_4681 di_tg_ctrl.P34.GatPoly VSS.$221.Metal1 5.27047e-07f
Cred_4682 di_tg_ctrl.P34.GatPoly VSS.$301.Metal1 3.38035e-05f
Cred_4683 di_tg_ctrl.P34.GatPoly VSS.$518.Metal2 6.33129e-07f
Cred_4684 di_tg_ctrl.P34.GatPoly VSS.$526.Metal2 4.06439e-09f
Cred_4685 di_tg_ctrl.P34.GatPoly VSS.$606.Metal2 3.57174e-06f
Cred_4686 di_tg_ctrl.P34.GatPoly VSS.$760.Metal3 2.11335e-07f
Cred_4687 di_tg_ctrl.P34.GatPoly VSS.P0.pSD 0.00278521f
Cred_4688 di_tg_ctrl.P35.GatPoly di_tg_ctrl_n.$103.GatPoly 5.6578e-05f
Cred_4689 di_tg_ctrl.P35.GatPoly di_tg_ctrl_n.$223.Metal1 6.96349e-05f
Cred_4690 di_tg_ctrl.P35.GatPoly di_tg_ctrl_n.$227.Metal1 1.52535e-05f
Cred_4691 di_tg_ctrl.P35.GatPoly di_tg_ctrl_n.$232.Metal1 9.09038e-06f
Cred_4692 di_tg_ctrl.P35.GatPoly di_tg_ctrl_n.$234.Metal1 1.5762e-05f
Cred_4693 di_tg_ctrl.P35.GatPoly di_tg_ctrl_n.$238.Metal1 6.60897e-06f
Cred_4694 di_tg_ctrl.P35.GatPoly di_tg_ctrl_n.$352.Metal2 3.36365e-08f
Cred_4695 di_tg_ctrl.P35.GatPoly di_tg_ctrl_n.$443.Metal3 6.3009e-10f
Cred_4696 di_tg_ctrl.P35.GatPoly di_tg_ctrl_n.$86.GatPoly 0.00320056f
Cred_4697 di_tg_ctrl.P35.GatPoly di_tg_ctrl_n.$89.GatPoly 0.000279915f
Cred_4698 di_tg_ctrl.P35.GatPoly di_tg_ctrl_n.$93.GatPoly 0.000120916f
Cred_4699 di_tg_ctrl.P35.GatPoly di_tg_ctrl_n.$95.GatPoly 0.000121483f
Cred_4700 di_tg_ctrl.P35.GatPoly di_tg_ctrl_n.$99.GatPoly 9.30186e-05f
Cred_4701 di_tg_ctrl.P35.GatPoly di_tg_ctrl_n.P0.GatPoly 0.106734f
Cred_4702 di_tg_ctrl.P35.GatPoly di_tg_ctrl_n.P1.GatPoly 0.0175169f
Cred_4703 di_tg_ctrl.P35.GatPoly di_tg_ctrl_n.P10.GatPoly 0.00265313f
Cred_4704 di_tg_ctrl.P35.GatPoly di_tg_ctrl_n.P11.GatPoly 0.0024258f
Cred_4705 di_tg_ctrl.P35.GatPoly di_tg_ctrl_n.P12.GatPoly 0.00223435f
Cred_4706 di_tg_ctrl.P35.GatPoly di_tg_ctrl_n.P13.GatPoly 0.0020709f
Cred_4707 di_tg_ctrl.P35.GatPoly di_tg_ctrl_n.P14.GatPoly 0.00192974f
Cred_4708 di_tg_ctrl.P35.GatPoly di_tg_ctrl_n.P2.GatPoly 0.0111597f
Cred_4709 di_tg_ctrl.P35.GatPoly di_tg_ctrl_n.P3.GatPoly 0.00847507f
Cred_4710 di_tg_ctrl.P35.GatPoly di_tg_ctrl_n.P4.GatPoly 0.00606144f
Cred_4711 di_tg_ctrl.P35.GatPoly di_tg_ctrl_n.P5.GatPoly 0.00499612f
Cred_4712 di_tg_ctrl.P35.GatPoly di_tg_ctrl_n.P6.GatPoly 0.00424546f
Cred_4713 di_tg_ctrl.P35.GatPoly di_tg_ctrl_n.P7.GatPoly 0.00369202f
Cred_4714 di_tg_ctrl.P35.GatPoly di_tg_ctrl_n.P8.GatPoly 0.00326512f
Cred_4715 di_tg_ctrl.P35.GatPoly di_tg_ctrl_n.P9.GatPoly 0.00292748f
Cred_4716 di_tg_ctrl.P35.GatPoly VSS 0.0182636f
Cred_4717 di_tg_ctrl.P35.GatPoly v_a.$2657.Metal3 0.014995f
Cred_4718 di_tg_ctrl.P35.GatPoly v_a.P34.nSD 0.0201692f
Cred_4719 di_tg_ctrl.P35.GatPoly v_a.P34.pSD 0.000230829f
Cred_4720 di_tg_ctrl.P35.GatPoly v_b.$2811.Metal2 7.79158e-05f
Cred_4721 di_tg_ctrl.P35.GatPoly v_b.$2871.Metal2 0.024998f
Cred_4722 di_tg_ctrl.P35.GatPoly v_b.P33.nSD 0.000147636f
Cred_4723 di_tg_ctrl.P35.GatPoly v_b.P33.pSD 1.56678e-06f
Cred_4724 di_tg_ctrl.P35.GatPoly v_b.P35.nSD 0.0137866f
Cred_4725 di_tg_ctrl.P35.GatPoly VSS.$17.Metal1 5.7356e-06f
Cred_4726 di_tg_ctrl.P35.GatPoly VSS.$205.Metal1 4.81228e-05f
Cred_4727 di_tg_ctrl.P35.GatPoly VSS.$213.Metal1 0.00337021f
Cred_4728 di_tg_ctrl.P35.GatPoly VSS.$221.Metal1 0.000617483f
Cred_4729 di_tg_ctrl.P35.GatPoly VSS.$301.Metal1 3.72877e-05f
Cred_4730 di_tg_ctrl.P35.GatPoly VSS.$518.Metal2 3.70034e-07f
Cred_4731 di_tg_ctrl.P35.GatPoly VSS.$526.Metal2 0.00219671f
Cred_4732 di_tg_ctrl.P35.GatPoly VSS.$534.Metal2 7.74911e-06f
Cred_4733 di_tg_ctrl.P35.GatPoly VSS.$606.Metal2 3.93987e-06f
Cred_4734 di_tg_ctrl.P35.GatPoly VSS.$716.Metal3 0.00146815f
Cred_4735 di_tg_ctrl.P35.GatPoly VSS.$724.Metal3 0.000484208f
Cred_4736 di_tg_ctrl.P35.GatPoly VSS.$760.Metal3 2.33117e-07f
Cred_4737 di_tg_ctrl.P35.GatPoly VSS.P0.pSD 0.00282279f
Cred_4738 di_tg_ctrl.P36.GatPoly di_tg_ctrl_n.$204.Metal1 8.26804e-07f
Cred_4739 di_tg_ctrl.P36.GatPoly di_tg_ctrl_n.$207.Metal1 4.23546e-06f
Cred_4740 di_tg_ctrl.P36.GatPoly di_tg_ctrl_n.$209.Metal1 2.4427e-06f
Cred_4741 di_tg_ctrl.P36.GatPoly di_tg_ctrl_n.$215.Metal1 5.31715e-06f
Cred_4742 di_tg_ctrl.P36.GatPoly di_tg_ctrl_n.$216.Metal1 8.86184e-06f
Cred_4743 di_tg_ctrl.P36.GatPoly di_tg_ctrl_n.$219.Metal1 0.000252907f
Cred_4744 di_tg_ctrl.P36.GatPoly di_tg_ctrl_n.$471.Metal4 0.000701283f
Cred_4745 di_tg_ctrl.P36.GatPoly di_tg_ctrl_n.$491.Metal4 0.000913107f
Cred_4746 di_tg_ctrl.P36.GatPoly di_tg_ctrl_n.$69.GatPoly 1.77516e-05f
Cred_4747 di_tg_ctrl.P36.GatPoly di_tg_ctrl_n.$72.GatPoly 2.29949e-05f
Cred_4748 di_tg_ctrl.P36.GatPoly di_tg_ctrl_n.$76.GatPoly 3.18886e-05f
Cred_4749 di_tg_ctrl.P36.GatPoly di_tg_ctrl_n.$79.GatPoly 4.58164e-05f
Cred_4750 di_tg_ctrl.P36.GatPoly di_tg_ctrl_n.$83.GatPoly 0.000547949f
Cred_4751 di_tg_ctrl.P36.GatPoly di_tg_ctrl_n.P39.GatPoly 0.00608944f
Cred_4752 di_tg_ctrl.P36.GatPoly di_tg_ctrl_n.P40.GatPoly 0.00647543f
Cred_4753 di_tg_ctrl.P36.GatPoly di_tg_ctrl_n.P41.GatPoly 0.00692235f
Cred_4754 di_tg_ctrl.P36.GatPoly di_tg_ctrl_n.P42.GatPoly 0.00718851f
Cred_4755 di_tg_ctrl.P36.GatPoly di_tg_ctrl_n.P43.GatPoly 0.00781014f
Cred_4756 di_tg_ctrl.P36.GatPoly di_tg_ctrl_n.P44.GatPoly 0.00856032f
Cred_4757 di_tg_ctrl.P36.GatPoly di_tg_ctrl_n.P45.GatPoly 0.00948354f
Cred_4758 di_tg_ctrl.P36.GatPoly di_tg_ctrl_n.P46.GatPoly 0.0106475f
Cred_4759 di_tg_ctrl.P36.GatPoly di_tg_ctrl_n.P47.GatPoly 0.0121605f
Cred_4760 di_tg_ctrl.P36.GatPoly di_tg_ctrl_n.P48.GatPoly 0.0142072f
Cred_4761 di_tg_ctrl.P36.GatPoly di_tg_ctrl_n.P49.GatPoly 0.0171298f
Cred_4762 di_tg_ctrl.P36.GatPoly di_tg_ctrl_n.P50.GatPoly 0.0216452f
Cred_4763 di_tg_ctrl.P36.GatPoly di_tg_ctrl_n.P51.GatPoly 0.0289876f
Cred_4764 di_tg_ctrl.P36.GatPoly di_tg_ctrl_n.P52.GatPoly 0.0463424f
Cred_4765 di_tg_ctrl.P36.GatPoly di_tg_ctrl_n.P53.GatPoly 0.245502f
Cred_4766 di_tg_ctrl.P36.GatPoly VSS 0.000114228f
Cred_4767 di_tg_ctrl.P36.GatPoly v_b.$2871.Metal2 0.0471226f
Cred_4768 di_tg_ctrl.P36.GatPoly v_b.$3779.Metal3 0.0245865f
Cred_4769 di_tg_ctrl.P36.GatPoly v_b.P35.pSD 0.0560926f
Cred_4770 di_tg_ctrl.P36.GatPoly v_b.P37.nSD 2.9395e-05f
Cred_4771 di_tg_ctrl.P36.GatPoly v_b.P37.pSD 0.0548415f
Cred_4772 di_tg_ctrl.P36.GatPoly VDD.$238.Metal1 0.00504424f
Cred_4773 di_tg_ctrl.P36.GatPoly VDD.$247.Metal1 1.91925e-05f
Cred_4774 di_tg_ctrl.P36.GatPoly VDD.$340.Metal1 1.79685e-05f
Cred_4775 di_tg_ctrl.P36.GatPoly VDD.$388.Metal2 3.11557e-08f
Cred_4776 di_tg_ctrl.P36.GatPoly VDD.$42.Metal1 1.4629e-06f
Cred_4777 di_tg_ctrl.P36.GatPoly VDD.$560.Metal2 0.00198146f
Cred_4778 di_tg_ctrl.P36.GatPoly VDD.$568.Metal2 0.00198156f
Cred_4779 di_tg_ctrl.P36.GatPoly VDD.$666.Metal3 1.37164e-09f
Cred_4780 di_tg_ctrl.P36.GatPoly VDD.$750.Metal3 0.000996141f
Cred_4781 di_tg_ctrl.P36.GatPoly VDD.$758.Metal3 0.000996141f
Cred_4782 di_tg_ctrl.P36.GatPoly VDD.P0.nSD 0.00386505f
Cred_4783 di_tg_ctrl.P37.GatPoly di_tg_ctrl_n.$471.Metal4 0.000701283f
Cred_4784 di_tg_ctrl.P37.GatPoly di_tg_ctrl_n.$491.Metal4 0.000913107f
Cred_4785 di_tg_ctrl.P37.GatPoly di_tg_ctrl_n.P53.GatPoly 0.0463382f
Cred_4786 di_tg_ctrl.P37.GatPoly v_b.$2871.Metal2 0.00349638f
Cred_4787 di_tg_ctrl.P37.GatPoly v_b.$2962.Metal2 0.0509485f
Cred_4788 di_tg_ctrl.P37.GatPoly v_b.$3779.Metal3 0.0248126f
Cred_4789 di_tg_ctrl.P37.GatPoly v_b.P37.nSD 2.7092e-05f
Cred_4790 di_tg_ctrl.P37.GatPoly v_b.P37.pSD 0.0525367f
Cred_4791 di_tg_ctrl.P37.GatPoly v_b.P39.pSD 0.051528f
Cred_4792 di_tg_ctrl.P37.GatPoly VDD.$340.Metal1 1.95646e-05f
Cred_4793 di_tg_ctrl.P37.GatPoly VDD.$388.Metal2 2.85999e-08f
Cred_4794 di_tg_ctrl.P37.GatPoly VDD.$42.Metal1 1.34289e-06f
Cred_4795 di_tg_ctrl.P37.GatPoly VDD.$666.Metal3 1.25912e-09f
Cred_4796 di_tg_ctrl.P37.GatPoly VDD.P0.nSD 0.00386355f
Cred_4797 di_tg_ctrl.P38.GatPoly di_tg_ctrl_n.P53.GatPoly 0.0289869f
Cred_4798 di_tg_ctrl.P38.GatPoly v_b.$2962.Metal2 0.0423471f
Cred_4799 di_tg_ctrl.P38.GatPoly v_b.$3053.Metal2 0.012353f
Cred_4800 di_tg_ctrl.P38.GatPoly v_b.$3779.Metal3 0.000759867f
Cred_4801 di_tg_ctrl.P38.GatPoly v_b.$3785.Metal3 0.0271619f
Cred_4802 di_tg_ctrl.P38.GatPoly v_b.P39.pSD 0.0515531f
Cred_4803 di_tg_ctrl.P38.GatPoly v_b.P41.pSD 0.0505652f
Cred_4804 di_tg_ctrl.P38.GatPoly VDD.$340.Metal1 2.31999e-05f
Cred_4805 di_tg_ctrl.P38.GatPoly VDD.$388.Metal2 2.41004e-08f
Cred_4806 di_tg_ctrl.P38.GatPoly VDD.$42.Metal1 1.13162e-06f
Cred_4807 di_tg_ctrl.P38.GatPoly VDD.$666.Metal3 1.06103e-09f
Cred_4808 di_tg_ctrl.P38.GatPoly VDD.P0.nSD 0.00386013f
Cred_4809 di_tg_ctrl.P39.GatPoly di_tg_ctrl_n.$219.Metal1 7.34673e-06f
Cred_4810 di_tg_ctrl.P39.GatPoly di_tg_ctrl_n.$83.GatPoly 3.81314e-05f
Cred_4811 di_tg_ctrl.P39.GatPoly di_tg_ctrl_n.P52.GatPoly 3.00108e-07f
Cred_4812 di_tg_ctrl.P39.GatPoly di_tg_ctrl_n.P53.GatPoly 0.0216456f
Cred_4813 di_tg_ctrl.P39.GatPoly VSS 1.38799e-05f
Cred_4814 di_tg_ctrl.P39.GatPoly v_b.$3053.Metal2 0.0309861f
Cred_4815 di_tg_ctrl.P39.GatPoly v_b.$3056.Metal2 0.0249641f
Cred_4816 di_tg_ctrl.P39.GatPoly v_b.$3089.Metal2 4.89212e-07f
Cred_4817 di_tg_ctrl.P39.GatPoly v_b.$3785.Metal3 0.0275198f
Cred_4818 di_tg_ctrl.P39.GatPoly v_b.$3821.Metal3 0.000389989f
Cred_4819 di_tg_ctrl.P39.GatPoly v_b.P41.pSD 0.0506829f
Cred_4820 di_tg_ctrl.P39.GatPoly v_b.P43.pSD 0.0517177f
Cred_4821 di_tg_ctrl.P39.GatPoly VDD.$251.Metal1 1.15245e-05f
Cred_4822 di_tg_ctrl.P39.GatPoly VDD.$263.Metal1 2.97199e-06f
Cred_4823 di_tg_ctrl.P39.GatPoly VDD.$340.Metal1 2.92498e-05f
Cred_4824 di_tg_ctrl.P39.GatPoly VDD.$388.Metal2 2.56122e-08f
Cred_4825 di_tg_ctrl.P39.GatPoly VDD.$42.Metal1 1.20261e-06f
Cred_4826 di_tg_ctrl.P39.GatPoly VDD.$576.Metal2 4.55072e-08f
Cred_4827 di_tg_ctrl.P39.GatPoly VDD.$580.Metal2 2.23591e-08f
Cred_4828 di_tg_ctrl.P39.GatPoly VDD.$666.Metal3 1.12759e-09f
Cred_4829 di_tg_ctrl.P39.GatPoly VDD.P0.nSD 0.00446654f
Cred_4830 di_tg_ctrl.P4.GatPoly VSS 0.0123426f
Cred_4831 di_tg_ctrl.P4.GatPoly v_a.$2237.Metal3 0.0213687f
Cred_4832 di_tg_ctrl.P4.GatPoly v_a.P4.nSD 0.0152022f
Cred_4833 di_tg_ctrl.P4.GatPoly v_b.$2361.Metal2 0.0102826f
Cred_4834 di_tg_ctrl.P4.GatPoly v_b.$2421.Metal2 0.0102826f
Cred_4835 di_tg_ctrl.P4.GatPoly v_b.P3.nSD 0.0131056f
Cred_4836 di_tg_ctrl.P4.GatPoly v_b.P3.pSD 0.00020677f
Cred_4837 di_tg_ctrl.P4.GatPoly VSS.$17.Metal1 0.000277399f
Cred_4838 di_tg_ctrl.P4.GatPoly VSS.$301.Metal1 7.43763e-07f
Cred_4839 di_tg_ctrl.P4.GatPoly VSS.$606.Metal2 7.85872e-08f
Cred_4840 di_tg_ctrl.P4.GatPoly VSS.$760.Metal3 4.6499e-09f
Cred_4841 di_tg_ctrl.P4.GatPoly VSS.P0.pSD 0.00255053f
Cred_4842 di_tg_ctrl.P40.GatPoly di_tg_ctrl_n.$219.Metal1 1.45007e-05f
Cred_4843 di_tg_ctrl.P40.GatPoly di_tg_ctrl_n.$471.Metal4 0.000986065f
Cred_4844 di_tg_ctrl.P40.GatPoly di_tg_ctrl_n.$491.Metal4 0.00239727f
Cred_4845 di_tg_ctrl.P40.GatPoly di_tg_ctrl_n.$83.GatPoly 7.52623e-05f
Cred_4846 di_tg_ctrl.P40.GatPoly di_tg_ctrl_n.P52.GatPoly 5.92342e-07f
Cred_4847 di_tg_ctrl.P40.GatPoly di_tg_ctrl_n.P53.GatPoly 0.0175151f
Cred_4848 di_tg_ctrl.P40.GatPoly VSS 9.53025e-05f
Cred_4849 di_tg_ctrl.P40.GatPoly v_b.$3053.Metal2 2.44094e-06f
Cred_4850 di_tg_ctrl.P40.GatPoly v_b.$3056.Metal2 0.0504252f
Cred_4851 di_tg_ctrl.P40.GatPoly v_b.$3089.Metal2 0.00557926f
Cred_4852 di_tg_ctrl.P40.GatPoly v_b.$3785.Metal3 0.000875934f
Cred_4853 di_tg_ctrl.P40.GatPoly v_b.$3821.Metal3 0.0271782f
Cred_4854 di_tg_ctrl.P40.GatPoly v_b.P43.pSD 0.05188f
Cred_4855 di_tg_ctrl.P40.GatPoly v_b.P45.pSD 0.0509406f
Cred_4856 di_tg_ctrl.P40.GatPoly VDD.$251.Metal1 8.1191e-06f
Cred_4857 di_tg_ctrl.P40.GatPoly VDD.$263.Metal1 6.6521e-05f
Cred_4858 di_tg_ctrl.P40.GatPoly VDD.$269.Metal1 8.1535e-06f
Cred_4859 di_tg_ctrl.P40.GatPoly VDD.$340.Metal1 2.99701e-05f
Cred_4860 di_tg_ctrl.P40.GatPoly VDD.$388.Metal2 1.86436e-08f
Cred_4861 di_tg_ctrl.P40.GatPoly VDD.$42.Metal1 8.75402e-07f
Cred_4862 di_tg_ctrl.P40.GatPoly VDD.$576.Metal2 3.206e-08f
Cred_4863 di_tg_ctrl.P40.GatPoly VDD.$580.Metal2 9.49731e-08f
Cred_4864 di_tg_ctrl.P40.GatPoly VDD.$584.Metal2 1.01345e-08f
Cred_4865 di_tg_ctrl.P40.GatPoly VDD.$588.Metal2 3.98616e-08f
Cred_4866 di_tg_ctrl.P40.GatPoly VDD.$666.Metal3 8.20794e-10f
Cred_4867 di_tg_ctrl.P40.GatPoly VDD.P0.nSD 0.00385367f
Cred_4868 di_tg_ctrl.P41.GatPoly di_tg_ctrl_n.$471.Metal4 0.00103924f
Cred_4869 di_tg_ctrl.P41.GatPoly di_tg_ctrl_n.$491.Metal4 0.00272353f
Cred_4870 di_tg_ctrl.P41.GatPoly di_tg_ctrl_n.P53.GatPoly 0.014595f
Cred_4871 di_tg_ctrl.P41.GatPoly v_b.$3089.Metal2 0.00732085f
Cred_4872 di_tg_ctrl.P41.GatPoly v_b.$3153.Metal2 0.052204f
Cred_4873 di_tg_ctrl.P41.GatPoly v_b.$3821.Metal3 0.0268442f
Cred_4874 di_tg_ctrl.P41.GatPoly v_b.$3857.Metal3 0.00105873f
Cred_4875 di_tg_ctrl.P41.GatPoly v_b.P45.pSD 0.0505661f
Cred_4876 di_tg_ctrl.P41.GatPoly v_b.P47.pSD 0.0515586f
Cred_4877 di_tg_ctrl.P41.GatPoly VDD.$340.Metal1 3.26429e-05f
Cred_4878 di_tg_ctrl.P41.GatPoly VDD.$388.Metal2 1.71148e-08f
Cred_4879 di_tg_ctrl.P41.GatPoly VDD.$42.Metal1 8.03617e-07f
Cred_4880 di_tg_ctrl.P41.GatPoly VDD.$666.Metal3 7.53486e-10f
Cred_4881 di_tg_ctrl.P41.GatPoly VDD.P0.nSD 0.00385103f
Cred_4882 di_tg_ctrl.P42.GatPoly di_tg_ctrl_n.$471.Metal4 0.000557237f
Cred_4883 di_tg_ctrl.P42.GatPoly di_tg_ctrl_n.$491.Metal4 0.00298511f
Cred_4884 di_tg_ctrl.P42.GatPoly di_tg_ctrl_n.P53.GatPoly 0.012383f
Cred_4885 di_tg_ctrl.P42.GatPoly v_b.$3153.Metal2 0.0537909f
Cred_4886 di_tg_ctrl.P42.GatPoly v_b.$3247.Metal2 0.0119996f
Cred_4887 di_tg_ctrl.P42.GatPoly v_b.$3857.Metal3 0.0147595f
Cred_4888 di_tg_ctrl.P42.GatPoly v_b.$3890.Metal3 0.013207f
Cred_4889 di_tg_ctrl.P42.GatPoly v_b.P47.pSD 0.0515586f
Cred_4890 di_tg_ctrl.P42.GatPoly v_b.P49.nSD 2.32584e-05f
Cred_4891 di_tg_ctrl.P42.GatPoly v_b.P49.pSD 0.0506233f
Cred_4892 di_tg_ctrl.P42.GatPoly VDD.$340.Metal1 3.87279e-05f
Cred_4893 di_tg_ctrl.P42.GatPoly VDD.$388.Metal2 1.44234e-08f
Cred_4894 di_tg_ctrl.P42.GatPoly VDD.$42.Metal1 6.77241e-07f
Cred_4895 di_tg_ctrl.P42.GatPoly VDD.$666.Metal3 6.34994e-10f
Cred_4896 di_tg_ctrl.P42.GatPoly VDD.P0.nSD 0.00384507f
Cred_4897 di_tg_ctrl.P43.GatPoly di_tg_ctrl_n.$219.Metal1 3.51562e-06f
Cred_4898 di_tg_ctrl.P43.GatPoly di_tg_ctrl_n.$471.Metal4 0.000283069f
Cred_4899 di_tg_ctrl.P43.GatPoly di_tg_ctrl_n.$491.Metal4 0.0015164f
Cred_4900 di_tg_ctrl.P43.GatPoly di_tg_ctrl_n.$83.GatPoly 1.82469e-05f
Cred_4901 di_tg_ctrl.P43.GatPoly di_tg_ctrl_n.P52.GatPoly 1.4361e-07f
Cred_4902 di_tg_ctrl.P43.GatPoly di_tg_ctrl_n.P53.GatPoly 0.0111206f
Cred_4903 di_tg_ctrl.P43.GatPoly VSS 1.38799e-05f
Cred_4904 di_tg_ctrl.P43.GatPoly v_b.$3153.Metal2 0.0136077f
Cred_4905 di_tg_ctrl.P43.GatPoly v_b.$3247.Metal2 0.0562129f
Cred_4906 di_tg_ctrl.P43.GatPoly v_b.$3857.Metal3 0.0126112f
Cred_4907 di_tg_ctrl.P43.GatPoly v_b.$3890.Metal3 0.0154272f
Cred_4908 di_tg_ctrl.P43.GatPoly v_b.P49.nSD 2.33052e-05f
Cred_4909 di_tg_ctrl.P43.GatPoly v_b.P49.pSD 0.0507402f
Cred_4910 di_tg_ctrl.P43.GatPoly v_b.P51.pSD 0.0517378f
Cred_4911 di_tg_ctrl.P43.GatPoly VDD.$273.Metal1 1.13805e-05f
Cred_4912 di_tg_ctrl.P43.GatPoly VDD.$283.Metal1 3.11331e-06f
Cred_4913 di_tg_ctrl.P43.GatPoly VDD.$340.Metal1 4.18063e-05f
Cred_4914 di_tg_ctrl.P43.GatPoly VDD.$388.Metal2 1.31222e-08f
Cred_4915 di_tg_ctrl.P43.GatPoly VDD.$42.Metal1 6.16145e-07f
Cred_4916 di_tg_ctrl.P43.GatPoly VDD.$596.Metal2 4.70782e-08f
Cred_4917 di_tg_ctrl.P43.GatPoly VDD.$600.Metal2 2.28359e-08f
Cred_4918 di_tg_ctrl.P43.GatPoly VDD.$666.Metal3 5.7771e-10f
Cred_4919 di_tg_ctrl.P43.GatPoly VDD.P0.nSD 0.00380721f
Cred_4920 di_tg_ctrl.P44.GatPoly di_tg_ctrl_n.$471.Metal4 0.000280109f
Cred_4921 di_tg_ctrl.P44.GatPoly di_tg_ctrl_n.$491.Metal4 0.00150054f
Cred_4922 di_tg_ctrl.P44.GatPoly di_tg_ctrl_n.P53.GatPoly 0.00969774f
Cred_4923 di_tg_ctrl.P44.GatPoly v_b.$3247.Metal2 0.061364f
Cred_4924 di_tg_ctrl.P44.GatPoly v_b.$3294.Metal2 0.00888945f
Cred_4925 di_tg_ctrl.P44.GatPoly v_b.$3890.Metal3 0.00107663f
Cred_4926 di_tg_ctrl.P44.GatPoly v_b.$3903.Metal3 0.0268356f
Cred_4927 di_tg_ctrl.P44.GatPoly v_b.P51.pSD 0.0515586f
Cred_4928 di_tg_ctrl.P44.GatPoly v_b.P53.pSD 0.0505661f
Cred_4929 di_tg_ctrl.P44.GatPoly VDD.$340.Metal1 5.00544e-05f
Cred_4930 di_tg_ctrl.P44.GatPoly VDD.$388.Metal2 1.11597e-08f
Cred_4931 di_tg_ctrl.P44.GatPoly VDD.$42.Metal1 5.23996e-07f
Cred_4932 di_tg_ctrl.P44.GatPoly VDD.$666.Metal3 4.91309e-10f
Cred_4933 di_tg_ctrl.P44.GatPoly VDD.P0.nSD 0.0038339f
Cred_4934 di_tg_ctrl.P45.GatPoly di_tg_ctrl_n.$219.Metal1 2.59014e-06f
Cred_4935 di_tg_ctrl.P45.GatPoly di_tg_ctrl_n.$471.Metal4 0.000269788f
Cred_4936 di_tg_ctrl.P45.GatPoly di_tg_ctrl_n.$491.Metal4 0.00144525f
Cred_4937 di_tg_ctrl.P45.GatPoly di_tg_ctrl_n.$83.GatPoly 2.79771e-05f
Cred_4938 di_tg_ctrl.P45.GatPoly di_tg_ctrl_n.P52.GatPoly 2.2019e-07f
Cred_4939 di_tg_ctrl.P45.GatPoly di_tg_ctrl_n.P53.GatPoly 0.00876987f
Cred_4940 di_tg_ctrl.P45.GatPoly VSS 9.53025e-05f
Cred_4941 di_tg_ctrl.P45.GatPoly v_b.$3294.Metal2 0.00888561f
Cred_4942 di_tg_ctrl.P45.GatPoly v_b.$3344.Metal2 0.0614418f
Cred_4943 di_tg_ctrl.P45.GatPoly v_b.$3435.Metal2 1.08709e-06f
Cred_4944 di_tg_ctrl.P45.GatPoly v_b.$3903.Metal3 0.0272319f
Cred_4945 di_tg_ctrl.P45.GatPoly v_b.$3934.Metal3 0.000862976f
Cred_4946 di_tg_ctrl.P45.GatPoly v_b.P53.pSD 0.0509879f
Cred_4947 di_tg_ctrl.P45.GatPoly v_b.P55.pSD 0.05188f
Cred_4948 di_tg_ctrl.P45.GatPoly VDD.$283.Metal1 1.80654e-05f
Cred_4949 di_tg_ctrl.P45.GatPoly VDD.$287.Metal1 4.17381e-05f
Cred_4950 di_tg_ctrl.P45.GatPoly VDD.$291.Metal1 1.46193e-05f
Cred_4951 di_tg_ctrl.P45.GatPoly VDD.$340.Metal1 5.45247e-05f
Cred_4952 di_tg_ctrl.P45.GatPoly VDD.$388.Metal2 1.02454e-08f
Cred_4953 di_tg_ctrl.P45.GatPoly VDD.$42.Metal1 4.81068e-07f
Cred_4954 di_tg_ctrl.P45.GatPoly VDD.$604.Metal2 4.0882e-08f
Cred_4955 di_tg_ctrl.P45.GatPoly VDD.$612.Metal2 3.40882e-08f
Cred_4956 di_tg_ctrl.P45.GatPoly VDD.$666.Metal3 4.51058e-10f
Cred_4957 di_tg_ctrl.P45.GatPoly VDD.$776.Metal3 2.73312e-10f
Cred_4958 di_tg_ctrl.P45.GatPoly VDD.P0.nSD 0.00382947f
Cred_4959 di_tg_ctrl.P46.GatPoly di_tg_ctrl_n.$219.Metal1 9.34668e-07f
Cred_4960 di_tg_ctrl.P46.GatPoly di_tg_ctrl_n.$471.Metal4 0.000257403f
Cred_4961 di_tg_ctrl.P46.GatPoly di_tg_ctrl_n.$491.Metal4 0.00137891f
Cred_4962 di_tg_ctrl.P46.GatPoly di_tg_ctrl_n.$83.GatPoly 1.00957e-05f
Cred_4963 di_tg_ctrl.P46.GatPoly di_tg_ctrl_n.P52.GatPoly 7.9457e-08f
Cred_4964 di_tg_ctrl.P46.GatPoly di_tg_ctrl_n.P53.GatPoly 0.00801365f
Cred_4965 di_tg_ctrl.P46.GatPoly VSS 1.38799e-05f
Cred_4966 di_tg_ctrl.P46.GatPoly v_b.$3294.Metal2 5.10645e-07f
Cred_4967 di_tg_ctrl.P46.GatPoly v_b.$3344.Metal2 0.0509777f
Cred_4968 di_tg_ctrl.P46.GatPoly v_b.$3435.Metal2 0.0196642f
Cred_4969 di_tg_ctrl.P46.GatPoly v_b.$3903.Metal3 0.000433597f
Cred_4970 di_tg_ctrl.P46.GatPoly v_b.$3934.Metal3 0.0275938f
Cred_4971 di_tg_ctrl.P46.GatPoly v_b.P55.pSD 0.0517389f
Cred_4972 di_tg_ctrl.P46.GatPoly v_b.P57.pSD 0.0506829f
Cred_4973 di_tg_ctrl.P46.GatPoly VDD.$295.Metal1 4.57383e-06f
Cred_4974 di_tg_ctrl.P46.GatPoly VDD.$299.Metal1 9.56346e-06f
Cred_4975 di_tg_ctrl.P46.GatPoly VDD.$340.Metal1 6.47005e-05f
Cred_4976 di_tg_ctrl.P46.GatPoly VDD.$388.Metal2 8.63613e-09f
Cred_4977 di_tg_ctrl.P46.GatPoly VDD.$42.Metal1 4.05505e-07f
Cred_4978 di_tg_ctrl.P46.GatPoly VDD.$612.Metal2 9.81175e-09f
Cred_4979 di_tg_ctrl.P46.GatPoly VDD.$620.Metal2 9.81175e-09f
Cred_4980 di_tg_ctrl.P46.GatPoly VDD.$666.Metal3 3.80209e-10f
Cred_4981 di_tg_ctrl.P46.GatPoly VDD.$780.Metal3 7.86684e-11f
Cred_4982 di_tg_ctrl.P46.GatPoly VDD.P0.nSD 0.00381937f
Cred_4983 di_tg_ctrl.P47.GatPoly di_tg_ctrl_n.$471.Metal4 0.000238086f
Cred_4984 di_tg_ctrl.P47.GatPoly di_tg_ctrl_n.$491.Metal4 0.00127542f
Cred_4985 di_tg_ctrl.P47.GatPoly di_tg_ctrl_n.P53.GatPoly 0.00738226f
Cred_4986 di_tg_ctrl.P47.GatPoly v_b.$3435.Metal2 0.0456025f
Cred_4987 di_tg_ctrl.P47.GatPoly v_b.$3438.Metal2 0.0249192f
Cred_4988 di_tg_ctrl.P47.GatPoly v_b.$3529.Metal2 5.34266e-07f
Cred_4989 di_tg_ctrl.P47.GatPoly v_b.$3934.Metal3 0.0274266f
Cred_4990 di_tg_ctrl.P47.GatPoly v_b.$3970.Metal3 0.000431051f
Cred_4991 di_tg_ctrl.P47.GatPoly v_b.P57.pSD 0.0505661f
Cred_4992 di_tg_ctrl.P47.GatPoly v_b.P59.pSD 0.0515586f
Cred_4993 di_tg_ctrl.P47.GatPoly VDD.$340.Metal1 7.04807e-05f
Cred_4994 di_tg_ctrl.P47.GatPoly VDD.$388.Metal2 7.92931e-09f
Cred_4995 di_tg_ctrl.P47.GatPoly VDD.$42.Metal1 3.72316e-07f
Cred_4996 di_tg_ctrl.P47.GatPoly VDD.$666.Metal3 3.49091e-10f
Cred_4997 di_tg_ctrl.P47.GatPoly VDD.P0.nSD 0.00381363f
Cred_4998 di_tg_ctrl.P48.GatPoly di_tg_ctrl_n.$471.Metal4 0.000221262f
Cred_4999 di_tg_ctrl.P48.GatPoly di_tg_ctrl_n.$491.Metal4 0.0011853f
Cred_5000 di_tg_ctrl.P48.GatPoly di_tg_ctrl_n.P53.GatPoly 0.00684982f
Cred_5001 di_tg_ctrl.P48.GatPoly v_b.$1992.Metal1 0.0108297f
Cred_5002 di_tg_ctrl.P48.GatPoly v_b.$1993.Metal1 0.0038608f
Cred_5003 di_tg_ctrl.P48.GatPoly v_b.$1994.Metal1 0.0038895f
Cred_5004 di_tg_ctrl.P48.GatPoly v_b.$1995.Metal1 0.00578294f
Cred_5005 di_tg_ctrl.P48.GatPoly v_b.$1997.Metal1 0.00575389f
Cred_5006 di_tg_ctrl.P48.GatPoly v_b.$1998.Metal1 0.00386134f
Cred_5007 di_tg_ctrl.P48.GatPoly v_b.$1999.Metal1 0.00388829f
Cred_5008 di_tg_ctrl.P48.GatPoly v_b.$2000.Metal1 0.0076153f
Cred_5009 di_tg_ctrl.P48.GatPoly v_b.$2003.Metal1 0.0214087f
Cred_5010 di_tg_ctrl.P48.GatPoly v_b.$3435.Metal2 2.59942e-06f
Cred_5011 di_tg_ctrl.P48.GatPoly v_b.$3438.Metal2 0.0613667f
Cred_5012 di_tg_ctrl.P48.GatPoly v_b.$3487.Metal2 0.000319385f
Cred_5013 di_tg_ctrl.P48.GatPoly v_b.$3491.Metal2 1.59924e-05f
Cred_5014 di_tg_ctrl.P48.GatPoly v_b.$3495.Metal2 4.41321e-05f
Cred_5015 di_tg_ctrl.P48.GatPoly v_b.$3499.Metal2 1.71872e-05f
Cred_5016 di_tg_ctrl.P48.GatPoly v_b.$3503.Metal2 6.7904e-05f
Cred_5017 di_tg_ctrl.P48.GatPoly v_b.$3505.Metal2 7.85461e-05f
Cred_5018 di_tg_ctrl.P48.GatPoly v_b.$3507.Metal2 0.00264382f
Cred_5019 di_tg_ctrl.P48.GatPoly v_b.$3529.Metal2 0.00977912f
Cred_5020 di_tg_ctrl.P48.GatPoly v_b.$3934.Metal3 0.000843969f
Cred_5021 di_tg_ctrl.P48.GatPoly v_b.$3970.Metal3 0.00188811f
Cred_5022 di_tg_ctrl.P48.GatPoly v_b.$3980.Metal3 0.000515475f
Cred_5023 di_tg_ctrl.P48.GatPoly v_b.$3982.Metal3 4.90975e-08f
Cred_5024 di_tg_ctrl.P48.GatPoly v_b.$3984.Metal3 5.82197e-08f
Cred_5025 di_tg_ctrl.P48.GatPoly v_b.$3986.Metal3 9.12522e-08f
Cred_5026 di_tg_ctrl.P48.GatPoly v_b.$3990.Metal3 0.00133319f
Cred_5027 di_tg_ctrl.P48.GatPoly v_b.P59.pSD 0.0515586f
Cred_5028 di_tg_ctrl.P48.GatPoly v_b.P61.pSD 0.00382157f
Cred_5029 di_tg_ctrl.P48.GatPoly VDD.$340.Metal1 8.36378e-05f
Cred_5030 di_tg_ctrl.P48.GatPoly VDD.$388.Metal2 6.68536e-09f
Cred_5031 di_tg_ctrl.P48.GatPoly VDD.$42.Metal1 3.13907e-07f
Cred_5032 di_tg_ctrl.P48.GatPoly VDD.$666.Metal3 2.94326e-10f
Cred_5033 di_tg_ctrl.P48.GatPoly VDD.P0.nSD 0.00380053f
Cred_5034 di_tg_ctrl.P49.GatPoly di_tg_ctrl_n.$219.Metal1 1.83226e-06f
Cred_5035 di_tg_ctrl.P49.GatPoly di_tg_ctrl_n.$471.Metal4 0.000199467f
Cred_5036 di_tg_ctrl.P49.GatPoly di_tg_ctrl_n.$491.Metal4 0.00106854f
Cred_5037 di_tg_ctrl.P49.GatPoly di_tg_ctrl_n.$83.GatPoly 1.9791e-05f
Cred_5038 di_tg_ctrl.P49.GatPoly di_tg_ctrl_n.P52.GatPoly 1.55763e-07f
Cred_5039 di_tg_ctrl.P49.GatPoly di_tg_ctrl_n.P53.GatPoly 0.00639069f
Cred_5040 di_tg_ctrl.P49.GatPoly VSS 9.53025e-05f
Cred_5041 di_tg_ctrl.P49.GatPoly v_b.$1992.Metal1 0.0108297f
Cred_5042 di_tg_ctrl.P49.GatPoly v_b.$1993.Metal1 0.0038608f
Cred_5043 di_tg_ctrl.P49.GatPoly v_b.$1994.Metal1 0.0038895f
Cred_5044 di_tg_ctrl.P49.GatPoly v_b.$1995.Metal1 0.00578294f
Cred_5045 di_tg_ctrl.P49.GatPoly v_b.$1997.Metal1 0.00575389f
Cred_5046 di_tg_ctrl.P49.GatPoly v_b.$1998.Metal1 0.00386134f
Cred_5047 di_tg_ctrl.P49.GatPoly v_b.$1999.Metal1 0.00388829f
Cred_5048 di_tg_ctrl.P49.GatPoly v_b.$2000.Metal1 0.0076153f
Cred_5049 di_tg_ctrl.P49.GatPoly v_b.$2003.Metal1 0.0216331f
Cred_5050 di_tg_ctrl.P49.GatPoly v_b.$3487.Metal2 0.000319385f
Cred_5051 di_tg_ctrl.P49.GatPoly v_b.$3491.Metal2 1.59924e-05f
Cred_5052 di_tg_ctrl.P49.GatPoly v_b.$3495.Metal2 4.41321e-05f
Cred_5053 di_tg_ctrl.P49.GatPoly v_b.$3499.Metal2 1.71872e-05f
Cred_5054 di_tg_ctrl.P49.GatPoly v_b.$3503.Metal2 6.7904e-05f
Cred_5055 di_tg_ctrl.P49.GatPoly v_b.$3505.Metal2 7.85461e-05f
Cred_5056 di_tg_ctrl.P49.GatPoly v_b.$3507.Metal2 0.00275871f
Cred_5057 di_tg_ctrl.P49.GatPoly v_b.$3529.Metal2 0.00815797f
Cred_5058 di_tg_ctrl.P49.GatPoly v_b.$3535.Metal2 0.0621726f
Cred_5059 di_tg_ctrl.P49.GatPoly v_b.$3565.Metal2 2.45862e-06f
Cred_5060 di_tg_ctrl.P49.GatPoly v_b.$3970.Metal3 0.00183991f
Cred_5061 di_tg_ctrl.P49.GatPoly v_b.$3980.Metal3 0.000515475f
Cred_5062 di_tg_ctrl.P49.GatPoly v_b.$3982.Metal3 4.90975e-08f
Cred_5063 di_tg_ctrl.P49.GatPoly v_b.$3984.Metal3 5.82197e-08f
Cred_5064 di_tg_ctrl.P49.GatPoly v_b.$3986.Metal3 9.12522e-08f
Cred_5065 di_tg_ctrl.P49.GatPoly v_b.$3990.Metal3 0.00141424f
Cred_5066 di_tg_ctrl.P49.GatPoly v_b.$4009.Metal3 0.000882281f
Cred_5067 di_tg_ctrl.P49.GatPoly v_b.P61.pSD 0.0040095f
Cred_5068 di_tg_ctrl.P49.GatPoly v_b.P63.pSD 0.05188f
Cred_5069 di_tg_ctrl.P49.GatPoly VDD.$299.Metal1 6.04473e-06f
Cred_5070 di_tg_ctrl.P49.GatPoly VDD.$309.Metal1 5.33472e-05f
Cred_5071 di_tg_ctrl.P49.GatPoly VDD.$313.Metal1 1.64348e-05f
Cred_5072 di_tg_ctrl.P49.GatPoly VDD.$340.Metal1 9.11113e-05f
Cred_5073 di_tg_ctrl.P49.GatPoly VDD.$388.Metal2 6.13911e-09f
Cred_5074 di_tg_ctrl.P49.GatPoly VDD.$42.Metal1 2.88258e-07f
Cred_5075 di_tg_ctrl.P49.GatPoly VDD.$620.Metal2 3.40985e-08f
Cred_5076 di_tg_ctrl.P49.GatPoly VDD.$624.Metal2 1.17834e-07f
Cred_5077 di_tg_ctrl.P49.GatPoly VDD.$632.Metal2 3.67887e-08f
Cred_5078 di_tg_ctrl.P49.GatPoly VDD.$666.Metal3 2.70277e-10f
Cred_5079 di_tg_ctrl.P49.GatPoly VDD.$786.Metal3 2.94964e-10f
Cred_5080 di_tg_ctrl.P49.GatPoly VDD.P0.nSD 0.00379311f
Cred_5081 di_tg_ctrl.P5.GatPoly VSS 0.0127329f
Cred_5082 di_tg_ctrl.P5.GatPoly v_a.$2237.Metal3 0.0214433f
Cred_5083 di_tg_ctrl.P5.GatPoly v_a.P4.nSD 0.0153023f
Cred_5084 di_tg_ctrl.P5.GatPoly v_b.$2421.Metal2 0.0219224f
Cred_5085 di_tg_ctrl.P5.GatPoly v_b.P5.nSD 0.0131503f
Cred_5086 di_tg_ctrl.P5.GatPoly VSS.$17.Metal1 0.000254646f
Cred_5087 di_tg_ctrl.P5.GatPoly VSS.$301.Metal1 8.10874e-07f
Cred_5088 di_tg_ctrl.P5.GatPoly VSS.$366.Metal2 2.20989e-08f
Cred_5089 di_tg_ctrl.P5.GatPoly VSS.$370.Metal2 4.4421e-08f
Cred_5090 di_tg_ctrl.P5.GatPoly VSS.$39.Metal1 2.86506e-06f
Cred_5091 di_tg_ctrl.P5.GatPoly VSS.$51.Metal1 2.28048e-05f
Cred_5092 di_tg_ctrl.P5.GatPoly VSS.$606.Metal2 8.56782e-08f
Cred_5093 di_tg_ctrl.P5.GatPoly VSS.$760.Metal3 5.06947e-09f
Cred_5094 di_tg_ctrl.P5.GatPoly VSS.P0.pSD 0.00257323f
Cred_5095 di_tg_ctrl.P50.GatPoly di_tg_ctrl_n.$219.Metal1 6.79824e-07f
Cred_5096 di_tg_ctrl.P50.GatPoly di_tg_ctrl_n.$471.Metal4 0.00018269f
Cred_5097 di_tg_ctrl.P50.GatPoly di_tg_ctrl_n.$491.Metal4 0.00097867f
Cred_5098 di_tg_ctrl.P50.GatPoly di_tg_ctrl_n.$83.GatPoly 7.34305e-06f
Cred_5099 di_tg_ctrl.P50.GatPoly di_tg_ctrl_n.P52.GatPoly 5.77925e-08f
Cred_5100 di_tg_ctrl.P50.GatPoly di_tg_ctrl_n.P53.GatPoly 0.00599456f
Cred_5101 di_tg_ctrl.P50.GatPoly VSS 1.38799e-05f
Cred_5102 di_tg_ctrl.P50.GatPoly v_b.$3529.Metal2 4.89212e-07f
Cred_5103 di_tg_ctrl.P50.GatPoly v_b.$3535.Metal2 0.02497f
Cred_5104 di_tg_ctrl.P50.GatPoly v_b.$3565.Metal2 0.0457895f
Cred_5105 di_tg_ctrl.P50.GatPoly v_b.$3970.Metal3 0.000389989f
Cred_5106 di_tg_ctrl.P50.GatPoly v_b.$4009.Metal3 0.0275198f
Cred_5107 di_tg_ctrl.P50.GatPoly v_b.P63.pSD 0.0517389f
Cred_5108 di_tg_ctrl.P50.GatPoly v_b.P65.pSD 0.0506829f
Cred_5109 di_tg_ctrl.P50.GatPoly VDD.$317.Metal1 3.29016e-06f
Cred_5110 di_tg_ctrl.P50.GatPoly VDD.$321.Metal1 7.89638e-06f
Cred_5111 di_tg_ctrl.P50.GatPoly VDD.$340.Metal1 0.000108122f
Cred_5112 di_tg_ctrl.P50.GatPoly VDD.$388.Metal2 5.17798e-09f
Cred_5113 di_tg_ctrl.P50.GatPoly VDD.$42.Metal1 2.43129e-07f
Cred_5114 di_tg_ctrl.P50.GatPoly VDD.$632.Metal2 7.3649e-09f
Cred_5115 di_tg_ctrl.P50.GatPoly VDD.$640.Metal2 7.3649e-09f
Cred_5116 di_tg_ctrl.P50.GatPoly VDD.$666.Metal3 2.27963e-10f
Cred_5117 di_tg_ctrl.P50.GatPoly VDD.$790.Metal3 5.90501e-11f
Cred_5118 di_tg_ctrl.P50.GatPoly VDD.P0.nSD 0.00377612f
Cred_5119 di_tg_ctrl.P51.GatPoly di_tg_ctrl_n.$471.Metal4 0.000273614f
Cred_5120 di_tg_ctrl.P51.GatPoly di_tg_ctrl_n.$491.Metal4 0.00146575f
Cred_5121 di_tg_ctrl.P51.GatPoly v_b.$3565.Metal2 0.0187482f
Cred_5122 di_tg_ctrl.P51.GatPoly v_b.$3629.Metal2 0.0514233f
Cred_5123 di_tg_ctrl.P51.GatPoly v_b.$4009.Metal3 0.0272001f
Cred_5124 di_tg_ctrl.P51.GatPoly v_b.$4042.Metal3 0.000773268f
Cred_5125 di_tg_ctrl.P51.GatPoly v_b.P65.pSD 0.0505661f
Cred_5126 di_tg_ctrl.P51.GatPoly v_b.P67.pSD 0.0515586f
Cred_5127 di_tg_ctrl.P51.GatPoly VDD.$340.Metal1 0.000117785f
Cred_5128 di_tg_ctrl.P51.GatPoly VDD.$388.Metal2 4.75607e-09f
Cred_5129 di_tg_ctrl.P51.GatPoly VDD.$42.Metal1 2.23319e-07f
Cred_5130 di_tg_ctrl.P51.GatPoly VDD.$666.Metal3 2.09388e-10f
Cred_5131 di_tg_ctrl.P51.GatPoly VDD.P0.nSD 0.00376648f
Cred_5132 di_tg_ctrl.P52.GatPoly v_b 0.00598437f
Cred_5133 di_tg_ctrl.P52.GatPoly v_b.$2244.Metal1 0.012747f
Cred_5134 di_tg_ctrl.P52.GatPoly v_b.$2246.Metal1 0.00578062f
Cred_5135 di_tg_ctrl.P52.GatPoly v_b.$2247.Metal1 0.00578294f
Cred_5136 di_tg_ctrl.P52.GatPoly v_b.$2249.Metal1 0.00767374f
Cred_5137 di_tg_ctrl.P52.GatPoly v_b.$2251.Metal1 0.00577778f
Cred_5138 di_tg_ctrl.P52.GatPoly v_b.$2252.Metal1 0.0076153f
Cred_5139 di_tg_ctrl.P52.GatPoly v_b.$2255.Metal1 0.0215277f
Cred_5140 di_tg_ctrl.P52.GatPoly v_b.$3629.Metal2 0.0644638f
Cred_5141 di_tg_ctrl.P52.GatPoly v_b.$3678.Metal2 0.000302548f
Cred_5142 di_tg_ctrl.P52.GatPoly v_b.$3680.Metal2 2.85616e-05f
Cred_5143 di_tg_ctrl.P52.GatPoly v_b.$3682.Metal2 2.39448e-05f
Cred_5144 di_tg_ctrl.P52.GatPoly v_b.$3686.Metal2 4.10824e-05f
Cred_5145 di_tg_ctrl.P52.GatPoly v_b.$3688.Metal2 1.40376e-05f
Cred_5146 di_tg_ctrl.P52.GatPoly v_b.$3690.Metal2 3.77812e-05f
Cred_5147 di_tg_ctrl.P52.GatPoly v_b.$3694.Metal2 6.7904e-05f
Cred_5148 di_tg_ctrl.P52.GatPoly v_b.$3696.Metal2 7.85461e-05f
Cred_5149 di_tg_ctrl.P52.GatPoly v_b.$3698.Metal2 0.00272381f
Cred_5150 di_tg_ctrl.P52.GatPoly v_b.$4042.Metal3 0.00217582f
Cred_5151 di_tg_ctrl.P52.GatPoly v_b.$4053.Metal3 0.00110495f
Cred_5152 di_tg_ctrl.P52.GatPoly v_b.$4057.Metal3 4.90975e-08f
Cred_5153 di_tg_ctrl.P52.GatPoly v_b.$4061.Metal3 9.12522e-08f
Cred_5154 di_tg_ctrl.P52.GatPoly v_b.$4065.Metal3 0.00141734f
Cred_5155 di_tg_ctrl.P52.GatPoly v_b.P67.pSD 0.0516685f
Cred_5156 di_tg_ctrl.P52.GatPoly v_b.P69.pSD 0.00396819f
Cred_5157 di_tg_ctrl.P52.GatPoly v_b.P71.pSD 8.62218e-05f
Cred_5158 di_tg_ctrl.P52.GatPoly VDD.$340.Metal1 0.000145609f
Cred_5159 di_tg_ctrl.P52.GatPoly VDD.$388.Metal2 4.18149e-09f
Cred_5160 di_tg_ctrl.P52.GatPoly VDD.$42.Metal1 1.9634e-07f
Cred_5161 di_tg_ctrl.P52.GatPoly VDD.$666.Metal3 1.84092e-10f
Cred_5162 di_tg_ctrl.P52.GatPoly VDD.P0.nSD 0.00390074f
Cred_5163 di_tg_ctrl.P53.GatPoly VSS 0.00211251f
Cred_5164 di_tg_ctrl.P53.GatPoly v_b 0.0486357f
Cred_5165 di_tg_ctrl.P53.GatPoly v_b.$2244.Metal1 0.0127961f
Cred_5166 di_tg_ctrl.P53.GatPoly v_b.$2246.Metal1 0.00578062f
Cred_5167 di_tg_ctrl.P53.GatPoly v_b.$2247.Metal1 0.00578294f
Cred_5168 di_tg_ctrl.P53.GatPoly v_b.$2249.Metal1 0.00767374f
Cred_5169 di_tg_ctrl.P53.GatPoly v_b.$2251.Metal1 0.00577778f
Cred_5170 di_tg_ctrl.P53.GatPoly v_b.$2252.Metal1 0.0076153f
Cred_5171 di_tg_ctrl.P53.GatPoly v_b.$2255.Metal1 0.0219491f
Cred_5172 di_tg_ctrl.P53.GatPoly v_b.$3678.Metal2 0.00308758f
Cred_5173 di_tg_ctrl.P53.GatPoly v_b.$3680.Metal2 2.85616e-05f
Cred_5174 di_tg_ctrl.P53.GatPoly v_b.$3682.Metal2 2.39448e-05f
Cred_5175 di_tg_ctrl.P53.GatPoly v_b.$3686.Metal2 4.10824e-05f
Cred_5176 di_tg_ctrl.P53.GatPoly v_b.$3688.Metal2 1.40376e-05f
Cred_5177 di_tg_ctrl.P53.GatPoly v_b.$3690.Metal2 3.77812e-05f
Cred_5178 di_tg_ctrl.P53.GatPoly v_b.$3694.Metal2 6.7904e-05f
Cred_5179 di_tg_ctrl.P53.GatPoly v_b.$3696.Metal2 7.85461e-05f
Cred_5180 di_tg_ctrl.P53.GatPoly v_b.$3698.Metal2 0.00285588f
Cred_5181 di_tg_ctrl.P53.GatPoly v_b.$4053.Metal3 0.00115811f
Cred_5182 di_tg_ctrl.P53.GatPoly v_b.$4057.Metal3 4.90975e-08f
Cred_5183 di_tg_ctrl.P53.GatPoly v_b.$4061.Metal3 9.12522e-08f
Cred_5184 di_tg_ctrl.P53.GatPoly v_b.$4065.Metal3 0.00146116f
Cred_5185 di_tg_ctrl.P53.GatPoly v_b.P69.pSD 0.00417793f
Cred_5186 di_tg_ctrl.P53.GatPoly v_b.P71.pSD 0.0668709f
Cred_5187 di_tg_ctrl.P53.GatPoly VDD.$321.Metal1 0.00161308f
Cred_5188 di_tg_ctrl.P53.GatPoly VDD.$332.Metal1 0.0151606f
Cred_5189 di_tg_ctrl.P53.GatPoly VDD.$340.Metal1 0.000199749f
Cred_5190 di_tg_ctrl.P53.GatPoly VDD.$388.Metal2 3.68847e-09f
Cred_5191 di_tg_ctrl.P53.GatPoly VDD.$42.Metal1 1.7319e-07f
Cred_5192 di_tg_ctrl.P53.GatPoly VDD.$640.Metal2 9.40274e-06f
Cred_5193 di_tg_ctrl.P53.GatPoly VDD.$644.Metal2 0.00410068f
Cred_5194 di_tg_ctrl.P53.GatPoly VDD.$666.Metal3 1.62386e-10f
Cred_5195 di_tg_ctrl.P53.GatPoly VDD.$794.Metal3 0.00205469f
Cred_5196 di_tg_ctrl.P53.GatPoly VDD.P0.nSD 0.00374857f
Cred_5197 di_tg_ctrl.P6.GatPoly VSS 0.0123426f
Cred_5198 di_tg_ctrl.P6.GatPoly v_a.$2237.Metal3 0.00907007f
Cred_5199 di_tg_ctrl.P6.GatPoly v_a.$2275.Metal3 0.00314676f
Cred_5200 di_tg_ctrl.P6.GatPoly v_a.$2297.Metal3 0.00907007f
Cred_5201 di_tg_ctrl.P6.GatPoly v_a.P6.nSD 0.015284f
Cred_5202 di_tg_ctrl.P6.GatPoly v_b.$2421.Metal2 0.0208858f
Cred_5203 di_tg_ctrl.P6.GatPoly v_b.P5.nSD 0.0129918f
Cred_5204 di_tg_ctrl.P6.GatPoly VSS.$17.Metal1 0.00021459f
Cred_5205 di_tg_ctrl.P6.GatPoly VSS.$301.Metal1 9.63471e-07f
Cred_5206 di_tg_ctrl.P6.GatPoly VSS.$606.Metal2 1.01802e-07f
Cred_5207 di_tg_ctrl.P6.GatPoly VSS.$760.Metal3 6.02348e-09f
Cred_5208 di_tg_ctrl.P6.GatPoly VSS.P0.pSD 0.0026131f
Cred_5209 di_tg_ctrl.P7.GatPoly VSS 0.0127329f
Cred_5210 di_tg_ctrl.P7.GatPoly v_a.$2237.Metal3 0.00910162f
Cred_5211 di_tg_ctrl.P7.GatPoly v_a.$2275.Metal3 0.0031577f
Cred_5212 di_tg_ctrl.P7.GatPoly v_a.$2297.Metal3 0.00910162f
Cred_5213 di_tg_ctrl.P7.GatPoly v_a.P6.nSD 0.0153841f
Cred_5214 di_tg_ctrl.P7.GatPoly v_b.$2421.Metal2 0.010678f
Cred_5215 di_tg_ctrl.P7.GatPoly v_b.$2481.Metal2 0.010678f
Cred_5216 di_tg_ctrl.P7.GatPoly v_b.P7.nSD 0.0132471f
Cred_5217 di_tg_ctrl.P7.GatPoly v_b.P7.pSD 0.00021472f
Cred_5218 di_tg_ctrl.P7.GatPoly VSS.$17.Metal1 0.000196993f
Cred_5219 di_tg_ctrl.P7.GatPoly VSS.$301.Metal1 1.05008e-06f
Cred_5220 di_tg_ctrl.P7.GatPoly VSS.$606.Metal2 1.10953e-07f
Cred_5221 di_tg_ctrl.P7.GatPoly VSS.$61.Metal1 3.10599e-05f
Cred_5222 di_tg_ctrl.P7.GatPoly VSS.$760.Metal3 6.56492e-09f
Cred_5223 di_tg_ctrl.P7.GatPoly VSS.P0.pSD 0.0026306f
Cred_5224 di_tg_ctrl.P8.GatPoly VSS 0.0123426f
Cred_5225 di_tg_ctrl.P8.GatPoly v_a.$2297.Metal3 0.0213687f
Cred_5226 di_tg_ctrl.P8.GatPoly v_a.P8.nSD 0.0152022f
Cred_5227 di_tg_ctrl.P8.GatPoly v_b.$2421.Metal2 0.0102826f
Cred_5228 di_tg_ctrl.P8.GatPoly v_b.$2481.Metal2 0.0102826f
Cred_5229 di_tg_ctrl.P8.GatPoly v_b.P7.nSD 0.0131056f
Cred_5230 di_tg_ctrl.P8.GatPoly v_b.P7.pSD 0.00020677f
Cred_5231 di_tg_ctrl.P8.GatPoly VSS.$17.Metal1 0.000166014f
Cred_5232 di_tg_ctrl.P8.GatPoly VSS.$301.Metal1 1.24708e-06f
Cred_5233 di_tg_ctrl.P8.GatPoly VSS.$606.Metal2 1.31768e-07f
Cred_5234 di_tg_ctrl.P8.GatPoly VSS.$760.Metal3 7.79655e-09f
Cred_5235 di_tg_ctrl.P8.GatPoly VSS.P0.pSD 0.00266136f
Cred_5236 di_tg_ctrl.P9.GatPoly VSS 0.0127329f
Cred_5237 di_tg_ctrl.P9.GatPoly v_a.$2297.Metal3 0.021443f
Cred_5238 di_tg_ctrl.P9.GatPoly v_a.P8.nSD 0.015302f
Cred_5239 di_tg_ctrl.P9.GatPoly v_b.$2481.Metal2 0.0222564f
Cred_5240 di_tg_ctrl.P9.GatPoly v_b.P10.nSD 0.0131808f
Cred_5241 di_tg_ctrl.P9.GatPoly VSS.$17.Metal1 0.000152405f
Cred_5242 di_tg_ctrl.P9.GatPoly VSS.$301.Metal1 1.35892e-06f
Cred_5243 di_tg_ctrl.P9.GatPoly VSS.$394.Metal2 6.24808e-08f
Cred_5244 di_tg_ctrl.P9.GatPoly VSS.$606.Metal2 1.43586e-07f
Cred_5245 di_tg_ctrl.P9.GatPoly VSS.$69.Metal1 1.75711e-05f
Cred_5246 di_tg_ctrl.P9.GatPoly VSS.$760.Metal3 8.49578e-09f
Cred_5247 di_tg_ctrl.P9.GatPoly VSS.$79.Metal1 8.10196e-06f
Cred_5248 di_tg_ctrl.P9.GatPoly VSS.P0.pSD 0.00267487f
Cred_5249 di_tg_ctrl_n VSS 0.0276374f
Cred_5250 di_tg_ctrl_n v_a.$1682.Metal2 0.00085869f
Cred_5251 di_tg_ctrl_n v_a.$1756.Metal2 4.42344e-08f
Cred_5252 di_tg_ctrl_n v_a.$1758.Metal2 2.07175e-05f
Cred_5253 di_tg_ctrl_n v_a.$2462.Metal3 0.00643174f
Cred_5254 di_tg_ctrl_n v_a.$2497.Metal3 0.0185733f
Cred_5255 di_tg_ctrl_n v_a.$2501.Metal3 0.000274678f
Cred_5256 di_tg_ctrl_n v_a.$2527.Metal3 0.00174779f
Cred_5257 di_tg_ctrl_n v_a.$611.Metal1 0.000318734f
Cred_5258 di_tg_ctrl_n v_a.$683.Metal1 3.45467e-06f
Cred_5259 di_tg_ctrl_n v_a.P18.pSD 0.000467573f
Cred_5260 di_tg_ctrl_n v_a.P20.pSD 1.59808e-06f
Cred_5261 di_tg_ctrl_n v_b.$2631.Metal2 0.00288678f
Cred_5262 di_tg_ctrl_n v_b.$2691.Metal2 0.000593073f
Cred_5263 di_tg_ctrl_n v_b.P19.pSD 0.008045f
Cred_5264 di_tg_ctrl_n v_b.P21.nSD 6.56267e-06f
Cred_5265 di_tg_ctrl_n v_b.P21.pSD 0.00394725f
Cred_5266 di_tg_ctrl_n VDD.$143.Metal1 2.5756e-06f
Cred_5267 di_tg_ctrl_n VDD.$151.Metal1 2.5757e-06f
Cred_5268 di_tg_ctrl_n VDD.$476.Metal2 2.62203e-05f
Cred_5269 di_tg_ctrl_n VDD.$480.Metal2 3.18569e-05f
Cred_5270 di_tg_ctrl_n VDD.$488.Metal2 1.70971e-05f
Cred_5271 di_tg_ctrl_n VDD.$496.Metal2 2.17032e-06f
Cred_5272 di_tg_ctrl_n VDD.$708.Metal3 0.00392739f
Cred_5273 di_tg_ctrl_n VDD.$714.Metal3 0.011786f
Cred_5274 di_tg_ctrl_n VDD.$718.Metal3 0.00478225f
Cred_5275 di_tg_ctrl_n VDD.$722.Metal3 0.000270689f
Cred_5276 di_tg_ctrl_n VDD.P0.nSD 4.36547e-09f
Cred_5277 di_tg_ctrl_n.$103.GatPoly VSS 0.0442383f
Cred_5278 di_tg_ctrl_n.$103.GatPoly v_b.$3153.Metal2 0.00033411f
Cred_5279 di_tg_ctrl_n.$103.GatPoly v_b.$3247.Metal2 0.00384089f
Cred_5280 di_tg_ctrl_n.$103.GatPoly v_b.$3857.Metal3 0.00204433f
Cred_5281 di_tg_ctrl_n.$103.GatPoly v_b.$3890.Metal3 0.00214655f
Cred_5282 di_tg_ctrl_n.$103.GatPoly v_b.P47.nSD 0.000310225f
Cred_5283 di_tg_ctrl_n.$103.GatPoly v_b.P49.nSD 0.0056456f
Cred_5284 di_tg_ctrl_n.$103.GatPoly v_b.P49.pSD 9.32873e-06f
Cred_5285 di_tg_ctrl_n.$103.GatPoly v_b.P51.nSD 0.00355645f
Cred_5286 di_tg_ctrl_n.$103.GatPoly VSS.$17.Metal1 4.39862e-09f
Cred_5287 di_tg_ctrl_n.$103.GatPoly VSS.$253.Metal1 0.000814758f
Cred_5288 di_tg_ctrl_n.$103.GatPoly VSS.$261.Metal1 0.00400121f
Cred_5289 di_tg_ctrl_n.$103.GatPoly VSS.$271.Metal1 0.000180619f
Cred_5290 di_tg_ctrl_n.$103.GatPoly VSS.$301.Metal1 2.22401e-07f
Cred_5291 di_tg_ctrl_n.$103.GatPoly VSS.$562.Metal2 6.28448e-06f
Cred_5292 di_tg_ctrl_n.$103.GatPoly VSS.$570.Metal2 1.39295e-06f
Cred_5293 di_tg_ctrl_n.$103.GatPoly VSS.$606.Metal2 2.34992e-08f
Cred_5294 di_tg_ctrl_n.$103.GatPoly VSS.$760.Metal3 1.39042e-09f
Cred_5295 di_tg_ctrl_n.$103.GatPoly VSS.P0.pSD 8.35435e-06f
Cred_5296 di_tg_ctrl_n.$105.GatPoly VSS 0.04671f
Cred_5297 di_tg_ctrl_n.$105.GatPoly v_b.$3247.Metal2 0.0040422f
Cred_5298 di_tg_ctrl_n.$105.GatPoly v_b.$3344.Metal2 0.00114105f
Cred_5299 di_tg_ctrl_n.$105.GatPoly v_b.$3903.Metal3 0.0058314f
Cred_5300 di_tg_ctrl_n.$105.GatPoly v_b.P51.nSD 0.00373798f
Cred_5301 di_tg_ctrl_n.$105.GatPoly v_b.P53.nSD 0.00783575f
Cred_5302 di_tg_ctrl_n.$105.GatPoly v_b.P55.nSD 0.00105517f
Cred_5303 di_tg_ctrl_n.$105.GatPoly VSS.$261.Metal1 0.00233959f
Cred_5304 di_tg_ctrl_n.$105.GatPoly VSS.$271.Metal1 0.00254277f
Cred_5305 di_tg_ctrl_n.$105.GatPoly VSS.$570.Metal2 9.89475e-06f
Cred_5306 di_tg_ctrl_n.$105.GatPoly VSS.P0.pSD 3.38525e-06f
Cred_5307 di_tg_ctrl_n.$109.GatPoly VSS 0.046758f
Cred_5308 di_tg_ctrl_n.$109.GatPoly v_b.$3344.Metal2 0.00499091f
Cred_5309 di_tg_ctrl_n.$109.GatPoly v_b.$3903.Metal3 0.00168235f
Cred_5310 di_tg_ctrl_n.$109.GatPoly v_b.$3934.Metal3 0.00296884f
Cred_5311 di_tg_ctrl_n.$109.GatPoly v_b.P53.nSD 0.00226067f
Cred_5312 di_tg_ctrl_n.$109.GatPoly v_b.P55.nSD 0.00461877f
Cred_5313 di_tg_ctrl_n.$109.GatPoly v_b.P57.nSD 0.00398965f
Cred_5314 di_tg_ctrl_n.$109.GatPoly VSS.$17.Metal1 3.24568e-09f
Cred_5315 di_tg_ctrl_n.$109.GatPoly VSS.$261.Metal1 0.00016498f
Cred_5316 di_tg_ctrl_n.$109.GatPoly VSS.$271.Metal1 0.00375032f
Cred_5317 di_tg_ctrl_n.$109.GatPoly VSS.$279.Metal1 0.00211703f
Cred_5318 di_tg_ctrl_n.$109.GatPoly VSS.$301.Metal1 3.86508e-07f
Cred_5319 di_tg_ctrl_n.$109.GatPoly VSS.$570.Metal2 1.2723e-06f
Cred_5320 di_tg_ctrl_n.$109.GatPoly VSS.$578.Metal2 1.61136e-05f
Cred_5321 di_tg_ctrl_n.$109.GatPoly VSS.$606.Metal2 4.0839e-08f
Cred_5322 di_tg_ctrl_n.$109.GatPoly VSS.$760.Metal3 2.41639e-09f
Cred_5323 di_tg_ctrl_n.$109.GatPoly VSS.P0.pSD 1.20157e-05f
Cred_5324 di_tg_ctrl_n.$111.GatPoly VSS 0.0280251f
Cred_5325 di_tg_ctrl_n.$111.GatPoly v_b.$3344.Metal2 0.000863019f
Cred_5326 di_tg_ctrl_n.$111.GatPoly v_b.$3438.Metal2 0.000862483f
Cred_5327 di_tg_ctrl_n.$111.GatPoly v_b.$3934.Metal3 0.00353933f
Cred_5328 di_tg_ctrl_n.$111.GatPoly v_b.P55.nSD 0.000801546f
Cred_5329 di_tg_ctrl_n.$111.GatPoly v_b.P57.nSD 0.00473903f
Cred_5330 di_tg_ctrl_n.$111.GatPoly v_b.P59.nSD 0.000800824f
Cred_5331 di_tg_ctrl_n.$111.GatPoly VSS.$17.Metal1 4.70308e-11f
Cred_5332 di_tg_ctrl_n.$111.GatPoly VSS.$271.Metal1 1.2723e-06f
Cred_5333 di_tg_ctrl_n.$111.GatPoly VSS.$279.Metal1 0.00413133f
Cred_5334 di_tg_ctrl_n.$111.GatPoly VSS.$301.Metal1 5.6006e-09f
Cred_5335 di_tg_ctrl_n.$111.GatPoly VSS.$578.Metal2 7.36027e-09f
Cred_5336 di_tg_ctrl_n.$111.GatPoly VSS.$606.Metal2 5.91768e-10f
Cred_5337 di_tg_ctrl_n.$111.GatPoly VSS.$760.Metal3 3.50141e-11f
Cred_5338 di_tg_ctrl_n.$111.GatPoly VSS.P0.pSD 9.85696e-08f
Cred_5339 di_tg_ctrl_n.$113.GatPoly VSS 0.0333851f
Cred_5340 di_tg_ctrl_n.$113.GatPoly v_b.$3438.Metal2 0.00350879f
Cred_5341 di_tg_ctrl_n.$113.GatPoly v_b.$3934.Metal3 0.00299597f
Cred_5342 di_tg_ctrl_n.$113.GatPoly v_b.P57.nSD 0.00403351f
Cred_5343 di_tg_ctrl_n.$113.GatPoly v_b.P59.nSD 0.00324395f
Cred_5344 di_tg_ctrl_n.$113.GatPoly VSS.$17.Metal1 2.56982e-09f
Cred_5345 di_tg_ctrl_n.$113.GatPoly VSS.$279.Metal1 0.00208204f
Cred_5346 di_tg_ctrl_n.$113.GatPoly VSS.$293.Metal1 0.00118706f
Cred_5347 di_tg_ctrl_n.$113.GatPoly VSS.$301.Metal1 3.63262e-07f
Cred_5348 di_tg_ctrl_n.$113.GatPoly VSS.$586.Metal2 1.57584e-05f
Cred_5349 di_tg_ctrl_n.$113.GatPoly VSS.$590.Metal2 9.15495e-06f
Cred_5350 di_tg_ctrl_n.$113.GatPoly VSS.$606.Metal2 3.83829e-08f
Cred_5351 di_tg_ctrl_n.$113.GatPoly VSS.$760.Metal3 2.27106e-09f
Cred_5352 di_tg_ctrl_n.$113.GatPoly VSS.P0.pSD 1.38947e-05f
Cred_5353 di_tg_ctrl_n.$115.GatPoly VSS 0.04671f
Cred_5354 di_tg_ctrl_n.$115.GatPoly v_b.$3438.Metal2 0.00404321f
Cred_5355 di_tg_ctrl_n.$115.GatPoly v_b.$3535.Metal2 0.00114076f
Cred_5356 di_tg_ctrl_n.$115.GatPoly v_b.$3970.Metal3 0.00608039f
Cred_5357 di_tg_ctrl_n.$115.GatPoly v_b.P59.nSD 0.00373889f
Cred_5358 di_tg_ctrl_n.$115.GatPoly v_b.P61.nSD 0.00817142f
Cred_5359 di_tg_ctrl_n.$115.GatPoly v_b.P63.nSD 0.00105491f
Cred_5360 di_tg_ctrl_n.$115.GatPoly VSS.$279.Metal1 0.00158844f
Cred_5361 di_tg_ctrl_n.$115.GatPoly VSS.$293.Metal1 0.00329022f
Cred_5362 di_tg_ctrl_n.$115.GatPoly VSS.$586.Metal2 1.22508e-05f
Cred_5363 di_tg_ctrl_n.$115.GatPoly VSS.$590.Metal2 1.59165e-05f
Cred_5364 di_tg_ctrl_n.$115.GatPoly VSS.P0.pSD 9.37535e-06f
Cred_5365 di_tg_ctrl_n.$119.GatPoly VSS 0.0467587f
Cred_5366 di_tg_ctrl_n.$119.GatPoly v_b.$3535.Metal2 0.00499079f
Cred_5367 di_tg_ctrl_n.$119.GatPoly v_b.$3970.Metal3 0.0017407f
Cred_5368 di_tg_ctrl_n.$119.GatPoly v_b.$4009.Metal3 0.00300645f
Cred_5369 di_tg_ctrl_n.$119.GatPoly v_b.P61.nSD 0.00233932f
Cred_5370 di_tg_ctrl_n.$119.GatPoly v_b.P63.nSD 0.00461891f
Cred_5371 di_tg_ctrl_n.$119.GatPoly v_b.P65.nSD 0.00404067f
Cred_5372 di_tg_ctrl_n.$119.GatPoly VSS.$17.Metal1 1.96271e-09f
Cred_5373 di_tg_ctrl_n.$119.GatPoly VSS.$279.Metal1 0.00011413f
Cred_5374 di_tg_ctrl_n.$119.GatPoly VSS.$293.Metal1 0.00384473f
Cred_5375 di_tg_ctrl_n.$119.GatPoly VSS.$301.Metal1 0.00212055f
Cred_5376 di_tg_ctrl_n.$119.GatPoly VSS.$586.Metal2 8.80225e-07f
Cred_5377 di_tg_ctrl_n.$119.GatPoly VSS.$590.Metal2 1.7694e-06f
Cred_5378 di_tg_ctrl_n.$119.GatPoly VSS.$598.Metal2 1.61217e-05f
Cred_5379 di_tg_ctrl_n.$119.GatPoly VSS.$606.Metal2 6.91683e-08f
Cred_5380 di_tg_ctrl_n.$119.GatPoly VSS.$760.Metal3 4.0926e-09f
Cred_5381 di_tg_ctrl_n.$119.GatPoly VSS.P0.pSD 1.22655e-05f
Cred_5382 di_tg_ctrl_n.$121.GatPoly VSS 0.0280265f
Cred_5383 di_tg_ctrl_n.$121.GatPoly v_b.$3535.Metal2 0.000864068f
Cred_5384 di_tg_ctrl_n.$121.GatPoly v_b.$3629.Metal2 0.000862483f
Cred_5385 di_tg_ctrl_n.$121.GatPoly v_b.$4009.Metal3 0.00358907f
Cred_5386 di_tg_ctrl_n.$121.GatPoly v_b.P63.nSD 0.000802956f
Cred_5387 di_tg_ctrl_n.$121.GatPoly v_b.P65.nSD 0.00480599f
Cred_5388 di_tg_ctrl_n.$121.GatPoly v_b.P67.nSD 0.000800824f
Cred_5389 di_tg_ctrl_n.$121.GatPoly VSS.$17.Metal1 8.289e-11f
Cred_5390 di_tg_ctrl_n.$121.GatPoly VSS.$293.Metal1 3.78358e-06f
Cred_5391 di_tg_ctrl_n.$121.GatPoly VSS.$301.Metal1 0.00413537f
Cred_5392 di_tg_ctrl_n.$121.GatPoly VSS.$598.Metal2 2.22326e-08f
Cred_5393 di_tg_ctrl_n.$121.GatPoly VSS.$606.Metal2 2.92114e-09f
Cred_5394 di_tg_ctrl_n.$121.GatPoly VSS.$760.Metal3 1.7284e-10f
Cred_5395 di_tg_ctrl_n.$121.GatPoly VSS.P0.pSD 2.78999e-07f
Cred_5396 di_tg_ctrl_n.$123.GatPoly VSS 0.0297005f
Cred_5397 di_tg_ctrl_n.$123.GatPoly v_b.$3629.Metal2 0.00339176f
Cred_5398 di_tg_ctrl_n.$123.GatPoly v_b.$4009.Metal3 0.00299923f
Cred_5399 di_tg_ctrl_n.$123.GatPoly v_b.P65.nSD 0.00403791f
Cred_5400 di_tg_ctrl_n.$123.GatPoly v_b.P67.nSD 0.00314785f
Cred_5401 di_tg_ctrl_n.$123.GatPoly VSS.$17.Metal1 3.21752e-09f
Cred_5402 di_tg_ctrl_n.$123.GatPoly VSS.$301.Metal1 0.00248414f
Cred_5403 di_tg_ctrl_n.$123.GatPoly VSS.$606.Metal2 7.9283e-05f
Cred_5404 di_tg_ctrl_n.$123.GatPoly VSS.$760.Metal3 3.43508e-06f
Cred_5405 di_tg_ctrl_n.$123.GatPoly VSS.P0.pSD 6.96561e-05f
Cred_5406 di_tg_ctrl_n.$124.GatPoly VSS 0.0831334f
Cred_5407 di_tg_ctrl_n.$124.GatPoly v_b 0.0018723f
Cred_5408 di_tg_ctrl_n.$124.GatPoly v_b.$3629.Metal2 0.00389743f
Cred_5409 di_tg_ctrl_n.$124.GatPoly v_b.$4042.Metal3 0.00927104f
Cred_5410 di_tg_ctrl_n.$124.GatPoly v_b.$4053.Metal3 0.000187024f
Cred_5411 di_tg_ctrl_n.$124.GatPoly v_b.P67.nSD 0.00361423f
Cred_5412 di_tg_ctrl_n.$124.GatPoly v_b.P69.nSD 0.0108839f
Cred_5413 di_tg_ctrl_n.$124.GatPoly v_b.P71.nSD 0.0021117f
Cred_5414 di_tg_ctrl_n.$124.GatPoly VSS.$17.Metal1 2.03909e-08f
Cred_5415 di_tg_ctrl_n.$124.GatPoly VSS.$301.Metal1 0.00668944f
Cred_5416 di_tg_ctrl_n.$124.GatPoly VSS.$606.Metal2 0.000403173f
Cred_5417 di_tg_ctrl_n.$124.GatPoly VSS.$760.Metal3 2.0465e-05f
Cred_5418 di_tg_ctrl_n.$124.GatPoly VSS.P0.pSD 0.000406662f
Cred_5419 di_tg_ctrl_n.$128.Metal1 VSS 0.0038236f
Cred_5420 di_tg_ctrl_n.$128.Metal1 v_a.$1168.Metal2 0.000140137f
Cred_5421 di_tg_ctrl_n.$128.Metal1 v_a.$1170.Metal2 0.00745375f
Cred_5422 di_tg_ctrl_n.$128.Metal1 v_a.$118.Metal1 4.62458e-07f
Cred_5423 di_tg_ctrl_n.$128.Metal1 v_a.$1238.Metal2 9.28586e-09f
Cred_5424 di_tg_ctrl_n.$128.Metal1 v_a.$1240.Metal2 4.57615e-06f
Cred_5425 di_tg_ctrl_n.$128.Metal1 v_a.$2197.Metal3 0.00805671f
Cred_5426 di_tg_ctrl_n.$128.Metal1 v_a.$2227.Metal3 5.73071e-05f
Cred_5427 di_tg_ctrl_n.$128.Metal1 v_a.$2233.Metal3 0.000124133f
Cred_5428 di_tg_ctrl_n.$128.Metal1 v_a.$48.Metal1 0.00752442f
Cred_5429 di_tg_ctrl_n.$128.Metal1 v_a.P0.pSD 0.0152207f
Cred_5430 di_tg_ctrl_n.$128.Metal1 v_a.P2.pSD 2.94399e-05f
Cred_5431 di_tg_ctrl_n.$128.Metal1 v_b.$2361.Metal2 0.00329609f
Cred_5432 di_tg_ctrl_n.$128.Metal1 v_b.$2421.Metal2 1.60327e-06f
Cred_5433 di_tg_ctrl_n.$128.Metal1 v_b.P0.nSD 6.58309e-06f
Cred_5434 di_tg_ctrl_n.$128.Metal1 v_b.P0.pSD 0.00333558f
Cred_5435 di_tg_ctrl_n.$128.Metal1 v_b.P1.pSD 0.012646f
Cred_5436 di_tg_ctrl_n.$128.Metal1 v_b.P3.nSD 1.7741e-08f
Cred_5437 di_tg_ctrl_n.$128.Metal1 v_b.P3.pSD 9.02513e-06f
Cred_5438 di_tg_ctrl_n.$128.Metal1 VDD.$340.Metal1 8.00409e-09f
Cred_5439 di_tg_ctrl_n.$128.Metal1 VDD.$388.Metal2 0.00127238f
Cred_5440 di_tg_ctrl_n.$128.Metal1 VDD.$392.Metal2 0.00074252f
Cred_5441 di_tg_ctrl_n.$128.Metal1 VDD.$400.Metal2 6.35543e-05f
Cred_5442 di_tg_ctrl_n.$128.Metal1 VDD.$404.Metal2 1.15639e-07f
Cred_5443 di_tg_ctrl_n.$128.Metal1 VDD.$42.Metal1 0.0391906f
Cred_5444 di_tg_ctrl_n.$128.Metal1 VDD.$55.Metal1 0.0215236f
Cred_5445 di_tg_ctrl_n.$128.Metal1 VDD.$59.Metal1 6.70653e-07f
Cred_5446 di_tg_ctrl_n.$128.Metal1 VDD.$666.Metal3 0.000179302f
Cred_5447 di_tg_ctrl_n.$128.Metal1 VDD.$67.Metal1 5.21538e-07f
Cred_5448 di_tg_ctrl_n.$128.Metal1 VDD.$670.Metal3 0.000116315f
Cred_5449 di_tg_ctrl_n.$128.Metal1 VDD.$676.Metal3 1.43006e-05f
Cred_5450 di_tg_ctrl_n.$128.Metal1 VDD.P0.nSD 0.00186929f
Cred_5451 di_tg_ctrl_n.$13.GatPoly VSS 0.00995367f
Cred_5452 di_tg_ctrl_n.$13.GatPoly v_a.$1286.Metal2 1.24293e-06f
Cred_5453 di_tg_ctrl_n.$13.GatPoly v_a.$1290.Metal2 1.24293e-06f
Cred_5454 di_tg_ctrl_n.$13.GatPoly v_a.$1294.Metal2 0.00230431f
Cred_5455 di_tg_ctrl_n.$13.GatPoly v_a.$1346.Metal2 6.59459e-06f
Cred_5456 di_tg_ctrl_n.$13.GatPoly v_a.$1348.Metal2 2.06333e-06f
Cred_5457 di_tg_ctrl_n.$13.GatPoly v_a.$1350.Metal2 0.000166742f
Cred_5458 di_tg_ctrl_n.$13.GatPoly v_a.$1352.Metal2 0.00582404f
Cred_5459 di_tg_ctrl_n.$13.GatPoly v_a.$177.Metal1 0.000458177f
Cred_5460 di_tg_ctrl_n.$13.GatPoly v_a.$178.Metal1 0.000170694f
Cred_5461 di_tg_ctrl_n.$13.GatPoly v_a.$180.Metal1 0.00668033f
Cred_5462 di_tg_ctrl_n.$13.GatPoly v_a.$2257.Metal3 2.37274e-08f
Cred_5463 di_tg_ctrl_n.$13.GatPoly v_a.$2261.Metal3 0.000643022f
Cred_5464 di_tg_ctrl_n.$13.GatPoly v_a.$2287.Metal3 7.71908e-06f
Cred_5465 di_tg_ctrl_n.$13.GatPoly v_a.$2291.Metal3 0.00149913f
Cred_5466 di_tg_ctrl_n.$13.GatPoly v_a.$240.Metal1 0.00119271f
Cred_5467 di_tg_ctrl_n.$13.GatPoly v_a.$242.Metal1 0.013209f
Cred_5468 di_tg_ctrl_n.$13.GatPoly v_a.P4.pSD 0.00228589f
Cred_5469 di_tg_ctrl_n.$13.GatPoly v_a.P6.pSD 0.00571661f
Cred_5470 di_tg_ctrl_n.$13.GatPoly v_b.$2421.Metal2 0.00802941f
Cred_5471 di_tg_ctrl_n.$13.GatPoly v_b.P5.pSD 0.027949f
Cred_5472 di_tg_ctrl_n.$13.GatPoly VDD.$400.Metal2 1.10416e-07f
Cred_5473 di_tg_ctrl_n.$13.GatPoly VDD.$404.Metal2 7.74514e-07f
Cred_5474 di_tg_ctrl_n.$13.GatPoly VDD.$412.Metal2 1.59861e-05f
Cred_5475 di_tg_ctrl_n.$13.GatPoly VDD.$420.Metal2 2.01353e-06f
Cred_5476 di_tg_ctrl_n.$13.GatPoly VDD.$59.Metal1 3.45418e-05f
Cred_5477 di_tg_ctrl_n.$13.GatPoly VDD.$67.Metal1 0.000338133f
Cred_5478 di_tg_ctrl_n.$13.GatPoly VDD.$676.Metal3 3.18055e-09f
Cred_5479 di_tg_ctrl_n.$13.GatPoly VDD.$680.Metal3 1.6144e-08f
Cred_5480 di_tg_ctrl_n.$13.GatPoly VDD.$71.Metal1 0.0033276f
Cred_5481 di_tg_ctrl_n.$13.GatPoly VDD.$77.Metal1 0.00445225f
Cred_5482 di_tg_ctrl_n.$13.GatPoly VDD.$81.Metal1 0.000938623f
Cred_5483 di_tg_ctrl_n.$13.GatPoly VDD.P0.nSD 3.29067e-06f
Cred_5484 di_tg_ctrl_n.$130.Metal1 VSS 0.00169327f
Cred_5485 di_tg_ctrl_n.$130.Metal1 v_a.$114.Metal1 0.000282354f
Cred_5486 di_tg_ctrl_n.$130.Metal1 v_a.$116.Metal1 4.41718e-05f
Cred_5487 di_tg_ctrl_n.$130.Metal1 v_a.$1168.Metal2 1.08686e-06f
Cred_5488 di_tg_ctrl_n.$130.Metal1 v_a.$1170.Metal2 0.000195791f
Cred_5489 di_tg_ctrl_n.$130.Metal1 v_a.$118.Metal1 0.0039882f
Cred_5490 di_tg_ctrl_n.$130.Metal1 v_a.$1230.Metal2 1.56116e-06f
Cred_5491 di_tg_ctrl_n.$130.Metal1 v_a.$1232.Metal2 4.8846e-07f
Cred_5492 di_tg_ctrl_n.$130.Metal1 v_a.$1238.Metal2 8.00805e-05f
Cred_5493 di_tg_ctrl_n.$130.Metal1 v_a.$1240.Metal2 0.00110461f
Cred_5494 di_tg_ctrl_n.$130.Metal1 v_a.$2197.Metal3 0.000397651f
Cred_5495 di_tg_ctrl_n.$130.Metal1 v_a.$2227.Metal3 0.00134031f
Cred_5496 di_tg_ctrl_n.$130.Metal1 v_a.$2233.Metal3 0.000213942f
Cred_5497 di_tg_ctrl_n.$130.Metal1 v_a.$48.Metal1 5.83568e-05f
Cred_5498 di_tg_ctrl_n.$130.Metal1 v_a.P0.pSD 0.000135041f
Cred_5499 di_tg_ctrl_n.$130.Metal1 v_a.P2.pSD 0.000939847f
Cred_5500 di_tg_ctrl_n.$130.Metal1 v_b.$2361.Metal2 0.00445084f
Cred_5501 di_tg_ctrl_n.$130.Metal1 v_b.$2421.Metal2 1.07905e-06f
Cred_5502 di_tg_ctrl_n.$130.Metal1 v_b.P1.pSD 0.0189839f
Cred_5503 di_tg_ctrl_n.$130.Metal1 v_b.P3.nSD 1.19402e-08f
Cred_5504 di_tg_ctrl_n.$130.Metal1 v_b.P3.pSD 6.07418e-06f
Cred_5505 di_tg_ctrl_n.$130.Metal1 VDD.$340.Metal1 1.22644e-13f
Cred_5506 di_tg_ctrl_n.$130.Metal1 VDD.$388.Metal2 0.000545664f
Cred_5507 di_tg_ctrl_n.$130.Metal1 VDD.$392.Metal2 0.000582031f
Cred_5508 di_tg_ctrl_n.$130.Metal1 VDD.$400.Metal2 6.61877e-05f
Cred_5509 di_tg_ctrl_n.$130.Metal1 VDD.$404.Metal2 7.78288e-08f
Cred_5510 di_tg_ctrl_n.$130.Metal1 VDD.$42.Metal1 0.00651821f
Cred_5511 di_tg_ctrl_n.$130.Metal1 VDD.$55.Metal1 0.028868f
Cred_5512 di_tg_ctrl_n.$130.Metal1 VDD.$59.Metal1 0.000185461f
Cred_5513 di_tg_ctrl_n.$130.Metal1 VDD.$666.Metal3 0.000112379f
Cred_5514 di_tg_ctrl_n.$130.Metal1 VDD.$67.Metal1 3.51011e-07f
Cred_5515 di_tg_ctrl_n.$130.Metal1 VDD.$670.Metal3 7.79873e-05f
Cred_5516 di_tg_ctrl_n.$130.Metal1 VDD.$676.Metal3 9.62471e-06f
Cred_5517 di_tg_ctrl_n.$130.Metal1 VDD.P0.nSD 4.24393e-05f
Cred_5518 di_tg_ctrl_n.$132.Metal1 VSS 0.00153284f
Cred_5519 di_tg_ctrl_n.$132.Metal1 v_a.$114.Metal1 0.000738146f
Cred_5520 di_tg_ctrl_n.$132.Metal1 v_a.$116.Metal1 0.000115476f
Cred_5521 di_tg_ctrl_n.$132.Metal1 v_a.$118.Metal1 0.0140237f
Cred_5522 di_tg_ctrl_n.$132.Metal1 v_a.$1230.Metal2 4.08128e-06f
Cred_5523 di_tg_ctrl_n.$132.Metal1 v_a.$1232.Metal2 1.27696e-06f
Cred_5524 di_tg_ctrl_n.$132.Metal1 v_a.$1238.Metal2 0.000281587f
Cred_5525 di_tg_ctrl_n.$132.Metal1 v_a.$1240.Metal2 0.00540188f
Cred_5526 di_tg_ctrl_n.$132.Metal1 v_a.$2227.Metal3 0.00235258f
Cred_5527 di_tg_ctrl_n.$132.Metal1 v_a.$2233.Metal3 0.000713897f
Cred_5528 di_tg_ctrl_n.$132.Metal1 v_a.P2.pSD 0.00950282f
Cred_5529 di_tg_ctrl_n.$132.Metal1 v_b.$2361.Metal2 0.000760055f
Cred_5530 di_tg_ctrl_n.$132.Metal1 v_b.P1.pSD 0.00266196f
Cred_5531 di_tg_ctrl_n.$132.Metal1 VDD.$388.Metal2 6.16042e-07f
Cred_5532 di_tg_ctrl_n.$132.Metal1 VDD.$392.Metal2 1.87904e-06f
Cred_5533 di_tg_ctrl_n.$132.Metal1 VDD.$400.Metal2 6.49771e-07f
Cred_5534 di_tg_ctrl_n.$132.Metal1 VDD.$42.Metal1 7.98759e-05f
Cred_5535 di_tg_ctrl_n.$132.Metal1 VDD.$55.Metal1 0.0177757f
Cred_5536 di_tg_ctrl_n.$132.Metal1 VDD.$59.Metal1 0.0150071f
Cred_5537 di_tg_ctrl_n.$132.Metal1 VDD.$670.Metal3 5.20972e-09f
Cred_5538 di_tg_ctrl_n.$132.Metal1 VDD.P0.nSD 5.38536e-07f
Cred_5539 di_tg_ctrl_n.$134.Metal1 VSS 0.000593363f
Cred_5540 di_tg_ctrl_n.$134.Metal1 v_a.$118.Metal1 0.00080447f
Cred_5541 di_tg_ctrl_n.$134.Metal1 v_a.$1238.Metal2 1.61533e-05f
Cred_5542 di_tg_ctrl_n.$134.Metal1 v_a.$1240.Metal2 0.000327914f
Cred_5543 di_tg_ctrl_n.$134.Metal1 v_a.$2227.Metal3 0.000301959f
Cred_5544 di_tg_ctrl_n.$134.Metal1 v_a.$2233.Metal3 4.39661e-05f
Cred_5545 di_tg_ctrl_n.$134.Metal1 v_a.P2.pSD 0.000880518f
Cred_5546 di_tg_ctrl_n.$134.Metal1 v_b.$2361.Metal2 0.00121854f
Cred_5547 di_tg_ctrl_n.$134.Metal1 v_b.$2421.Metal2 0.00121854f
Cred_5548 di_tg_ctrl_n.$134.Metal1 v_b.P3.nSD 1.34838e-05f
Cred_5549 di_tg_ctrl_n.$134.Metal1 v_b.P3.pSD 0.012163f
Cred_5550 di_tg_ctrl_n.$134.Metal1 VDD.$400.Metal2 2.44979e-05f
Cred_5551 di_tg_ctrl_n.$134.Metal1 VDD.$404.Metal2 1.40099e-05f
Cred_5552 di_tg_ctrl_n.$134.Metal1 VDD.$59.Metal1 0.0237598f
Cred_5553 di_tg_ctrl_n.$134.Metal1 VDD.$67.Metal1 0.00745074f
Cred_5554 di_tg_ctrl_n.$134.Metal1 VDD.P0.nSD 1.25436e-05f
Cred_5555 di_tg_ctrl_n.$136.Metal1 VSS 0.000593363f
Cred_5556 di_tg_ctrl_n.$136.Metal1 v_a.$1294.Metal2 0.000391916f
Cred_5557 di_tg_ctrl_n.$136.Metal1 v_a.$180.Metal1 0.000793134f
Cred_5558 di_tg_ctrl_n.$136.Metal1 v_a.$2257.Metal3 0.000879353f
Cred_5559 di_tg_ctrl_n.$136.Metal1 v_a.$2261.Metal3 0.000122586f
Cred_5560 di_tg_ctrl_n.$136.Metal1 v_a.P4.pSD 0.00162223f
Cred_5561 di_tg_ctrl_n.$136.Metal1 v_b.$2361.Metal2 0.00123307f
Cred_5562 di_tg_ctrl_n.$136.Metal1 v_b.$2421.Metal2 0.00123307f
Cred_5563 di_tg_ctrl_n.$136.Metal1 v_b.P3.nSD 1.36445e-05f
Cred_5564 di_tg_ctrl_n.$136.Metal1 v_b.P3.pSD 0.0122705f
Cred_5565 di_tg_ctrl_n.$136.Metal1 VDD.$400.Metal2 2.62351e-05f
Cred_5566 di_tg_ctrl_n.$136.Metal1 VDD.$404.Metal2 9.50432e-05f
Cred_5567 di_tg_ctrl_n.$136.Metal1 VDD.$412.Metal2 1.36343e-05f
Cred_5568 di_tg_ctrl_n.$136.Metal1 VDD.$59.Metal1 0.00820725f
Cred_5569 di_tg_ctrl_n.$136.Metal1 VDD.$67.Metal1 0.0228852f
Cred_5570 di_tg_ctrl_n.$136.Metal1 VDD.$676.Metal3 1.09317e-07f
Cred_5571 di_tg_ctrl_n.$136.Metal1 VDD.$71.Metal1 9.96202e-08f
Cred_5572 di_tg_ctrl_n.$136.Metal1 VDD.P0.nSD 1.38306e-05f
Cred_5573 di_tg_ctrl_n.$138.Metal1 VSS 0.00150899f
Cred_5574 di_tg_ctrl_n.$138.Metal1 v_a.$1286.Metal2 1.68387e-06f
Cred_5575 di_tg_ctrl_n.$138.Metal1 v_a.$1290.Metal2 1.68387e-06f
Cred_5576 di_tg_ctrl_n.$138.Metal1 v_a.$1294.Metal2 0.00546449f
Cred_5577 di_tg_ctrl_n.$138.Metal1 v_a.$177.Metal1 0.000620721f
Cred_5578 di_tg_ctrl_n.$138.Metal1 v_a.$178.Metal1 0.000231249f
Cred_5579 di_tg_ctrl_n.$138.Metal1 v_a.$180.Metal1 0.012801f
Cred_5580 di_tg_ctrl_n.$138.Metal1 v_a.$2257.Metal3 0.00168376f
Cred_5581 di_tg_ctrl_n.$138.Metal1 v_a.$2261.Metal3 0.00162933f
Cred_5582 di_tg_ctrl_n.$138.Metal1 v_a.P4.pSD 0.00901252f
Cred_5583 di_tg_ctrl_n.$138.Metal1 v_b.$2421.Metal2 0.000742529f
Cred_5584 di_tg_ctrl_n.$138.Metal1 v_b.P5.pSD 0.00259347f
Cred_5585 di_tg_ctrl_n.$138.Metal1 VDD.$400.Metal2 1.49587e-07f
Cred_5586 di_tg_ctrl_n.$138.Metal1 VDD.$404.Metal2 0.000120978f
Cred_5587 di_tg_ctrl_n.$138.Metal1 VDD.$412.Metal2 2.14431e-05f
Cred_5588 di_tg_ctrl_n.$138.Metal1 VDD.$59.Metal1 4.67959e-05f
Cred_5589 di_tg_ctrl_n.$138.Metal1 VDD.$67.Metal1 0.0167089f
Cred_5590 di_tg_ctrl_n.$138.Metal1 VDD.$676.Metal3 1.67689e-07f
Cred_5591 di_tg_ctrl_n.$138.Metal1 VDD.$71.Metal1 0.0151484f
Cred_5592 di_tg_ctrl_n.$138.Metal1 VDD.$77.Metal1 9.3664e-05f
Cred_5593 di_tg_ctrl_n.$138.Metal1 VDD.P0.nSD 2.04435e-07f
Cred_5594 di_tg_ctrl_n.$140.Metal1 VSS 0.00164438f
Cred_5595 di_tg_ctrl_n.$140.Metal1 v_a.$1286.Metal2 6.5737e-07f
Cred_5596 di_tg_ctrl_n.$140.Metal1 v_a.$1290.Metal2 6.5737e-07f
Cred_5597 di_tg_ctrl_n.$140.Metal1 v_a.$1294.Metal2 0.00121872f
Cred_5598 di_tg_ctrl_n.$140.Metal1 v_a.$177.Metal1 0.000242325f
Cred_5599 di_tg_ctrl_n.$140.Metal1 v_a.$178.Metal1 9.02779e-05f
Cred_5600 di_tg_ctrl_n.$140.Metal1 v_a.$180.Metal1 0.00353315f
Cred_5601 di_tg_ctrl_n.$140.Metal1 v_a.$2257.Metal3 0.00147407f
Cred_5602 di_tg_ctrl_n.$140.Metal1 v_a.$2261.Metal3 0.000340087f
Cred_5603 di_tg_ctrl_n.$140.Metal1 v_a.$2287.Metal3 0.000650136f
Cred_5604 di_tg_ctrl_n.$140.Metal1 v_a.P4.pSD 0.0027959f
Cred_5605 di_tg_ctrl_n.$140.Metal1 v_b.$2421.Metal2 0.0050101f
Cred_5606 di_tg_ctrl_n.$140.Metal1 v_b.P5.pSD 0.0234523f
Cred_5607 di_tg_ctrl_n.$140.Metal1 VDD.$400.Metal2 5.83976e-08f
Cred_5608 di_tg_ctrl_n.$140.Metal1 VDD.$404.Metal2 4.09632e-07f
Cred_5609 di_tg_ctrl_n.$140.Metal1 VDD.$412.Metal2 6.46664e-05f
Cred_5610 di_tg_ctrl_n.$140.Metal1 VDD.$59.Metal1 1.82688e-05f
Cred_5611 di_tg_ctrl_n.$140.Metal1 VDD.$67.Metal1 0.000178835f
Cred_5612 di_tg_ctrl_n.$140.Metal1 VDD.$676.Metal3 1.68216e-09f
Cred_5613 di_tg_ctrl_n.$140.Metal1 VDD.$71.Metal1 0.0286184f
Cred_5614 di_tg_ctrl_n.$140.Metal1 VDD.$77.Metal1 0.0184199f
Cred_5615 di_tg_ctrl_n.$140.Metal1 VDD.P0.nSD 1.92843e-05f
Cred_5616 di_tg_ctrl_n.$143.Metal1 VSS 0.000938236f
Cred_5617 di_tg_ctrl_n.$143.Metal1 v_a.$1346.Metal2 3.50839e-06f
Cred_5618 di_tg_ctrl_n.$143.Metal1 v_a.$1348.Metal2 1.09771e-06f
Cred_5619 di_tg_ctrl_n.$143.Metal1 v_a.$1350.Metal2 0.000125399f
Cred_5620 di_tg_ctrl_n.$143.Metal1 v_a.$1352.Metal2 0.00562481f
Cred_5621 di_tg_ctrl_n.$143.Metal1 v_a.$2287.Metal3 0.00304404f
Cred_5622 di_tg_ctrl_n.$143.Metal1 v_a.$2291.Metal3 0.00160249f
Cred_5623 di_tg_ctrl_n.$143.Metal1 v_a.$240.Metal1 0.000634532f
Cred_5624 di_tg_ctrl_n.$143.Metal1 v_a.$242.Metal1 0.00989281f
Cred_5625 di_tg_ctrl_n.$143.Metal1 v_a.P6.pSD 0.0104405f
Cred_5626 di_tg_ctrl_n.$143.Metal1 v_b.$2421.Metal2 0.00146479f
Cred_5627 di_tg_ctrl_n.$143.Metal1 v_b.P5.pSD 0.00654031f
Cred_5628 di_tg_ctrl_n.$143.Metal1 VDD.$412.Metal2 8.52657e-05f
Cred_5629 di_tg_ctrl_n.$143.Metal1 VDD.$420.Metal2 0.000116254f
Cred_5630 di_tg_ctrl_n.$143.Metal1 VDD.$680.Metal3 4.98914e-07f
Cred_5631 di_tg_ctrl_n.$143.Metal1 VDD.$71.Metal1 0.00408701f
Cred_5632 di_tg_ctrl_n.$143.Metal1 VDD.$77.Metal1 0.0283853f
Cred_5633 di_tg_ctrl_n.$143.Metal1 VDD.$81.Metal1 0.0150235f
Cred_5634 di_tg_ctrl_n.$143.Metal1 VDD.P0.nSD 6.91648e-06f
Cred_5635 di_tg_ctrl_n.$145.Metal1 VSS 0.000593363f
Cred_5636 di_tg_ctrl_n.$145.Metal1 v_a.$1350.Metal2 8.739e-06f
Cred_5637 di_tg_ctrl_n.$145.Metal1 v_a.$1352.Metal2 0.000421248f
Cred_5638 di_tg_ctrl_n.$145.Metal1 v_a.$2287.Metal3 0.000384565f
Cred_5639 di_tg_ctrl_n.$145.Metal1 v_a.$2291.Metal3 0.000123559f
Cred_5640 di_tg_ctrl_n.$145.Metal1 v_a.$242.Metal1 0.000682509f
Cred_5641 di_tg_ctrl_n.$145.Metal1 v_a.P6.pSD 0.00110599f
Cred_5642 di_tg_ctrl_n.$145.Metal1 v_b.$2421.Metal2 0.00119228f
Cred_5643 di_tg_ctrl_n.$145.Metal1 v_b.$2481.Metal2 0.00119228f
Cred_5644 di_tg_ctrl_n.$145.Metal1 v_b.P7.nSD 1.31932e-05f
Cred_5645 di_tg_ctrl_n.$145.Metal1 v_b.P7.pSD 0.0119687f
Cred_5646 di_tg_ctrl_n.$145.Metal1 VDD.$412.Metal2 1.74234e-05f
Cred_5647 di_tg_ctrl_n.$145.Metal1 VDD.$420.Metal2 3.35945e-05f
Cred_5648 di_tg_ctrl_n.$145.Metal1 VDD.$428.Metal2 4.09076e-08f
Cred_5649 di_tg_ctrl_n.$145.Metal1 VDD.$680.Metal3 1.39697e-07f
Cred_5650 di_tg_ctrl_n.$145.Metal1 VDD.$684.Metal3 3.27988e-10f
Cred_5651 di_tg_ctrl_n.$145.Metal1 VDD.$77.Metal1 3.03169e-06f
Cred_5652 di_tg_ctrl_n.$145.Metal1 VDD.$81.Metal1 0.0163674f
Cred_5653 di_tg_ctrl_n.$145.Metal1 VDD.$85.Metal1 0.0148466f
Cred_5654 di_tg_ctrl_n.$145.Metal1 VDD.$89.Metal1 4.87329e-05f
Cred_5655 di_tg_ctrl_n.$147.Metal1 VSS 0.000593363f
Cred_5656 di_tg_ctrl_n.$147.Metal1 v_a.$1408.Metal2 9.19654e-06f
Cred_5657 di_tg_ctrl_n.$147.Metal1 v_a.$1410.Metal2 0.000456285f
Cred_5658 di_tg_ctrl_n.$147.Metal1 v_a.$2317.Metal3 0.000784868f
Cred_5659 di_tg_ctrl_n.$147.Metal1 v_a.$2321.Metal3 0.000135398f
Cred_5660 di_tg_ctrl_n.$147.Metal1 v_a.$305.Metal1 0.000718242f
Cred_5661 di_tg_ctrl_n.$147.Metal1 v_a.P8.pSD 0.00159252f
Cred_5662 di_tg_ctrl_n.$147.Metal1 v_b.$2421.Metal2 0.00125885f
Cred_5663 di_tg_ctrl_n.$147.Metal1 v_b.$2481.Metal2 0.00125885f
Cred_5664 di_tg_ctrl_n.$147.Metal1 v_b.P7.nSD 1.39298e-05f
Cred_5665 di_tg_ctrl_n.$147.Metal1 v_b.P7.pSD 0.0124613f
Cred_5666 di_tg_ctrl_n.$147.Metal1 VDD.$420.Metal2 3.0492e-05f
Cred_5667 di_tg_ctrl_n.$147.Metal1 VDD.$428.Metal2 5.57947e-05f
Cred_5668 di_tg_ctrl_n.$147.Metal1 VDD.$684.Metal3 2.43261e-07f
Cred_5669 di_tg_ctrl_n.$147.Metal1 VDD.$81.Metal1 4.48526e-05f
Cred_5670 di_tg_ctrl_n.$147.Metal1 VDD.$85.Metal1 0.0163824f
Cred_5671 di_tg_ctrl_n.$147.Metal1 VDD.$89.Metal1 0.0147071f
Cred_5672 di_tg_ctrl_n.$149.Metal1 VSS 0.000938236f
Cred_5673 di_tg_ctrl_n.$149.Metal1 v_a.$1404.Metal2 3.50839e-06f
Cred_5674 di_tg_ctrl_n.$149.Metal1 v_a.$1406.Metal2 1.09771e-06f
Cred_5675 di_tg_ctrl_n.$149.Metal1 v_a.$1408.Metal2 0.000128041f
Cred_5676 di_tg_ctrl_n.$149.Metal1 v_a.$1410.Metal2 0.00572897f
Cred_5677 di_tg_ctrl_n.$149.Metal1 v_a.$2317.Metal3 0.00235074f
Cred_5678 di_tg_ctrl_n.$149.Metal1 v_a.$2321.Metal3 0.00162986f
Cred_5679 di_tg_ctrl_n.$149.Metal1 v_a.$303.Metal1 0.000634532f
Cred_5680 di_tg_ctrl_n.$149.Metal1 v_a.$305.Metal1 0.0100992f
Cred_5681 di_tg_ctrl_n.$149.Metal1 v_a.P8.pSD 0.010177f
Cred_5682 di_tg_ctrl_n.$149.Metal1 v_b.$2481.Metal2 0.00151324f
Cred_5683 di_tg_ctrl_n.$149.Metal1 v_b.P10.pSD 0.00752319f
Cred_5684 di_tg_ctrl_n.$149.Metal1 VDD.$420.Metal2 5.19813e-05f
Cred_5685 di_tg_ctrl_n.$149.Metal1 VDD.$428.Metal2 0.000201201f
Cred_5686 di_tg_ctrl_n.$149.Metal1 VDD.$432.Metal2 6.65055e-05f
Cred_5687 di_tg_ctrl_n.$149.Metal1 VDD.$684.Metal3 4.16774e-07f
Cred_5688 di_tg_ctrl_n.$149.Metal1 VDD.$85.Metal1 7.95463e-05f
Cred_5689 di_tg_ctrl_n.$149.Metal1 VDD.$89.Metal1 0.0341282f
Cred_5690 di_tg_ctrl_n.$149.Metal1 VDD.$99.Metal1 0.0121962f
Cred_5691 di_tg_ctrl_n.$149.Metal1 VDD.P0.nSD 5.02697e-05f
Cred_5692 di_tg_ctrl_n.$153.Metal1 VSS 0.00164438f
Cred_5693 di_tg_ctrl_n.$153.Metal1 v_a.$1462.Metal2 1.58433e-06f
Cred_5694 di_tg_ctrl_n.$153.Metal1 v_a.$1464.Metal2 4.95708e-07f
Cred_5695 di_tg_ctrl_n.$153.Metal1 v_a.$1466.Metal2 4.00593e-05f
Cred_5696 di_tg_ctrl_n.$153.Metal1 v_a.$1468.Metal2 0.00139921f
Cred_5697 di_tg_ctrl_n.$153.Metal1 v_a.$2317.Metal3 0.000720882f
Cred_5698 di_tg_ctrl_n.$153.Metal1 v_a.$2347.Metal3 0.00135796f
Cred_5699 di_tg_ctrl_n.$153.Metal1 v_a.$2351.Metal3 0.00036016f
Cred_5700 di_tg_ctrl_n.$153.Metal1 v_a.$366.Metal1 0.000286544f
Cred_5701 di_tg_ctrl_n.$153.Metal1 v_a.$368.Metal1 0.00317342f
Cred_5702 di_tg_ctrl_n.$153.Metal1 v_a.P10.pSD 0.00235796f
Cred_5703 di_tg_ctrl_n.$153.Metal1 v_a.P8.pSD 0.000734818f
Cred_5704 di_tg_ctrl_n.$153.Metal1 v_b.$2481.Metal2 0.00496147f
Cred_5705 di_tg_ctrl_n.$153.Metal1 v_b.P10.pSD 0.0226043f
Cred_5706 di_tg_ctrl_n.$153.Metal1 VDD.$107.Metal1 7.81541e-05f
Cred_5707 di_tg_ctrl_n.$153.Metal1 VDD.$428.Metal2 8.0933e-05f
Cred_5708 di_tg_ctrl_n.$153.Metal1 VDD.$432.Metal2 0.000103407f
Cred_5709 di_tg_ctrl_n.$153.Metal1 VDD.$436.Metal2 8.25204e-07f
Cred_5710 di_tg_ctrl_n.$153.Metal1 VDD.$440.Metal2 2.20435e-07f
Cred_5711 di_tg_ctrl_n.$153.Metal1 VDD.$89.Metal1 0.0134505f
Cred_5712 di_tg_ctrl_n.$153.Metal1 VDD.$99.Metal1 0.0335257f
Cred_5713 di_tg_ctrl_n.$153.Metal1 VDD.P0.nSD 5.48142e-05f
Cred_5714 di_tg_ctrl_n.$154.Metal1 VSS 0.00150899f
Cred_5715 di_tg_ctrl_n.$154.Metal1 v_a.$1462.Metal2 4.0583e-06f
Cred_5716 di_tg_ctrl_n.$154.Metal1 v_a.$1464.Metal2 1.26977e-06f
Cred_5717 di_tg_ctrl_n.$154.Metal1 v_a.$1466.Metal2 0.000144002f
Cred_5718 di_tg_ctrl_n.$154.Metal1 v_a.$1468.Metal2 0.00631648f
Cred_5719 di_tg_ctrl_n.$154.Metal1 v_a.$2347.Metal3 0.00142782f
Cred_5720 di_tg_ctrl_n.$154.Metal1 v_a.$2351.Metal3 0.00178546f
Cred_5721 di_tg_ctrl_n.$154.Metal1 v_a.$366.Metal1 0.000733989f
Cred_5722 di_tg_ctrl_n.$154.Metal1 v_a.$368.Metal1 0.0113613f
Cred_5723 di_tg_ctrl_n.$154.Metal1 v_a.P10.pSD 0.010885f
Cred_5724 di_tg_ctrl_n.$154.Metal1 v_b.$2481.Metal2 0.000740861f
Cred_5725 di_tg_ctrl_n.$154.Metal1 v_b.P10.pSD 0.00259513f
Cred_5726 di_tg_ctrl_n.$154.Metal1 VDD.$107.Metal1 0.00752091f
Cred_5727 di_tg_ctrl_n.$154.Metal1 VDD.$428.Metal2 4.87077e-07f
Cred_5728 di_tg_ctrl_n.$154.Metal1 VDD.$432.Metal2 1.11616e-06f
Cred_5729 di_tg_ctrl_n.$154.Metal1 VDD.$436.Metal2 0.000138026f
Cred_5730 di_tg_ctrl_n.$154.Metal1 VDD.$440.Metal2 7.31858e-05f
Cred_5731 di_tg_ctrl_n.$154.Metal1 VDD.$89.Metal1 8.09489e-05f
Cred_5732 di_tg_ctrl_n.$154.Metal1 VDD.$99.Metal1 0.0251241f
Cred_5733 di_tg_ctrl_n.$154.Metal1 VDD.P0.nSD 1.31599e-05f
Cred_5734 di_tg_ctrl_n.$156.Metal1 VSS 0.000593363f
Cred_5735 di_tg_ctrl_n.$156.Metal1 v_a.$1466.Metal2 9.17496e-06f
Cred_5736 di_tg_ctrl_n.$156.Metal1 v_a.$1468.Metal2 0.000444797f
Cred_5737 di_tg_ctrl_n.$156.Metal1 v_a.$2347.Metal3 0.00045505f
Cred_5738 di_tg_ctrl_n.$156.Metal1 v_a.$2351.Metal3 0.000130771f
Cred_5739 di_tg_ctrl_n.$156.Metal1 v_a.$368.Metal1 0.000716556f
Cred_5740 di_tg_ctrl_n.$156.Metal1 v_a.P10.pSD 0.00121734f
Cred_5741 di_tg_ctrl_n.$156.Metal1 v_b.$2481.Metal2 0.00122737f
Cred_5742 di_tg_ctrl_n.$156.Metal1 v_b.$2541.Metal2 0.00122737f
Cred_5743 di_tg_ctrl_n.$156.Metal1 v_b.P11.nSD 1.35816e-05f
Cred_5744 di_tg_ctrl_n.$156.Metal1 v_b.P11.pSD 0.0122284f
Cred_5745 di_tg_ctrl_n.$156.Metal1 VDD.$107.Metal1 0.0229981f
Cred_5746 di_tg_ctrl_n.$156.Metal1 VDD.$111.Metal1 4.89084e-05f
Cred_5747 di_tg_ctrl_n.$156.Metal1 VDD.$436.Metal2 5.82053e-05f
Cred_5748 di_tg_ctrl_n.$156.Metal1 VDD.$440.Metal2 4.11986e-05f
Cred_5749 di_tg_ctrl_n.$156.Metal1 VDD.$448.Metal2 3.64932e-08f
Cred_5750 di_tg_ctrl_n.$156.Metal1 VDD.$694.Metal3 2.92594e-10f
Cred_5751 di_tg_ctrl_n.$156.Metal1 VDD.$99.Metal1 0.00816114f
Cred_5752 di_tg_ctrl_n.$156.Metal1 VDD.P0.nSD 1.38261e-05f
Cred_5753 di_tg_ctrl_n.$158.Metal1 VSS 0.000593363f
Cred_5754 di_tg_ctrl_n.$158.Metal1 v_a.$1524.Metal2 9.44999e-06f
Cred_5755 di_tg_ctrl_n.$158.Metal1 v_a.$1526.Metal2 0.000466114f
Cred_5756 di_tg_ctrl_n.$158.Metal1 v_a.$2377.Metal3 0.000695099f
Cred_5757 di_tg_ctrl_n.$158.Metal1 v_a.$2381.Metal3 0.000137994f
Cred_5758 di_tg_ctrl_n.$158.Metal1 v_a.$431.Metal1 0.000738037f
Cred_5759 di_tg_ctrl_n.$158.Metal1 v_a.P12.pSD 0.00151016f
Cred_5760 di_tg_ctrl_n.$158.Metal1 v_b.$2481.Metal2 0.00122403f
Cred_5761 di_tg_ctrl_n.$158.Metal1 v_b.$2541.Metal2 0.00122403f
Cred_5762 di_tg_ctrl_n.$158.Metal1 v_b.P11.nSD 1.35445e-05f
Cred_5763 di_tg_ctrl_n.$158.Metal1 v_b.P11.pSD 0.0122036f
Cred_5764 di_tg_ctrl_n.$158.Metal1 VDD.$107.Metal1 0.0164098f
Cred_5765 di_tg_ctrl_n.$158.Metal1 VDD.$111.Metal1 0.0146895f
Cred_5766 di_tg_ctrl_n.$158.Metal1 VDD.$436.Metal2 4.72837e-08f
Cred_5767 di_tg_ctrl_n.$158.Metal1 VDD.$440.Metal2 2.828e-05f
Cred_5768 di_tg_ctrl_n.$158.Metal1 VDD.$448.Metal2 5.14929e-05f
Cred_5769 di_tg_ctrl_n.$158.Metal1 VDD.$694.Metal3 2.25065e-07f
Cred_5770 di_tg_ctrl_n.$158.Metal1 VDD.$99.Metal1 2.09553e-05f
Cred_5771 di_tg_ctrl_n.$158.Metal1 VDD.P0.nSD 3.55146e-08f
Cred_5772 di_tg_ctrl_n.$16.GatPoly VSS 0.00685292f
Cred_5773 di_tg_ctrl_n.$16.GatPoly v_a.$1346.Metal2 8.84469e-06f
Cred_5774 di_tg_ctrl_n.$16.GatPoly v_a.$1348.Metal2 2.76734e-06f
Cred_5775 di_tg_ctrl_n.$16.GatPoly v_a.$1350.Metal2 0.000218711f
Cred_5776 di_tg_ctrl_n.$16.GatPoly v_a.$1352.Metal2 0.00794496f
Cred_5777 di_tg_ctrl_n.$16.GatPoly v_a.$2291.Metal3 0.0020861f
Cred_5778 di_tg_ctrl_n.$16.GatPoly v_a.$240.Metal1 0.00159966f
Cred_5779 di_tg_ctrl_n.$16.GatPoly v_a.$242.Metal1 0.0173314f
Cred_5780 di_tg_ctrl_n.$16.GatPoly v_a.P6.pSD 0.0078474f
Cred_5781 di_tg_ctrl_n.$16.GatPoly v_b.$2421.Metal2 0.00391328f
Cred_5782 di_tg_ctrl_n.$16.GatPoly v_b.$2481.Metal2 0.00320345f
Cred_5783 di_tg_ctrl_n.$16.GatPoly v_b.P5.pSD 0.00251088f
Cred_5784 di_tg_ctrl_n.$16.GatPoly v_b.P7.nSD 3.54479e-05f
Cred_5785 di_tg_ctrl_n.$16.GatPoly v_b.P7.pSD 0.022745f
Cred_5786 di_tg_ctrl_n.$16.GatPoly VDD.$412.Metal2 1.67204e-06f
Cred_5787 di_tg_ctrl_n.$16.GatPoly VDD.$420.Metal2 8.32933e-06f
Cred_5788 di_tg_ctrl_n.$16.GatPoly VDD.$428.Metal2 3.09385e-07f
Cred_5789 di_tg_ctrl_n.$16.GatPoly VDD.$680.Metal3 1.3406e-08f
Cred_5790 di_tg_ctrl_n.$16.GatPoly VDD.$684.Metal3 2.48058e-09f
Cred_5791 di_tg_ctrl_n.$16.GatPoly VDD.$77.Metal1 0.00162973f
Cred_5792 di_tg_ctrl_n.$16.GatPoly VDD.$81.Metal1 0.00265495f
Cred_5793 di_tg_ctrl_n.$16.GatPoly VDD.$85.Metal1 0.00224264f
Cred_5794 di_tg_ctrl_n.$16.GatPoly VDD.$89.Metal1 0.000368568f
Cred_5795 di_tg_ctrl_n.$160.Metal1 VSS 0.000938236f
Cred_5796 di_tg_ctrl_n.$160.Metal1 v_a.$1520.Metal2 3.50839e-06f
Cred_5797 di_tg_ctrl_n.$160.Metal1 v_a.$1522.Metal2 1.09771e-06f
Cred_5798 di_tg_ctrl_n.$160.Metal1 v_a.$1524.Metal2 0.000128f
Cred_5799 di_tg_ctrl_n.$160.Metal1 v_a.$1526.Metal2 0.00573527f
Cred_5800 di_tg_ctrl_n.$160.Metal1 v_a.$2377.Metal3 0.00228972f
Cred_5801 di_tg_ctrl_n.$160.Metal1 v_a.$2381.Metal3 0.0016327f
Cred_5802 di_tg_ctrl_n.$160.Metal1 v_a.$429.Metal1 0.000634532f
Cred_5803 di_tg_ctrl_n.$160.Metal1 v_a.$431.Metal1 0.010096f
Cred_5804 di_tg_ctrl_n.$160.Metal1 v_a.P12.pSD 0.0103265f
Cred_5805 di_tg_ctrl_n.$160.Metal1 v_b.$2541.Metal2 0.00151313f
Cred_5806 di_tg_ctrl_n.$160.Metal1 v_b.P13.pSD 0.00750402f
Cred_5807 di_tg_ctrl_n.$160.Metal1 VDD.$107.Metal1 7.63688e-05f
Cred_5808 di_tg_ctrl_n.$160.Metal1 VDD.$111.Metal1 0.0341499f
Cred_5809 di_tg_ctrl_n.$160.Metal1 VDD.$121.Metal1 0.0121898f
Cred_5810 di_tg_ctrl_n.$160.Metal1 VDD.$440.Metal2 5.47111e-05f
Cred_5811 di_tg_ctrl_n.$160.Metal1 VDD.$448.Metal2 0.00020911f
Cred_5812 di_tg_ctrl_n.$160.Metal1 VDD.$452.Metal2 6.41789e-05f
Cred_5813 di_tg_ctrl_n.$160.Metal1 VDD.$694.Metal3 4.38662e-07f
Cred_5814 di_tg_ctrl_n.$160.Metal1 VDD.P0.nSD 5.02398e-05f
Cred_5815 di_tg_ctrl_n.$163.Metal1 VSS 0.00164438f
Cred_5816 di_tg_ctrl_n.$163.Metal1 v_a.$1574.Metal2 3.13376e-05f
Cred_5817 di_tg_ctrl_n.$163.Metal1 v_a.$1576.Metal2 0.00137554f
Cred_5818 di_tg_ctrl_n.$163.Metal1 v_a.$2377.Metal3 0.000711411f
Cred_5819 di_tg_ctrl_n.$163.Metal1 v_a.$2407.Metal3 0.00224856f
Cred_5820 di_tg_ctrl_n.$163.Metal1 v_a.$489.Metal1 0.00168261f
Cred_5821 di_tg_ctrl_n.$163.Metal1 v_a.P12.pSD 0.000680482f
Cred_5822 di_tg_ctrl_n.$163.Metal1 v_a.P14.pSD 0.00323104f
Cred_5823 di_tg_ctrl_n.$163.Metal1 v_b.$2541.Metal2 0.00496087f
Cred_5824 di_tg_ctrl_n.$163.Metal1 v_b.P13.pSD 0.0227698f
Cred_5825 di_tg_ctrl_n.$163.Metal1 VDD.$111.Metal1 0.0135295f
Cred_5826 di_tg_ctrl_n.$163.Metal1 VDD.$121.Metal1 0.0340957f
Cred_5827 di_tg_ctrl_n.$163.Metal1 VDD.$129.Metal1 8.4666e-05f
Cred_5828 di_tg_ctrl_n.$163.Metal1 VDD.$448.Metal2 8.39522e-05f
Cred_5829 di_tg_ctrl_n.$163.Metal1 VDD.$452.Metal2 0.000100778f
Cred_5830 di_tg_ctrl_n.$163.Metal1 VDD.$456.Metal2 8.77891e-07f
Cred_5831 di_tg_ctrl_n.$163.Metal1 VDD.$460.Metal2 2.22882e-07f
Cred_5832 di_tg_ctrl_n.$163.Metal1 VDD.P0.nSD 5.52101e-05f
Cred_5833 di_tg_ctrl_n.$165.Metal1 VSS 0.00150899f
Cred_5834 di_tg_ctrl_n.$165.Metal1 v_a.$1574.Metal2 0.000118997f
Cred_5835 di_tg_ctrl_n.$165.Metal1 v_a.$1576.Metal2 0.00603645f
Cred_5836 di_tg_ctrl_n.$165.Metal1 v_a.$2407.Metal3 0.00553613f
Cred_5837 di_tg_ctrl_n.$165.Metal1 v_a.$489.Metal1 0.00638933f
Cred_5838 di_tg_ctrl_n.$165.Metal1 v_a.P14.pSD 0.0139158f
Cred_5839 di_tg_ctrl_n.$165.Metal1 v_b.$2541.Metal2 0.000740861f
Cred_5840 di_tg_ctrl_n.$165.Metal1 v_b.P13.pSD 0.00259513f
Cred_5841 di_tg_ctrl_n.$165.Metal1 VDD.$111.Metal1 8.1108e-05f
Cred_5842 di_tg_ctrl_n.$165.Metal1 VDD.$121.Metal1 0.0244766f
Cred_5843 di_tg_ctrl_n.$165.Metal1 VDD.$129.Metal1 0.00752705f
Cred_5844 di_tg_ctrl_n.$165.Metal1 VDD.$448.Metal2 5.03286e-07f
Cred_5845 di_tg_ctrl_n.$165.Metal1 VDD.$452.Metal2 1.1338e-06f
Cred_5846 di_tg_ctrl_n.$165.Metal1 VDD.$456.Metal2 0.000134798f
Cred_5847 di_tg_ctrl_n.$165.Metal1 VDD.$460.Metal2 6.97361e-05f
Cred_5848 di_tg_ctrl_n.$165.Metal1 VDD.P0.nSD 1.31707e-05f
Cred_5849 di_tg_ctrl_n.$167.Metal1 VSS 0.000593363f
Cred_5850 di_tg_ctrl_n.$167.Metal1 v_a.$1574.Metal2 7.39762e-06f
Cred_5851 di_tg_ctrl_n.$167.Metal1 v_a.$1576.Metal2 0.000422178f
Cred_5852 di_tg_ctrl_n.$167.Metal1 v_a.$2407.Metal3 0.000826259f
Cred_5853 di_tg_ctrl_n.$167.Metal1 v_a.$489.Metal1 0.000397202f
Cred_5854 di_tg_ctrl_n.$167.Metal1 v_a.P14.pSD 0.00154272f
Cred_5855 di_tg_ctrl_n.$167.Metal1 v_b.$2541.Metal2 0.00122623f
Cred_5856 di_tg_ctrl_n.$167.Metal1 v_b.$2601.Metal2 0.00122623f
Cred_5857 di_tg_ctrl_n.$167.Metal1 v_b.P15.nSD 1.35688e-05f
Cred_5858 di_tg_ctrl_n.$167.Metal1 v_b.P15.pSD 0.0122199f
Cred_5859 di_tg_ctrl_n.$167.Metal1 VDD.$121.Metal1 0.00816239f
Cred_5860 di_tg_ctrl_n.$167.Metal1 VDD.$129.Metal1 0.0230192f
Cred_5861 di_tg_ctrl_n.$167.Metal1 VDD.$134.Metal1 2.4404e-05f
Cred_5862 di_tg_ctrl_n.$167.Metal1 VDD.$456.Metal2 6.44121e-05f
Cred_5863 di_tg_ctrl_n.$167.Metal1 VDD.$460.Metal2 4.16514e-05f
Cred_5864 di_tg_ctrl_n.$167.Metal1 VDD.$464.Metal2 1.88194e-07f
Cred_5865 di_tg_ctrl_n.$167.Metal1 VDD.P0.nSD 1.387e-05f
Cred_5866 di_tg_ctrl_n.$169.Metal1 VSS 0.000593363f
Cred_5867 di_tg_ctrl_n.$169.Metal1 v_a.$2387.Metal3 0.000476991f
Cred_5868 di_tg_ctrl_n.$169.Metal1 v_a.$2447.Metal3 0.000476991f
Cred_5869 di_tg_ctrl_n.$169.Metal1 v_a.P16.nSD 4.30184e-06f
Cred_5870 di_tg_ctrl_n.$169.Metal1 v_a.P16.pSD 0.00242495f
Cred_5871 di_tg_ctrl_n.$169.Metal1 v_b.$2541.Metal2 0.00122511f
Cred_5872 di_tg_ctrl_n.$169.Metal1 v_b.$2601.Metal2 0.00122511f
Cred_5873 di_tg_ctrl_n.$169.Metal1 v_b.P15.nSD 1.35565e-05f
Cred_5874 di_tg_ctrl_n.$169.Metal1 v_b.P15.pSD 0.0122117f
Cred_5875 di_tg_ctrl_n.$169.Metal1 VDD.$121.Metal1 1.95581e-05f
Cred_5876 di_tg_ctrl_n.$169.Metal1 VDD.$129.Metal1 0.023816f
Cred_5877 di_tg_ctrl_n.$169.Metal1 VDD.$134.Metal1 0.00740799f
Cred_5878 di_tg_ctrl_n.$169.Metal1 VDD.$456.Metal2 4.78086e-08f
Cred_5879 di_tg_ctrl_n.$169.Metal1 VDD.$460.Metal2 1.99083e-07f
Cred_5880 di_tg_ctrl_n.$169.Metal1 VDD.$464.Metal2 0.000100139f
Cred_5881 di_tg_ctrl_n.$169.Metal1 VDD.$472.Metal2 1.061e-05f
Cred_5882 di_tg_ctrl_n.$169.Metal1 VDD.$704.Metal3 4.23645e-08f
Cred_5883 di_tg_ctrl_n.$169.Metal1 VDD.$708.Metal3 4.23645e-08f
Cred_5884 di_tg_ctrl_n.$169.Metal1 VDD.P0.nSD 1.25696e-05f
Cred_5885 di_tg_ctrl_n.$171.Metal1 VSS 0.000938236f
Cred_5886 di_tg_ctrl_n.$171.Metal1 v_a.$2387.Metal3 0.00435506f
Cred_5887 di_tg_ctrl_n.$171.Metal1 v_a.$2447.Metal3 0.00435506f
Cred_5888 di_tg_ctrl_n.$171.Metal1 v_a.P16.nSD 3.9277e-05f
Cred_5889 di_tg_ctrl_n.$171.Metal1 v_a.P16.pSD 0.0221897f
Cred_5890 di_tg_ctrl_n.$171.Metal1 v_b.$2601.Metal2 0.00151438f
Cred_5891 di_tg_ctrl_n.$171.Metal1 v_b.P17.pSD 0.00699786f
Cred_5892 di_tg_ctrl_n.$171.Metal1 VDD.$129.Metal1 0.00859851f
Cred_5893 di_tg_ctrl_n.$171.Metal1 VDD.$134.Metal1 0.0350265f
Cred_5894 di_tg_ctrl_n.$171.Metal1 VDD.$143.Metal1 0.00348108f
Cred_5895 di_tg_ctrl_n.$171.Metal1 VDD.$464.Metal2 0.000182892f
Cred_5896 di_tg_ctrl_n.$171.Metal1 VDD.$472.Metal2 4.14193e-05f
Cred_5897 di_tg_ctrl_n.$171.Metal1 VDD.$704.Metal3 9.48157e-08f
Cred_5898 di_tg_ctrl_n.$171.Metal1 VDD.$708.Metal3 9.48157e-08f
Cred_5899 di_tg_ctrl_n.$171.Metal1 VDD.P0.nSD 2.03423e-05f
Cred_5900 di_tg_ctrl_n.$174.Metal1 VSS 0.00164438f
Cred_5901 di_tg_ctrl_n.$174.Metal1 v_a.$1682.Metal2 0.00107891f
Cred_5902 di_tg_ctrl_n.$174.Metal1 v_a.$2387.Metal3 0.000233899f
Cred_5903 di_tg_ctrl_n.$174.Metal1 v_a.$2447.Metal3 0.000233899f
Cred_5904 di_tg_ctrl_n.$174.Metal1 v_a.$2462.Metal3 0.00238328f
Cred_5905 di_tg_ctrl_n.$174.Metal1 v_a.$611.Metal1 0.00112885f
Cred_5906 di_tg_ctrl_n.$174.Metal1 v_a.P16.nSD 2.10947e-06f
Cred_5907 di_tg_ctrl_n.$174.Metal1 v_a.P16.pSD 0.000850431f
Cred_5908 di_tg_ctrl_n.$174.Metal1 v_a.P18.pSD 0.00395424f
Cred_5909 di_tg_ctrl_n.$174.Metal1 v_b.$2601.Metal2 0.0048933f
Cred_5910 di_tg_ctrl_n.$174.Metal1 v_b.P17.pSD 0.0221752f
Cred_5911 di_tg_ctrl_n.$174.Metal1 VDD.$134.Metal1 0.0211902f
Cred_5912 di_tg_ctrl_n.$174.Metal1 VDD.$143.Metal1 0.0283751f
Cred_5913 di_tg_ctrl_n.$174.Metal1 VDD.$151.Metal1 9.11788e-05f
Cred_5914 di_tg_ctrl_n.$174.Metal1 VDD.$472.Metal2 0.000209797f
Cred_5915 di_tg_ctrl_n.$174.Metal1 VDD.$476.Metal2 6.32076e-05f
Cred_5916 di_tg_ctrl_n.$174.Metal1 VDD.$480.Metal2 2.22882e-07f
Cred_5917 di_tg_ctrl_n.$174.Metal1 VDD.P0.nSD 2.211e-05f
Cred_5918 di_tg_ctrl_n.$176.Metal1 VSS 0.00150899f
Cred_5919 di_tg_ctrl_n.$176.Metal1 v_a.$1682.Metal2 0.00422893f
Cred_5920 di_tg_ctrl_n.$176.Metal1 v_a.$2462.Metal3 0.00673375f
Cred_5921 di_tg_ctrl_n.$176.Metal1 v_a.$611.Metal1 0.00440504f
Cred_5922 di_tg_ctrl_n.$176.Metal1 v_a.P18.pSD 0.016044f
Cred_5923 di_tg_ctrl_n.$176.Metal1 v_b.$2601.Metal2 0.000667592f
Cred_5924 di_tg_ctrl_n.$176.Metal1 v_b.P17.pSD 0.00232753f
Cred_5925 di_tg_ctrl_n.$176.Metal1 VDD.$134.Metal1 0.000123237f
Cred_5926 di_tg_ctrl_n.$176.Metal1 VDD.$143.Metal1 0.0248072f
Cred_5927 di_tg_ctrl_n.$176.Metal1 VDD.$151.Metal1 0.00782323f
Cred_5928 di_tg_ctrl_n.$176.Metal1 VDD.$472.Metal2 1.73657e-05f
Cred_5929 di_tg_ctrl_n.$176.Metal1 VDD.$476.Metal2 2.95031e-05f
Cred_5930 di_tg_ctrl_n.$176.Metal1 VDD.$480.Metal2 1.91235e-05f
Cred_5931 di_tg_ctrl_n.$176.Metal1 VDD.P0.nSD 1.34679e-05f
Cred_5932 di_tg_ctrl_n.$178.Metal1 VSS 0.000593363f
Cred_5933 di_tg_ctrl_n.$178.Metal1 v_a.$1682.Metal2 0.000329005f
Cred_5934 di_tg_ctrl_n.$178.Metal1 v_a.$2462.Metal3 0.000848241f
Cred_5935 di_tg_ctrl_n.$178.Metal1 v_a.$611.Metal1 0.000296069f
Cred_5936 di_tg_ctrl_n.$178.Metal1 v_a.P18.pSD 0.00180628f
Cred_5937 di_tg_ctrl_n.$178.Metal1 v_b.$2631.Metal2 0.00252897f
Cred_5938 di_tg_ctrl_n.$178.Metal1 v_b.P19.pSD 0.012305f
Cred_5939 di_tg_ctrl_n.$178.Metal1 VDD.$143.Metal1 0.00827274f
Cred_5940 di_tg_ctrl_n.$178.Metal1 VDD.$151.Metal1 0.0235655f
Cred_5941 di_tg_ctrl_n.$178.Metal1 VDD.$161.Metal1 1.61326e-05f
Cred_5942 di_tg_ctrl_n.$178.Metal1 VDD.$476.Metal2 2.17778e-05f
Cred_5943 di_tg_ctrl_n.$178.Metal1 VDD.$480.Metal2 0.000101215f
Cred_5944 di_tg_ctrl_n.$178.Metal1 VDD.$484.Metal2 3.38142e-05f
Cred_5945 di_tg_ctrl_n.$178.Metal1 VDD.$488.Metal2 1.00105e-07f
Cred_5946 di_tg_ctrl_n.$178.Metal1 VDD.P0.nSD 1.41038e-05f
Cred_5947 di_tg_ctrl_n.$180.Metal1 VSS 0.000593363f
Cred_5948 di_tg_ctrl_n.$180.Metal1 v_a.$1756.Metal2 9.33136e-06f
Cred_5949 di_tg_ctrl_n.$180.Metal1 v_a.$1758.Metal2 0.000417243f
Cred_5950 di_tg_ctrl_n.$180.Metal1 v_a.$2497.Metal3 0.000508752f
Cred_5951 di_tg_ctrl_n.$180.Metal1 v_a.$2501.Metal3 0.000118466f
Cred_5952 di_tg_ctrl_n.$180.Metal1 v_a.$683.Metal1 0.000728772f
Cred_5953 di_tg_ctrl_n.$180.Metal1 v_a.P20.pSD 0.00131039f
Cred_5954 di_tg_ctrl_n.$180.Metal1 v_b.$2631.Metal2 0.00253369f
Cred_5955 di_tg_ctrl_n.$180.Metal1 v_b.P19.pSD 0.0123203f
Cred_5956 di_tg_ctrl_n.$180.Metal1 VDD.$143.Metal1 3.52127e-05f
Cred_5957 di_tg_ctrl_n.$180.Metal1 VDD.$151.Metal1 0.026875f
Cred_5958 di_tg_ctrl_n.$180.Metal1 VDD.$161.Metal1 0.00491784f
Cred_5959 di_tg_ctrl_n.$180.Metal1 VDD.$476.Metal2 9.26968e-08f
Cred_5960 di_tg_ctrl_n.$180.Metal1 VDD.$480.Metal2 8.55648e-05f
Cred_5961 di_tg_ctrl_n.$180.Metal1 VDD.$484.Metal2 8.78745e-05f
Cred_5962 di_tg_ctrl_n.$180.Metal1 VDD.$488.Metal2 3.05158e-05f
Cred_5963 di_tg_ctrl_n.$180.Metal1 VDD.P0.nSD 2.50959e-05f
Cred_5964 di_tg_ctrl_n.$182.Metal1 VSS 0.000938236f
Cred_5965 di_tg_ctrl_n.$182.Metal1 v_a.$1752.Metal2 3.50839e-06f
Cred_5966 di_tg_ctrl_n.$182.Metal1 v_a.$1754.Metal2 1.09771e-06f
Cred_5967 di_tg_ctrl_n.$182.Metal1 v_a.$1756.Metal2 0.000128054f
Cred_5968 di_tg_ctrl_n.$182.Metal1 v_a.$1758.Metal2 0.00565339f
Cred_5969 di_tg_ctrl_n.$182.Metal1 v_a.$2497.Metal3 0.00210695f
Cred_5970 di_tg_ctrl_n.$182.Metal1 v_a.$2501.Metal3 0.00159852f
Cred_5971 di_tg_ctrl_n.$182.Metal1 v_a.$681.Metal1 0.000634532f
Cred_5972 di_tg_ctrl_n.$182.Metal1 v_a.$683.Metal1 0.0101001f
Cred_5973 di_tg_ctrl_n.$182.Metal1 v_a.P20.pSD 0.0106315f
Cred_5974 di_tg_ctrl_n.$182.Metal1 v_b.$2631.Metal2 0.000743453f
Cred_5975 di_tg_ctrl_n.$182.Metal1 v_b.$2691.Metal2 0.000743453f
Cred_5976 di_tg_ctrl_n.$182.Metal1 v_b.P21.nSD 8.22671e-06f
Cred_5977 di_tg_ctrl_n.$182.Metal1 v_b.P21.pSD 0.00690442f
Cred_5978 di_tg_ctrl_n.$182.Metal1 VDD.$151.Metal1 0.019266f
Cred_5979 di_tg_ctrl_n.$182.Metal1 VDD.$161.Metal1 0.0281799f
Cred_5980 di_tg_ctrl_n.$182.Metal1 VDD.$484.Metal2 0.000101435f
Cred_5981 di_tg_ctrl_n.$182.Metal1 VDD.$488.Metal2 0.000131492f
Cred_5982 di_tg_ctrl_n.$182.Metal1 VDD.P0.nSD 6.8369e-05f
Cred_5983 di_tg_ctrl_n.$185.Metal1 VSS 0.00164438f
Cred_5984 di_tg_ctrl_n.$185.Metal1 v_a.$1810.Metal2 1.58433e-06f
Cred_5985 di_tg_ctrl_n.$185.Metal1 v_a.$1812.Metal2 4.95708e-07f
Cred_5986 di_tg_ctrl_n.$185.Metal1 v_a.$1814.Metal2 3.77222e-05f
Cred_5987 di_tg_ctrl_n.$185.Metal1 v_a.$1816.Metal2 0.00137579f
Cred_5988 di_tg_ctrl_n.$185.Metal1 v_a.$2497.Metal3 0.000685455f
Cred_5989 di_tg_ctrl_n.$185.Metal1 v_a.$2527.Metal3 0.00147747f
Cred_5990 di_tg_ctrl_n.$185.Metal1 v_a.$2531.Metal3 0.000362349f
Cred_5991 di_tg_ctrl_n.$185.Metal1 v_a.$744.Metal1 0.000286544f
Cred_5992 di_tg_ctrl_n.$185.Metal1 v_a.$746.Metal1 0.0029909f
Cred_5993 di_tg_ctrl_n.$185.Metal1 v_a.P20.pSD 0.000555585f
Cred_5994 di_tg_ctrl_n.$185.Metal1 v_a.P22.pSD 0.00275307f
Cred_5995 di_tg_ctrl_n.$185.Metal1 v_b.$2631.Metal2 0.0024516f
Cred_5996 di_tg_ctrl_n.$185.Metal1 v_b.$2691.Metal2 0.0024516f
Cred_5997 di_tg_ctrl_n.$185.Metal1 v_b.P21.nSD 2.71283e-05f
Cred_5998 di_tg_ctrl_n.$185.Metal1 v_b.P21.pSD 0.0225418f
Cred_5999 di_tg_ctrl_n.$185.Metal1 VDD.$151.Metal1 0.00283027f
Cred_6000 di_tg_ctrl_n.$185.Metal1 VDD.$161.Metal1 0.0310309f
Cred_6001 di_tg_ctrl_n.$185.Metal1 VDD.$165.Metal1 0.0160216f
Cred_6002 di_tg_ctrl_n.$185.Metal1 VDD.$169.Metal1 0.000196035f
Cred_6003 di_tg_ctrl_n.$185.Metal1 VDD.$484.Metal2 1.49012e-05f
Cred_6004 di_tg_ctrl_n.$185.Metal1 VDD.$488.Metal2 0.000104391f
Cred_6005 di_tg_ctrl_n.$185.Metal1 VDD.$496.Metal2 0.000130046f
Cred_6006 di_tg_ctrl_n.$185.Metal1 VDD.$718.Metal3 5.54304e-07f
Cred_6007 di_tg_ctrl_n.$185.Metal1 VDD.P0.nSD 1.44113e-05f
Cred_6008 di_tg_ctrl_n.$187.Metal1 VSS 0.00150899f
Cred_6009 di_tg_ctrl_n.$187.Metal1 v_a.$1810.Metal2 4.0583e-06f
Cred_6010 di_tg_ctrl_n.$187.Metal1 v_a.$1812.Metal2 1.26977e-06f
Cred_6011 di_tg_ctrl_n.$187.Metal1 v_a.$1814.Metal2 0.000140776f
Cred_6012 di_tg_ctrl_n.$187.Metal1 v_a.$1816.Metal2 0.00611191f
Cred_6013 di_tg_ctrl_n.$187.Metal1 v_a.$2527.Metal3 0.00153684f
Cred_6014 di_tg_ctrl_n.$187.Metal1 v_a.$2531.Metal3 0.00171858f
Cred_6015 di_tg_ctrl_n.$187.Metal1 v_a.$744.Metal1 0.000733989f
Cred_6016 di_tg_ctrl_n.$187.Metal1 v_a.$746.Metal1 0.0111093f
Cred_6017 di_tg_ctrl_n.$187.Metal1 v_a.P22.pSD 0.0100896f
Cred_6018 di_tg_ctrl_n.$187.Metal1 v_b.$2631.Metal2 0.000364205f
Cred_6019 di_tg_ctrl_n.$187.Metal1 v_b.$2691.Metal2 0.000364205f
Cred_6020 di_tg_ctrl_n.$187.Metal1 v_b.P21.nSD 4.03013e-06f
Cred_6021 di_tg_ctrl_n.$187.Metal1 v_b.P21.pSD 0.00259589f
Cred_6022 di_tg_ctrl_n.$187.Metal1 VDD.$161.Metal1 0.000246798f
Cred_6023 di_tg_ctrl_n.$187.Metal1 VDD.$165.Metal1 0.0168919f
Cred_6024 di_tg_ctrl_n.$187.Metal1 VDD.$169.Metal1 0.0156865f
Cred_6025 di_tg_ctrl_n.$187.Metal1 VDD.$488.Metal2 1.06482e-05f
Cred_6026 di_tg_ctrl_n.$187.Metal1 VDD.$496.Metal2 2.1627e-05f
Cred_6027 di_tg_ctrl_n.$187.Metal1 VDD.$718.Metal3 8.53751e-08f
Cred_6028 di_tg_ctrl_n.$189.Metal1 VSS 0.000593363f
Cred_6029 di_tg_ctrl_n.$189.Metal1 v_a.$1814.Metal2 9.32723e-06f
Cred_6030 di_tg_ctrl_n.$189.Metal1 v_a.$1816.Metal2 0.000417059f
Cred_6031 di_tg_ctrl_n.$189.Metal1 v_a.$2527.Metal3 0.000670305f
Cred_6032 di_tg_ctrl_n.$189.Metal1 v_a.$2531.Metal3 0.000118414f
Cred_6033 di_tg_ctrl_n.$189.Metal1 v_a.$746.Metal1 0.000728449f
Cred_6034 di_tg_ctrl_n.$189.Metal1 v_a.P22.pSD 0.00149641f
Cred_6035 di_tg_ctrl_n.$189.Metal1 v_b.$2691.Metal2 0.00248622f
Cred_6036 di_tg_ctrl_n.$189.Metal1 v_b.P23.pSD 0.012179f
Cred_6037 di_tg_ctrl_n.$189.Metal1 VDD.$169.Metal1 0.016628f
Cred_6038 di_tg_ctrl_n.$189.Metal1 VDD.$173.Metal1 0.0151865f
Cred_6039 di_tg_ctrl_n.$189.Metal1 VDD.$179.Metal1 2.42318e-05f
Cred_6040 di_tg_ctrl_n.$189.Metal1 VDD.$496.Metal2 3.09243e-07f
Cred_6041 di_tg_ctrl_n.$189.Metal1 VDD.$504.Metal2 4.86982e-07f
Cred_6042 di_tg_ctrl_n.$189.Metal1 VDD.$722.Metal3 2.47945e-09f
Cred_6043 di_tg_ctrl_n.$189.Metal1 VDD.P0.nSD 4.10077e-08f
Cred_6044 di_tg_ctrl_n.$19.GatPoly VSS 0.00685292f
Cred_6045 di_tg_ctrl_n.$19.GatPoly v_a.$1404.Metal2 8.84469e-06f
Cred_6046 di_tg_ctrl_n.$19.GatPoly v_a.$1406.Metal2 2.76734e-06f
Cred_6047 di_tg_ctrl_n.$19.GatPoly v_a.$1408.Metal2 0.000223065f
Cred_6048 di_tg_ctrl_n.$19.GatPoly v_a.$1410.Metal2 0.0078267f
Cred_6049 di_tg_ctrl_n.$19.GatPoly v_a.$2321.Metal3 0.00201936f
Cred_6050 di_tg_ctrl_n.$19.GatPoly v_a.$303.Metal1 0.00159966f
Cred_6051 di_tg_ctrl_n.$19.GatPoly v_a.$305.Metal1 0.0176715f
Cred_6052 di_tg_ctrl_n.$19.GatPoly v_a.P8.pSD 0.007688f
Cred_6053 di_tg_ctrl_n.$19.GatPoly v_b.$2421.Metal2 0.00319632f
Cred_6054 di_tg_ctrl_n.$19.GatPoly v_b.$2481.Metal2 0.00390783f
Cred_6055 di_tg_ctrl_n.$19.GatPoly v_b.P10.pSD 0.0025092f
Cred_6056 di_tg_ctrl_n.$19.GatPoly v_b.P7.nSD 3.5369e-05f
Cred_6057 di_tg_ctrl_n.$19.GatPoly v_b.P7.pSD 0.0227593f
Cred_6058 di_tg_ctrl_n.$19.GatPoly VDD.$420.Metal2 3.32564e-06f
Cred_6059 di_tg_ctrl_n.$19.GatPoly VDD.$428.Metal2 7.52477e-06f
Cred_6060 di_tg_ctrl_n.$19.GatPoly VDD.$432.Metal2 2.20611e-06f
Cred_6061 di_tg_ctrl_n.$19.GatPoly VDD.$684.Metal3 1.74588e-08f
Cred_6062 di_tg_ctrl_n.$19.GatPoly VDD.$81.Metal1 0.000339222f
Cred_6063 di_tg_ctrl_n.$19.GatPoly VDD.$85.Metal1 0.00131548f
Cred_6064 di_tg_ctrl_n.$19.GatPoly VDD.$89.Metal1 0.00348273f
Cred_6065 di_tg_ctrl_n.$19.GatPoly VDD.$99.Metal1 0.000404569f
Cred_6066 di_tg_ctrl_n.$19.GatPoly VDD.P0.nSD 2.05996e-06f
Cred_6067 di_tg_ctrl_n.$191.Metal1 VSS 0.000593363f
Cred_6068 di_tg_ctrl_n.$191.Metal1 v_a.$1872.Metal2 9.17496e-06f
Cred_6069 di_tg_ctrl_n.$191.Metal1 v_a.$1874.Metal2 0.000444797f
Cred_6070 di_tg_ctrl_n.$191.Metal1 v_a.$2557.Metal3 0.00045505f
Cred_6071 di_tg_ctrl_n.$191.Metal1 v_a.$2561.Metal3 0.000130771f
Cred_6072 di_tg_ctrl_n.$191.Metal1 v_a.$809.Metal1 0.000716556f
Cred_6073 di_tg_ctrl_n.$191.Metal1 v_a.P24.pSD 0.00121734f
Cred_6074 di_tg_ctrl_n.$191.Metal1 v_b.$2691.Metal2 0.00249301f
Cred_6075 di_tg_ctrl_n.$191.Metal1 v_b.P23.pSD 0.0122037f
Cred_6076 di_tg_ctrl_n.$191.Metal1 VDD.$169.Metal1 6.89493e-05f
Cred_6077 di_tg_ctrl_n.$191.Metal1 VDD.$173.Metal1 0.0242531f
Cred_6078 di_tg_ctrl_n.$191.Metal1 VDD.$179.Metal1 0.00730505f
Cred_6079 di_tg_ctrl_n.$191.Metal1 VDD.$183.Metal1 4.05145e-09f
Cred_6080 di_tg_ctrl_n.$191.Metal1 VDD.$496.Metal2 1.41479e-07f
Cred_6081 di_tg_ctrl_n.$191.Metal1 VDD.$504.Metal2 8.84309e-05f
Cred_6082 di_tg_ctrl_n.$191.Metal1 VDD.$512.Metal2 8.59327e-06f
Cred_6083 di_tg_ctrl_n.$191.Metal1 VDD.$722.Metal3 1.13435e-09f
Cred_6084 di_tg_ctrl_n.$191.Metal1 VDD.$726.Metal3 6.8899e-08f
Cred_6085 di_tg_ctrl_n.$191.Metal1 VDD.P0.nSD 1.23579e-05f
Cred_6086 di_tg_ctrl_n.$193.Metal1 VSS 0.000938236f
Cred_6087 di_tg_ctrl_n.$193.Metal1 v_a.$1868.Metal2 3.50839e-06f
Cred_6088 di_tg_ctrl_n.$193.Metal1 v_a.$1870.Metal2 1.09771e-06f
Cred_6089 di_tg_ctrl_n.$193.Metal1 v_a.$1872.Metal2 0.000129799f
Cred_6090 di_tg_ctrl_n.$193.Metal1 v_a.$1874.Metal2 0.00583382f
Cred_6091 di_tg_ctrl_n.$193.Metal1 v_a.$2557.Metal3 0.00209623f
Cred_6092 di_tg_ctrl_n.$193.Metal1 v_a.$2561.Metal3 0.00166303f
Cred_6093 di_tg_ctrl_n.$193.Metal1 v_a.$807.Metal1 0.000634532f
Cred_6094 di_tg_ctrl_n.$193.Metal1 v_a.$809.Metal1 0.0102364f
Cred_6095 di_tg_ctrl_n.$193.Metal1 v_a.P24.pSD 0.010898f
Cred_6096 di_tg_ctrl_n.$193.Metal1 v_b.$2691.Metal2 0.000743435f
Cred_6097 di_tg_ctrl_n.$193.Metal1 v_b.$2751.Metal2 0.000743435f
Cred_6098 di_tg_ctrl_n.$193.Metal1 v_b.P25.nSD 8.2265e-06f
Cred_6099 di_tg_ctrl_n.$193.Metal1 v_b.P25.pSD 0.00681199f
Cred_6100 di_tg_ctrl_n.$193.Metal1 VDD.$173.Metal1 0.00845596f
Cred_6101 di_tg_ctrl_n.$193.Metal1 VDD.$179.Metal1 0.0312573f
Cred_6102 di_tg_ctrl_n.$193.Metal1 VDD.$183.Metal1 0.00701356f
Cred_6103 di_tg_ctrl_n.$193.Metal1 VDD.$504.Metal2 0.000190931f
Cred_6104 di_tg_ctrl_n.$193.Metal1 VDD.$512.Metal2 2.58536e-05f
Cred_6105 di_tg_ctrl_n.$193.Metal1 VDD.$726.Metal3 2.07289e-07f
Cred_6106 di_tg_ctrl_n.$193.Metal1 VDD.P0.nSD 1.42229e-05f
Cred_6107 di_tg_ctrl_n.$196.Metal1 VSS 0.00164438f
Cred_6108 di_tg_ctrl_n.$196.Metal1 v_a.$1926.Metal2 1.58433e-06f
Cred_6109 di_tg_ctrl_n.$196.Metal1 v_a.$1928.Metal2 4.95708e-07f
Cred_6110 di_tg_ctrl_n.$196.Metal1 v_a.$1930.Metal2 3.87575e-05f
Cred_6111 di_tg_ctrl_n.$196.Metal1 v_a.$1932.Metal2 0.00141225f
Cred_6112 di_tg_ctrl_n.$196.Metal1 v_a.$2557.Metal3 0.000668966f
Cred_6113 di_tg_ctrl_n.$196.Metal1 v_a.$2587.Metal3 0.00146032f
Cred_6114 di_tg_ctrl_n.$196.Metal1 v_a.$2591.Metal3 0.000371426f
Cred_6115 di_tg_ctrl_n.$196.Metal1 v_a.$870.Metal1 0.000286544f
Cred_6116 di_tg_ctrl_n.$196.Metal1 v_a.$872.Metal1 0.00307176f
Cred_6117 di_tg_ctrl_n.$196.Metal1 v_a.P24.pSD 0.000485019f
Cred_6118 di_tg_ctrl_n.$196.Metal1 v_a.P26.pSD 0.00288415f
Cred_6119 di_tg_ctrl_n.$196.Metal1 v_b.$2691.Metal2 0.00243658f
Cred_6120 di_tg_ctrl_n.$196.Metal1 v_b.$2751.Metal2 0.00243658f
Cred_6121 di_tg_ctrl_n.$196.Metal1 v_b.P25.nSD 2.69621e-05f
Cred_6122 di_tg_ctrl_n.$196.Metal1 v_b.P25.pSD 0.0223551f
Cred_6123 di_tg_ctrl_n.$196.Metal1 VDD 0.0157117f
Cred_6124 di_tg_ctrl_n.$196.Metal1 VDD.$179.Metal1 0.00822406f
Cred_6125 di_tg_ctrl_n.$196.Metal1 VDD.$183.Metal1 0.0240696f
Cred_6126 di_tg_ctrl_n.$196.Metal1 VDD.$189.Metal1 0.000228914f
Cred_6127 di_tg_ctrl_n.$196.Metal1 VDD.$512.Metal2 1.51413e-06f
Cred_6128 di_tg_ctrl_n.$196.Metal1 VDD.$520.Metal2 3.4161e-07f
Cred_6129 di_tg_ctrl_n.$196.Metal1 VDD.$730.Metal3 2.73895e-09f
Cred_6130 di_tg_ctrl_n.$198.Metal1 VSS 0.00150899f
Cred_6131 di_tg_ctrl_n.$198.Metal1 v_a.$1926.Metal2 4.0583e-06f
Cred_6132 di_tg_ctrl_n.$198.Metal1 v_a.$1928.Metal2 1.26977e-06f
Cred_6133 di_tg_ctrl_n.$198.Metal1 v_a.$1930.Metal2 0.00014142f
Cred_6134 di_tg_ctrl_n.$198.Metal1 v_a.$1932.Metal2 0.00621601f
Cred_6135 di_tg_ctrl_n.$198.Metal1 v_a.$2587.Metal3 0.00161186f
Cred_6136 di_tg_ctrl_n.$198.Metal1 v_a.$2591.Metal3 0.0017579f
Cred_6137 di_tg_ctrl_n.$198.Metal1 v_a.$870.Metal1 0.000733989f
Cred_6138 di_tg_ctrl_n.$198.Metal1 v_a.$872.Metal1 0.0111596f
Cred_6139 di_tg_ctrl_n.$198.Metal1 v_a.P26.pSD 0.00992535f
Cred_6140 di_tg_ctrl_n.$198.Metal1 v_b.$2691.Metal2 0.000361965f
Cred_6141 di_tg_ctrl_n.$198.Metal1 v_b.$2751.Metal2 0.000361965f
Cred_6142 di_tg_ctrl_n.$198.Metal1 v_b.P25.nSD 4.00533e-06f
Cred_6143 di_tg_ctrl_n.$198.Metal1 v_b.P25.pSD 0.00258198f
Cred_6144 di_tg_ctrl_n.$198.Metal1 VDD 0.0153993f
Cred_6145 di_tg_ctrl_n.$198.Metal1 VDD.$183.Metal1 0.000240483f
Cred_6146 di_tg_ctrl_n.$198.Metal1 VDD.$189.Metal1 0.0165776f
Cred_6147 di_tg_ctrl_n.$198.Metal1 VDD.$512.Metal2 5.34051e-05f
Cred_6148 di_tg_ctrl_n.$198.Metal1 VDD.$520.Metal2 9.678e-05f
Cred_6149 di_tg_ctrl_n.$198.Metal1 VDD.$730.Metal3 4.24927e-07f
Cred_6150 di_tg_ctrl_n.$2.GatPoly VSS 0.0151694f
Cred_6151 di_tg_ctrl_n.$2.GatPoly v_a.$114.Metal1 0.000541807f
Cred_6152 di_tg_ctrl_n.$2.GatPoly v_a.$116.Metal1 8.47608e-05f
Cred_6153 di_tg_ctrl_n.$2.GatPoly v_a.$1168.Metal2 0.000255994f
Cred_6154 di_tg_ctrl_n.$2.GatPoly v_a.$1170.Metal2 0.0137237f
Cred_6155 di_tg_ctrl_n.$2.GatPoly v_a.$118.Metal1 0.00765232f
Cred_6156 di_tg_ctrl_n.$2.GatPoly v_a.$1230.Metal2 2.99571e-06f
Cred_6157 di_tg_ctrl_n.$2.GatPoly v_a.$1232.Metal2 9.37302e-07f
Cred_6158 di_tg_ctrl_n.$2.GatPoly v_a.$1238.Metal2 0.000153654f
Cred_6159 di_tg_ctrl_n.$2.GatPoly v_a.$1240.Metal2 0.00211372f
Cred_6160 di_tg_ctrl_n.$2.GatPoly v_a.$2197.Metal3 0.0135653f
Cred_6161 di_tg_ctrl_n.$2.GatPoly v_a.$2227.Metal3 1.01596e-07f
Cred_6162 di_tg_ctrl_n.$2.GatPoly v_a.$2233.Metal3 0.000250218f
Cred_6163 di_tg_ctrl_n.$2.GatPoly v_a.$48.Metal1 0.0137451f
Cred_6164 di_tg_ctrl_n.$2.GatPoly v_a.P0.pSD 0.0173023f
Cred_6165 di_tg_ctrl_n.$2.GatPoly v_a.P2.pSD 0.00174504f
Cred_6166 di_tg_ctrl_n.$2.GatPoly v_b.$2361.Metal2 0.0126003f
Cred_6167 di_tg_ctrl_n.$2.GatPoly v_b.P0.nSD 4.39296e-05f
Cred_6168 di_tg_ctrl_n.$2.GatPoly v_b.P0.pSD 0.0220732f
Cred_6169 di_tg_ctrl_n.$2.GatPoly v_b.P1.pSD 0.0268043f
Cred_6170 di_tg_ctrl_n.$2.GatPoly VDD.$340.Metal1 1.18877e-09f
Cred_6171 di_tg_ctrl_n.$2.GatPoly VDD.$388.Metal2 3.89762e-05f
Cred_6172 di_tg_ctrl_n.$2.GatPoly VDD.$392.Metal2 2.50876e-05f
Cred_6173 di_tg_ctrl_n.$2.GatPoly VDD.$400.Metal2 7.94454e-07f
Cred_6174 di_tg_ctrl_n.$2.GatPoly VDD.$42.Metal1 0.00719294f
Cred_6175 di_tg_ctrl_n.$2.GatPoly VDD.$55.Metal1 0.00502049f
Cred_6176 di_tg_ctrl_n.$2.GatPoly VDD.$59.Metal1 0.00035491f
Cred_6177 di_tg_ctrl_n.$2.GatPoly VDD.$666.Metal3 4.53907e-07f
Cred_6178 di_tg_ctrl_n.$2.GatPoly VDD.$670.Metal3 6.36975e-09f
Cred_6179 di_tg_ctrl_n.$2.GatPoly VDD.P0.nSD 0.000274528f
Cred_6180 di_tg_ctrl_n.$200.Metal1 VSS 0.000593363f
Cred_6181 di_tg_ctrl_n.$200.Metal1 v_a.$1930.Metal2 9.19654e-06f
Cred_6182 di_tg_ctrl_n.$200.Metal1 v_a.$1932.Metal2 0.000456285f
Cred_6183 di_tg_ctrl_n.$200.Metal1 v_a.$2587.Metal3 0.000773281f
Cred_6184 di_tg_ctrl_n.$200.Metal1 v_a.$2591.Metal3 0.000135398f
Cred_6185 di_tg_ctrl_n.$200.Metal1 v_a.$872.Metal1 0.000718242f
Cred_6186 di_tg_ctrl_n.$200.Metal1 v_a.P26.pSD 0.00159252f
Cred_6187 di_tg_ctrl_n.$200.Metal1 v_b.$2751.Metal2 0.00255694f
Cred_6188 di_tg_ctrl_n.$200.Metal1 v_b.P27.pSD 0.012436f
Cred_6189 di_tg_ctrl_n.$200.Metal1 VDD 1.17622e-07f
Cred_6190 di_tg_ctrl_n.$200.Metal1 VDD.$189.Metal1 0.0145772f
Cred_6191 di_tg_ctrl_n.$200.Metal1 VDD.$193.Metal1 0.0166181f
Cred_6192 di_tg_ctrl_n.$200.Metal1 VDD.$197.Metal1 5.14801e-05f
Cred_6193 di_tg_ctrl_n.$200.Metal1 VDD.$512.Metal2 3.03041e-05f
Cred_6194 di_tg_ctrl_n.$200.Metal1 VDD.$520.Metal2 5.62866e-05f
Cred_6195 di_tg_ctrl_n.$200.Metal1 VDD.$528.Metal2 9.60303e-09f
Cred_6196 di_tg_ctrl_n.$200.Metal1 VDD.$730.Metal3 2.42972e-07f
Cred_6197 di_tg_ctrl_n.$200.Metal1 VDD.$734.Metal3 7.69949e-11f
Cred_6198 di_tg_ctrl_n.$202.Metal1 VSS 0.000593363f
Cred_6199 di_tg_ctrl_n.$202.Metal1 v_a.$1990.Metal2 0.000374906f
Cred_6200 di_tg_ctrl_n.$202.Metal1 v_a.$2617.Metal3 0.000384565f
Cred_6201 di_tg_ctrl_n.$202.Metal1 v_a.$2621.Metal3 0.000115697f
Cred_6202 di_tg_ctrl_n.$202.Metal1 v_a.$936.Metal1 0.000790172f
Cred_6203 di_tg_ctrl_n.$202.Metal1 v_a.P28.pSD 0.00106127f
Cred_6204 di_tg_ctrl_n.$202.Metal1 v_b.$2751.Metal2 0.00242172f
Cred_6205 di_tg_ctrl_n.$202.Metal1 v_b.P27.pSD 0.0119447f
Cred_6206 di_tg_ctrl_n.$202.Metal1 VDD.$189.Metal1 5.45106e-05f
Cred_6207 di_tg_ctrl_n.$202.Metal1 VDD.$193.Metal1 0.0148185f
Cred_6208 di_tg_ctrl_n.$202.Metal1 VDD.$197.Metal1 0.0164229f
Cred_6209 di_tg_ctrl_n.$202.Metal1 VDD.$203.Metal1 1.46285e-06f
Cred_6210 di_tg_ctrl_n.$202.Metal1 VDD.$520.Metal2 1.76706e-05f
Cred_6211 di_tg_ctrl_n.$202.Metal1 VDD.$528.Metal2 3.27131e-05f
Cred_6212 di_tg_ctrl_n.$202.Metal1 VDD.$734.Metal3 1.39624e-07f
Cred_6213 di_tg_ctrl_n.$202.Metal1 VDD.P0.nSD 2.47758e-09f
Cred_6214 di_tg_ctrl_n.$204.Metal1 VSS 0.000938236f
Cred_6215 di_tg_ctrl_n.$204.Metal1 v_a.$1982.Metal2 5.39658e-07f
Cred_6216 di_tg_ctrl_n.$204.Metal1 v_a.$1984.Metal2 6.89007e-06f
Cred_6217 di_tg_ctrl_n.$204.Metal1 v_a.$1990.Metal2 0.00496441f
Cred_6218 di_tg_ctrl_n.$204.Metal1 v_a.$2617.Metal3 0.00304404f
Cred_6219 di_tg_ctrl_n.$204.Metal1 v_a.$2621.Metal3 0.00149253f
Cred_6220 di_tg_ctrl_n.$204.Metal1 v_a.$932.Metal1 0.000264923f
Cred_6221 di_tg_ctrl_n.$204.Metal1 v_a.$934.Metal1 0.000464251f
Cred_6222 di_tg_ctrl_n.$204.Metal1 v_a.$936.Metal1 0.0113114f
Cred_6223 di_tg_ctrl_n.$204.Metal1 v_a.P28.pSD 0.00980726f
Cred_6224 di_tg_ctrl_n.$204.Metal1 v_b.$2751.Metal2 0.000743427f
Cred_6225 di_tg_ctrl_n.$204.Metal1 v_b.$2811.Metal2 0.000743427f
Cred_6226 di_tg_ctrl_n.$204.Metal1 v_b.P29.nSD 8.22641e-06f
Cred_6227 di_tg_ctrl_n.$204.Metal1 v_b.P29.pSD 0.00671965f
Cred_6228 di_tg_ctrl_n.$204.Metal1 VDD.$193.Metal1 2.47644e-05f
Cred_6229 di_tg_ctrl_n.$204.Metal1 VDD.$197.Metal1 0.0271771f
Cred_6230 di_tg_ctrl_n.$204.Metal1 VDD.$203.Metal1 0.0203411f
Cred_6231 di_tg_ctrl_n.$204.Metal1 VDD.$520.Metal2 6.14169e-05f
Cred_6232 di_tg_ctrl_n.$204.Metal1 VDD.$528.Metal2 0.000181176f
Cred_6233 di_tg_ctrl_n.$204.Metal1 VDD.$734.Metal3 4.92427e-07f
Cred_6234 di_tg_ctrl_n.$204.Metal1 VDD.P0.nSD 2.03172e-05f
Cred_6235 di_tg_ctrl_n.$207.Metal1 VSS 0.00164438f
Cred_6236 di_tg_ctrl_n.$207.Metal1 v_a.$2042.Metal2 1.58433e-06f
Cred_6237 di_tg_ctrl_n.$207.Metal1 v_a.$2044.Metal2 4.95708e-07f
Cred_6238 di_tg_ctrl_n.$207.Metal1 v_a.$2046.Metal2 3.87575e-05f
Cred_6239 di_tg_ctrl_n.$207.Metal1 v_a.$2048.Metal2 0.00141225f
Cred_6240 di_tg_ctrl_n.$207.Metal1 v_a.$2617.Metal3 0.000650136f
Cred_6241 di_tg_ctrl_n.$207.Metal1 v_a.$2647.Metal3 0.00147406f
Cred_6242 di_tg_ctrl_n.$207.Metal1 v_a.$2651.Metal3 0.000371426f
Cred_6243 di_tg_ctrl_n.$207.Metal1 v_a.$996.Metal1 0.000286544f
Cred_6244 di_tg_ctrl_n.$207.Metal1 v_a.$998.Metal1 0.00307176f
Cred_6245 di_tg_ctrl_n.$207.Metal1 v_a.P30.pSD 0.00298251f
Cred_6246 di_tg_ctrl_n.$207.Metal1 v_b.$2751.Metal2 0.00243624f
Cred_6247 di_tg_ctrl_n.$207.Metal1 v_b.$2811.Metal2 0.00243624f
Cred_6248 di_tg_ctrl_n.$207.Metal1 v_b.P29.nSD 2.69583e-05f
Cred_6249 di_tg_ctrl_n.$207.Metal1 v_b.P29.pSD 0.0222596f
Cred_6250 di_tg_ctrl_n.$207.Metal1 VDD.$197.Metal1 0.0034857f
Cred_6251 di_tg_ctrl_n.$207.Metal1 VDD.$203.Metal1 0.0266073f
Cred_6252 di_tg_ctrl_n.$207.Metal1 VDD.$207.Metal1 0.0170982f
Cred_6253 di_tg_ctrl_n.$207.Metal1 VDD.$211.Metal1 0.000248312f
Cred_6254 di_tg_ctrl_n.$207.Metal1 VDD.$528.Metal2 1.97047e-05f
Cred_6255 di_tg_ctrl_n.$207.Metal1 VDD.$536.Metal2 1.41276e-06f
Cred_6256 di_tg_ctrl_n.$207.Metal1 VDD.$738.Metal3 5.71182e-09f
Cred_6257 di_tg_ctrl_n.$207.Metal1 VDD.P0.nSD 5.89889e-06f
Cred_6258 di_tg_ctrl_n.$209.Metal1 VSS 0.00150899f
Cred_6259 di_tg_ctrl_n.$209.Metal1 v_a.$2042.Metal2 4.0583e-06f
Cred_6260 di_tg_ctrl_n.$209.Metal1 v_a.$2044.Metal2 1.26977e-06f
Cred_6261 di_tg_ctrl_n.$209.Metal1 v_a.$2046.Metal2 0.000141391f
Cred_6262 di_tg_ctrl_n.$209.Metal1 v_a.$2048.Metal2 0.00620736f
Cred_6263 di_tg_ctrl_n.$209.Metal1 v_a.$2647.Metal3 0.00166518f
Cred_6264 di_tg_ctrl_n.$209.Metal1 v_a.$2651.Metal3 0.00175449f
Cred_6265 di_tg_ctrl_n.$209.Metal1 v_a.$996.Metal1 0.000733989f
Cred_6266 di_tg_ctrl_n.$209.Metal1 v_a.$998.Metal1 0.0111574f
Cred_6267 di_tg_ctrl_n.$209.Metal1 v_a.P30.pSD 0.00973025f
Cred_6268 di_tg_ctrl_n.$209.Metal1 v_b.$2751.Metal2 0.000361965f
Cred_6269 di_tg_ctrl_n.$209.Metal1 v_b.$2811.Metal2 0.000361965f
Cred_6270 di_tg_ctrl_n.$209.Metal1 v_b.P29.nSD 4.00533e-06f
Cred_6271 di_tg_ctrl_n.$209.Metal1 v_b.P29.pSD 0.00258198f
Cred_6272 di_tg_ctrl_n.$209.Metal1 VDD.$203.Metal1 0.000220925f
Cred_6273 di_tg_ctrl_n.$209.Metal1 VDD.$207.Metal1 0.0149588f
Cred_6274 di_tg_ctrl_n.$209.Metal1 VDD.$211.Metal1 0.017057f
Cred_6275 di_tg_ctrl_n.$209.Metal1 VDD.$215.Metal1 1.26796e-07f
Cred_6276 di_tg_ctrl_n.$209.Metal1 VDD.$528.Metal2 2.47266e-07f
Cred_6277 di_tg_ctrl_n.$209.Metal1 VDD.$536.Metal2 0.000122639f
Cred_6278 di_tg_ctrl_n.$209.Metal1 VDD.$544.Metal2 2.0704e-05f
Cred_6279 di_tg_ctrl_n.$209.Metal1 VDD.$738.Metal3 1.98253e-09f
Cred_6280 di_tg_ctrl_n.$209.Metal1 VDD.$742.Metal3 1.66e-07f
Cred_6281 di_tg_ctrl_n.$211.Metal1 VSS 0.000593363f
Cred_6282 di_tg_ctrl_n.$211.Metal1 v_a.$2046.Metal2 8.77176e-06f
Cred_6283 di_tg_ctrl_n.$211.Metal1 v_a.$2048.Metal2 0.000438432f
Cred_6284 di_tg_ctrl_n.$211.Metal1 v_a.$2647.Metal3 0.000867141f
Cred_6285 di_tg_ctrl_n.$211.Metal1 v_a.$2651.Metal3 0.000130477f
Cred_6286 di_tg_ctrl_n.$211.Metal1 v_a.$998.Metal1 0.000685067f
Cred_6287 di_tg_ctrl_n.$211.Metal1 v_a.P30.pSD 0.00166712f
Cred_6288 di_tg_ctrl_n.$211.Metal1 v_b.$2811.Metal2 0.00250457f
Cred_6289 di_tg_ctrl_n.$211.Metal1 v_b.P31.pSD 0.0122457f
Cred_6290 di_tg_ctrl_n.$211.Metal1 VDD.$211.Metal1 0.0145889f
Cred_6291 di_tg_ctrl_n.$211.Metal1 VDD.$215.Metal1 0.0166319f
Cred_6292 di_tg_ctrl_n.$211.Metal1 VDD.$225.Metal1 1.67765e-05f
Cred_6293 di_tg_ctrl_n.$211.Metal1 VDD.$536.Metal2 7.965e-05f
Cred_6294 di_tg_ctrl_n.$211.Metal1 VDD.$544.Metal2 1.40846e-05f
Cred_6295 di_tg_ctrl_n.$211.Metal1 VDD.$548.Metal2 8.83276e-08f
Cred_6296 di_tg_ctrl_n.$211.Metal1 VDD.$742.Metal3 1.11175e-07f
Cred_6297 di_tg_ctrl_n.$211.Metal1 VDD.P0.nSD 8.54234e-08f
Cred_6298 di_tg_ctrl_n.$213.Metal1 VSS 0.000593363f
Cred_6299 di_tg_ctrl_n.$213.Metal1 v_a.$1062.Metal1 0.000728559f
Cred_6300 di_tg_ctrl_n.$213.Metal1 v_a.$2106.Metal2 0.000317559f
Cred_6301 di_tg_ctrl_n.$213.Metal1 v_a.$2677.Metal3 0.000301959f
Cred_6302 di_tg_ctrl_n.$213.Metal1 v_a.$2681.Metal3 9.5046e-05f
Cred_6303 di_tg_ctrl_n.$213.Metal1 v_a.P32.pSD 0.000931858f
Cred_6304 di_tg_ctrl_n.$213.Metal1 v_b.$2811.Metal2 0.00247506f
Cred_6305 di_tg_ctrl_n.$213.Metal1 v_b.P31.pSD 0.0121385f
Cred_6306 di_tg_ctrl_n.$213.Metal1 VDD.$211.Metal1 5.09372e-05f
Cred_6307 di_tg_ctrl_n.$213.Metal1 VDD.$215.Metal1 0.0257067f
Cred_6308 di_tg_ctrl_n.$213.Metal1 VDD.$225.Metal1 0.00540931f
Cred_6309 di_tg_ctrl_n.$213.Metal1 VDD.$536.Metal2 1.23523e-07f
Cred_6310 di_tg_ctrl_n.$213.Metal1 VDD.$544.Metal2 6.75598e-05f
Cred_6311 di_tg_ctrl_n.$213.Metal1 VDD.$548.Metal2 2.84798e-05f
Cred_6312 di_tg_ctrl_n.$213.Metal1 VDD.$742.Metal3 9.90378e-10f
Cred_6313 di_tg_ctrl_n.$213.Metal1 VDD.P0.nSD 2.75434e-05f
Cred_6314 di_tg_ctrl_n.$215.Metal1 VSS 0.00153284f
Cred_6315 di_tg_ctrl_n.$215.Metal1 v_a.$1058.Metal1 0.000308183f
Cred_6316 di_tg_ctrl_n.$215.Metal1 v_a.$1060.Metal1 0.000540059f
Cred_6317 di_tg_ctrl_n.$215.Metal1 v_a.$1062.Metal1 0.0126054f
Cred_6318 di_tg_ctrl_n.$215.Metal1 v_a.$2098.Metal2 6.27779e-07f
Cred_6319 di_tg_ctrl_n.$215.Metal1 v_a.$2100.Metal2 8.01516e-06f
Cred_6320 di_tg_ctrl_n.$215.Metal1 v_a.$2106.Metal2 0.0053047f
Cred_6321 di_tg_ctrl_n.$215.Metal1 v_a.$2677.Metal3 0.00235258f
Cred_6322 di_tg_ctrl_n.$215.Metal1 v_a.$2681.Metal3 0.00157315f
Cred_6323 di_tg_ctrl_n.$215.Metal1 v_a.P32.pSD 0.0104094f
Cred_6324 di_tg_ctrl_n.$215.Metal1 v_b.$2811.Metal2 0.000371345f
Cred_6325 di_tg_ctrl_n.$215.Metal1 v_b.$2871.Metal2 0.000371345f
Cred_6326 di_tg_ctrl_n.$215.Metal1 v_b.P33.nSD 4.10913e-06f
Cred_6327 di_tg_ctrl_n.$215.Metal1 v_b.P33.pSD 0.00264849f
Cred_6328 di_tg_ctrl_n.$215.Metal1 VDD.$215.Metal1 0.0159374f
Cred_6329 di_tg_ctrl_n.$215.Metal1 VDD.$225.Metal1 0.0168915f
Cred_6330 di_tg_ctrl_n.$215.Metal1 VDD.$230.Metal1 2.30831e-05f
Cred_6331 di_tg_ctrl_n.$215.Metal1 VDD.$544.Metal2 9.88935e-05f
Cred_6332 di_tg_ctrl_n.$215.Metal1 VDD.$548.Metal2 8.84649e-05f
Cred_6333 di_tg_ctrl_n.$215.Metal1 VDD.$552.Metal2 1.78048e-07f
Cred_6334 di_tg_ctrl_n.$215.Metal1 VDD.P0.nSD 5.52191e-05f
Cred_6335 di_tg_ctrl_n.$216.Metal1 VSS 0.00162034f
Cred_6336 di_tg_ctrl_n.$216.Metal1 v_a.$1058.Metal1 0.000117885f
Cred_6337 di_tg_ctrl_n.$216.Metal1 v_a.$1060.Metal1 0.000206582f
Cred_6338 di_tg_ctrl_n.$216.Metal1 v_a.$1062.Metal1 0.0034543f
Cred_6339 di_tg_ctrl_n.$216.Metal1 v_a.$2098.Metal2 2.40137e-07f
Cred_6340 di_tg_ctrl_n.$216.Metal1 v_a.$2100.Metal2 3.06594e-06f
Cred_6341 di_tg_ctrl_n.$216.Metal1 v_a.$2106.Metal2 0.00119482f
Cred_6342 di_tg_ctrl_n.$216.Metal1 v_a.$2657.Metal3 0.000351829f
Cred_6343 di_tg_ctrl_n.$216.Metal1 v_a.$2677.Metal3 0.00134031f
Cred_6344 di_tg_ctrl_n.$216.Metal1 v_a.$2681.Metal3 0.000408557f
Cred_6345 di_tg_ctrl_n.$216.Metal1 v_a.P32.pSD 0.0012113f
Cred_6346 di_tg_ctrl_n.$216.Metal1 v_a.P34.nSD 2.31351e-06f
Cred_6347 di_tg_ctrl_n.$216.Metal1 v_a.P34.pSD 0.000433784f
Cred_6348 di_tg_ctrl_n.$216.Metal1 v_b.$2811.Metal2 0.00218817f
Cred_6349 di_tg_ctrl_n.$216.Metal1 v_b.$2871.Metal2 0.00218598f
Cred_6350 di_tg_ctrl_n.$216.Metal1 v_b.P31.pSD 6.05258e-06f
Cred_6351 di_tg_ctrl_n.$216.Metal1 v_b.P33.nSD 2.4189e-05f
Cred_6352 di_tg_ctrl_n.$216.Metal1 v_b.P33.pSD 0.0187898f
Cred_6353 di_tg_ctrl_n.$216.Metal1 VDD.$215.Metal1 0.00502415f
Cred_6354 di_tg_ctrl_n.$216.Metal1 VDD.$225.Metal1 0.0302019f
Cred_6355 di_tg_ctrl_n.$216.Metal1 VDD.$230.Metal1 0.000607652f
Cred_6356 di_tg_ctrl_n.$216.Metal1 VDD.$238.Metal1 4.16787e-06f
Cred_6357 di_tg_ctrl_n.$216.Metal1 VDD.$544.Metal2 3.16209e-05f
Cred_6358 di_tg_ctrl_n.$216.Metal1 VDD.$548.Metal2 0.000356526f
Cred_6359 di_tg_ctrl_n.$216.Metal1 VDD.$552.Metal2 0.000590249f
Cred_6360 di_tg_ctrl_n.$216.Metal1 VDD.$560.Metal2 0.000162831f
Cred_6361 di_tg_ctrl_n.$216.Metal1 VDD.$742.Metal3 6.70718e-05f
Cred_6362 di_tg_ctrl_n.$216.Metal1 VDD.$750.Metal3 0.000114773f
Cred_6363 di_tg_ctrl_n.$216.Metal1 VDD.P0.nSD 2.58239e-05f
Cred_6364 di_tg_ctrl_n.$219.Metal1 VSS 0.00246709f
Cred_6365 di_tg_ctrl_n.$219.Metal1 v_a.$1062.Metal1 1.66445e-06f
Cred_6366 di_tg_ctrl_n.$219.Metal1 v_a.$2106.Metal2 8.52402e-06f
Cred_6367 di_tg_ctrl_n.$219.Metal1 v_a.$2657.Metal3 0.0106542f
Cred_6368 di_tg_ctrl_n.$219.Metal1 v_a.$2677.Metal3 5.73071e-05f
Cred_6369 di_tg_ctrl_n.$219.Metal1 v_a.$2681.Metal3 0.000114291f
Cred_6370 di_tg_ctrl_n.$219.Metal1 v_a.P32.pSD 2.98747e-05f
Cred_6371 di_tg_ctrl_n.$219.Metal1 v_a.P34.nSD 7.00585e-05f
Cred_6372 di_tg_ctrl_n.$219.Metal1 v_a.P34.pSD 0.0276337f
Cred_6373 di_tg_ctrl_n.$219.Metal1 v_b.$2811.Metal2 0.00133904f
Cred_6374 di_tg_ctrl_n.$219.Metal1 v_b.$2871.Metal2 0.00210243f
Cred_6375 di_tg_ctrl_n.$219.Metal1 v_b.P31.pSD 8.99303e-06f
Cred_6376 di_tg_ctrl_n.$219.Metal1 v_b.P33.nSD 1.47812e-05f
Cred_6377 di_tg_ctrl_n.$219.Metal1 v_b.P33.pSD 0.01231f
Cred_6378 di_tg_ctrl_n.$219.Metal1 v_b.P35.pSD 0.00274182f
Cred_6379 di_tg_ctrl_n.$219.Metal1 VDD.$215.Metal1 1.20469e-05f
Cred_6380 di_tg_ctrl_n.$219.Metal1 VDD.$225.Metal1 0.0226642f
Cred_6381 di_tg_ctrl_n.$219.Metal1 VDD.$230.Metal1 0.0321544f
Cred_6382 di_tg_ctrl_n.$219.Metal1 VDD.$238.Metal1 0.00248472f
Cred_6383 di_tg_ctrl_n.$219.Metal1 VDD.$544.Metal2 7.43161e-07f
Cred_6384 di_tg_ctrl_n.$219.Metal1 VDD.$548.Metal2 0.000293603f
Cred_6385 di_tg_ctrl_n.$219.Metal1 VDD.$552.Metal2 0.00108421f
Cred_6386 di_tg_ctrl_n.$219.Metal1 VDD.$560.Metal2 0.000350508f
Cred_6387 di_tg_ctrl_n.$219.Metal1 VDD.$742.Metal3 0.000100486f
Cred_6388 di_tg_ctrl_n.$219.Metal1 VDD.$750.Metal3 0.000177703f
Cred_6389 di_tg_ctrl_n.$219.Metal1 VDD.P0.nSD 3.10669e-05f
Cred_6390 di_tg_ctrl_n.$22.GatPoly VSS 0.00995367f
Cred_6391 di_tg_ctrl_n.$22.GatPoly v_a.$1404.Metal2 6.59459e-06f
Cred_6392 di_tg_ctrl_n.$22.GatPoly v_a.$1406.Metal2 2.06333e-06f
Cred_6393 di_tg_ctrl_n.$22.GatPoly v_a.$1408.Metal2 0.000162646f
Cred_6394 di_tg_ctrl_n.$22.GatPoly v_a.$1410.Metal2 0.00593529f
Cred_6395 di_tg_ctrl_n.$22.GatPoly v_a.$1462.Metal2 2.99558e-06f
Cred_6396 di_tg_ctrl_n.$22.GatPoly v_a.$1464.Metal2 9.37263e-07f
Cred_6397 di_tg_ctrl_n.$22.GatPoly v_a.$1466.Metal2 7.57423e-05f
Cred_6398 di_tg_ctrl_n.$22.GatPoly v_a.$1468.Metal2 0.00264556f
Cred_6399 di_tg_ctrl_n.$22.GatPoly v_a.$2317.Metal3 8.55904e-06f
Cred_6400 di_tg_ctrl_n.$22.GatPoly v_a.$2321.Metal3 0.0015619f
Cred_6401 di_tg_ctrl_n.$22.GatPoly v_a.$2351.Metal3 0.000680975f
Cred_6402 di_tg_ctrl_n.$22.GatPoly v_a.$303.Metal1 0.00119271f
Cred_6403 di_tg_ctrl_n.$22.GatPoly v_a.$305.Metal1 0.0128891f
Cred_6404 di_tg_ctrl_n.$22.GatPoly v_a.$366.Metal1 0.000541785f
Cred_6405 di_tg_ctrl_n.$22.GatPoly v_a.$368.Metal1 0.00600017f
Cred_6406 di_tg_ctrl_n.$22.GatPoly v_a.P10.pSD 0.00259676f
Cred_6407 di_tg_ctrl_n.$22.GatPoly v_a.P8.pSD 0.00587529f
Cred_6408 di_tg_ctrl_n.$22.GatPoly v_b.$2481.Metal2 0.00803658f
Cred_6409 di_tg_ctrl_n.$22.GatPoly v_b.P10.pSD 0.0279543f
Cred_6410 di_tg_ctrl_n.$22.GatPoly VDD.$107.Metal1 0.00014777f
Cred_6411 di_tg_ctrl_n.$22.GatPoly VDD.$420.Metal2 3.4816e-07f
Cred_6412 di_tg_ctrl_n.$22.GatPoly VDD.$428.Metal2 2.11538e-05f
Cred_6413 di_tg_ctrl_n.$22.GatPoly VDD.$432.Metal2 1.98221e-05f
Cred_6414 di_tg_ctrl_n.$22.GatPoly VDD.$436.Metal2 1.56026e-06f
Cred_6415 di_tg_ctrl_n.$22.GatPoly VDD.$440.Metal2 4.16788e-07f
Cred_6416 di_tg_ctrl_n.$22.GatPoly VDD.$684.Metal3 2.79147e-09f
Cred_6417 di_tg_ctrl_n.$22.GatPoly VDD.$85.Metal1 0.000149314f
Cred_6418 di_tg_ctrl_n.$22.GatPoly VDD.$89.Metal1 0.00387251f
Cred_6419 di_tg_ctrl_n.$22.GatPoly VDD.$99.Metal1 0.00432657f
Cred_6420 di_tg_ctrl_n.$22.GatPoly VDD.P0.nSD 1.10516e-05f
Cred_6421 di_tg_ctrl_n.$223.Metal1 VSS 0.0167921f
Cred_6422 di_tg_ctrl_n.$223.Metal1 v_b.$2871.Metal2 0.000118587f
Cred_6423 di_tg_ctrl_n.$223.Metal1 v_b.$2962.Metal2 0.00950517f
Cred_6424 di_tg_ctrl_n.$223.Metal1 v_b.$3779.Metal3 0.0126369f
Cred_6425 di_tg_ctrl_n.$223.Metal1 v_b.$3785.Metal3 0.000104109f
Cred_6426 di_tg_ctrl_n.$223.Metal1 v_b.P35.nSD 0.000103605f
Cred_6427 di_tg_ctrl_n.$223.Metal1 v_b.P37.nSD 0.0179385f
Cred_6428 di_tg_ctrl_n.$223.Metal1 v_b.P37.pSD 3.53671e-05f
Cred_6429 di_tg_ctrl_n.$223.Metal1 v_b.P39.nSD 0.0126346f
Cred_6430 di_tg_ctrl_n.$223.Metal1 v_b.P41.nSD 0.000192012f
Cred_6431 di_tg_ctrl_n.$223.Metal1 VSS.$17.Metal1 2.29948e-06f
Cred_6432 di_tg_ctrl_n.$223.Metal1 VSS.$221.Metal1 0.0209489f
Cred_6433 di_tg_ctrl_n.$223.Metal1 VSS.$231.Metal1 0.0257833f
Cred_6434 di_tg_ctrl_n.$223.Metal1 VSS.$239.Metal1 0.00137593f
Cred_6435 di_tg_ctrl_n.$223.Metal1 VSS.$301.Metal1 2.81473e-05f
Cred_6436 di_tg_ctrl_n.$223.Metal1 VSS.$526.Metal2 6.78126e-05f
Cred_6437 di_tg_ctrl_n.$223.Metal1 VSS.$534.Metal2 0.000488779f
Cred_6438 di_tg_ctrl_n.$223.Metal1 VSS.$542.Metal2 1.06123e-05f
Cred_6439 di_tg_ctrl_n.$223.Metal1 VSS.$606.Metal2 2.97409e-06f
Cred_6440 di_tg_ctrl_n.$223.Metal1 VSS.$716.Metal3 3.31326e-06f
Cred_6441 di_tg_ctrl_n.$223.Metal1 VSS.$724.Metal3 6.6383e-06f
Cred_6442 di_tg_ctrl_n.$223.Metal1 VSS.$760.Metal3 1.75973e-07f
Cred_6443 di_tg_ctrl_n.$223.Metal1 VSS.P0.pSD 0.00158516f
Cred_6444 di_tg_ctrl_n.$227.Metal1 VSS 0.0137655f
Cred_6445 di_tg_ctrl_n.$227.Metal1 v_b.$2962.Metal2 0.00337432f
Cred_6446 di_tg_ctrl_n.$227.Metal1 v_b.$3056.Metal2 0.00327558f
Cred_6447 di_tg_ctrl_n.$227.Metal1 v_b.$3785.Metal3 0.0115045f
Cred_6448 di_tg_ctrl_n.$227.Metal1 v_b.P39.nSD 0.00415768f
Cred_6449 di_tg_ctrl_n.$227.Metal1 v_b.P41.nSD 0.0193431f
Cred_6450 di_tg_ctrl_n.$227.Metal1 v_b.P43.nSD 0.0043291f
Cred_6451 di_tg_ctrl_n.$227.Metal1 VSS.$17.Metal1 1.34677e-06f
Cred_6452 di_tg_ctrl_n.$227.Metal1 VSS.$221.Metal1 0.000817265f
Cred_6453 di_tg_ctrl_n.$227.Metal1 VSS.$231.Metal1 0.0212716f
Cred_6454 di_tg_ctrl_n.$227.Metal1 VSS.$239.Metal1 0.0200064f
Cred_6455 di_tg_ctrl_n.$227.Metal1 VSS.$253.Metal1 0.000269587f
Cred_6456 di_tg_ctrl_n.$227.Metal1 VSS.$301.Metal1 2.23205e-05f
Cred_6457 di_tg_ctrl_n.$227.Metal1 VSS.$534.Metal2 6.30244e-06f
Cred_6458 di_tg_ctrl_n.$227.Metal1 VSS.$542.Metal2 7.3786e-05f
Cred_6459 di_tg_ctrl_n.$227.Metal1 VSS.$550.Metal2 4.17937e-06f
Cred_6460 di_tg_ctrl_n.$227.Metal1 VSS.$554.Metal2 2.07934e-06f
Cred_6461 di_tg_ctrl_n.$227.Metal1 VSS.$606.Metal2 2.35842e-06f
Cred_6462 di_tg_ctrl_n.$227.Metal1 VSS.$760.Metal3 1.39545e-07f
Cred_6463 di_tg_ctrl_n.$227.Metal1 VSS.P0.pSD 0.00109457f
Cred_6464 di_tg_ctrl_n.$230.Metal1 VSS 0.0078385f
Cred_6465 di_tg_ctrl_n.$230.Metal1 v_b.$3056.Metal2 0.00862136f
Cred_6466 di_tg_ctrl_n.$230.Metal1 v_b.$3785.Metal3 0.000477348f
Cred_6467 di_tg_ctrl_n.$230.Metal1 v_b.$3821.Metal3 0.00108711f
Cred_6468 di_tg_ctrl_n.$230.Metal1 v_b.P41.nSD 2.56214e-05f
Cred_6469 di_tg_ctrl_n.$230.Metal1 v_b.P43.nSD 0.0122913f
Cred_6470 di_tg_ctrl_n.$230.Metal1 v_b.P45.nSD 0.00175749f
Cred_6471 di_tg_ctrl_n.$230.Metal1 VSS.$17.Metal1 1.32429e-06f
Cred_6472 di_tg_ctrl_n.$230.Metal1 VSS.$231.Metal1 0.0015357f
Cred_6473 di_tg_ctrl_n.$230.Metal1 VSS.$239.Metal1 0.0252973f
Cred_6474 di_tg_ctrl_n.$230.Metal1 VSS.$253.Metal1 0.00428237f
Cred_6475 di_tg_ctrl_n.$230.Metal1 VSS.$301.Metal1 2.92047e-05f
Cred_6476 di_tg_ctrl_n.$230.Metal1 VSS.$542.Metal2 1.18454e-05f
Cred_6477 di_tg_ctrl_n.$230.Metal1 VSS.$550.Metal2 6.63889e-05f
Cred_6478 di_tg_ctrl_n.$230.Metal1 VSS.$554.Metal2 3.30302e-05f
Cred_6479 di_tg_ctrl_n.$230.Metal1 VSS.$606.Metal2 3.08581e-06f
Cred_6480 di_tg_ctrl_n.$230.Metal1 VSS.$760.Metal3 1.82584e-07f
Cred_6481 di_tg_ctrl_n.$230.Metal1 VSS.P0.pSD 0.00122674f
Cred_6482 di_tg_ctrl_n.$232.Metal1 VSS 0.0116261f
Cred_6483 di_tg_ctrl_n.$232.Metal1 v_b.$3089.Metal2 1.75563e-06f
Cred_6484 di_tg_ctrl_n.$232.Metal1 v_b.$3153.Metal2 0.000458024f
Cred_6485 di_tg_ctrl_n.$232.Metal1 v_b.$3821.Metal3 0.0119128f
Cred_6486 di_tg_ctrl_n.$232.Metal1 v_b.$3857.Metal3 5.19798e-09f
Cred_6487 di_tg_ctrl_n.$232.Metal1 v_b.P45.nSD 0.0163991f
Cred_6488 di_tg_ctrl_n.$232.Metal1 v_b.P47.nSD 0.000425399f
Cred_6489 di_tg_ctrl_n.$232.Metal1 VSS.$17.Metal1 8.29068e-07f
Cred_6490 di_tg_ctrl_n.$232.Metal1 VSS.$239.Metal1 0.0108997f
Cred_6491 di_tg_ctrl_n.$232.Metal1 VSS.$253.Metal1 0.00980172f
Cred_6492 di_tg_ctrl_n.$232.Metal1 VSS.$301.Metal1 2.31285e-05f
Cred_6493 di_tg_ctrl_n.$232.Metal1 VSS.$550.Metal2 9.06456e-05f
Cred_6494 di_tg_ctrl_n.$232.Metal1 VSS.$554.Metal2 0.000145787f
Cred_6495 di_tg_ctrl_n.$232.Metal1 VSS.$606.Metal2 2.44379e-06f
Cred_6496 di_tg_ctrl_n.$232.Metal1 VSS.$760.Metal3 1.44596e-07f
Cred_6497 di_tg_ctrl_n.$232.Metal1 VSS.P0.pSD 0.000888695f
Cred_6498 di_tg_ctrl_n.$234.Metal1 VSS 0.0149778f
Cred_6499 di_tg_ctrl_n.$234.Metal1 v_b.$3089.Metal2 2.36101e-06f
Cred_6500 di_tg_ctrl_n.$234.Metal1 v_b.$3153.Metal2 0.00969475f
Cred_6501 di_tg_ctrl_n.$234.Metal1 v_b.$3821.Metal3 0.00196808f
Cred_6502 di_tg_ctrl_n.$234.Metal1 v_b.$3857.Metal3 1.62972e-05f
Cred_6503 di_tg_ctrl_n.$234.Metal1 v_b.$3890.Metal3 1.71047e-05f
Cred_6504 di_tg_ctrl_n.$234.Metal1 v_b.P45.nSD 0.00286668f
Cred_6505 di_tg_ctrl_n.$234.Metal1 v_b.P47.nSD 0.0127471f
Cred_6506 di_tg_ctrl_n.$234.Metal1 v_b.P49.nSD 6.12326e-05f
Cred_6507 di_tg_ctrl_n.$234.Metal1 v_b.P49.pSD 7.43356e-08f
Cred_6508 di_tg_ctrl_n.$234.Metal1 VSS.$17.Metal1 1.00879e-06f
Cred_6509 di_tg_ctrl_n.$234.Metal1 VSS.$239.Metal1 0.00610059f
Cred_6510 di_tg_ctrl_n.$234.Metal1 VSS.$253.Metal1 0.0248142f
Cred_6511 di_tg_ctrl_n.$234.Metal1 VSS.$261.Metal1 0.00130168f
Cred_6512 di_tg_ctrl_n.$234.Metal1 VSS.$301.Metal1 3.6035e-05f
Cred_6513 di_tg_ctrl_n.$234.Metal1 VSS.$550.Metal2 5.82791e-05f
Cred_6514 di_tg_ctrl_n.$234.Metal1 VSS.$554.Metal2 0.000173189f
Cred_6515 di_tg_ctrl_n.$234.Metal1 VSS.$562.Metal2 1.00394e-05f
Cred_6516 di_tg_ctrl_n.$234.Metal1 VSS.$606.Metal2 3.80752e-06f
Cred_6517 di_tg_ctrl_n.$234.Metal1 VSS.$760.Metal3 2.25286e-07f
Cred_6518 di_tg_ctrl_n.$234.Metal1 VSS.P0.pSD 0.00119645f
Cred_6519 di_tg_ctrl_n.$238.Metal1 VSS 0.0137974f
Cred_6520 di_tg_ctrl_n.$238.Metal1 v_b.$3153.Metal2 0.00344724f
Cred_6521 di_tg_ctrl_n.$238.Metal1 v_b.$3247.Metal2 0.00327651f
Cred_6522 di_tg_ctrl_n.$238.Metal1 v_b.$3857.Metal3 0.00525948f
Cred_6523 di_tg_ctrl_n.$238.Metal1 v_b.$3890.Metal3 0.00552246f
Cred_6524 di_tg_ctrl_n.$238.Metal1 v_b.P47.nSD 0.00414504f
Cred_6525 di_tg_ctrl_n.$238.Metal1 v_b.P49.nSD 0.0182972f
Cred_6526 di_tg_ctrl_n.$238.Metal1 v_b.P49.pSD 2.40002e-05f
Cred_6527 di_tg_ctrl_n.$238.Metal1 v_b.P51.nSD 0.00432827f
Cred_6528 di_tg_ctrl_n.$238.Metal1 VSS.$17.Metal1 8.1832e-07f
Cred_6529 di_tg_ctrl_n.$238.Metal1 VSS.$239.Metal1 0.00059516f
Cred_6530 di_tg_ctrl_n.$238.Metal1 VSS.$253.Metal1 0.0220189f
Cred_6531 di_tg_ctrl_n.$238.Metal1 VSS.$261.Metal1 0.019501f
Cred_6532 di_tg_ctrl_n.$238.Metal1 VSS.$271.Metal1 0.000331078f
Cred_6533 di_tg_ctrl_n.$238.Metal1 VSS.$301.Metal1 3.78124e-05f
Cred_6534 di_tg_ctrl_n.$238.Metal1 VSS.$550.Metal2 4.58972e-06f
Cred_6535 di_tg_ctrl_n.$238.Metal1 VSS.$554.Metal2 9.22726e-06f
Cred_6536 di_tg_ctrl_n.$238.Metal1 VSS.$562.Metal2 7.41762e-05f
Cred_6537 di_tg_ctrl_n.$238.Metal1 VSS.$570.Metal2 2.5533e-06f
Cred_6538 di_tg_ctrl_n.$238.Metal1 VSS.$606.Metal2 3.99531e-06f
Cred_6539 di_tg_ctrl_n.$238.Metal1 VSS.$760.Metal3 2.36397e-07f
Cred_6540 di_tg_ctrl_n.$238.Metal1 VSS.P0.pSD 0.00109538f
Cred_6541 di_tg_ctrl_n.$241.Metal1 VSS 0.00784611f
Cred_6542 di_tg_ctrl_n.$241.Metal1 v_b.$3247.Metal2 0.00861872f
Cred_6543 di_tg_ctrl_n.$241.Metal1 v_b.$3857.Metal3 0.000232149f
Cred_6544 di_tg_ctrl_n.$241.Metal1 v_b.$3890.Metal3 0.000243756f
Cred_6545 di_tg_ctrl_n.$241.Metal1 v_b.$3903.Metal3 0.00105459f
Cred_6546 di_tg_ctrl_n.$241.Metal1 v_b.P49.nSD 2.6055e-05f
Cred_6547 di_tg_ctrl_n.$241.Metal1 v_b.P49.pSD 1.05935e-06f
Cred_6548 di_tg_ctrl_n.$241.Metal1 v_b.P51.nSD 0.0122914f
Cred_6549 di_tg_ctrl_n.$241.Metal1 v_b.P53.nSD 0.00172559f
Cred_6550 di_tg_ctrl_n.$241.Metal1 VSS.$17.Metal1 7.66327e-07f
Cred_6551 di_tg_ctrl_n.$241.Metal1 VSS.$253.Metal1 0.00159639f
Cred_6552 di_tg_ctrl_n.$241.Metal1 VSS.$261.Metal1 0.0230669f
Cred_6553 di_tg_ctrl_n.$241.Metal1 VSS.$271.Metal1 0.00590548f
Cred_6554 di_tg_ctrl_n.$241.Metal1 VSS.$301.Metal1 4.69464e-05f
Cred_6555 di_tg_ctrl_n.$241.Metal1 VSS.$562.Metal2 1.23135e-05f
Cred_6556 di_tg_ctrl_n.$241.Metal1 VSS.$570.Metal2 4.55436e-05f
Cred_6557 di_tg_ctrl_n.$241.Metal1 VSS.$606.Metal2 4.96043e-06f
Cred_6558 di_tg_ctrl_n.$241.Metal1 VSS.$760.Metal3 2.93502e-07f
Cred_6559 di_tg_ctrl_n.$241.Metal1 VSS.P0.pSD 0.00114735f
Cred_6560 di_tg_ctrl_n.$243.Metal1 VSS 0.0116212f
Cred_6561 di_tg_ctrl_n.$243.Metal1 v_b.$3294.Metal2 5.25282e-06f
Cred_6562 di_tg_ctrl_n.$243.Metal1 v_b.$3344.Metal2 0.000458677f
Cred_6563 di_tg_ctrl_n.$243.Metal1 v_b.$3435.Metal2 4.47494e-12f
Cred_6564 di_tg_ctrl_n.$243.Metal1 v_b.$3903.Metal3 0.0118658f
Cred_6565 di_tg_ctrl_n.$243.Metal1 v_b.$3934.Metal3 3.55238e-09f
Cred_6566 di_tg_ctrl_n.$243.Metal1 v_b.P53.nSD 0.0163642f
Cred_6567 di_tg_ctrl_n.$243.Metal1 v_b.P55.nSD 0.000426336f
Cred_6568 di_tg_ctrl_n.$243.Metal1 VSS.$17.Metal1 5.01379e-07f
Cred_6569 di_tg_ctrl_n.$243.Metal1 VSS.$261.Metal1 0.0060939f
Cred_6570 di_tg_ctrl_n.$243.Metal1 VSS.$271.Metal1 0.0141293f
Cred_6571 di_tg_ctrl_n.$243.Metal1 VSS.$301.Metal1 3.88998e-05f
Cred_6572 di_tg_ctrl_n.$243.Metal1 VSS.$570.Metal2 8.39609e-05f
Cred_6573 di_tg_ctrl_n.$243.Metal1 VSS.$578.Metal2 3.26104e-05f
Cred_6574 di_tg_ctrl_n.$243.Metal1 VSS.$606.Metal2 4.11021e-06f
Cred_6575 di_tg_ctrl_n.$243.Metal1 VSS.$738.Metal3 1.2866e-07f
Cred_6576 di_tg_ctrl_n.$243.Metal1 VSS.$746.Metal3 1.2866e-07f
Cred_6577 di_tg_ctrl_n.$243.Metal1 VSS.$760.Metal3 2.43196e-07f
Cred_6578 di_tg_ctrl_n.$243.Metal1 VSS.P0.pSD 0.000842813f
Cred_6579 di_tg_ctrl_n.$245.Metal1 VSS 0.0150149f
Cred_6580 di_tg_ctrl_n.$245.Metal1 v_b.$3294.Metal2 7.97651e-06f
Cred_6581 di_tg_ctrl_n.$245.Metal1 v_b.$3344.Metal2 0.00943497f
Cred_6582 di_tg_ctrl_n.$245.Metal1 v_b.$3435.Metal2 6.79528e-12f
Cred_6583 di_tg_ctrl_n.$245.Metal1 v_b.$3903.Metal3 0.00201688f
Cred_6584 di_tg_ctrl_n.$245.Metal1 v_b.$3934.Metal3 0.000519494f
Cred_6585 di_tg_ctrl_n.$245.Metal1 v_b.P53.nSD 0.00295773f
Cred_6586 di_tg_ctrl_n.$245.Metal1 v_b.P55.nSD 0.0130588f
Cred_6587 di_tg_ctrl_n.$245.Metal1 v_b.P57.nSD 9.32585e-05f
Cred_6588 di_tg_ctrl_n.$245.Metal1 VSS.$17.Metal1 6.369e-07f
Cred_6589 di_tg_ctrl_n.$245.Metal1 VSS.$261.Metal1 0.00109124f
Cred_6590 di_tg_ctrl_n.$245.Metal1 VSS.$271.Metal1 0.021486f
Cred_6591 di_tg_ctrl_n.$245.Metal1 VSS.$279.Metal1 0.00862765f
Cred_6592 di_tg_ctrl_n.$245.Metal1 VSS.$301.Metal1 6.32523e-05f
Cred_6593 di_tg_ctrl_n.$245.Metal1 VSS.$570.Metal2 6.97451e-05f
Cred_6594 di_tg_ctrl_n.$245.Metal1 VSS.$578.Metal2 9.79568e-05f
Cred_6595 di_tg_ctrl_n.$245.Metal1 VSS.$606.Metal2 6.68334e-06f
Cred_6596 di_tg_ctrl_n.$245.Metal1 VSS.$738.Metal3 1.95373e-07f
Cred_6597 di_tg_ctrl_n.$245.Metal1 VSS.$746.Metal3 1.95373e-07f
Cred_6598 di_tg_ctrl_n.$245.Metal1 VSS.$760.Metal3 3.95444e-07f
Cred_6599 di_tg_ctrl_n.$245.Metal1 VSS.P0.pSD 0.00120352f
Cred_6600 di_tg_ctrl_n.$248.Metal1 VSS 0.00804272f
Cred_6601 di_tg_ctrl_n.$248.Metal1 v_b.$3294.Metal2 1.83798e-10f
Cred_6602 di_tg_ctrl_n.$248.Metal1 v_b.$3344.Metal2 0.00307415f
Cred_6603 di_tg_ctrl_n.$248.Metal1 v_b.$3435.Metal2 1.00308e-05f
Cred_6604 di_tg_ctrl_n.$248.Metal1 v_b.$3438.Metal2 0.00329375f
Cred_6605 di_tg_ctrl_n.$248.Metal1 v_b.$3529.Metal2 2.00494e-10f
Cred_6606 di_tg_ctrl_n.$248.Metal1 v_b.$3903.Metal3 1.56066e-07f
Cred_6607 di_tg_ctrl_n.$248.Metal1 v_b.$3934.Metal3 0.0110889f
Cred_6608 di_tg_ctrl_n.$248.Metal1 v_b.$3970.Metal3 1.6176e-07f
Cred_6609 di_tg_ctrl_n.$248.Metal1 v_b.P55.nSD 0.00413029f
Cred_6610 di_tg_ctrl_n.$248.Metal1 v_b.P57.nSD 0.0184326f
Cred_6611 di_tg_ctrl_n.$248.Metal1 v_b.P59.nSD 0.00400951f
Cred_6612 di_tg_ctrl_n.$248.Metal1 VSS.$17.Metal1 4.8903e-07f
Cred_6613 di_tg_ctrl_n.$248.Metal1 VSS.$271.Metal1 0.00729086f
Cred_6614 di_tg_ctrl_n.$248.Metal1 VSS.$279.Metal1 0.0293739f
Cred_6615 di_tg_ctrl_n.$248.Metal1 VSS.$293.Metal1 0.00328433f
Cred_6616 di_tg_ctrl_n.$248.Metal1 VSS.$301.Metal1 6.31284e-05f
Cred_6617 di_tg_ctrl_n.$248.Metal1 VSS.$570.Metal2 1.0106e-08f
Cred_6618 di_tg_ctrl_n.$248.Metal1 VSS.$578.Metal2 0.000141641f
Cred_6619 di_tg_ctrl_n.$248.Metal1 VSS.$586.Metal2 0.000126714f
Cred_6620 di_tg_ctrl_n.$248.Metal1 VSS.$590.Metal2 2.53342e-05f
Cred_6621 di_tg_ctrl_n.$248.Metal1 VSS.$606.Metal2 6.67025e-06f
Cred_6622 di_tg_ctrl_n.$248.Metal1 VSS.$738.Metal3 6.31483e-07f
Cred_6623 di_tg_ctrl_n.$248.Metal1 VSS.$746.Metal3 7.22516e-06f
Cred_6624 di_tg_ctrl_n.$248.Metal1 VSS.$752.Metal3 5.51933e-07f
Cred_6625 di_tg_ctrl_n.$248.Metal1 VSS.$760.Metal3 3.9467e-07f
Cred_6626 di_tg_ctrl_n.$248.Metal1 VSS.P0.pSD 0.00107458f
Cred_6627 di_tg_ctrl_n.$252.Metal1 VSS 0.00787632f
Cred_6628 di_tg_ctrl_n.$252.Metal1 v_b.$3435.Metal2 1.70458e-11f
Cred_6629 di_tg_ctrl_n.$252.Metal1 v_b.$3438.Metal2 0.00888955f
Cred_6630 di_tg_ctrl_n.$252.Metal1 v_b.$3529.Metal2 2.36102e-06f
Cred_6631 di_tg_ctrl_n.$252.Metal1 v_b.$3934.Metal3 5.53436e-09f
Cred_6632 di_tg_ctrl_n.$252.Metal1 v_b.$3970.Metal3 0.00110099f
Cred_6633 di_tg_ctrl_n.$252.Metal1 v_b.P59.nSD 0.0119955f
Cred_6634 di_tg_ctrl_n.$252.Metal1 v_b.P61.nSD 0.00168361f
Cred_6635 di_tg_ctrl_n.$252.Metal1 VSS.$17.Metal1 4.34522e-07f
Cred_6636 di_tg_ctrl_n.$252.Metal1 VSS.$279.Metal1 0.0173775f
Cred_6637 di_tg_ctrl_n.$252.Metal1 VSS.$293.Metal1 0.0125979f
Cred_6638 di_tg_ctrl_n.$252.Metal1 VSS.$301.Metal1 7.40842e-05f
Cred_6639 di_tg_ctrl_n.$252.Metal1 VSS.$586.Metal2 0.000120132f
Cred_6640 di_tg_ctrl_n.$252.Metal1 VSS.$590.Metal2 0.000191823f
Cred_6641 di_tg_ctrl_n.$252.Metal1 VSS.$606.Metal2 7.82785e-06f
Cred_6642 di_tg_ctrl_n.$252.Metal1 VSS.$760.Metal3 4.63163e-07f
Cred_6643 di_tg_ctrl_n.$252.Metal1 VSS.P0.pSD 0.00110373f
Cred_6644 di_tg_ctrl_n.$254.Metal1 VSS 0.0116261f
Cred_6645 di_tg_ctrl_n.$254.Metal1 v_b.$3435.Metal2 1.26751e-11f
Cred_6646 di_tg_ctrl_n.$254.Metal1 v_b.$3438.Metal2 6.5437e-06f
Cred_6647 di_tg_ctrl_n.$254.Metal1 v_b.$3529.Metal2 1.75563e-06f
Cred_6648 di_tg_ctrl_n.$254.Metal1 v_b.$3535.Metal2 0.000452501f
Cred_6649 di_tg_ctrl_n.$254.Metal1 v_b.$3934.Metal3 4.1153e-09f
Cred_6650 di_tg_ctrl_n.$254.Metal1 v_b.$3970.Metal3 0.0119517f
Cred_6651 di_tg_ctrl_n.$254.Metal1 v_b.P59.nSD 7.86906e-06f
Cred_6652 di_tg_ctrl_n.$254.Metal1 v_b.P61.nSD 0.016438f
Cred_6653 di_tg_ctrl_n.$254.Metal1 v_b.P63.nSD 0.000418449f
Cred_6654 di_tg_ctrl_n.$254.Metal1 VSS.$17.Metal1 2.97371e-07f
Cred_6655 di_tg_ctrl_n.$254.Metal1 VSS.$279.Metal1 0.0041984f
Cred_6656 di_tg_ctrl_n.$254.Metal1 VSS.$293.Metal1 0.015985f
Cred_6657 di_tg_ctrl_n.$254.Metal1 VSS.$301.Metal1 6.42668e-05f
Cred_6658 di_tg_ctrl_n.$254.Metal1 VSS.$586.Metal2 4.07329e-05f
Cred_6659 di_tg_ctrl_n.$254.Metal1 VSS.$590.Metal2 0.000130335f
Cred_6660 di_tg_ctrl_n.$254.Metal1 VSS.$606.Metal2 6.79053e-06f
Cred_6661 di_tg_ctrl_n.$254.Metal1 VSS.$760.Metal3 4.01786e-07f
Cred_6662 di_tg_ctrl_n.$254.Metal1 VSS.P0.pSD 0.000823481f
Cred_6663 di_tg_ctrl_n.$256.Metal1 VSS 0.0150595f
Cred_6664 di_tg_ctrl_n.$256.Metal1 v_b.$3535.Metal2 0.0094717f
Cred_6665 di_tg_ctrl_n.$256.Metal1 v_b.$3970.Metal3 0.00200775f
Cred_6666 di_tg_ctrl_n.$256.Metal1 v_b.$4009.Metal3 0.00060652f
Cred_6667 di_tg_ctrl_n.$256.Metal1 v_b.P61.nSD 0.00299474f
Cred_6668 di_tg_ctrl_n.$256.Metal1 v_b.P63.nSD 0.0131052f
Cred_6669 di_tg_ctrl_n.$256.Metal1 v_b.P65.nSD 0.00023195f
Cred_6670 di_tg_ctrl_n.$256.Metal1 VSS.$17.Metal1 3.96486e-07f
Cred_6671 di_tg_ctrl_n.$256.Metal1 VSS.$279.Metal1 0.000797525f
Cred_6672 di_tg_ctrl_n.$256.Metal1 VSS.$293.Metal1 0.0219267f
Cred_6673 di_tg_ctrl_n.$256.Metal1 VSS.$301.Metal1 0.0088298f
Cred_6674 di_tg_ctrl_n.$256.Metal1 VSS.$586.Metal2 6.1509e-06f
Cred_6675 di_tg_ctrl_n.$256.Metal1 VSS.$590.Metal2 1.23643e-05f
Cred_6676 di_tg_ctrl_n.$256.Metal1 VSS.$598.Metal2 4.79814e-05f
Cred_6677 di_tg_ctrl_n.$256.Metal1 VSS.$606.Metal2 1.15988e-05f
Cred_6678 di_tg_ctrl_n.$256.Metal1 VSS.$760.Metal3 6.86285e-07f
Cred_6679 di_tg_ctrl_n.$256.Metal1 VSS.P0.pSD 0.00120627f
Cred_6680 di_tg_ctrl_n.$259.Metal1 VSS 0.00892274f
Cred_6681 di_tg_ctrl_n.$259.Metal1 v_b.$3535.Metal2 0.00302676f
Cred_6682 di_tg_ctrl_n.$259.Metal1 v_b.$3565.Metal2 4.53888e-06f
Cred_6683 di_tg_ctrl_n.$259.Metal1 v_b.$3629.Metal2 0.00490827f
Cred_6684 di_tg_ctrl_n.$259.Metal1 v_b.$4009.Metal3 0.0110126f
Cred_6685 di_tg_ctrl_n.$259.Metal1 v_b.$4042.Metal3 9.51119e-09f
Cred_6686 di_tg_ctrl_n.$259.Metal1 v_b.P63.nSD 0.0040693f
Cred_6687 di_tg_ctrl_n.$259.Metal1 v_b.P65.nSD 0.0184842f
Cred_6688 di_tg_ctrl_n.$259.Metal1 v_b.P67.nSD 0.00630338f
Cred_6689 di_tg_ctrl_n.$259.Metal1 VSS.$17.Metal1 1.76376e-07f
Cred_6690 di_tg_ctrl_n.$259.Metal1 VSS.$293.Metal1 0.00722721f
Cred_6691 di_tg_ctrl_n.$259.Metal1 VSS.$301.Metal1 0.0371388f
Cred_6692 di_tg_ctrl_n.$259.Metal1 VSS.$598.Metal2 0.000141899f
Cred_6693 di_tg_ctrl_n.$259.Metal1 VSS.$606.Metal2 0.000521927f
Cred_6694 di_tg_ctrl_n.$259.Metal1 VSS.$752.Metal3 3.14621e-07f
Cred_6695 di_tg_ctrl_n.$259.Metal1 VSS.$760.Metal3 2.00021e-05f
Cred_6696 di_tg_ctrl_n.$259.Metal1 VSS.P0.pSD 0.000929453f
Cred_6697 di_tg_ctrl_n.$26.GatPoly VSS 0.00829178f
Cred_6698 di_tg_ctrl_n.$26.GatPoly v_a.$1462.Metal2 1.0231e-05f
Cred_6699 di_tg_ctrl_n.$26.GatPoly v_a.$1464.Metal2 3.2011e-06f
Cred_6700 di_tg_ctrl_n.$26.GatPoly v_a.$1466.Metal2 0.000253764f
Cred_6701 di_tg_ctrl_n.$26.GatPoly v_a.$1468.Metal2 0.0091693f
Cred_6702 di_tg_ctrl_n.$26.GatPoly v_a.$2351.Metal3 0.00240124f
Cred_6703 di_tg_ctrl_n.$26.GatPoly v_a.$366.Metal1 0.00185039f
Cred_6704 di_tg_ctrl_n.$26.GatPoly v_a.$368.Metal1 0.0201082f
Cred_6705 di_tg_ctrl_n.$26.GatPoly v_a.P10.pSD 0.00904915f
Cred_6706 di_tg_ctrl_n.$26.GatPoly v_b.$2481.Metal2 0.00507117f
Cred_6707 di_tg_ctrl_n.$26.GatPoly v_b.$2541.Metal2 0.00320345f
Cred_6708 di_tg_ctrl_n.$26.GatPoly v_b.P10.pSD 0.00654236f
Cred_6709 di_tg_ctrl_n.$26.GatPoly v_b.P11.nSD 3.54479e-05f
Cred_6710 di_tg_ctrl_n.$26.GatPoly v_b.P11.pSD 0.022745f
Cred_6711 di_tg_ctrl_n.$26.GatPoly VDD.$107.Metal1 0.00372187f
Cred_6712 di_tg_ctrl_n.$26.GatPoly VDD.$111.Metal1 0.000369895f
Cred_6713 di_tg_ctrl_n.$26.GatPoly VDD.$428.Metal2 1.22793e-06f
Cred_6714 di_tg_ctrl_n.$26.GatPoly VDD.$432.Metal2 2.81386e-06f
Cred_6715 di_tg_ctrl_n.$26.GatPoly VDD.$436.Metal2 7.30603e-06f
Cred_6716 di_tg_ctrl_n.$26.GatPoly VDD.$440.Metal2 1.04526e-05f
Cred_6717 di_tg_ctrl_n.$26.GatPoly VDD.$448.Metal2 2.75999e-07f
Cred_6718 di_tg_ctrl_n.$26.GatPoly VDD.$694.Metal3 2.2129e-09f
Cred_6719 di_tg_ctrl_n.$26.GatPoly VDD.$89.Metal1 0.000204073f
Cred_6720 di_tg_ctrl_n.$26.GatPoly VDD.$99.Metal1 0.00375392f
Cred_6721 di_tg_ctrl_n.$26.GatPoly VDD.P0.nSD 3.37945e-06f
Cred_6722 di_tg_ctrl_n.$264.Metal1 VSS 0.0404484f
Cred_6723 di_tg_ctrl_n.$264.Metal1 v_b 0.000743789f
Cred_6724 di_tg_ctrl_n.$264.Metal1 v_b.$3565.Metal2 5.98842e-10f
Cred_6725 di_tg_ctrl_n.$264.Metal1 v_b.$3629.Metal2 0.00735837f
Cred_6726 di_tg_ctrl_n.$264.Metal1 v_b.$4009.Metal3 1.63656e-06f
Cred_6727 di_tg_ctrl_n.$264.Metal1 v_b.$4042.Metal3 0.013607f
Cred_6728 di_tg_ctrl_n.$264.Metal1 v_b.$4053.Metal3 0.000274447f
Cred_6729 di_tg_ctrl_n.$264.Metal1 v_b.P65.nSD 9.035e-08f
Cred_6730 di_tg_ctrl_n.$264.Metal1 v_b.P67.nSD 0.00987819f
Cred_6731 di_tg_ctrl_n.$264.Metal1 v_b.P69.nSD 0.0193522f
Cred_6732 di_tg_ctrl_n.$264.Metal1 v_b.P71.nSD 0.000830987f
Cred_6733 di_tg_ctrl_n.$264.Metal1 VSS.$17.Metal1 5.23325e-07f
Cred_6734 di_tg_ctrl_n.$264.Metal1 VSS.$301.Metal1 0.0449765f
Cred_6735 di_tg_ctrl_n.$264.Metal1 VSS.$598.Metal2 3.75534e-08f
Cred_6736 di_tg_ctrl_n.$264.Metal1 VSS.$606.Metal2 0.00292886f
Cred_6737 di_tg_ctrl_n.$264.Metal1 VSS.$752.Metal3 2.34655e-06f
Cred_6738 di_tg_ctrl_n.$264.Metal1 VSS.$760.Metal3 0.000166518f
Cred_6739 di_tg_ctrl_n.$264.Metal1 VSS.P0.pSD 0.00551824f
Cred_6740 di_tg_ctrl_n.$270.Metal2 VSS 0.00395702f
Cred_6741 di_tg_ctrl_n.$270.Metal2 v_a.$1168.Metal2 5.79288e-05f
Cred_6742 di_tg_ctrl_n.$270.Metal2 v_a.$1170.Metal2 0.0104711f
Cred_6743 di_tg_ctrl_n.$270.Metal2 v_a.$118.Metal1 0.00239276f
Cred_6744 di_tg_ctrl_n.$270.Metal2 v_a.$1238.Metal2 4.80451e-05f
Cred_6745 di_tg_ctrl_n.$270.Metal2 v_a.$1240.Metal2 0.0212676f
Cred_6746 di_tg_ctrl_n.$270.Metal2 v_a.$2197.Metal3 0.0221782f
Cred_6747 di_tg_ctrl_n.$270.Metal2 v_a.$2227.Metal3 0.0124363f
Cred_6748 di_tg_ctrl_n.$270.Metal2 v_a.$2233.Metal3 0.0106609f
Cred_6749 di_tg_ctrl_n.$270.Metal2 v_a.$48.Metal1 0.00311038f
Cred_6750 di_tg_ctrl_n.$270.Metal2 v_a.P0.pSD 0.00714099f
Cred_6751 di_tg_ctrl_n.$270.Metal2 v_a.P2.pSD 0.0071528f
Cred_6752 di_tg_ctrl_n.$270.Metal2 v_b.$2361.Metal2 0.00860185f
Cred_6753 di_tg_ctrl_n.$270.Metal2 v_b.$2421.Metal2 8.88766e-05f
Cred_6754 di_tg_ctrl_n.$270.Metal2 v_b.P1.pSD 0.0249051f
Cred_6755 di_tg_ctrl_n.$270.Metal2 v_b.P3.nSD 9.83467e-07f
Cred_6756 di_tg_ctrl_n.$270.Metal2 v_b.P3.pSD 0.000500305f
Cred_6757 di_tg_ctrl_n.$270.Metal2 VDD.$340.Metal1 6.44858e-12f
Cred_6758 di_tg_ctrl_n.$270.Metal2 VDD.$388.Metal2 0.0260345f
Cred_6759 di_tg_ctrl_n.$270.Metal2 VDD.$392.Metal2 0.0345935f
Cred_6760 di_tg_ctrl_n.$270.Metal2 VDD.$400.Metal2 0.0193407f
Cred_6761 di_tg_ctrl_n.$270.Metal2 VDD.$404.Metal2 6.41043e-06f
Cred_6762 di_tg_ctrl_n.$270.Metal2 VDD.$42.Metal1 0.00416181f
Cred_6763 di_tg_ctrl_n.$270.Metal2 VDD.$55.Metal1 0.00705298f
Cred_6764 di_tg_ctrl_n.$270.Metal2 VDD.$59.Metal1 0.00275425f
Cred_6765 di_tg_ctrl_n.$270.Metal2 VDD.$666.Metal3 0.00771251f
Cred_6766 di_tg_ctrl_n.$270.Metal2 VDD.$67.Metal1 2.89113e-05f
Cred_6767 di_tg_ctrl_n.$270.Metal2 VDD.$670.Metal3 0.00601317f
Cred_6768 di_tg_ctrl_n.$270.Metal2 VDD.$676.Metal3 0.000792746f
Cred_6769 di_tg_ctrl_n.$270.Metal2 VDD.P0.nSD 1.72347e-05f
Cred_6770 di_tg_ctrl_n.$272.Metal2 VSS 6.77186e-05f
Cred_6771 di_tg_ctrl_n.$272.Metal2 v_a.$1168.Metal2 4.92983e-07f
Cred_6772 di_tg_ctrl_n.$272.Metal2 v_a.$1170.Metal2 0.000106429f
Cred_6773 di_tg_ctrl_n.$272.Metal2 v_a.$118.Metal1 4.14484e-06f
Cred_6774 di_tg_ctrl_n.$272.Metal2 v_a.$1238.Metal2 8.32257e-08f
Cred_6775 di_tg_ctrl_n.$272.Metal2 v_a.$1240.Metal2 4.10143e-05f
Cred_6776 di_tg_ctrl_n.$272.Metal2 v_a.$1294.Metal2 0.00680563f
Cred_6777 di_tg_ctrl_n.$272.Metal2 v_a.$180.Metal1 0.00156038f
Cred_6778 di_tg_ctrl_n.$272.Metal2 v_a.$2197.Metal3 0.000667533f
Cred_6779 di_tg_ctrl_n.$272.Metal2 v_a.$2227.Metal3 1.87972e-06f
Cred_6780 di_tg_ctrl_n.$272.Metal2 v_a.$2233.Metal3 0.00111256f
Cred_6781 di_tg_ctrl_n.$272.Metal2 v_a.$2257.Metal3 0.00377783f
Cred_6782 di_tg_ctrl_n.$272.Metal2 v_a.$2261.Metal3 0.00273741f
Cred_6783 di_tg_ctrl_n.$272.Metal2 v_a.$48.Metal1 2.64698e-05f
Cred_6784 di_tg_ctrl_n.$272.Metal2 v_a.P0.pSD 3.32016e-05f
Cred_6785 di_tg_ctrl_n.$272.Metal2 v_a.P2.pSD 2.18107e-06f
Cred_6786 di_tg_ctrl_n.$272.Metal2 v_a.P4.pSD 0.0019824f
Cred_6787 di_tg_ctrl_n.$272.Metal2 v_b.$2361.Metal2 0.00438043f
Cred_6788 di_tg_ctrl_n.$272.Metal2 v_b.$2421.Metal2 0.00431187f
Cred_6789 di_tg_ctrl_n.$272.Metal2 v_b.P1.pSD 0.000200404f
Cred_6790 di_tg_ctrl_n.$272.Metal2 v_b.P3.nSD 4.77131e-05f
Cred_6791 di_tg_ctrl_n.$272.Metal2 v_b.P3.pSD 0.0282995f
Cred_6792 di_tg_ctrl_n.$272.Metal2 VDD.$340.Metal1 1.19146e-14f
Cred_6793 di_tg_ctrl_n.$272.Metal2 VDD.$388.Metal2 2.58556e-05f
Cred_6794 di_tg_ctrl_n.$272.Metal2 VDD.$392.Metal2 1.98321e-05f
Cred_6795 di_tg_ctrl_n.$272.Metal2 VDD.$400.Metal2 0.0178479f
Cred_6796 di_tg_ctrl_n.$272.Metal2 VDD.$404.Metal2 0.0179285f
Cred_6797 di_tg_ctrl_n.$272.Metal2 VDD.$412.Metal2 0.00180729f
Cred_6798 di_tg_ctrl_n.$272.Metal2 VDD.$42.Metal1 1.593e-05f
Cred_6799 di_tg_ctrl_n.$272.Metal2 VDD.$55.Metal1 1.20764e-05f
Cred_6800 di_tg_ctrl_n.$272.Metal2 VDD.$59.Metal1 0.00172347f
Cred_6801 di_tg_ctrl_n.$272.Metal2 VDD.$666.Metal3 0.000904219f
Cred_6802 di_tg_ctrl_n.$272.Metal2 VDD.$67.Metal1 0.0034615f
Cred_6803 di_tg_ctrl_n.$272.Metal2 VDD.$670.Metal3 0.00106499f
Cred_6804 di_tg_ctrl_n.$272.Metal2 VDD.$676.Metal3 0.000267335f
Cred_6805 di_tg_ctrl_n.$272.Metal2 VDD.$71.Metal1 1.32051e-05f
Cred_6806 di_tg_ctrl_n.$272.Metal2 VDD.P0.nSD 2.98524e-06f
Cred_6807 di_tg_ctrl_n.$276.Metal2 v_a.$1294.Metal2 0.00940649f
Cred_6808 di_tg_ctrl_n.$276.Metal2 v_a.$1350.Metal2 1.40565e-08f
Cred_6809 di_tg_ctrl_n.$276.Metal2 v_a.$1352.Metal2 6.58345e-06f
Cred_6810 di_tg_ctrl_n.$276.Metal2 v_a.$180.Metal1 0.00215446f
Cred_6811 di_tg_ctrl_n.$276.Metal2 v_a.$2257.Metal3 0.00817377f
Cred_6812 di_tg_ctrl_n.$276.Metal2 v_a.$2261.Metal3 0.00404001f
Cred_6813 di_tg_ctrl_n.$276.Metal2 v_a.$2291.Metal3 8.72849e-05f
Cred_6814 di_tg_ctrl_n.$276.Metal2 v_a.$242.Metal1 1.0978e-06f
Cred_6815 di_tg_ctrl_n.$276.Metal2 v_a.P4.pSD 0.00509458f
Cred_6816 di_tg_ctrl_n.$276.Metal2 v_a.P6.pSD 5.07824e-07f
Cred_6817 di_tg_ctrl_n.$276.Metal2 v_b.$2421.Metal2 0.00293283f
Cred_6818 di_tg_ctrl_n.$276.Metal2 v_b.P5.pSD 0.0095527f
Cred_6819 di_tg_ctrl_n.$276.Metal2 VDD.$404.Metal2 0.0189438f
Cred_6820 di_tg_ctrl_n.$276.Metal2 VDD.$412.Metal2 0.0176842f
Cred_6821 di_tg_ctrl_n.$276.Metal2 VDD.$67.Metal1 0.00174354f
Cred_6822 di_tg_ctrl_n.$276.Metal2 VDD.$676.Metal3 0.000434242f
Cred_6823 di_tg_ctrl_n.$276.Metal2 VDD.$680.Metal3 0.000163635f
Cred_6824 di_tg_ctrl_n.$276.Metal2 VDD.$71.Metal1 0.00364938f
Cred_6825 di_tg_ctrl_n.$276.Metal2 VDD.$77.Metal1 0.000659662f
Cred_6826 di_tg_ctrl_n.$276.Metal2 VDD.P0.nSD 1.11709e-06f
Cred_6827 di_tg_ctrl_n.$278.Metal2 v_a.$1294.Metal2 9.76341e-06f
Cred_6828 di_tg_ctrl_n.$278.Metal2 v_a.$1350.Metal2 2.05031e-05f
Cred_6829 di_tg_ctrl_n.$278.Metal2 v_a.$1352.Metal2 0.00819446f
Cred_6830 di_tg_ctrl_n.$278.Metal2 v_a.$180.Metal1 1.90647e-06f
Cred_6831 di_tg_ctrl_n.$278.Metal2 v_a.$2261.Metal3 0.000130909f
Cred_6832 di_tg_ctrl_n.$278.Metal2 v_a.$2287.Metal3 0.00803262f
Cred_6833 di_tg_ctrl_n.$278.Metal2 v_a.$2291.Metal3 0.00344165f
Cred_6834 di_tg_ctrl_n.$278.Metal2 v_a.$242.Metal1 0.00160128f
Cred_6835 di_tg_ctrl_n.$278.Metal2 v_a.P4.pSD 6.53842e-07f
Cred_6836 di_tg_ctrl_n.$278.Metal2 v_a.P6.pSD 0.00506491f
Cred_6837 di_tg_ctrl_n.$278.Metal2 v_b.$2421.Metal2 0.00583229f
Cred_6838 di_tg_ctrl_n.$278.Metal2 v_b.P5.pSD 0.0161565f
Cred_6839 di_tg_ctrl_n.$278.Metal2 VDD.$412.Metal2 0.0249014f
Cred_6840 di_tg_ctrl_n.$278.Metal2 VDD.$420.Metal2 0.0114786f
Cred_6841 di_tg_ctrl_n.$278.Metal2 VDD.$676.Metal3 0.000269151f
Cred_6842 di_tg_ctrl_n.$278.Metal2 VDD.$680.Metal3 0.000315726f
Cred_6843 di_tg_ctrl_n.$278.Metal2 VDD.$71.Metal1 0.00115257f
Cred_6844 di_tg_ctrl_n.$278.Metal2 VDD.$77.Metal1 0.00406587f
Cred_6845 di_tg_ctrl_n.$278.Metal2 VDD.$81.Metal1 0.00139635f
Cred_6846 di_tg_ctrl_n.$278.Metal2 VDD.P0.nSD 1.93938e-06f
Cred_6847 di_tg_ctrl_n.$282.Metal2 v_a.$1350.Metal2 2.04747e-05f
Cred_6848 di_tg_ctrl_n.$282.Metal2 v_a.$1352.Metal2 0.00818117f
Cred_6849 di_tg_ctrl_n.$282.Metal2 v_a.$1408.Metal2 1.81774e-05f
Cred_6850 di_tg_ctrl_n.$282.Metal2 v_a.$1410.Metal2 0.00726408f
Cred_6851 di_tg_ctrl_n.$282.Metal2 v_a.$2287.Metal3 0.00438615f
Cred_6852 di_tg_ctrl_n.$282.Metal2 v_a.$2291.Metal3 0.00326541f
Cred_6853 di_tg_ctrl_n.$282.Metal2 v_a.$2317.Metal3 0.00381736f
Cred_6854 di_tg_ctrl_n.$282.Metal2 v_a.$2321.Metal3 0.00289938f
Cred_6855 di_tg_ctrl_n.$282.Metal2 v_a.$242.Metal1 0.00159906f
Cred_6856 di_tg_ctrl_n.$282.Metal2 v_a.$305.Metal1 0.00141964f
Cred_6857 di_tg_ctrl_n.$282.Metal2 v_a.P6.pSD 0.00302015f
Cred_6858 di_tg_ctrl_n.$282.Metal2 v_a.P8.pSD 0.00210479f
Cred_6859 di_tg_ctrl_n.$282.Metal2 v_b.$2421.Metal2 0.0043097f
Cred_6860 di_tg_ctrl_n.$282.Metal2 v_b.$2481.Metal2 0.0043097f
Cred_6861 di_tg_ctrl_n.$282.Metal2 v_b.P7.nSD 4.76891e-05f
Cred_6862 di_tg_ctrl_n.$282.Metal2 v_b.P7.pSD 0.0264586f
Cred_6863 di_tg_ctrl_n.$282.Metal2 VDD.$412.Metal2 0.00415166f
Cred_6864 di_tg_ctrl_n.$282.Metal2 VDD.$420.Metal2 0.0335314f
Cred_6865 di_tg_ctrl_n.$282.Metal2 VDD.$428.Metal2 0.0116374f
Cred_6866 di_tg_ctrl_n.$282.Metal2 VDD.$680.Metal3 0.000122034f
Cred_6867 di_tg_ctrl_n.$282.Metal2 VDD.$684.Metal3 0.000229902f
Cred_6868 di_tg_ctrl_n.$282.Metal2 VDD.$77.Metal1 0.000722393f
Cred_6869 di_tg_ctrl_n.$282.Metal2 VDD.$81.Metal1 0.00138681f
Cred_6870 di_tg_ctrl_n.$282.Metal2 VDD.$85.Metal1 0.00356942f
Cred_6871 di_tg_ctrl_n.$282.Metal2 VDD.$89.Metal1 0.0017823f
Cred_6872 di_tg_ctrl_n.$286.Metal2 v_a.$1408.Metal2 2.28803e-05f
Cred_6873 di_tg_ctrl_n.$286.Metal2 v_a.$1410.Metal2 0.00915131f
Cred_6874 di_tg_ctrl_n.$286.Metal2 v_a.$1466.Metal2 1.52278e-08f
Cred_6875 di_tg_ctrl_n.$286.Metal2 v_a.$1468.Metal2 7.13208e-06f
Cred_6876 di_tg_ctrl_n.$286.Metal2 v_a.$2317.Metal3 0.00822433f
Cred_6877 di_tg_ctrl_n.$286.Metal2 v_a.$2321.Metal3 0.00389488f
Cred_6878 di_tg_ctrl_n.$286.Metal2 v_a.$2351.Metal3 9.45588e-05f
Cred_6879 di_tg_ctrl_n.$286.Metal2 v_a.$305.Metal1 0.00178693f
Cred_6880 di_tg_ctrl_n.$286.Metal2 v_a.$368.Metal1 1.18928e-06f
Cred_6881 di_tg_ctrl_n.$286.Metal2 v_a.P10.pSD 5.50143e-07f
Cred_6882 di_tg_ctrl_n.$286.Metal2 v_a.P8.pSD 0.005192f
Cred_6883 di_tg_ctrl_n.$286.Metal2 v_b.$2481.Metal2 0.00334191f
Cred_6884 di_tg_ctrl_n.$286.Metal2 v_b.P10.pSD 0.0105384f
Cred_6885 di_tg_ctrl_n.$286.Metal2 VDD.$420.Metal2 0.00431048f
Cred_6886 di_tg_ctrl_n.$286.Metal2 VDD.$428.Metal2 0.024992f
Cred_6887 di_tg_ctrl_n.$286.Metal2 VDD.$432.Metal2 0.00743674f
Cred_6888 di_tg_ctrl_n.$286.Metal2 VDD.$436.Metal2 2.68522e-07f
Cred_6889 di_tg_ctrl_n.$286.Metal2 VDD.$440.Metal2 1.33725e-07f
Cred_6890 di_tg_ctrl_n.$286.Metal2 VDD.$684.Metal3 0.000153803f
Cred_6891 di_tg_ctrl_n.$286.Metal2 VDD.$688.Metal3 0.000379766f
Cred_6892 di_tg_ctrl_n.$286.Metal2 VDD.$694.Metal3 1.66786e-05f
Cred_6893 di_tg_ctrl_n.$286.Metal2 VDD.$85.Metal1 9.13699e-06f
Cred_6894 di_tg_ctrl_n.$286.Metal2 VDD.$89.Metal1 0.00421826f
Cred_6895 di_tg_ctrl_n.$286.Metal2 VDD.$99.Metal1 0.00199256f
Cred_6896 di_tg_ctrl_n.$286.Metal2 VDD.P0.nSD 7.5353e-06f
Cred_6897 di_tg_ctrl_n.$288.Metal2 v_a.$1408.Metal2 1.99134e-08f
Cred_6898 di_tg_ctrl_n.$288.Metal2 v_a.$1410.Metal2 9.32659e-06f
Cred_6899 di_tg_ctrl_n.$288.Metal2 v_a.$1466.Metal2 2.05062e-05f
Cred_6900 di_tg_ctrl_n.$288.Metal2 v_a.$1468.Metal2 0.00819562f
Cred_6901 di_tg_ctrl_n.$288.Metal2 v_a.$2321.Metal3 0.000123654f
Cred_6902 di_tg_ctrl_n.$288.Metal2 v_a.$2347.Metal3 0.00813553f
Cred_6903 di_tg_ctrl_n.$288.Metal2 v_a.$2351.Metal3 0.00345635f
Cred_6904 di_tg_ctrl_n.$288.Metal2 v_a.$305.Metal1 1.55522e-06f
Cred_6905 di_tg_ctrl_n.$288.Metal2 v_a.$368.Metal1 0.00160151f
Cred_6906 di_tg_ctrl_n.$288.Metal2 v_a.P10.pSD 0.00482604f
Cred_6907 di_tg_ctrl_n.$288.Metal2 v_a.P8.pSD 7.1942e-07f
Cred_6908 di_tg_ctrl_n.$288.Metal2 v_b.$2481.Metal2 0.00546487f
Cred_6909 di_tg_ctrl_n.$288.Metal2 v_b.P10.pSD 0.0152704f
Cred_6910 di_tg_ctrl_n.$288.Metal2 VDD.$107.Metal1 0.00071176f
Cred_6911 di_tg_ctrl_n.$288.Metal2 VDD.$428.Metal2 4.54759e-06f
Cred_6912 di_tg_ctrl_n.$288.Metal2 VDD.$432.Metal2 0.0170661f
Cred_6913 di_tg_ctrl_n.$288.Metal2 VDD.$436.Metal2 0.0157979f
Cred_6914 di_tg_ctrl_n.$288.Metal2 VDD.$440.Metal2 0.00364579f
Cred_6915 di_tg_ctrl_n.$288.Metal2 VDD.$684.Metal3 5.90575e-05f
Cred_6916 di_tg_ctrl_n.$288.Metal2 VDD.$688.Metal3 0.000429482f
Cred_6917 di_tg_ctrl_n.$288.Metal2 VDD.$694.Metal3 3.36755e-05f
Cred_6918 di_tg_ctrl_n.$288.Metal2 VDD.$89.Metal1 0.000677084f
Cred_6919 di_tg_ctrl_n.$288.Metal2 VDD.$99.Metal1 0.00486609f
Cred_6920 di_tg_ctrl_n.$288.Metal2 VDD.P0.nSD 4.64284e-06f
Cred_6921 di_tg_ctrl_n.$29.GatPoly VSS 0.00685292f
Cred_6922 di_tg_ctrl_n.$29.GatPoly v_a.$1520.Metal2 8.84469e-06f
Cred_6923 di_tg_ctrl_n.$29.GatPoly v_a.$1522.Metal2 2.76734e-06f
Cred_6924 di_tg_ctrl_n.$29.GatPoly v_a.$1524.Metal2 0.000222453f
Cred_6925 di_tg_ctrl_n.$29.GatPoly v_a.$1526.Metal2 0.00780033f
Cred_6926 di_tg_ctrl_n.$29.GatPoly v_a.$2381.Metal3 0.00201201f
Cred_6927 di_tg_ctrl_n.$29.GatPoly v_a.$429.Metal1 0.00159966f
Cred_6928 di_tg_ctrl_n.$29.GatPoly v_a.$431.Metal1 0.0176236f
Cred_6929 di_tg_ctrl_n.$29.GatPoly v_a.P12.pSD 0.00766134f
Cred_6930 di_tg_ctrl_n.$29.GatPoly v_b.$2481.Metal2 0.00319632f
Cred_6931 di_tg_ctrl_n.$29.GatPoly v_b.$2541.Metal2 0.00390783f
Cred_6932 di_tg_ctrl_n.$29.GatPoly v_b.P11.nSD 3.5369e-05f
Cred_6933 di_tg_ctrl_n.$29.GatPoly v_b.P11.pSD 0.0227593f
Cred_6934 di_tg_ctrl_n.$29.GatPoly v_b.P13.pSD 0.0025092f
Cred_6935 di_tg_ctrl_n.$29.GatPoly VDD.$107.Metal1 0.00138283f
Cred_6936 di_tg_ctrl_n.$29.GatPoly VDD.$111.Metal1 0.00350513f
Cred_6937 di_tg_ctrl_n.$29.GatPoly VDD.$121.Metal1 0.000397812f
Cred_6938 di_tg_ctrl_n.$29.GatPoly VDD.$436.Metal2 3.57608e-07f
Cred_6939 di_tg_ctrl_n.$29.GatPoly VDD.$440.Metal2 3.57537e-06f
Cred_6940 di_tg_ctrl_n.$29.GatPoly VDD.$448.Metal2 7.1744e-06f
Cred_6941 di_tg_ctrl_n.$29.GatPoly VDD.$452.Metal2 2.09446e-06f
Cred_6942 di_tg_ctrl_n.$29.GatPoly VDD.$694.Metal3 1.59731e-08f
Cred_6943 di_tg_ctrl_n.$29.GatPoly VDD.$99.Metal1 0.000158485f
Cred_6944 di_tg_ctrl_n.$29.GatPoly VDD.P0.nSD 2.29419e-06f
Cred_6945 di_tg_ctrl_n.$292.Metal2 v_a.$1466.Metal2 2.04754e-05f
Cred_6946 di_tg_ctrl_n.$292.Metal2 v_a.$1468.Metal2 0.00818122f
Cred_6947 di_tg_ctrl_n.$292.Metal2 v_a.$1524.Metal2 1.90967e-05f
Cred_6948 di_tg_ctrl_n.$292.Metal2 v_a.$1526.Metal2 0.00763094f
Cred_6949 di_tg_ctrl_n.$292.Metal2 v_a.$2347.Metal3 0.00419814f
Cred_6950 di_tg_ctrl_n.$292.Metal2 v_a.$2351.Metal3 0.00326543f
Cred_6951 di_tg_ctrl_n.$292.Metal2 v_a.$2377.Metal3 0.00385687f
Cred_6952 di_tg_ctrl_n.$292.Metal2 v_a.$2381.Metal3 0.0030458f
Cred_6953 di_tg_ctrl_n.$292.Metal2 v_a.$368.Metal1 0.00159911f
Cred_6954 di_tg_ctrl_n.$292.Metal2 v_a.$431.Metal1 0.00149144f
Cred_6955 di_tg_ctrl_n.$292.Metal2 v_a.P10.pSD 0.00243971f
Cred_6956 di_tg_ctrl_n.$292.Metal2 v_a.P12.pSD 0.00213877f
Cred_6957 di_tg_ctrl_n.$292.Metal2 v_b.$2481.Metal2 0.00434593f
Cred_6958 di_tg_ctrl_n.$292.Metal2 v_b.$2541.Metal2 0.00434593f
Cred_6959 di_tg_ctrl_n.$292.Metal2 v_b.P11.nSD 4.80901e-05f
Cred_6960 di_tg_ctrl_n.$292.Metal2 v_b.P11.pSD 0.026475f
Cred_6961 di_tg_ctrl_n.$292.Metal2 VDD.$107.Metal1 0.00428041f
Cred_6962 di_tg_ctrl_n.$292.Metal2 VDD.$111.Metal1 0.00173303f
Cred_6963 di_tg_ctrl_n.$292.Metal2 VDD.$436.Metal2 0.00837194f
Cred_6964 di_tg_ctrl_n.$292.Metal2 VDD.$440.Metal2 0.0294128f
Cred_6965 di_tg_ctrl_n.$292.Metal2 VDD.$448.Metal2 0.0116622f
Cred_6966 di_tg_ctrl_n.$292.Metal2 VDD.$688.Metal3 5.8772e-05f
Cred_6967 di_tg_ctrl_n.$292.Metal2 VDD.$694.Metal3 0.000259369f
Cred_6968 di_tg_ctrl_n.$292.Metal2 VDD.$99.Metal1 0.00136176f
Cred_6969 di_tg_ctrl_n.$292.Metal2 VDD.P0.nSD 1.20642e-06f
Cred_6970 di_tg_ctrl_n.$296.Metal2 v_a.$1524.Metal2 2.19321e-05f
Cred_6971 di_tg_ctrl_n.$296.Metal2 v_a.$1526.Metal2 0.0087697f
Cred_6972 di_tg_ctrl_n.$296.Metal2 v_a.$1574.Metal2 6.16027e-08f
Cred_6973 di_tg_ctrl_n.$296.Metal2 v_a.$1576.Metal2 1.35643e-05f
Cred_6974 di_tg_ctrl_n.$296.Metal2 v_a.$2377.Metal3 0.0082632f
Cred_6975 di_tg_ctrl_n.$296.Metal2 v_a.$2381.Metal3 0.00372828f
Cred_6976 di_tg_ctrl_n.$296.Metal2 v_a.$2407.Metal3 9.07425e-05f
Cred_6977 di_tg_ctrl_n.$296.Metal2 v_a.$431.Metal1 0.00171288f
Cred_6978 di_tg_ctrl_n.$296.Metal2 v_a.$489.Metal1 3.30764e-06f
Cred_6979 di_tg_ctrl_n.$296.Metal2 v_a.P12.pSD 0.00515483f
Cred_6980 di_tg_ctrl_n.$296.Metal2 v_a.P14.pSD 3.72687e-06f
Cred_6981 di_tg_ctrl_n.$296.Metal2 v_b.$2541.Metal2 0.00373193f
Cred_6982 di_tg_ctrl_n.$296.Metal2 v_b.P13.pSD 0.0114202f
Cred_6983 di_tg_ctrl_n.$296.Metal2 VDD.$107.Metal1 8.16925e-06f
Cred_6984 di_tg_ctrl_n.$296.Metal2 VDD.$111.Metal1 0.00412617f
Cred_6985 di_tg_ctrl_n.$296.Metal2 VDD.$121.Metal1 0.00202428f
Cred_6986 di_tg_ctrl_n.$296.Metal2 VDD.$440.Metal2 0.00433527f
Cred_6987 di_tg_ctrl_n.$296.Metal2 VDD.$448.Metal2 0.0250109f
Cred_6988 di_tg_ctrl_n.$296.Metal2 VDD.$452.Metal2 0.00743653f
Cred_6989 di_tg_ctrl_n.$296.Metal2 VDD.$456.Metal2 2.68522e-07f
Cred_6990 di_tg_ctrl_n.$296.Metal2 VDD.$460.Metal2 1.33725e-07f
Cred_6991 di_tg_ctrl_n.$296.Metal2 VDD.$694.Metal3 0.000160372f
Cred_6992 di_tg_ctrl_n.$296.Metal2 VDD.$698.Metal3 0.000386135f
Cred_6993 di_tg_ctrl_n.$296.Metal2 VDD.$704.Metal3 1.66786e-05f
Cred_6994 di_tg_ctrl_n.$296.Metal2 VDD.P0.nSD 7.51774e-06f
Cred_6995 di_tg_ctrl_n.$298.Metal2 v_a.$1524.Metal2 1.8742e-08f
Cred_6996 di_tg_ctrl_n.$298.Metal2 v_a.$1526.Metal2 8.77796e-06f
Cred_6997 di_tg_ctrl_n.$298.Metal2 v_a.$1574.Metal2 2.95732e-05f
Cred_6998 di_tg_ctrl_n.$298.Metal2 v_a.$1576.Metal2 0.00526218f
Cred_6999 di_tg_ctrl_n.$298.Metal2 v_a.$2381.Metal3 0.00011638f
Cred_7000 di_tg_ctrl_n.$298.Metal2 v_a.$2407.Metal3 0.0134972f
Cred_7001 di_tg_ctrl_n.$298.Metal2 v_a.$431.Metal1 1.46373e-06f
Cred_7002 di_tg_ctrl_n.$298.Metal2 v_a.$489.Metal1 0.00158788f
Cred_7003 di_tg_ctrl_n.$298.Metal2 v_a.P12.pSD 6.77101e-07f
Cred_7004 di_tg_ctrl_n.$298.Metal2 v_a.P14.pSD 0.00616493f
Cred_7005 di_tg_ctrl_n.$298.Metal2 v_b.$2541.Metal2 0.00520302f
Cred_7006 di_tg_ctrl_n.$298.Metal2 v_b.P13.pSD 0.014678f
Cred_7007 di_tg_ctrl_n.$298.Metal2 VDD.$111.Metal1 0.000639334f
Cred_7008 di_tg_ctrl_n.$298.Metal2 VDD.$121.Metal1 0.0048832f
Cred_7009 di_tg_ctrl_n.$298.Metal2 VDD.$129.Metal1 0.000737752f
Cred_7010 di_tg_ctrl_n.$298.Metal2 VDD.$448.Metal2 4.46595e-06f
Cred_7011 di_tg_ctrl_n.$298.Metal2 VDD.$452.Metal2 0.0170655f
Cred_7012 di_tg_ctrl_n.$298.Metal2 VDD.$456.Metal2 0.0157981f
Cred_7013 di_tg_ctrl_n.$298.Metal2 VDD.$460.Metal2 0.00364573f
Cred_7014 di_tg_ctrl_n.$298.Metal2 VDD.$694.Metal3 6.22123e-05f
Cred_7015 di_tg_ctrl_n.$298.Metal2 VDD.$698.Metal3 0.000432637f
Cred_7016 di_tg_ctrl_n.$298.Metal2 VDD.$704.Metal3 3.36755e-05f
Cred_7017 di_tg_ctrl_n.$298.Metal2 VDD.P0.nSD 4.50522e-06f
Cred_7018 di_tg_ctrl_n.$302.Metal2 v_a.$1574.Metal2 2.94488e-05f
Cred_7019 di_tg_ctrl_n.$302.Metal2 v_a.$1576.Metal2 0.00523479f
Cred_7020 di_tg_ctrl_n.$302.Metal2 v_a.$2387.Metal3 0.00406428f
Cred_7021 di_tg_ctrl_n.$302.Metal2 v_a.$2407.Metal3 0.00907302f
Cred_7022 di_tg_ctrl_n.$302.Metal2 v_a.$2447.Metal3 0.00406428f
Cred_7023 di_tg_ctrl_n.$302.Metal2 v_a.$489.Metal1 0.0015812f
Cred_7024 di_tg_ctrl_n.$302.Metal2 v_a.P14.pSD 0.00343079f
Cred_7025 di_tg_ctrl_n.$302.Metal2 v_a.P16.nSD 3.66545e-05f
Cred_7026 di_tg_ctrl_n.$302.Metal2 v_a.P16.pSD 0.0094881f
Cred_7027 di_tg_ctrl_n.$302.Metal2 v_b.$2541.Metal2 0.00443208f
Cred_7028 di_tg_ctrl_n.$302.Metal2 v_b.$2601.Metal2 0.00443208f
Cred_7029 di_tg_ctrl_n.$302.Metal2 v_b.P15.nSD 4.90433e-05f
Cred_7030 di_tg_ctrl_n.$302.Metal2 v_b.P15.pSD 0.0269893f
Cred_7031 di_tg_ctrl_n.$302.Metal2 VDD.$121.Metal1 0.0013377f
Cred_7032 di_tg_ctrl_n.$302.Metal2 VDD.$129.Metal1 0.00510545f
Cred_7033 di_tg_ctrl_n.$302.Metal2 VDD.$134.Metal1 0.000828964f
Cred_7034 di_tg_ctrl_n.$302.Metal2 VDD.$456.Metal2 0.00837216f
Cred_7035 di_tg_ctrl_n.$302.Metal2 VDD.$460.Metal2 0.0214001f
Cred_7036 di_tg_ctrl_n.$302.Metal2 VDD.$464.Metal2 0.0180273f
Cred_7037 di_tg_ctrl_n.$302.Metal2 VDD.$472.Metal2 0.0018073f
Cred_7038 di_tg_ctrl_n.$302.Metal2 VDD.$698.Metal3 5.8772e-05f
Cred_7039 di_tg_ctrl_n.$302.Metal2 VDD.$704.Metal3 0.000202294f
Cred_7040 di_tg_ctrl_n.$302.Metal2 VDD.$708.Metal3 7.21634e-06f
Cred_7041 di_tg_ctrl_n.$302.Metal2 VDD.P0.nSD 2.62878e-06f
Cred_7042 di_tg_ctrl_n.$306.Metal2 VSS 1.37738e-06f
Cred_7043 di_tg_ctrl_n.$306.Metal2 v_a.$1574.Metal2 6.8578e-11f
Cred_7044 di_tg_ctrl_n.$306.Metal2 v_a.$1576.Metal2 1.51003e-08f
Cred_7045 di_tg_ctrl_n.$306.Metal2 v_a.$1682.Metal2 0.000218313f
Cred_7046 di_tg_ctrl_n.$306.Metal2 v_a.$2387.Metal3 0.0055934f
Cred_7047 di_tg_ctrl_n.$306.Metal2 v_a.$2407.Metal3 1.01017e-07f
Cred_7048 di_tg_ctrl_n.$306.Metal2 v_a.$2447.Metal3 0.0055934f
Cred_7049 di_tg_ctrl_n.$306.Metal2 v_a.$2462.Metal3 0.00174546f
Cred_7050 di_tg_ctrl_n.$306.Metal2 v_a.$489.Metal1 3.68217e-09f
Cred_7051 di_tg_ctrl_n.$306.Metal2 v_a.$611.Metal1 7.87376e-05f
Cred_7052 di_tg_ctrl_n.$306.Metal2 v_a.P14.pSD 4.14886e-09f
Cred_7053 di_tg_ctrl_n.$306.Metal2 v_a.P16.nSD 5.04452e-05f
Cred_7054 di_tg_ctrl_n.$306.Metal2 v_a.P16.pSD 0.0139127f
Cred_7055 di_tg_ctrl_n.$306.Metal2 v_a.P18.pSD 0.00153482f
Cred_7056 di_tg_ctrl_n.$306.Metal2 v_b.$2601.Metal2 0.00660479f
Cred_7057 di_tg_ctrl_n.$306.Metal2 v_b.P17.pSD 0.019313f
Cred_7058 di_tg_ctrl_n.$306.Metal2 VDD.$129.Metal1 0.000813623f
Cred_7059 di_tg_ctrl_n.$306.Metal2 VDD.$134.Metal1 0.00494179f
Cred_7060 di_tg_ctrl_n.$306.Metal2 VDD.$143.Metal1 0.00248661f
Cred_7061 di_tg_ctrl_n.$306.Metal2 VDD.$464.Metal2 0.0190393f
Cred_7062 di_tg_ctrl_n.$306.Metal2 VDD.$472.Metal2 0.0260475f
Cred_7063 di_tg_ctrl_n.$306.Metal2 VDD.$476.Metal2 0.00364345f
Cred_7064 di_tg_ctrl_n.$306.Metal2 VDD.$704.Metal3 0.000136378f
Cred_7065 di_tg_ctrl_n.$306.Metal2 VDD.$708.Metal3 0.000212559f
Cred_7066 di_tg_ctrl_n.$306.Metal2 VDD.P0.nSD 3.6178e-06f
Cred_7067 di_tg_ctrl_n.$310.Metal2 VSS 1.75426e-06f
Cred_7068 di_tg_ctrl_n.$310.Metal2 v_a.$1682.Metal2 0.00729004f
Cred_7069 di_tg_ctrl_n.$310.Metal2 v_a.$1756.Metal2 8.22714e-12f
Cred_7070 di_tg_ctrl_n.$310.Metal2 v_a.$1758.Metal2 3.85325e-09f
Cred_7071 di_tg_ctrl_n.$310.Metal2 v_a.$2462.Metal3 0.0176076f
Cred_7072 di_tg_ctrl_n.$310.Metal2 v_a.$2501.Metal3 5.10872e-08f
Cred_7073 di_tg_ctrl_n.$310.Metal2 v_a.$611.Metal1 0.00377685f
Cred_7074 di_tg_ctrl_n.$310.Metal2 v_a.$683.Metal1 6.42533e-10f
Cred_7075 di_tg_ctrl_n.$310.Metal2 v_a.P18.pSD 0.0113256f
Cred_7076 di_tg_ctrl_n.$310.Metal2 v_a.P20.pSD 2.97226e-10f
Cred_7077 di_tg_ctrl_n.$310.Metal2 v_b.$2601.Metal2 0.00199548f
Cred_7078 di_tg_ctrl_n.$310.Metal2 v_b.$2631.Metal2 0.00439974f
Cred_7079 di_tg_ctrl_n.$310.Metal2 v_b.P17.pSD 0.00592986f
Cred_7080 di_tg_ctrl_n.$310.Metal2 v_b.P19.pSD 0.0127968f
Cred_7081 di_tg_ctrl_n.$310.Metal2 VDD.$134.Metal1 0.000448648f
Cred_7082 di_tg_ctrl_n.$310.Metal2 VDD.$143.Metal1 0.00429705f
Cred_7083 di_tg_ctrl_n.$310.Metal2 VDD.$151.Metal1 0.00330365f
Cred_7084 di_tg_ctrl_n.$310.Metal2 VDD.$472.Metal2 0.00837199f
Cred_7085 di_tg_ctrl_n.$310.Metal2 VDD.$476.Metal2 0.0207074f
Cred_7086 di_tg_ctrl_n.$310.Metal2 VDD.$480.Metal2 0.0161445f
Cred_7087 di_tg_ctrl_n.$310.Metal2 VDD.$484.Metal2 0.00364355f
Cred_7088 di_tg_ctrl_n.$310.Metal2 VDD.$708.Metal3 0.000146527f
Cred_7089 di_tg_ctrl_n.$310.Metal2 VDD.$714.Metal3 0.000111132f
Cred_7090 di_tg_ctrl_n.$310.Metal2 VDD.P0.nSD 3.40907e-06f
Cred_7091 di_tg_ctrl_n.$314.Metal2 v_a.$1756.Metal2 4.17295e-05f
Cred_7092 di_tg_ctrl_n.$314.Metal2 v_a.$1758.Metal2 0.0166741f
Cred_7093 di_tg_ctrl_n.$314.Metal2 v_a.$2497.Metal3 0.00454902f
Cred_7094 di_tg_ctrl_n.$314.Metal2 v_a.$2501.Metal3 0.00665528f
Cred_7095 di_tg_ctrl_n.$314.Metal2 v_a.$683.Metal1 0.00325904f
Cred_7096 di_tg_ctrl_n.$314.Metal2 v_a.P20.pSD 0.00463256f
Cred_7097 di_tg_ctrl_n.$314.Metal2 v_b.$2631.Metal2 0.00439961f
Cred_7098 di_tg_ctrl_n.$314.Metal2 v_b.P19.pSD 0.0127965f
Cred_7099 di_tg_ctrl_n.$314.Metal2 VDD.$151.Metal1 0.00421299f
Cred_7100 di_tg_ctrl_n.$314.Metal2 VDD.$161.Metal1 0.00173997f
Cred_7101 di_tg_ctrl_n.$314.Metal2 VDD.$480.Metal2 0.00871396f
Cred_7102 di_tg_ctrl_n.$314.Metal2 VDD.$484.Metal2 0.0206545f
Cred_7103 di_tg_ctrl_n.$314.Metal2 VDD.$488.Metal2 0.00743667f
Cred_7104 di_tg_ctrl_n.$314.Metal2 VDD.P0.nSD 7.1337e-06f
Cred_7105 di_tg_ctrl_n.$316.Metal2 VSS 2.24447e-06f
Cred_7106 di_tg_ctrl_n.$316.Metal2 v_a.$1756.Metal2 2.47591e-08f
Cred_7107 di_tg_ctrl_n.$316.Metal2 v_a.$1758.Metal2 1.15961e-05f
Cred_7108 di_tg_ctrl_n.$316.Metal2 v_a.$1814.Metal2 1.37263e-06f
Cred_7109 di_tg_ctrl_n.$316.Metal2 v_a.$1816.Metal2 0.00055003f
Cred_7110 di_tg_ctrl_n.$316.Metal2 v_a.$2497.Metal3 0.00425517f
Cred_7111 di_tg_ctrl_n.$316.Metal2 v_a.$2501.Metal3 0.000153744f
Cred_7112 di_tg_ctrl_n.$316.Metal2 v_a.$2527.Metal3 0.00215643f
Cred_7113 di_tg_ctrl_n.$316.Metal2 v_a.$2531.Metal3 0.000219561f
Cred_7114 di_tg_ctrl_n.$316.Metal2 v_a.$683.Metal1 1.93366e-06f
Cred_7115 di_tg_ctrl_n.$316.Metal2 v_a.$746.Metal1 0.000107201f
Cred_7116 di_tg_ctrl_n.$316.Metal2 v_a.P20.pSD 0.00273769f
Cred_7117 di_tg_ctrl_n.$316.Metal2 v_a.P22.pSD 0.00147342f
Cred_7118 di_tg_ctrl_n.$316.Metal2 v_b.$2631.Metal2 0.00345452f
Cred_7119 di_tg_ctrl_n.$316.Metal2 v_b.$2691.Metal2 0.00345452f
Cred_7120 di_tg_ctrl_n.$316.Metal2 v_b.P21.nSD 3.82261e-05f
Cred_7121 di_tg_ctrl_n.$316.Metal2 v_b.P21.pSD 0.0203103f
Cred_7122 di_tg_ctrl_n.$316.Metal2 VDD.$151.Metal1 0.000866191f
Cred_7123 di_tg_ctrl_n.$316.Metal2 VDD.$161.Metal1 0.00449705f
Cred_7124 di_tg_ctrl_n.$316.Metal2 VDD.$165.Metal1 0.00123313f
Cred_7125 di_tg_ctrl_n.$316.Metal2 VDD.$484.Metal2 4.56046e-06f
Cred_7126 di_tg_ctrl_n.$316.Metal2 VDD.$488.Metal2 0.0248506f
Cred_7127 di_tg_ctrl_n.$316.Metal2 VDD.$496.Metal2 0.0114785f
Cred_7128 di_tg_ctrl_n.$316.Metal2 VDD.$714.Metal3 9.69124e-05f
Cred_7129 di_tg_ctrl_n.$316.Metal2 VDD.$718.Metal3 0.000236644f
Cred_7130 di_tg_ctrl_n.$316.Metal2 VDD.$722.Metal3 7.30606e-08f
Cred_7131 di_tg_ctrl_n.$316.Metal2 VDD.P0.nSD 4.41051e-06f
Cred_7132 di_tg_ctrl_n.$32.GatPoly VSS 0.00995367f
Cred_7133 di_tg_ctrl_n.$32.GatPoly v_a.$1520.Metal2 6.59459e-06f
Cred_7134 di_tg_ctrl_n.$32.GatPoly v_a.$1522.Metal2 2.06333e-06f
Cred_7135 di_tg_ctrl_n.$32.GatPoly v_a.$1524.Metal2 0.000158243f
Cred_7136 di_tg_ctrl_n.$32.GatPoly v_a.$1526.Metal2 0.00574569f
Cred_7137 di_tg_ctrl_n.$32.GatPoly v_a.$1574.Metal2 5.92517e-05f
Cred_7138 di_tg_ctrl_n.$32.GatPoly v_a.$1576.Metal2 0.0026008f
Cred_7139 di_tg_ctrl_n.$32.GatPoly v_a.$2377.Metal3 8.44659e-06f
Cred_7140 di_tg_ctrl_n.$32.GatPoly v_a.$2381.Metal3 0.00150902f
Cred_7141 di_tg_ctrl_n.$32.GatPoly v_a.$2407.Metal3 0.00162205f
Cred_7142 di_tg_ctrl_n.$32.GatPoly v_a.$429.Metal1 0.00119271f
Cred_7143 di_tg_ctrl_n.$32.GatPoly v_a.$431.Metal1 0.0125452f
Cred_7144 di_tg_ctrl_n.$32.GatPoly v_a.$489.Metal1 0.00318141f
Cred_7145 di_tg_ctrl_n.$32.GatPoly v_a.P12.pSD 0.00568302f
Cred_7146 di_tg_ctrl_n.$32.GatPoly v_a.P14.pSD 0.00397787f
Cred_7147 di_tg_ctrl_n.$32.GatPoly v_b.$2541.Metal2 0.00803657f
Cred_7148 di_tg_ctrl_n.$32.GatPoly v_b.P13.pSD 0.027954f
Cred_7149 di_tg_ctrl_n.$32.GatPoly VDD.$107.Metal1 0.000143354f
Cred_7150 di_tg_ctrl_n.$32.GatPoly VDD.$111.Metal1 0.00389357f
Cred_7151 di_tg_ctrl_n.$32.GatPoly VDD.$121.Metal1 0.00435816f
Cred_7152 di_tg_ctrl_n.$32.GatPoly VDD.$129.Metal1 0.000160083f
Cred_7153 di_tg_ctrl_n.$32.GatPoly VDD.$440.Metal2 3.47635e-07f
Cred_7154 di_tg_ctrl_n.$32.GatPoly VDD.$448.Metal2 2.16167e-05f
Cred_7155 di_tg_ctrl_n.$32.GatPoly VDD.$452.Metal2 1.93704e-05f
Cred_7156 di_tg_ctrl_n.$32.GatPoly VDD.$456.Metal2 1.65988e-06f
Cred_7157 di_tg_ctrl_n.$32.GatPoly VDD.$460.Metal2 4.21415e-07f
Cred_7158 di_tg_ctrl_n.$32.GatPoly VDD.$694.Metal3 2.78726e-09f
Cred_7159 di_tg_ctrl_n.$32.GatPoly VDD.P0.nSD 1.11157e-05f
Cred_7160 di_tg_ctrl_n.$320.Metal2 VSS 8.30996e-07f
Cred_7161 di_tg_ctrl_n.$320.Metal2 v_a.$1814.Metal2 4.03785e-05f
Cred_7162 di_tg_ctrl_n.$320.Metal2 v_a.$1816.Metal2 0.0161424f
Cred_7163 di_tg_ctrl_n.$320.Metal2 v_a.$2527.Metal3 0.00655511f
Cred_7164 di_tg_ctrl_n.$320.Metal2 v_a.$2531.Metal3 0.00695487f
Cred_7165 di_tg_ctrl_n.$320.Metal2 v_a.$746.Metal1 0.00315353f
Cred_7166 di_tg_ctrl_n.$320.Metal2 v_a.P22.pSD 0.00583552f
Cred_7167 di_tg_ctrl_n.$320.Metal2 v_b.$2631.Metal2 0.000888863f
Cred_7168 di_tg_ctrl_n.$320.Metal2 v_b.$2691.Metal2 0.00091348f
Cred_7169 di_tg_ctrl_n.$320.Metal2 v_b.P21.nSD 9.83574e-06f
Cred_7170 di_tg_ctrl_n.$320.Metal2 v_b.P21.pSD 0.00551827f
Cred_7171 di_tg_ctrl_n.$320.Metal2 v_b.P23.pSD 7.08472e-05f
Cred_7172 di_tg_ctrl_n.$320.Metal2 VDD.$161.Metal1 0.0008753f
Cred_7173 di_tg_ctrl_n.$320.Metal2 VDD.$165.Metal1 0.00224511f
Cred_7174 di_tg_ctrl_n.$320.Metal2 VDD.$169.Metal1 0.00325694f
Cred_7175 di_tg_ctrl_n.$320.Metal2 VDD.$173.Metal1 2.68652e-05f
Cred_7176 di_tg_ctrl_n.$320.Metal2 VDD.$488.Metal2 0.00415161f
Cred_7177 di_tg_ctrl_n.$320.Metal2 VDD.$496.Metal2 0.0285382f
Cred_7178 di_tg_ctrl_n.$320.Metal2 VDD.$504.Metal2 0.00368362f
Cred_7179 di_tg_ctrl_n.$320.Metal2 VDD.$718.Metal3 0.000153292f
Cred_7180 di_tg_ctrl_n.$320.Metal2 VDD.$722.Metal3 0.000392563f
Cred_7181 di_tg_ctrl_n.$320.Metal2 VDD.$726.Metal3 2.46301e-05f
Cred_7182 di_tg_ctrl_n.$322.Metal2 VSS 1.69372e-06f
Cred_7183 di_tg_ctrl_n.$322.Metal2 v_a.$1814.Metal2 4.16995e-08f
Cred_7184 di_tg_ctrl_n.$322.Metal2 v_a.$1816.Metal2 1.95303e-05f
Cred_7185 di_tg_ctrl_n.$322.Metal2 v_a.$1872.Metal2 2.04754e-05f
Cred_7186 di_tg_ctrl_n.$322.Metal2 v_a.$1874.Metal2 0.00818122f
Cred_7187 di_tg_ctrl_n.$322.Metal2 v_a.$2531.Metal3 0.000258937f
Cred_7188 di_tg_ctrl_n.$322.Metal2 v_a.$2557.Metal3 0.00419814f
Cred_7189 di_tg_ctrl_n.$322.Metal2 v_a.$2561.Metal3 0.00326543f
Cred_7190 di_tg_ctrl_n.$322.Metal2 v_a.$746.Metal1 3.2567e-06f
Cred_7191 di_tg_ctrl_n.$322.Metal2 v_a.$809.Metal1 0.00159911f
Cred_7192 di_tg_ctrl_n.$322.Metal2 v_a.P22.pSD 1.5065e-06f
Cred_7193 di_tg_ctrl_n.$322.Metal2 v_a.P24.pSD 0.00243971f
Cred_7194 di_tg_ctrl_n.$322.Metal2 v_b.$2691.Metal2 0.00884016f
Cred_7195 di_tg_ctrl_n.$322.Metal2 v_b.P23.pSD 0.025825f
Cred_7196 di_tg_ctrl_n.$322.Metal2 VDD.$169.Metal1 3.19976e-05f
Cred_7197 di_tg_ctrl_n.$322.Metal2 VDD.$173.Metal1 0.00436846f
Cred_7198 di_tg_ctrl_n.$322.Metal2 VDD.$179.Metal1 0.00132542f
Cred_7199 di_tg_ctrl_n.$322.Metal2 VDD.$183.Metal1 8.52067e-07f
Cred_7200 di_tg_ctrl_n.$322.Metal2 VDD.$496.Metal2 0.00881282f
Cred_7201 di_tg_ctrl_n.$322.Metal2 VDD.$504.Metal2 0.0263901f
Cred_7202 di_tg_ctrl_n.$322.Metal2 VDD.$512.Metal2 0.00180727f
Cred_7203 di_tg_ctrl_n.$322.Metal2 VDD.$718.Metal3 5.88889e-05f
Cred_7204 di_tg_ctrl_n.$322.Metal2 VDD.$722.Metal3 0.000469278f
Cred_7205 di_tg_ctrl_n.$322.Metal2 VDD.$726.Metal3 6.46909e-05f
Cred_7206 di_tg_ctrl_n.$322.Metal2 VDD.P0.nSD 1.2893e-06f
Cred_7207 di_tg_ctrl_n.$326.Metal2 v_a.$1872.Metal2 2.05062e-05f
Cred_7208 di_tg_ctrl_n.$326.Metal2 v_a.$1874.Metal2 0.00819562f
Cred_7209 di_tg_ctrl_n.$326.Metal2 v_a.$1930.Metal2 1.99134e-08f
Cred_7210 di_tg_ctrl_n.$326.Metal2 v_a.$1932.Metal2 9.32659e-06f
Cred_7211 di_tg_ctrl_n.$326.Metal2 v_a.$2557.Metal3 0.00814817f
Cred_7212 di_tg_ctrl_n.$326.Metal2 v_a.$2561.Metal3 0.00345635f
Cred_7213 di_tg_ctrl_n.$326.Metal2 v_a.$2591.Metal3 0.000123654f
Cred_7214 di_tg_ctrl_n.$326.Metal2 v_a.$809.Metal1 0.00160151f
Cred_7215 di_tg_ctrl_n.$326.Metal2 v_a.$872.Metal1 1.55522e-06f
Cred_7216 di_tg_ctrl_n.$326.Metal2 v_a.P24.pSD 0.0048352f
Cred_7217 di_tg_ctrl_n.$326.Metal2 v_a.P26.pSD 7.1942e-07f
Cred_7218 di_tg_ctrl_n.$326.Metal2 v_b.$2691.Metal2 0.00270214f
Cred_7219 di_tg_ctrl_n.$326.Metal2 v_b.$2751.Metal2 0.00270214f
Cred_7220 di_tg_ctrl_n.$326.Metal2 v_b.P25.nSD 2.99007e-05f
Cred_7221 di_tg_ctrl_n.$326.Metal2 v_b.P25.pSD 0.0154355f
Cred_7222 di_tg_ctrl_n.$326.Metal2 VDD.$173.Metal1 0.000761249f
Cred_7223 di_tg_ctrl_n.$326.Metal2 VDD.$179.Metal1 0.00390118f
Cred_7224 di_tg_ctrl_n.$326.Metal2 VDD.$183.Metal1 0.00197107f
Cred_7225 di_tg_ctrl_n.$326.Metal2 VDD.$504.Metal2 0.0185828f
Cred_7226 di_tg_ctrl_n.$326.Metal2 VDD.$512.Metal2 0.0176654f
Cred_7227 di_tg_ctrl_n.$326.Metal2 VDD.$726.Metal3 0.000455683f
Cred_7228 di_tg_ctrl_n.$326.Metal2 VDD.$730.Metal3 0.000165332f
Cred_7229 di_tg_ctrl_n.$326.Metal2 VDD.P0.nSD 1.2893e-06f
Cred_7230 di_tg_ctrl_n.$328.Metal2 v_a.$1872.Metal2 1.52278e-08f
Cred_7231 di_tg_ctrl_n.$328.Metal2 v_a.$1874.Metal2 7.13208e-06f
Cred_7232 di_tg_ctrl_n.$328.Metal2 v_a.$1930.Metal2 2.28803e-05f
Cred_7233 di_tg_ctrl_n.$328.Metal2 v_a.$1932.Metal2 0.00915131f
Cred_7234 di_tg_ctrl_n.$328.Metal2 v_a.$2561.Metal3 9.45588e-05f
Cred_7235 di_tg_ctrl_n.$328.Metal2 v_a.$2587.Metal3 0.00993413f
Cred_7236 di_tg_ctrl_n.$328.Metal2 v_a.$2591.Metal3 0.00389488f
Cred_7237 di_tg_ctrl_n.$328.Metal2 v_a.$809.Metal1 1.18928e-06f
Cred_7238 di_tg_ctrl_n.$328.Metal2 v_a.$872.Metal1 0.00178693f
Cred_7239 di_tg_ctrl_n.$328.Metal2 v_a.P24.pSD 5.50143e-07f
Cred_7240 di_tg_ctrl_n.$328.Metal2 v_a.P26.pSD 0.00517985f
Cred_7241 di_tg_ctrl_n.$328.Metal2 v_b.$2691.Metal2 0.00163526f
Cred_7242 di_tg_ctrl_n.$328.Metal2 v_b.$2751.Metal2 0.00163526f
Cred_7243 di_tg_ctrl_n.$328.Metal2 v_b.P25.nSD 1.8095e-05f
Cred_7244 di_tg_ctrl_n.$328.Metal2 v_b.P25.pSD 0.010463f
Cred_7245 di_tg_ctrl_n.$328.Metal2 VDD 0.00267175f
Cred_7246 di_tg_ctrl_n.$328.Metal2 VDD.$183.Metal1 0.00157932f
Cred_7247 di_tg_ctrl_n.$328.Metal2 VDD.$189.Metal1 0.0017435f
Cred_7248 di_tg_ctrl_n.$328.Metal2 VDD.$512.Metal2 0.0250811f
Cred_7249 di_tg_ctrl_n.$328.Metal2 VDD.$520.Metal2 0.0116647f
Cred_7250 di_tg_ctrl_n.$328.Metal2 VDD.$726.Metal3 0.000282417f
Cred_7251 di_tg_ctrl_n.$328.Metal2 VDD.$730.Metal3 0.000320645f
Cred_7252 di_tg_ctrl_n.$332.Metal2 v_a.$1930.Metal2 1.81774e-05f
Cred_7253 di_tg_ctrl_n.$332.Metal2 v_a.$1932.Metal2 0.00726408f
Cred_7254 di_tg_ctrl_n.$332.Metal2 v_a.$1990.Metal2 0.00807259f
Cred_7255 di_tg_ctrl_n.$332.Metal2 v_a.$2587.Metal3 0.00215881f
Cred_7256 di_tg_ctrl_n.$332.Metal2 v_a.$2591.Metal3 0.00289938f
Cred_7257 di_tg_ctrl_n.$332.Metal2 v_a.$2617.Metal3 0.00438615f
Cred_7258 di_tg_ctrl_n.$332.Metal2 v_a.$2621.Metal3 0.00324699f
Cred_7259 di_tg_ctrl_n.$332.Metal2 v_a.$872.Metal1 0.00141964f
Cred_7260 di_tg_ctrl_n.$332.Metal2 v_a.$936.Metal1 0.00185131f
Cred_7261 di_tg_ctrl_n.$332.Metal2 v_a.P26.pSD 0.00210479f
Cred_7262 di_tg_ctrl_n.$332.Metal2 v_a.P28.pSD 0.00291537f
Cred_7263 di_tg_ctrl_n.$332.Metal2 v_b.$2751.Metal2 0.00875394f
Cred_7264 di_tg_ctrl_n.$332.Metal2 v_b.P27.pSD 0.0252803f
Cred_7265 di_tg_ctrl_n.$332.Metal2 VDD 1.68363e-05f
Cred_7266 di_tg_ctrl_n.$332.Metal2 VDD.$189.Metal1 0.00172831f
Cred_7267 di_tg_ctrl_n.$332.Metal2 VDD.$193.Metal1 0.00355699f
Cred_7268 di_tg_ctrl_n.$332.Metal2 VDD.$197.Metal1 0.00178403f
Cred_7269 di_tg_ctrl_n.$332.Metal2 VDD.$203.Metal1 0.000348568f
Cred_7270 di_tg_ctrl_n.$332.Metal2 VDD.$512.Metal2 0.00433769f
Cred_7271 di_tg_ctrl_n.$332.Metal2 VDD.$520.Metal2 0.0335742f
Cred_7272 di_tg_ctrl_n.$332.Metal2 VDD.$528.Metal2 0.0114656f
Cred_7273 di_tg_ctrl_n.$332.Metal2 VDD.$730.Metal3 0.000126112f
Cred_7274 di_tg_ctrl_n.$332.Metal2 VDD.$734.Metal3 0.000231096f
Cred_7275 di_tg_ctrl_n.$332.Metal2 VDD.P0.nSD 5.90357e-07f
Cred_7276 di_tg_ctrl_n.$336.Metal2 v_a.$1990.Metal2 0.00808573f
Cred_7277 di_tg_ctrl_n.$336.Metal2 v_a.$2046.Metal2 2.10848e-08f
Cred_7278 di_tg_ctrl_n.$336.Metal2 v_a.$2048.Metal2 9.87522e-06f
Cred_7279 di_tg_ctrl_n.$336.Metal2 v_a.$2617.Metal3 0.00803262f
Cred_7280 di_tg_ctrl_n.$336.Metal2 v_a.$2621.Metal3 0.0034232f
Cred_7281 di_tg_ctrl_n.$336.Metal2 v_a.$2651.Metal3 0.000130928f
Cred_7282 di_tg_ctrl_n.$336.Metal2 v_a.$936.Metal1 0.00185387f
Cred_7283 di_tg_ctrl_n.$336.Metal2 v_a.$998.Metal1 1.6467e-06f
Cred_7284 di_tg_ctrl_n.$336.Metal2 v_a.P28.pSD 0.00495998f
Cred_7285 di_tg_ctrl_n.$336.Metal2 v_a.P30.pSD 7.6174e-07f
Cred_7286 di_tg_ctrl_n.$336.Metal2 v_b.$2751.Metal2 0.0028719f
Cred_7287 di_tg_ctrl_n.$336.Metal2 v_b.$2811.Metal2 0.0028719f
Cred_7288 di_tg_ctrl_n.$336.Metal2 v_b.P29.nSD 3.17791e-05f
Cred_7289 di_tg_ctrl_n.$336.Metal2 v_b.P29.pSD 0.0162179f
Cred_7290 di_tg_ctrl_n.$336.Metal2 VDD.$193.Metal1 1.95039e-06f
Cred_7291 di_tg_ctrl_n.$336.Metal2 VDD.$197.Metal1 0.00284195f
Cred_7292 di_tg_ctrl_n.$336.Metal2 VDD.$203.Metal1 0.00375378f
Cred_7293 di_tg_ctrl_n.$336.Metal2 VDD.$207.Metal1 1.6978e-05f
Cred_7294 di_tg_ctrl_n.$336.Metal2 VDD.$520.Metal2 0.00413684f
Cred_7295 di_tg_ctrl_n.$336.Metal2 VDD.$528.Metal2 0.0284705f
Cred_7296 di_tg_ctrl_n.$336.Metal2 VDD.$536.Metal2 0.00368363f
Cred_7297 di_tg_ctrl_n.$336.Metal2 VDD.$734.Metal3 0.000162067f
Cred_7298 di_tg_ctrl_n.$336.Metal2 VDD.$738.Metal3 0.000407395f
Cred_7299 di_tg_ctrl_n.$336.Metal2 VDD.$742.Metal3 2.51849e-05f
Cred_7300 di_tg_ctrl_n.$336.Metal2 VDD.P0.nSD 2.4277e-06f
Cred_7301 di_tg_ctrl_n.$338.Metal2 v_a.$1990.Metal2 6.50891e-06f
Cred_7302 di_tg_ctrl_n.$338.Metal2 v_a.$2046.Metal2 2.38275e-05f
Cred_7303 di_tg_ctrl_n.$338.Metal2 v_a.$2048.Metal2 0.00953284f
Cred_7304 di_tg_ctrl_n.$338.Metal2 v_a.$2621.Metal3 8.72723e-05f
Cred_7305 di_tg_ctrl_n.$338.Metal2 v_a.$2647.Metal3 0.00985412f
Cred_7306 di_tg_ctrl_n.$338.Metal2 v_a.$2651.Metal3 0.00406145f
Cred_7307 di_tg_ctrl_n.$338.Metal2 v_a.$936.Metal1 1.27097e-06f
Cred_7308 di_tg_ctrl_n.$338.Metal2 v_a.$998.Metal1 0.00186091f
Cred_7309 di_tg_ctrl_n.$338.Metal2 v_a.P28.pSD 4.35893e-07f
Cred_7310 di_tg_ctrl_n.$338.Metal2 v_a.P30.pSD 0.00521651f
Cred_7311 di_tg_ctrl_n.$338.Metal2 v_b.$2751.Metal2 0.00144391f
Cred_7312 di_tg_ctrl_n.$338.Metal2 v_b.$2811.Metal2 0.00144391f
Cred_7313 di_tg_ctrl_n.$338.Metal2 v_b.P29.nSD 1.59776e-05f
Cred_7314 di_tg_ctrl_n.$338.Metal2 v_b.P29.pSD 0.00958173f
Cred_7315 di_tg_ctrl_n.$338.Metal2 VDD.$203.Metal1 0.00136842f
Cred_7316 di_tg_ctrl_n.$338.Metal2 VDD.$207.Metal1 0.0029385f
Cred_7317 di_tg_ctrl_n.$338.Metal2 VDD.$211.Metal1 0.00173991f
Cred_7318 di_tg_ctrl_n.$338.Metal2 VDD.$215.Metal1 1.10682e-05f
Cred_7319 di_tg_ctrl_n.$338.Metal2 VDD.$528.Metal2 0.00845904f
Cred_7320 di_tg_ctrl_n.$338.Metal2 VDD.$536.Metal2 0.026412f
Cred_7321 di_tg_ctrl_n.$338.Metal2 VDD.$544.Metal2 0.00180729f
Cred_7322 di_tg_ctrl_n.$338.Metal2 VDD.$734.Metal3 6.38401e-05f
Cred_7323 di_tg_ctrl_n.$338.Metal2 VDD.$738.Metal3 0.000478742f
Cred_7324 di_tg_ctrl_n.$338.Metal2 VDD.$742.Metal3 6.5341e-05f
Cred_7325 di_tg_ctrl_n.$342.Metal2 v_a.$1062.Metal1 1.48593e-05f
Cred_7326 di_tg_ctrl_n.$342.Metal2 v_a.$2046.Metal2 1.72572e-05f
Cred_7327 di_tg_ctrl_n.$342.Metal2 v_a.$2048.Metal2 0.00689714f
Cred_7328 di_tg_ctrl_n.$342.Metal2 v_a.$2106.Metal2 7.60976e-05f
Cred_7329 di_tg_ctrl_n.$342.Metal2 v_a.$2647.Metal3 0.00215914f
Cred_7330 di_tg_ctrl_n.$342.Metal2 v_a.$2651.Metal3 0.00275294f
Cred_7331 di_tg_ctrl_n.$342.Metal2 v_a.$2657.Metal3 0.000465615f
Cred_7332 di_tg_ctrl_n.$342.Metal2 v_a.$2677.Metal3 1.87972e-06f
Cred_7333 di_tg_ctrl_n.$342.Metal2 v_a.$2681.Metal3 0.00102033f
Cred_7334 di_tg_ctrl_n.$342.Metal2 v_a.$998.Metal1 0.00134777f
Cred_7335 di_tg_ctrl_n.$342.Metal2 v_a.P30.pSD 0.00207071f
Cred_7336 di_tg_ctrl_n.$342.Metal2 v_a.P32.pSD 6.05734e-06f
Cred_7337 di_tg_ctrl_n.$342.Metal2 v_a.P34.nSD 3.06173e-06f
Cred_7338 di_tg_ctrl_n.$342.Metal2 v_a.P34.pSD 0.00036545f
Cred_7339 di_tg_ctrl_n.$342.Metal2 v_b.$2811.Metal2 0.00879201f
Cred_7340 di_tg_ctrl_n.$342.Metal2 v_b.$2871.Metal2 3.37525e-05f
Cred_7341 di_tg_ctrl_n.$342.Metal2 v_b.P31.pSD 0.0249618f
Cred_7342 di_tg_ctrl_n.$342.Metal2 v_b.P33.nSD 3.73489e-07f
Cred_7343 di_tg_ctrl_n.$342.Metal2 v_b.P33.pSD 0.000201084f
Cred_7344 di_tg_ctrl_n.$342.Metal2 VDD.$211.Metal1 0.00175662f
Cred_7345 di_tg_ctrl_n.$342.Metal2 VDD.$215.Metal1 0.00352561f
Cred_7346 di_tg_ctrl_n.$342.Metal2 VDD.$225.Metal1 1.17068e-05f
Cred_7347 di_tg_ctrl_n.$342.Metal2 VDD.$230.Metal1 1.58537e-05f
Cred_7348 di_tg_ctrl_n.$342.Metal2 VDD.$238.Metal1 2.03125e-07f
Cred_7349 di_tg_ctrl_n.$342.Metal2 VDD.$536.Metal2 0.0193931f
Cred_7350 di_tg_ctrl_n.$342.Metal2 VDD.$544.Metal2 0.0181048f
Cred_7351 di_tg_ctrl_n.$342.Metal2 VDD.$548.Metal2 1.70501e-05f
Cred_7352 di_tg_ctrl_n.$342.Metal2 VDD.$552.Metal2 3.19079e-05f
Cred_7353 di_tg_ctrl_n.$342.Metal2 VDD.$560.Metal2 7.93572e-06f
Cred_7354 di_tg_ctrl_n.$342.Metal2 VDD.$742.Metal3 0.00114191f
Cred_7355 di_tg_ctrl_n.$342.Metal2 VDD.$750.Metal3 0.00103861f
Cred_7356 di_tg_ctrl_n.$342.Metal2 VDD.P0.nSD 1.76035e-08f
Cred_7357 di_tg_ctrl_n.$344.Metal2 v_a.$1062.Metal1 0.00386145f
Cred_7358 di_tg_ctrl_n.$344.Metal2 v_a.$2106.Metal2 0.0169069f
Cred_7359 di_tg_ctrl_n.$344.Metal2 v_a.$2657.Metal3 0.0193702f
Cred_7360 di_tg_ctrl_n.$344.Metal2 v_a.$2677.Metal3 0.0124363f
Cred_7361 di_tg_ctrl_n.$344.Metal2 v_a.$2681.Metal3 0.0127072f
Cred_7362 di_tg_ctrl_n.$344.Metal2 v_a.P32.pSD 0.00781007f
Cred_7363 di_tg_ctrl_n.$344.Metal2 v_a.P34.nSD 0.000127372f
Cred_7364 di_tg_ctrl_n.$344.Metal2 v_a.P34.pSD 0.023461f
Cred_7365 di_tg_ctrl_n.$344.Metal2 v_b.$2811.Metal2 0.00437172f
Cred_7366 di_tg_ctrl_n.$344.Metal2 v_b.$2871.Metal2 0.00419119f
Cred_7367 di_tg_ctrl_n.$344.Metal2 v_b.P31.pSD 0.000498525f
Cred_7368 di_tg_ctrl_n.$344.Metal2 v_b.P33.nSD 4.63778e-05f
Cred_7369 di_tg_ctrl_n.$344.Metal2 v_b.P33.pSD 0.0249895f
Cred_7370 di_tg_ctrl_n.$344.Metal2 VDD.$215.Metal1 0.00294748f
Cred_7371 di_tg_ctrl_n.$344.Metal2 VDD.$225.Metal1 0.0075231f
Cred_7372 di_tg_ctrl_n.$344.Metal2 VDD.$230.Metal1 0.0032149f
Cred_7373 di_tg_ctrl_n.$344.Metal2 VDD.$238.Metal1 0.000218738f
Cred_7374 di_tg_ctrl_n.$344.Metal2 VDD.$544.Metal2 0.017056f
Cred_7375 di_tg_ctrl_n.$344.Metal2 VDD.$548.Metal2 0.0233825f
Cred_7376 di_tg_ctrl_n.$344.Metal2 VDD.$552.Metal2 0.0309217f
Cred_7377 di_tg_ctrl_n.$344.Metal2 VDD.$560.Metal2 0.00854568f
Cred_7378 di_tg_ctrl_n.$344.Metal2 VDD.$742.Metal3 0.00515937f
Cred_7379 di_tg_ctrl_n.$344.Metal2 VDD.$750.Metal3 0.00807115f
Cred_7380 di_tg_ctrl_n.$344.Metal2 VDD.P0.nSD 1.33287e-05f
Cred_7381 di_tg_ctrl_n.$352.Metal2 VSS 0.00638476f
Cred_7382 di_tg_ctrl_n.$352.Metal2 v_b.$2871.Metal2 0.000357835f
Cred_7383 di_tg_ctrl_n.$352.Metal2 v_b.$2962.Metal2 0.0276779f
Cred_7384 di_tg_ctrl_n.$352.Metal2 v_b.$3053.Metal2 0.000779575f
Cred_7385 di_tg_ctrl_n.$352.Metal2 v_b.$3779.Metal3 0.024679f
Cred_7386 di_tg_ctrl_n.$352.Metal2 v_b.$3785.Metal3 4.58954e-06f
Cred_7387 di_tg_ctrl_n.$352.Metal2 v_b.P37.nSD 0.0123903f
Cred_7388 di_tg_ctrl_n.$352.Metal2 v_b.P37.pSD 6.89714e-05f
Cred_7389 di_tg_ctrl_n.$352.Metal2 v_b.P39.nSD 0.0102618f
Cred_7390 di_tg_ctrl_n.$352.Metal2 v_b.P41.nSD 2.8497e-06f
Cred_7391 di_tg_ctrl_n.$352.Metal2 VSS.$17.Metal1 2.44492e-08f
Cred_7392 di_tg_ctrl_n.$352.Metal2 VSS.$221.Metal1 0.00214806f
Cred_7393 di_tg_ctrl_n.$352.Metal2 VSS.$231.Metal1 0.00408905f
Cred_7394 di_tg_ctrl_n.$352.Metal2 VSS.$239.Metal1 0.000278203f
Cred_7395 di_tg_ctrl_n.$352.Metal2 VSS.$301.Metal1 3.12767e-07f
Cred_7396 di_tg_ctrl_n.$352.Metal2 VSS.$526.Metal2 0.00360342f
Cred_7397 di_tg_ctrl_n.$352.Metal2 VSS.$534.Metal2 0.0320584f
Cred_7398 di_tg_ctrl_n.$352.Metal2 VSS.$542.Metal2 0.00845567f
Cred_7399 di_tg_ctrl_n.$352.Metal2 VSS.$606.Metal2 3.30474e-08f
Cred_7400 di_tg_ctrl_n.$352.Metal2 VSS.$716.Metal3 0.000176059f
Cred_7401 di_tg_ctrl_n.$352.Metal2 VSS.$724.Metal3 0.000420524f
Cred_7402 di_tg_ctrl_n.$352.Metal2 VSS.$760.Metal3 1.95537e-09f
Cred_7403 di_tg_ctrl_n.$352.Metal2 VSS.P0.pSD 2.36625e-05f
Cred_7404 di_tg_ctrl_n.$354.Metal2 VSS 0.00278268f
Cred_7405 di_tg_ctrl_n.$354.Metal2 v_b.$2962.Metal2 0.000689363f
Cred_7406 di_tg_ctrl_n.$354.Metal2 v_b.$3053.Metal2 0.000484603f
Cred_7407 di_tg_ctrl_n.$354.Metal2 v_b.$3056.Metal2 8.65135e-07f
Cred_7408 di_tg_ctrl_n.$354.Metal2 v_b.$3779.Metal3 1.01548e-06f
Cred_7409 di_tg_ctrl_n.$354.Metal2 v_b.$3785.Metal3 0.0293121f
Cred_7410 di_tg_ctrl_n.$354.Metal2 v_b.P39.nSD 4.16332e-06f
Cred_7411 di_tg_ctrl_n.$354.Metal2 v_b.P41.nSD 0.0150059f
Cred_7412 di_tg_ctrl_n.$354.Metal2 v_b.P43.nSD 3.66196e-07f
Cred_7413 di_tg_ctrl_n.$354.Metal2 VSS.$17.Metal1 6.35212e-10f
Cred_7414 di_tg_ctrl_n.$354.Metal2 VSS.$221.Metal1 7.13485e-07f
Cred_7415 di_tg_ctrl_n.$354.Metal2 VSS.$231.Metal1 0.00187224f
Cred_7416 di_tg_ctrl_n.$354.Metal2 VSS.$239.Metal1 0.00149306f
Cred_7417 di_tg_ctrl_n.$354.Metal2 VSS.$301.Metal1 9.69651e-09f
Cred_7418 di_tg_ctrl_n.$354.Metal2 VSS.$534.Metal2 0.00104222f
Cred_7419 di_tg_ctrl_n.$354.Metal2 VSS.$542.Metal2 0.0182141f
Cred_7420 di_tg_ctrl_n.$354.Metal2 VSS.$606.Metal2 1.02455e-09f
Cred_7421 di_tg_ctrl_n.$354.Metal2 VSS.$724.Metal3 0.000130751f
Cred_7422 di_tg_ctrl_n.$354.Metal2 VSS.$728.Metal3 9.97735e-05f
Cred_7423 di_tg_ctrl_n.$354.Metal2 VSS.$760.Metal3 6.06211e-11f
Cred_7424 di_tg_ctrl_n.$354.Metal2 VSS.P0.pSD 4.41219e-06f
Cred_7425 di_tg_ctrl_n.$356.Metal2 VSS 0.00242964f
Cred_7426 di_tg_ctrl_n.$356.Metal2 v_b.$3053.Metal2 0.00209035f
Cred_7427 di_tg_ctrl_n.$356.Metal2 v_b.$3056.Metal2 0.0218777f
Cred_7428 di_tg_ctrl_n.$356.Metal2 v_b.$3785.Metal3 0.00158295f
Cred_7429 di_tg_ctrl_n.$356.Metal2 v_b.P41.nSD 8.49639e-05f
Cred_7430 di_tg_ctrl_n.$356.Metal2 v_b.P43.nSD 0.00769353f
Cred_7431 di_tg_ctrl_n.$356.Metal2 VSS.$17.Metal1 1.02428e-08f
Cred_7432 di_tg_ctrl_n.$356.Metal2 VSS.$231.Metal1 0.000414129f
Cred_7433 di_tg_ctrl_n.$356.Metal2 VSS.$239.Metal1 0.00308237f
Cred_7434 di_tg_ctrl_n.$356.Metal2 VSS.$253.Metal1 0.000112062f
Cred_7435 di_tg_ctrl_n.$356.Metal2 VSS.$301.Metal1 1.85506e-07f
Cred_7436 di_tg_ctrl_n.$356.Metal2 VSS.$542.Metal2 0.0106179f
Cred_7437 di_tg_ctrl_n.$356.Metal2 VSS.$550.Metal2 0.00851528f
Cred_7438 di_tg_ctrl_n.$356.Metal2 VSS.$554.Metal2 8.64337e-07f
Cred_7439 di_tg_ctrl_n.$356.Metal2 VSS.$606.Metal2 1.96009e-08f
Cred_7440 di_tg_ctrl_n.$356.Metal2 VSS.$728.Metal3 6.82597e-05f
Cred_7441 di_tg_ctrl_n.$356.Metal2 VSS.$760.Metal3 1.15976e-09f
Cred_7442 di_tg_ctrl_n.$356.Metal2 VSS.P0.pSD 1.13536e-05f
Cred_7443 di_tg_ctrl_n.$358.Metal2 VSS 0.00386118f
Cred_7444 di_tg_ctrl_n.$358.Metal2 v_b.$3053.Metal2 2.40001e-08f
Cred_7445 di_tg_ctrl_n.$358.Metal2 v_b.$3056.Metal2 0.00309952f
Cred_7446 di_tg_ctrl_n.$358.Metal2 v_b.$3089.Metal2 0.00168671f
Cred_7447 di_tg_ctrl_n.$358.Metal2 v_b.$3153.Metal2 0.000807655f
Cred_7448 di_tg_ctrl_n.$358.Metal2 v_b.$3785.Metal3 8.61249e-06f
Cred_7449 di_tg_ctrl_n.$358.Metal2 v_b.$3821.Metal3 0.0200315f
Cred_7450 di_tg_ctrl_n.$358.Metal2 v_b.$3857.Metal3 6.4156e-07f
Cred_7451 di_tg_ctrl_n.$358.Metal2 v_b.P43.nSD 0.00249972f
Cred_7452 di_tg_ctrl_n.$358.Metal2 v_b.P45.nSD 0.00993573f
Cred_7453 di_tg_ctrl_n.$358.Metal2 v_b.P47.nSD 0.000971239f
Cred_7454 di_tg_ctrl_n.$358.Metal2 VSS.$17.Metal1 7.47032e-09f
Cred_7455 di_tg_ctrl_n.$358.Metal2 VSS.$239.Metal1 0.00245581f
Cred_7456 di_tg_ctrl_n.$358.Metal2 VSS.$253.Metal1 0.00173903f
Cred_7457 di_tg_ctrl_n.$358.Metal2 VSS.$301.Metal1 2.01551e-07f
Cred_7458 di_tg_ctrl_n.$358.Metal2 VSS.$542.Metal2 0.00104221f
Cred_7459 di_tg_ctrl_n.$358.Metal2 VSS.$550.Metal2 0.019788f
Cred_7460 di_tg_ctrl_n.$358.Metal2 VSS.$554.Metal2 0.00867653f
Cred_7461 di_tg_ctrl_n.$358.Metal2 VSS.$606.Metal2 2.12962e-08f
Cred_7462 di_tg_ctrl_n.$358.Metal2 VSS.$728.Metal3 0.000153236f
Cred_7463 di_tg_ctrl_n.$358.Metal2 VSS.$734.Metal3 6.12262e-05f
Cred_7464 di_tg_ctrl_n.$358.Metal2 VSS.$760.Metal3 1.26007e-09f
Cred_7465 di_tg_ctrl_n.$358.Metal2 VSS.P0.pSD 1.85349e-05f
Cred_7466 di_tg_ctrl_n.$36.GatPoly VSS 0.00829178f
Cred_7467 di_tg_ctrl_n.$36.GatPoly v_a.$1574.Metal2 0.00019605f
Cred_7468 di_tg_ctrl_n.$36.GatPoly v_a.$1576.Metal2 0.0086507f
Cred_7469 di_tg_ctrl_n.$36.GatPoly v_a.$2407.Metal3 0.00542336f
Cred_7470 di_tg_ctrl_n.$36.GatPoly v_a.$489.Metal1 0.0105266f
Cred_7471 di_tg_ctrl_n.$36.GatPoly v_a.P14.pSD 0.0132704f
Cred_7472 di_tg_ctrl_n.$36.GatPoly v_b.$2541.Metal2 0.00507117f
Cred_7473 di_tg_ctrl_n.$36.GatPoly v_b.$2601.Metal2 0.00320345f
Cred_7474 di_tg_ctrl_n.$36.GatPoly v_b.P13.pSD 0.00654236f
Cred_7475 di_tg_ctrl_n.$36.GatPoly v_b.P15.nSD 3.54479e-05f
Cred_7476 di_tg_ctrl_n.$36.GatPoly v_b.P15.pSD 0.022745f
Cred_7477 di_tg_ctrl_n.$36.GatPoly VDD.$111.Metal1 0.000204474f
Cred_7478 di_tg_ctrl_n.$36.GatPoly VDD.$121.Metal1 0.00367989f
Cred_7479 di_tg_ctrl_n.$36.GatPoly VDD.$129.Metal1 0.00398938f
Cred_7480 di_tg_ctrl_n.$36.GatPoly VDD.$134.Metal1 0.000184568f
Cred_7481 di_tg_ctrl_n.$36.GatPoly VDD.$448.Metal2 1.26879e-06f
Cred_7482 di_tg_ctrl_n.$36.GatPoly VDD.$452.Metal2 2.85833e-06f
Cred_7483 di_tg_ctrl_n.$36.GatPoly VDD.$456.Metal2 7.66821e-06f
Cred_7484 di_tg_ctrl_n.$36.GatPoly VDD.$460.Metal2 9.76395e-06f
Cred_7485 di_tg_ctrl_n.$36.GatPoly VDD.$464.Metal2 1.42332e-06f
Cred_7486 di_tg_ctrl_n.$36.GatPoly VDD.P0.nSD 3.66609e-06f
Cred_7487 di_tg_ctrl_n.$362.Metal2 VSS 0.00373915f
Cred_7488 di_tg_ctrl_n.$362.Metal2 v_b.$3089.Metal2 0.000216688f
Cred_7489 di_tg_ctrl_n.$362.Metal2 v_b.$3153.Metal2 0.0257113f
Cred_7490 di_tg_ctrl_n.$362.Metal2 v_b.$3247.Metal2 0.000581169f
Cred_7491 di_tg_ctrl_n.$362.Metal2 v_b.$3821.Metal3 0.00771182f
Cred_7492 di_tg_ctrl_n.$362.Metal2 v_b.$3857.Metal3 0.000517652f
Cred_7493 di_tg_ctrl_n.$362.Metal2 v_b.$3890.Metal3 0.000539043f
Cred_7494 di_tg_ctrl_n.$362.Metal2 v_b.P45.nSD 0.0038202f
Cred_7495 di_tg_ctrl_n.$362.Metal2 v_b.P47.nSD 0.0091942f
Cred_7496 di_tg_ctrl_n.$362.Metal2 v_b.P49.nSD 5.82518e-05f
Cred_7497 di_tg_ctrl_n.$362.Metal2 v_b.P49.pSD 2.33115e-06f
Cred_7498 di_tg_ctrl_n.$362.Metal2 VSS.$17.Metal1 9.21421e-09f
Cred_7499 di_tg_ctrl_n.$362.Metal2 VSS.$239.Metal1 0.000825732f
Cred_7500 di_tg_ctrl_n.$362.Metal2 VSS.$253.Metal1 0.00387172f
Cred_7501 di_tg_ctrl_n.$362.Metal2 VSS.$261.Metal1 0.00028381f
Cred_7502 di_tg_ctrl_n.$362.Metal2 VSS.$301.Metal1 3.63819e-07f
Cred_7503 di_tg_ctrl_n.$362.Metal2 VSS.$550.Metal2 0.0010373f
Cred_7504 di_tg_ctrl_n.$362.Metal2 VSS.$554.Metal2 0.019228f
Cred_7505 di_tg_ctrl_n.$362.Metal2 VSS.$562.Metal2 0.00845571f
Cred_7506 di_tg_ctrl_n.$362.Metal2 VSS.$606.Metal2 3.84417e-08f
Cred_7507 di_tg_ctrl_n.$362.Metal2 VSS.$734.Metal3 6.77785e-05f
Cred_7508 di_tg_ctrl_n.$362.Metal2 VSS.$760.Metal3 2.27454e-09f
Cred_7509 di_tg_ctrl_n.$362.Metal2 VSS.P0.pSD 1.93154e-05f
Cred_7510 di_tg_ctrl_n.$364.Metal2 VSS 0.00277407f
Cred_7511 di_tg_ctrl_n.$364.Metal2 v_b.$3153.Metal2 0.000753947f
Cred_7512 di_tg_ctrl_n.$364.Metal2 v_b.$3247.Metal2 0.000313138f
Cred_7513 di_tg_ctrl_n.$364.Metal2 v_b.$3857.Metal3 0.0125976f
Cred_7514 di_tg_ctrl_n.$364.Metal2 v_b.$3890.Metal3 0.0132254f
Cred_7515 di_tg_ctrl_n.$364.Metal2 v_b.$3903.Metal3 7.96853e-08f
Cred_7516 di_tg_ctrl_n.$364.Metal2 v_b.P47.nSD 1.1577e-06f
Cred_7517 di_tg_ctrl_n.$364.Metal2 v_b.P49.nSD 0.0150335f
Cred_7518 di_tg_ctrl_n.$364.Metal2 v_b.P49.pSD 5.74705e-05f
Cred_7519 di_tg_ctrl_n.$364.Metal2 v_b.P51.nSD 1.01528e-07f
Cred_7520 di_tg_ctrl_n.$364.Metal2 v_b.P53.nSD 6.06299e-09f
Cred_7521 di_tg_ctrl_n.$364.Metal2 VSS.$17.Metal1 1.30326e-10f
Cred_7522 di_tg_ctrl_n.$364.Metal2 VSS.$239.Metal1 1.73195e-07f
Cred_7523 di_tg_ctrl_n.$364.Metal2 VSS.$253.Metal1 0.00187039f
Cred_7524 di_tg_ctrl_n.$364.Metal2 VSS.$261.Metal1 0.00148389f
Cred_7525 di_tg_ctrl_n.$364.Metal2 VSS.$301.Metal1 5.55259e-09f
Cred_7526 di_tg_ctrl_n.$364.Metal2 VSS.$550.Metal2 1.33563e-09f
Cred_7527 di_tg_ctrl_n.$364.Metal2 VSS.$554.Metal2 0.00104222f
Cred_7528 di_tg_ctrl_n.$364.Metal2 VSS.$562.Metal2 0.0182142f
Cred_7529 di_tg_ctrl_n.$364.Metal2 VSS.$606.Metal2 5.86696e-10f
Cred_7530 di_tg_ctrl_n.$364.Metal2 VSS.$734.Metal3 0.000128633f
Cred_7531 di_tg_ctrl_n.$364.Metal2 VSS.$738.Metal3 9.85198e-05f
Cred_7532 di_tg_ctrl_n.$364.Metal2 VSS.$760.Metal3 3.4714e-11f
Cred_7533 di_tg_ctrl_n.$364.Metal2 VSS.P0.pSD 4.06442e-06f
Cred_7534 di_tg_ctrl_n.$366.Metal2 VSS 0.00244776f
Cred_7535 di_tg_ctrl_n.$366.Metal2 v_b.$3153.Metal2 0.000631338f
Cred_7536 di_tg_ctrl_n.$366.Metal2 v_b.$3247.Metal2 0.0245095f
Cred_7537 di_tg_ctrl_n.$366.Metal2 v_b.$3857.Metal3 0.000644754f
Cred_7538 di_tg_ctrl_n.$366.Metal2 v_b.$3890.Metal3 0.000680665f
Cred_7539 di_tg_ctrl_n.$366.Metal2 v_b.P49.nSD 7.20515e-05f
Cred_7540 di_tg_ctrl_n.$366.Metal2 v_b.P49.pSD 2.92947e-06f
Cred_7541 di_tg_ctrl_n.$366.Metal2 v_b.P51.nSD 0.00799209f
Cred_7542 di_tg_ctrl_n.$366.Metal2 VSS.$17.Metal1 5.91142e-09f
Cred_7543 di_tg_ctrl_n.$366.Metal2 VSS.$253.Metal1 0.000399339f
Cred_7544 di_tg_ctrl_n.$366.Metal2 VSS.$261.Metal1 0.00306012f
Cred_7545 di_tg_ctrl_n.$366.Metal2 VSS.$271.Metal1 0.000146083f
Cred_7546 di_tg_ctrl_n.$366.Metal2 VSS.$301.Metal1 2.98891e-07f
Cred_7547 di_tg_ctrl_n.$366.Metal2 VSS.$562.Metal2 0.0105577f
Cred_7548 di_tg_ctrl_n.$366.Metal2 VSS.$570.Metal2 0.00845465f
Cred_7549 di_tg_ctrl_n.$366.Metal2 VSS.$606.Metal2 3.15812e-08f
Cred_7550 di_tg_ctrl_n.$366.Metal2 VSS.$738.Metal3 6.77785e-05f
Cred_7551 di_tg_ctrl_n.$366.Metal2 VSS.$760.Metal3 1.86862e-09f
Cred_7552 di_tg_ctrl_n.$366.Metal2 VSS.P0.pSD 1.02948e-05f
Cred_7553 di_tg_ctrl_n.$368.Metal2 VSS 0.00386674f
Cred_7554 di_tg_ctrl_n.$368.Metal2 v_b.$3247.Metal2 0.00163761f
Cred_7555 di_tg_ctrl_n.$368.Metal2 v_b.$3294.Metal2 0.00211538f
Cred_7556 di_tg_ctrl_n.$368.Metal2 v_b.$3344.Metal2 0.000803483f
Cred_7557 di_tg_ctrl_n.$368.Metal2 v_b.$3435.Metal2 5.93172e-10f
Cred_7558 di_tg_ctrl_n.$368.Metal2 v_b.$3890.Metal3 1.01697e-05f
Cred_7559 di_tg_ctrl_n.$368.Metal2 v_b.$3903.Metal3 0.0208683f
Cred_7560 di_tg_ctrl_n.$368.Metal2 v_b.$3934.Metal3 4.70883e-07f
Cred_7561 di_tg_ctrl_n.$368.Metal2 v_b.P51.nSD 0.00211842f
Cred_7562 di_tg_ctrl_n.$368.Metal2 v_b.P53.nSD 0.0103086f
Cred_7563 di_tg_ctrl_n.$368.Metal2 v_b.P55.nSD 0.00103194f
Cred_7564 di_tg_ctrl_n.$368.Metal2 VSS.$17.Metal1 4.5238e-09f
Cred_7565 di_tg_ctrl_n.$368.Metal2 VSS.$261.Metal1 0.00163654f
Cred_7566 di_tg_ctrl_n.$368.Metal2 VSS.$271.Metal1 0.00257508f
Cred_7567 di_tg_ctrl_n.$368.Metal2 VSS.$301.Metal1 3.40863e-07f
Cred_7568 di_tg_ctrl_n.$368.Metal2 VSS.$562.Metal2 0.00104221f
Cred_7569 di_tg_ctrl_n.$368.Metal2 VSS.$570.Metal2 0.02411f
Cred_7570 di_tg_ctrl_n.$368.Metal2 VSS.$578.Metal2 0.00432335f
Cred_7571 di_tg_ctrl_n.$368.Metal2 VSS.$606.Metal2 3.60161e-08f
Cred_7572 di_tg_ctrl_n.$368.Metal2 VSS.$738.Metal3 0.000182813f
Cred_7573 di_tg_ctrl_n.$368.Metal2 VSS.$746.Metal3 6.16634e-05f
Cred_7574 di_tg_ctrl_n.$368.Metal2 VSS.$760.Metal3 2.13102e-09f
Cred_7575 di_tg_ctrl_n.$368.Metal2 VSS.P0.pSD 1.20317e-05f
Cred_7576 di_tg_ctrl_n.$372.Metal2 VSS 0.00514899f
Cred_7577 di_tg_ctrl_n.$372.Metal2 v_b.$3294.Metal2 0.000696324f
Cred_7578 di_tg_ctrl_n.$372.Metal2 v_b.$3344.Metal2 0.0252066f
Cred_7579 di_tg_ctrl_n.$372.Metal2 v_b.$3435.Metal2 0.00142331f
Cred_7580 di_tg_ctrl_n.$372.Metal2 v_b.$3438.Metal2 7.09267e-05f
Cred_7581 di_tg_ctrl_n.$372.Metal2 v_b.$3529.Metal2 2.11045e-08f
Cred_7582 di_tg_ctrl_n.$372.Metal2 v_b.$3903.Metal3 0.006365f
Cred_7583 di_tg_ctrl_n.$372.Metal2 v_b.$3934.Metal3 0.0167047f
Cred_7584 di_tg_ctrl_n.$372.Metal2 v_b.$3970.Metal3 1.70273e-05f
Cred_7585 di_tg_ctrl_n.$372.Metal2 v_b.P53.nSD 0.00318578f
Cred_7586 di_tg_ctrl_n.$372.Metal2 v_b.P55.nSD 0.0090822f
Cred_7587 di_tg_ctrl_n.$372.Metal2 v_b.P57.nSD 0.00759663f
Cred_7588 di_tg_ctrl_n.$372.Metal2 v_b.P59.nSD 2.76634e-05f
Cred_7589 di_tg_ctrl_n.$372.Metal2 VSS.$17.Metal1 5.76659e-09f
Cred_7590 di_tg_ctrl_n.$372.Metal2 VSS.$261.Metal1 0.000146997f
Cred_7591 di_tg_ctrl_n.$372.Metal2 VSS.$271.Metal1 0.00336693f
Cred_7592 di_tg_ctrl_n.$372.Metal2 VSS.$279.Metal1 0.00300725f
Cred_7593 di_tg_ctrl_n.$372.Metal2 VSS.$293.Metal1 8.13028e-05f
Cred_7594 di_tg_ctrl_n.$372.Metal2 VSS.$301.Metal1 6.38165e-07f
Cred_7595 di_tg_ctrl_n.$372.Metal2 VSS.$570.Metal2 0.00639899f
Cred_7596 di_tg_ctrl_n.$372.Metal2 VSS.$578.Metal2 0.0277228f
Cred_7597 di_tg_ctrl_n.$372.Metal2 VSS.$586.Metal2 0.00418068f
Cred_7598 di_tg_ctrl_n.$372.Metal2 VSS.$590.Metal2 1.09285e-06f
Cred_7599 di_tg_ctrl_n.$372.Metal2 VSS.$606.Metal2 6.74295e-08f
Cred_7600 di_tg_ctrl_n.$372.Metal2 VSS.$738.Metal3 0.000146015f
Cred_7601 di_tg_ctrl_n.$372.Metal2 VSS.$746.Metal3 0.000902756f
Cred_7602 di_tg_ctrl_n.$372.Metal2 VSS.$752.Metal3 5.80978e-05f
Cred_7603 di_tg_ctrl_n.$372.Metal2 VSS.$760.Metal3 3.98971e-09f
Cred_7604 di_tg_ctrl_n.$372.Metal2 VSS.P0.pSD 1.81422e-05f
Cred_7605 di_tg_ctrl_n.$376.Metal2 VSS 0.00517166f
Cred_7606 di_tg_ctrl_n.$376.Metal2 v_b.$3294.Metal2 1.93471e-08f
Cred_7607 di_tg_ctrl_n.$376.Metal2 v_b.$3344.Metal2 6.95621e-05f
Cred_7608 di_tg_ctrl_n.$376.Metal2 v_b.$3435.Metal2 0.00251404f
Cred_7609 di_tg_ctrl_n.$376.Metal2 v_b.$3438.Metal2 0.0239676f
Cred_7610 di_tg_ctrl_n.$376.Metal2 v_b.$3529.Metal2 0.000216731f
Cred_7611 di_tg_ctrl_n.$376.Metal2 v_b.$3903.Metal3 1.64279e-05f
Cred_7612 di_tg_ctrl_n.$376.Metal2 v_b.$3934.Metal3 0.0164188f
Cred_7613 di_tg_ctrl_n.$376.Metal2 v_b.$3970.Metal3 0.00902436f
Cred_7614 di_tg_ctrl_n.$376.Metal2 v_b.P55.nSD 2.6563e-05f
Cred_7615 di_tg_ctrl_n.$376.Metal2 v_b.P57.nSD 0.00758019f
Cred_7616 di_tg_ctrl_n.$376.Metal2 v_b.P59.nSD 0.00912673f
Cred_7617 di_tg_ctrl_n.$376.Metal2 v_b.P61.nSD 0.00388877f
Cred_7618 di_tg_ctrl_n.$376.Metal2 VSS.$17.Metal1 4.23293e-09f
Cred_7619 di_tg_ctrl_n.$376.Metal2 VSS.$271.Metal1 0.000212653f
Cred_7620 di_tg_ctrl_n.$376.Metal2 VSS.$279.Metal1 0.00351762f
Cred_7621 di_tg_ctrl_n.$376.Metal2 VSS.$293.Metal1 0.00187171f
Cred_7622 di_tg_ctrl_n.$376.Metal2 VSS.$301.Metal1 6.5078e-07f
Cred_7623 di_tg_ctrl_n.$376.Metal2 VSS.$570.Metal2 1.06379e-06f
Cred_7624 di_tg_ctrl_n.$376.Metal2 VSS.$578.Metal2 0.00625557f
Cred_7625 di_tg_ctrl_n.$376.Metal2 VSS.$586.Metal2 0.0244154f
Cred_7626 di_tg_ctrl_n.$376.Metal2 VSS.$590.Metal2 0.00870343f
Cred_7627 di_tg_ctrl_n.$376.Metal2 VSS.$606.Metal2 6.87624e-08f
Cred_7628 di_tg_ctrl_n.$376.Metal2 VSS.$738.Metal3 6.64715e-05f
Cred_7629 di_tg_ctrl_n.$376.Metal2 VSS.$746.Metal3 0.000878917f
Cred_7630 di_tg_ctrl_n.$376.Metal2 VSS.$752.Metal3 0.000118698f
Cred_7631 di_tg_ctrl_n.$376.Metal2 VSS.$760.Metal3 4.06858e-09f
Cred_7632 di_tg_ctrl_n.$376.Metal2 VSS.P0.pSD 2.20495e-05f
Cred_7633 di_tg_ctrl_n.$380.Metal2 VSS 0.00387796f
Cred_7634 di_tg_ctrl_n.$380.Metal2 v_b.$3435.Metal2 1.56443e-09f
Cred_7635 di_tg_ctrl_n.$380.Metal2 v_b.$3438.Metal2 0.000807656f
Cred_7636 di_tg_ctrl_n.$380.Metal2 v_b.$3529.Metal2 0.00168673f
Cred_7637 di_tg_ctrl_n.$380.Metal2 v_b.$3535.Metal2 0.00314521f
Cred_7638 di_tg_ctrl_n.$380.Metal2 v_b.$3565.Metal2 7.27621e-08f
Cred_7639 di_tg_ctrl_n.$380.Metal2 v_b.$3934.Metal3 5.0793e-07f
Cred_7640 di_tg_ctrl_n.$380.Metal2 v_b.$3970.Metal3 0.0214159f
Cred_7641 di_tg_ctrl_n.$380.Metal2 v_b.$4009.Metal3 7.04791e-05f
Cred_7642 di_tg_ctrl_n.$380.Metal2 v_b.P59.nSD 0.000971239f
Cred_7643 di_tg_ctrl_n.$380.Metal2 v_b.P61.nSD 0.0100113f
Cred_7644 di_tg_ctrl_n.$380.Metal2 v_b.P63.nSD 0.00252266f
Cred_7645 di_tg_ctrl_n.$380.Metal2 v_b.P65.nSD 3.37584e-06f
Cred_7646 di_tg_ctrl_n.$380.Metal2 VSS.$17.Metal1 2.59107e-09f
Cred_7647 di_tg_ctrl_n.$380.Metal2 VSS.$279.Metal1 0.000704355f
Cred_7648 di_tg_ctrl_n.$380.Metal2 VSS.$293.Metal1 0.00340807f
Cred_7649 di_tg_ctrl_n.$380.Metal2 VSS.$301.Metal1 5.81062e-07f
Cred_7650 di_tg_ctrl_n.$380.Metal2 VSS.$586.Metal2 0.00103645f
Cred_7651 di_tg_ctrl_n.$380.Metal2 VSS.$590.Metal2 0.0196494f
Cred_7652 di_tg_ctrl_n.$380.Metal2 VSS.$598.Metal2 0.0088509f
Cred_7653 di_tg_ctrl_n.$380.Metal2 VSS.$606.Metal2 5.59831e-07f
Cred_7654 di_tg_ctrl_n.$380.Metal2 VSS.$746.Metal3 9.67681e-06f
Cred_7655 di_tg_ctrl_n.$380.Metal2 VSS.$752.Metal3 0.000441493f
Cred_7656 di_tg_ctrl_n.$380.Metal2 VSS.$760.Metal3 3.11619e-05f
Cred_7657 di_tg_ctrl_n.$380.Metal2 VSS.P0.pSD 1.33777e-05f
Cred_7658 di_tg_ctrl_n.$382.Metal2 VSS 0.00381814f
Cred_7659 di_tg_ctrl_n.$382.Metal2 v_b.$3529.Metal2 3.6697e-08f
Cred_7660 di_tg_ctrl_n.$382.Metal2 v_b.$3535.Metal2 0.0215631f
Cred_7661 di_tg_ctrl_n.$382.Metal2 v_b.$3565.Metal2 0.00232821f
Cred_7662 di_tg_ctrl_n.$382.Metal2 v_b.$3629.Metal2 0.000336147f
Cred_7663 di_tg_ctrl_n.$382.Metal2 v_b.$3970.Metal3 0.000209864f
Cred_7664 di_tg_ctrl_n.$382.Metal2 v_b.$4009.Metal3 0.0158506f
Cred_7665 di_tg_ctrl_n.$382.Metal2 v_b.$4042.Metal3 4.9823e-07f
Cred_7666 di_tg_ctrl_n.$382.Metal2 v_b.P61.nSD 1.3742e-05f
Cred_7667 di_tg_ctrl_n.$382.Metal2 v_b.P63.nSD 0.00763814f
Cred_7668 di_tg_ctrl_n.$382.Metal2 v_b.P65.nSD 0.00743583f
Cred_7669 di_tg_ctrl_n.$382.Metal2 VSS.$17.Metal1 3.01278e-09f
Cred_7670 di_tg_ctrl_n.$382.Metal2 VSS.$279.Metal1 5.79962e-07f
Cred_7671 di_tg_ctrl_n.$382.Metal2 VSS.$293.Metal1 0.00214686f
Cred_7672 di_tg_ctrl_n.$382.Metal2 VSS.$301.Metal1 0.00306987f
Cred_7673 di_tg_ctrl_n.$382.Metal2 VSS.$586.Metal2 4.28994e-08f
Cred_7674 di_tg_ctrl_n.$382.Metal2 VSS.$590.Metal2 0.0010423f
Cred_7675 di_tg_ctrl_n.$382.Metal2 VSS.$598.Metal2 0.023391f
Cred_7676 di_tg_ctrl_n.$382.Metal2 VSS.$606.Metal2 0.00418526f
Cred_7677 di_tg_ctrl_n.$382.Metal2 VSS.$746.Metal3 4.79266e-06f
Cred_7678 di_tg_ctrl_n.$382.Metal2 VSS.$752.Metal3 0.000374459f
Cred_7679 di_tg_ctrl_n.$382.Metal2 VSS.$760.Metal3 7.96948e-05f
Cred_7680 di_tg_ctrl_n.$382.Metal2 VSS.P0.pSD 2.02773e-05f
Cred_7681 di_tg_ctrl_n.$386.Metal2 VSS 0.0135954f
Cred_7682 di_tg_ctrl_n.$386.Metal2 v_b 0.000399109f
Cred_7683 di_tg_ctrl_n.$386.Metal2 v_b.$3565.Metal2 0.0010174f
Cred_7684 di_tg_ctrl_n.$386.Metal2 v_b.$3629.Metal2 0.0280557f
Cred_7685 di_tg_ctrl_n.$386.Metal2 v_b.$4009.Metal3 0.0143202f
Cred_7686 di_tg_ctrl_n.$386.Metal2 v_b.$4042.Metal3 0.0258588f
Cred_7687 di_tg_ctrl_n.$386.Metal2 v_b.$4053.Metal3 0.000517437f
Cred_7688 di_tg_ctrl_n.$386.Metal2 v_b.P65.nSD 0.00735036f
Cred_7689 di_tg_ctrl_n.$386.Metal2 v_b.P67.nSD 0.0104174f
Cred_7690 di_tg_ctrl_n.$386.Metal2 v_b.P69.nSD 0.012431f
Cred_7691 di_tg_ctrl_n.$386.Metal2 VSS.$17.Metal1 1.73554e-08f
Cred_7692 di_tg_ctrl_n.$386.Metal2 VSS.$293.Metal1 0.000210142f
Cred_7693 di_tg_ctrl_n.$386.Metal2 VSS.$301.Metal1 0.00809288f
Cred_7694 di_tg_ctrl_n.$386.Metal2 VSS.$598.Metal2 0.00625596f
Cred_7695 di_tg_ctrl_n.$386.Metal2 VSS.$606.Metal2 0.0469073f
Cred_7696 di_tg_ctrl_n.$386.Metal2 VSS.$752.Metal3 0.000262562f
Cred_7697 di_tg_ctrl_n.$386.Metal2 VSS.$760.Metal3 0.0029751f
Cred_7698 di_tg_ctrl_n.$386.Metal2 VSS.P0.pSD 0.000355147f
Cred_7699 di_tg_ctrl_n.$39.GatPoly VSS 0.00685292f
Cred_7700 di_tg_ctrl_n.$39.GatPoly v_a.$2387.Metal3 0.00491011f
Cred_7701 di_tg_ctrl_n.$39.GatPoly v_a.$2447.Metal3 0.00491011f
Cred_7702 di_tg_ctrl_n.$39.GatPoly v_a.P16.nSD 4.42828e-05f
Cred_7703 di_tg_ctrl_n.$39.GatPoly v_a.P16.pSD 0.0226213f
Cred_7704 di_tg_ctrl_n.$39.GatPoly v_b.$2541.Metal2 0.00319632f
Cred_7705 di_tg_ctrl_n.$39.GatPoly v_b.$2601.Metal2 0.00382868f
Cred_7706 di_tg_ctrl_n.$39.GatPoly v_b.P15.nSD 3.5369e-05f
Cred_7707 di_tg_ctrl_n.$39.GatPoly v_b.P15.pSD 0.0227593f
Cred_7708 di_tg_ctrl_n.$39.GatPoly v_b.P17.pSD 0.00223058f
Cred_7709 di_tg_ctrl_n.$39.GatPoly VDD.$121.Metal1 0.000147918f
Cred_7710 di_tg_ctrl_n.$39.GatPoly VDD.$129.Metal1 0.00264987f
Cred_7711 di_tg_ctrl_n.$39.GatPoly VDD.$134.Metal1 0.0026958f
Cred_7712 di_tg_ctrl_n.$39.GatPoly VDD.$456.Metal2 3.61577e-07f
Cred_7713 di_tg_ctrl_n.$39.GatPoly VDD.$460.Metal2 1.50567e-06f
Cred_7714 di_tg_ctrl_n.$39.GatPoly VDD.$464.Metal2 1.05494e-05f
Cred_7715 di_tg_ctrl_n.$39.GatPoly VDD.P0.nSD 2.56575e-06f
Cred_7716 di_tg_ctrl_n.$394.Metal3 VSS 0.00354735f
Cred_7717 di_tg_ctrl_n.$394.Metal3 v_a.$1168.Metal2 2.58242e-05f
Cred_7718 di_tg_ctrl_n.$394.Metal3 v_a.$1170.Metal2 0.00557514f
Cred_7719 di_tg_ctrl_n.$394.Metal3 v_a.$118.Metal1 0.000217122f
Cred_7720 di_tg_ctrl_n.$394.Metal3 v_a.$1238.Metal2 4.35966e-06f
Cred_7721 di_tg_ctrl_n.$394.Metal3 v_a.$1240.Metal2 0.00214848f
Cred_7722 di_tg_ctrl_n.$394.Metal3 v_a.$1294.Metal2 0.00412198f
Cred_7723 di_tg_ctrl_n.$394.Metal3 v_a.$1350.Metal2 7.36327e-07f
Cred_7724 di_tg_ctrl_n.$394.Metal3 v_a.$1352.Metal2 0.000344865f
Cred_7725 di_tg_ctrl_n.$394.Metal3 v_a.$180.Metal1 0.000809302f
Cred_7726 di_tg_ctrl_n.$394.Metal3 v_a.$2197.Metal3 0.0349678f
Cred_7727 di_tg_ctrl_n.$394.Metal3 v_a.$2227.Metal3 9.84663e-05f
Cred_7728 di_tg_ctrl_n.$394.Metal3 v_a.$2233.Metal3 0.0582797f
Cred_7729 di_tg_ctrl_n.$394.Metal3 v_a.$2257.Metal3 7.21185e-05f
Cred_7730 di_tg_ctrl_n.$394.Metal3 v_a.$2261.Metal3 0.0535783f
Cred_7731 di_tg_ctrl_n.$394.Metal3 v_a.$2291.Metal3 0.0045723f
Cred_7732 di_tg_ctrl_n.$394.Metal3 v_a.$242.Metal1 5.75066e-05f
Cred_7733 di_tg_ctrl_n.$394.Metal3 v_a.$48.Metal1 0.00138659f
Cred_7734 di_tg_ctrl_n.$394.Metal3 v_a.P0.pSD 0.00173922f
Cred_7735 di_tg_ctrl_n.$394.Metal3 v_a.P2.pSD 0.000114252f
Cred_7736 di_tg_ctrl_n.$394.Metal3 v_a.P4.pSD 0.000305186f
Cred_7737 di_tg_ctrl_n.$394.Metal3 v_a.P6.pSD 2.66017e-05f
Cred_7738 di_tg_ctrl_n.$394.Metal3 v_b.$2361.Metal2 0.00537748f
Cred_7739 di_tg_ctrl_n.$394.Metal3 v_b.$2421.Metal2 0.00324103f
Cred_7740 di_tg_ctrl_n.$394.Metal3 v_b.P1.pSD 0.0104979f
Cred_7741 di_tg_ctrl_n.$394.Metal3 v_b.P3.nSD 1.97662e-05f
Cred_7742 di_tg_ctrl_n.$394.Metal3 v_b.P3.pSD 0.0100554f
Cred_7743 di_tg_ctrl_n.$394.Metal3 v_b.P5.pSD 0.00485561f
Cred_7744 di_tg_ctrl_n.$394.Metal3 VDD.$340.Metal1 6.2413e-13f
Cred_7745 di_tg_ctrl_n.$394.Metal3 VDD.$388.Metal2 0.00135441f
Cred_7746 di_tg_ctrl_n.$394.Metal3 VDD.$392.Metal2 0.00103887f
Cred_7747 di_tg_ctrl_n.$394.Metal3 VDD.$400.Metal2 0.000312779f
Cred_7748 di_tg_ctrl_n.$394.Metal3 VDD.$404.Metal2 0.00040776f
Cred_7749 di_tg_ctrl_n.$394.Metal3 VDD.$412.Metal2 8.19874e-05f
Cred_7750 di_tg_ctrl_n.$394.Metal3 VDD.$42.Metal1 0.000834471f
Cred_7751 di_tg_ctrl_n.$394.Metal3 VDD.$55.Metal1 0.000632603f
Cred_7752 di_tg_ctrl_n.$394.Metal3 VDD.$59.Metal1 0.000581171f
Cred_7753 di_tg_ctrl_n.$394.Metal3 VDD.$666.Metal3 0.0473662f
Cred_7754 di_tg_ctrl_n.$394.Metal3 VDD.$67.Metal1 0.00189999f
Cred_7755 di_tg_ctrl_n.$394.Metal3 VDD.$670.Metal3 0.0620044f
Cred_7756 di_tg_ctrl_n.$394.Metal3 VDD.$676.Metal3 0.0523185f
Cred_7757 di_tg_ctrl_n.$394.Metal3 VDD.$680.Metal3 0.00857176f
Cred_7758 di_tg_ctrl_n.$394.Metal3 VDD.$71.Metal1 0.000695125f
Cred_7759 di_tg_ctrl_n.$394.Metal3 VDD.P0.nSD 4.33446e-06f
Cred_7760 di_tg_ctrl_n.$397.Metal3 v_a.$1294.Metal2 0.000511442f
Cred_7761 di_tg_ctrl_n.$397.Metal3 v_a.$1350.Metal2 9.40902e-06f
Cred_7762 di_tg_ctrl_n.$397.Metal3 v_a.$1352.Metal2 0.0043799f
Cred_7763 di_tg_ctrl_n.$397.Metal3 v_a.$180.Metal1 9.98675e-05f
Cred_7764 di_tg_ctrl_n.$397.Metal3 v_a.$2261.Metal3 0.00685748f
Cred_7765 di_tg_ctrl_n.$397.Metal3 v_a.$2287.Metal3 8.37315e-05f
Cred_7766 di_tg_ctrl_n.$397.Metal3 v_a.$2291.Metal3 0.0560615f
Cred_7767 di_tg_ctrl_n.$397.Metal3 v_a.$242.Metal1 0.000734837f
Cred_7768 di_tg_ctrl_n.$397.Metal3 v_a.P4.pSD 3.42506e-05f
Cred_7769 di_tg_ctrl_n.$397.Metal3 v_a.P6.pSD 0.000383458f
Cred_7770 di_tg_ctrl_n.$397.Metal3 v_b.$2421.Metal2 0.00273486f
Cred_7771 di_tg_ctrl_n.$397.Metal3 v_b.$2481.Metal2 0.000955434f
Cred_7772 di_tg_ctrl_n.$397.Metal3 v_b.P5.pSD 0.00536596f
Cred_7773 di_tg_ctrl_n.$397.Metal3 v_b.P7.nSD 1.05724e-05f
Cred_7774 di_tg_ctrl_n.$397.Metal3 v_b.P7.pSD 0.00551033f
Cred_7775 di_tg_ctrl_n.$397.Metal3 VDD.$412.Metal2 0.00014259f
Cred_7776 di_tg_ctrl_n.$397.Metal3 VDD.$420.Metal2 0.000218627f
Cred_7777 di_tg_ctrl_n.$397.Metal3 VDD.$676.Metal3 0.0140991f
Cred_7778 di_tg_ctrl_n.$397.Metal3 VDD.$680.Metal3 0.0410696f
Cred_7779 di_tg_ctrl_n.$397.Metal3 VDD.$684.Metal3 0.0127447f
Cred_7780 di_tg_ctrl_n.$397.Metal3 VDD.$71.Metal1 0.000344152f
Cred_7781 di_tg_ctrl_n.$397.Metal3 VDD.$77.Metal1 1.37904e-05f
Cred_7782 di_tg_ctrl_n.$397.Metal3 VDD.$81.Metal1 0.00104751f
Cred_7783 di_tg_ctrl_n.$397.Metal3 VDD.$85.Metal1 0.000636797f
Cred_7784 di_tg_ctrl_n.$399.Metal3 v_a.$1408.Metal2 9.05432e-06f
Cred_7785 di_tg_ctrl_n.$399.Metal3 v_a.$1410.Metal2 0.00421681f
Cred_7786 di_tg_ctrl_n.$399.Metal3 v_a.$1466.Metal2 7.97689e-07f
Cred_7787 di_tg_ctrl_n.$399.Metal3 v_a.$1468.Metal2 0.000373604f
Cred_7788 di_tg_ctrl_n.$399.Metal3 v_a.$2317.Metal3 7.28732e-05f
Cred_7789 di_tg_ctrl_n.$399.Metal3 v_a.$2321.Metal3 0.0541243f
Cred_7790 di_tg_ctrl_n.$399.Metal3 v_a.$2351.Metal3 0.00495333f
Cred_7791 di_tg_ctrl_n.$399.Metal3 v_a.$305.Metal1 0.000707135f
Cred_7792 di_tg_ctrl_n.$399.Metal3 v_a.$368.Metal1 6.22988e-05f
Cred_7793 di_tg_ctrl_n.$399.Metal3 v_a.P10.pSD 2.88185e-05f
Cred_7794 di_tg_ctrl_n.$399.Metal3 v_a.P8.pSD 0.000354754f
Cred_7795 di_tg_ctrl_n.$399.Metal3 v_b.$2421.Metal2 0.000955434f
Cred_7796 di_tg_ctrl_n.$399.Metal3 v_b.$2481.Metal2 0.00247959f
Cred_7797 di_tg_ctrl_n.$399.Metal3 v_b.P10.pSD 0.00496471f
Cred_7798 di_tg_ctrl_n.$399.Metal3 v_b.P7.nSD 1.05724e-05f
Cred_7799 di_tg_ctrl_n.$399.Metal3 v_b.P7.pSD 0.00551033f
Cred_7800 di_tg_ctrl_n.$399.Metal3 VDD.$420.Metal2 0.00011956f
Cred_7801 di_tg_ctrl_n.$399.Metal3 VDD.$428.Metal2 0.000237139f
Cred_7802 di_tg_ctrl_n.$399.Metal3 VDD.$432.Metal2 1.20593e-06f
Cred_7803 di_tg_ctrl_n.$399.Metal3 VDD.$436.Metal2 1.40662e-05f
Cred_7804 di_tg_ctrl_n.$399.Metal3 VDD.$440.Metal2 7.005e-06f
Cred_7805 di_tg_ctrl_n.$399.Metal3 VDD.$680.Metal3 0.00464886f
Cred_7806 di_tg_ctrl_n.$399.Metal3 VDD.$684.Metal3 0.0378399f
Cred_7807 di_tg_ctrl_n.$399.Metal3 VDD.$688.Metal3 0.0239525f
Cred_7808 di_tg_ctrl_n.$399.Metal3 VDD.$694.Metal3 0.000873683f
Cred_7809 di_tg_ctrl_n.$399.Metal3 VDD.$85.Metal1 0.000636971f
Cred_7810 di_tg_ctrl_n.$399.Metal3 VDD.$89.Metal1 0.00176326f
Cred_7811 di_tg_ctrl_n.$399.Metal3 VDD.$99.Metal1 0.00022115f
Cred_7812 di_tg_ctrl_n.$399.Metal3 VDD.P0.nSD 1.12604e-06f
Cred_7813 di_tg_ctrl_n.$402.Metal3 v_a.$1408.Metal2 1.04313e-06f
Cred_7814 di_tg_ctrl_n.$402.Metal3 v_a.$1410.Metal2 0.00048856f
Cred_7815 di_tg_ctrl_n.$402.Metal3 v_a.$1466.Metal2 9.3855e-06f
Cred_7816 di_tg_ctrl_n.$402.Metal3 v_a.$1468.Metal2 0.00436888f
Cred_7817 di_tg_ctrl_n.$402.Metal3 v_a.$2321.Metal3 0.00647745f
Cred_7818 di_tg_ctrl_n.$402.Metal3 v_a.$2347.Metal3 8.01423e-05f
Cred_7819 di_tg_ctrl_n.$402.Metal3 v_a.$2351.Metal3 0.0559154f
Cred_7820 di_tg_ctrl_n.$402.Metal3 v_a.$305.Metal1 8.14679e-05f
Cred_7821 di_tg_ctrl_n.$402.Metal3 v_a.$368.Metal1 0.000733f
Cred_7822 di_tg_ctrl_n.$402.Metal3 v_a.P10.pSD 0.000371527f
Cred_7823 di_tg_ctrl_n.$402.Metal3 v_a.P8.pSD 3.76858e-05f
Cred_7824 di_tg_ctrl_n.$402.Metal3 v_b.$2481.Metal2 0.00274383f
Cred_7825 di_tg_ctrl_n.$402.Metal3 v_b.$2541.Metal2 0.000978634f
Cred_7826 di_tg_ctrl_n.$402.Metal3 v_b.P10.pSD 0.00534359f
Cred_7827 di_tg_ctrl_n.$402.Metal3 v_b.P11.nSD 1.08291e-05f
Cred_7828 di_tg_ctrl_n.$402.Metal3 v_b.P11.pSD 0.00573741f
Cred_7829 di_tg_ctrl_n.$402.Metal3 VDD.$107.Metal1 0.001178f
Cred_7830 di_tg_ctrl_n.$402.Metal3 VDD.$428.Metal2 2.6127e-05f
Cred_7831 di_tg_ctrl_n.$402.Metal3 VDD.$432.Metal2 5.97264e-07f
Cred_7832 di_tg_ctrl_n.$402.Metal3 VDD.$436.Metal2 0.000336923f
Cred_7833 di_tg_ctrl_n.$402.Metal3 VDD.$440.Metal2 0.000228508f
Cred_7834 di_tg_ctrl_n.$402.Metal3 VDD.$684.Metal3 0.00309364f
Cred_7835 di_tg_ctrl_n.$402.Metal3 VDD.$688.Metal3 0.040897f
Cred_7836 di_tg_ctrl_n.$402.Metal3 VDD.$694.Metal3 0.0236716f
Cred_7837 di_tg_ctrl_n.$402.Metal3 VDD.$89.Metal1 0.000219852f
Cred_7838 di_tg_ctrl_n.$402.Metal3 VDD.$99.Metal1 0.0006632f
Cred_7839 di_tg_ctrl_n.$402.Metal3 VDD.P0.nSD 1.47502e-06f
Cred_7840 di_tg_ctrl_n.$404.Metal3 v_a.$1524.Metal2 9.23402e-06f
Cred_7841 di_tg_ctrl_n.$404.Metal3 v_a.$1526.Metal2 0.00429976f
Cred_7842 di_tg_ctrl_n.$404.Metal3 v_a.$1574.Metal2 3.22697e-06f
Cred_7843 di_tg_ctrl_n.$404.Metal3 v_a.$1576.Metal2 0.000710549f
Cred_7844 di_tg_ctrl_n.$404.Metal3 v_a.$2377.Metal3 7.36274e-05f
Cred_7845 di_tg_ctrl_n.$404.Metal3 v_a.$2381.Metal3 0.055134f
Cred_7846 di_tg_ctrl_n.$404.Metal3 v_a.$2407.Metal3 0.00475342f
Cred_7847 di_tg_ctrl_n.$404.Metal3 v_a.$431.Metal1 0.00072117f
Cred_7848 di_tg_ctrl_n.$404.Metal3 v_a.$489.Metal1 0.000173266f
Cred_7849 di_tg_ctrl_n.$404.Metal3 v_a.P12.pSD 0.000361261f
Cred_7850 di_tg_ctrl_n.$404.Metal3 v_a.P14.pSD 0.000195227f
Cred_7851 di_tg_ctrl_n.$404.Metal3 v_b.$2481.Metal2 0.000978634f
Cred_7852 di_tg_ctrl_n.$404.Metal3 v_b.$2541.Metal2 0.00260647f
Cred_7853 di_tg_ctrl_n.$404.Metal3 v_b.P11.nSD 1.08291e-05f
Cred_7854 di_tg_ctrl_n.$404.Metal3 v_b.P11.pSD 0.00573741f
Cred_7855 di_tg_ctrl_n.$404.Metal3 v_b.P13.pSD 0.00512768f
Cred_7856 di_tg_ctrl_n.$404.Metal3 VDD.$107.Metal1 0.000636953f
Cred_7857 di_tg_ctrl_n.$404.Metal3 VDD.$111.Metal1 0.00128059f
Cred_7858 di_tg_ctrl_n.$404.Metal3 VDD.$436.Metal2 2.46842e-05f
Cred_7859 di_tg_ctrl_n.$404.Metal3 VDD.$440.Metal2 0.000132326f
Cred_7860 di_tg_ctrl_n.$404.Metal3 VDD.$448.Metal2 0.000237617f
Cred_7861 di_tg_ctrl_n.$404.Metal3 VDD.$456.Metal2 1.40662e-05f
Cred_7862 di_tg_ctrl_n.$404.Metal3 VDD.$460.Metal2 7.005e-06f
Cred_7863 di_tg_ctrl_n.$404.Metal3 VDD.$688.Metal3 0.00307869f
Cred_7864 di_tg_ctrl_n.$404.Metal3 VDD.$694.Metal3 0.0397446f
Cred_7865 di_tg_ctrl_n.$404.Metal3 VDD.$698.Metal3 0.0242862f
Cred_7866 di_tg_ctrl_n.$404.Metal3 VDD.$704.Metal3 0.000873683f
Cred_7867 di_tg_ctrl_n.$407.Metal3 v_a.$1524.Metal2 9.81773e-07f
Cred_7868 di_tg_ctrl_n.$407.Metal3 v_a.$1526.Metal2 0.000459821f
Cred_7869 di_tg_ctrl_n.$407.Metal3 v_a.$1574.Metal2 3.38531e-05f
Cred_7870 di_tg_ctrl_n.$407.Metal3 v_a.$1576.Metal2 0.00743028f
Cred_7871 di_tg_ctrl_n.$407.Metal3 v_a.$2381.Metal3 0.00609642f
Cred_7872 di_tg_ctrl_n.$407.Metal3 v_a.$2407.Metal3 0.0492116f
Cred_7873 di_tg_ctrl_n.$407.Metal3 v_a.$431.Metal1 7.66757e-05f
Cred_7874 di_tg_ctrl_n.$407.Metal3 v_a.$489.Metal1 0.00181768f
Cred_7875 di_tg_ctrl_n.$407.Metal3 v_a.P12.pSD 3.5469e-05f
Cred_7876 di_tg_ctrl_n.$407.Metal3 v_a.P14.pSD 0.00207954f
Cred_7877 di_tg_ctrl_n.$407.Metal3 v_b.$2541.Metal2 0.00275724f
Cred_7878 di_tg_ctrl_n.$407.Metal3 v_b.$2601.Metal2 0.000937091f
Cred_7879 di_tg_ctrl_n.$407.Metal3 v_b.P13.pSD 0.00542997f
Cred_7880 di_tg_ctrl_n.$407.Metal3 v_b.P15.nSD 1.03694e-05f
Cred_7881 di_tg_ctrl_n.$407.Metal3 v_b.P15.pSD 0.00560395f
Cred_7882 di_tg_ctrl_n.$407.Metal3 VDD.$121.Metal1 0.000572032f
Cred_7883 di_tg_ctrl_n.$407.Metal3 VDD.$129.Metal1 0.00119735f
Cred_7884 di_tg_ctrl_n.$407.Metal3 VDD.$448.Metal2 2.61292e-05f
Cred_7885 di_tg_ctrl_n.$407.Metal3 VDD.$456.Metal2 0.000336871f
Cred_7886 di_tg_ctrl_n.$407.Metal3 VDD.$460.Metal2 0.000228357f
Cred_7887 di_tg_ctrl_n.$407.Metal3 VDD.$694.Metal3 0.00325891f
Cred_7888 di_tg_ctrl_n.$407.Metal3 VDD.$698.Metal3 0.0410371f
Cred_7889 di_tg_ctrl_n.$407.Metal3 VDD.$704.Metal3 0.0236591f
Cred_7890 di_tg_ctrl_n.$407.Metal3 VDD.P0.nSD 9.50105e-07f
Cred_7891 di_tg_ctrl_n.$409.Metal3 VSS 0.000353728f
Cred_7892 di_tg_ctrl_n.$409.Metal3 v_a.$1574.Metal2 1.07771e-08f
Cred_7893 di_tg_ctrl_n.$409.Metal3 v_a.$1576.Metal2 2.37302e-06f
Cred_7894 di_tg_ctrl_n.$409.Metal3 v_a.$2387.Metal3 0.0176988f
Cred_7895 di_tg_ctrl_n.$409.Metal3 v_a.$2407.Metal3 1.5875e-05f
Cred_7896 di_tg_ctrl_n.$409.Metal3 v_a.$2447.Metal3 0.0176988f
Cred_7897 di_tg_ctrl_n.$409.Metal3 v_a.$489.Metal1 5.78656e-07f
Cred_7898 di_tg_ctrl_n.$409.Metal3 v_a.P14.pSD 6.51997e-07f
Cred_7899 di_tg_ctrl_n.$409.Metal3 v_a.P16.nSD 0.00015962f
Cred_7900 di_tg_ctrl_n.$409.Metal3 v_a.P16.pSD 0.0219102f
Cred_7901 di_tg_ctrl_n.$409.Metal3 v_b.$2541.Metal2 0.000937091f
Cred_7902 di_tg_ctrl_n.$409.Metal3 v_b.$2601.Metal2 0.00173261f
Cred_7903 di_tg_ctrl_n.$409.Metal3 v_b.P15.nSD 1.03694e-05f
Cred_7904 di_tg_ctrl_n.$409.Metal3 v_b.P15.pSD 0.00560395f
Cred_7905 di_tg_ctrl_n.$409.Metal3 v_b.P17.pSD 0.00253526f
Cred_7906 di_tg_ctrl_n.$409.Metal3 VDD.$129.Metal1 0.00125503f
Cred_7907 di_tg_ctrl_n.$409.Metal3 VDD.$134.Metal1 0.000619449f
Cred_7908 di_tg_ctrl_n.$409.Metal3 VDD.$456.Metal2 2.46842e-05f
Cred_7909 di_tg_ctrl_n.$409.Metal3 VDD.$460.Metal2 4.95664e-05f
Cred_7910 di_tg_ctrl_n.$409.Metal3 VDD.$464.Metal2 0.000241605f
Cred_7911 di_tg_ctrl_n.$409.Metal3 VDD.$472.Metal2 7.06656e-05f
Cred_7912 di_tg_ctrl_n.$409.Metal3 VDD.$698.Metal3 0.00307869f
Cred_7913 di_tg_ctrl_n.$409.Metal3 VDD.$704.Metal3 0.038352f
Cred_7914 di_tg_ctrl_n.$409.Metal3 VDD.$708.Metal3 0.0131167f
Cred_7915 di_tg_ctrl_n.$409.Metal3 VDD.P0.nSD 1.04734e-06f
Cred_7916 di_tg_ctrl_n.$413.Metal3 VSS 0.000275563f
Cred_7917 di_tg_ctrl_n.$413.Metal3 v_a.$1574.Metal2 3.59236e-09f
Cred_7918 di_tg_ctrl_n.$413.Metal3 v_a.$1576.Metal2 7.91006e-07f
Cred_7919 di_tg_ctrl_n.$413.Metal3 v_a.$1682.Metal2 0.00609324f
Cred_7920 di_tg_ctrl_n.$413.Metal3 v_a.$1756.Metal2 1.91341e-09f
Cred_7921 di_tg_ctrl_n.$413.Metal3 v_a.$1758.Metal2 8.96161e-07f
Cred_7922 di_tg_ctrl_n.$413.Metal3 v_a.$2387.Metal3 0.00294216f
Cred_7923 di_tg_ctrl_n.$413.Metal3 v_a.$2407.Metal3 5.29165e-06f
Cred_7924 di_tg_ctrl_n.$413.Metal3 v_a.$2447.Metal3 0.00294216f
Cred_7925 di_tg_ctrl_n.$413.Metal3 v_a.$2462.Metal3 0.0297866f
Cred_7926 di_tg_ctrl_n.$413.Metal3 v_a.$2501.Metal3 1.18815e-05f
Cred_7927 di_tg_ctrl_n.$413.Metal3 v_a.$489.Metal1 1.92885e-07f
Cred_7928 di_tg_ctrl_n.$413.Metal3 v_a.$611.Metal1 0.00259202f
Cred_7929 di_tg_ctrl_n.$413.Metal3 v_a.$683.Metal1 1.49436e-07f
Cred_7930 di_tg_ctrl_n.$413.Metal3 v_a.P14.pSD 2.17332e-07f
Cred_7931 di_tg_ctrl_n.$413.Metal3 v_a.P16.nSD 2.65345e-05f
Cred_7932 di_tg_ctrl_n.$413.Metal3 v_a.P16.pSD 0.00362849f
Cred_7933 di_tg_ctrl_n.$413.Metal3 v_a.P18.pSD 0.00418831f
Cred_7934 di_tg_ctrl_n.$413.Metal3 v_a.P20.pSD 6.91267e-08f
Cred_7935 di_tg_ctrl_n.$413.Metal3 v_b.$2601.Metal2 0.00245444f
Cred_7936 di_tg_ctrl_n.$413.Metal3 v_b.$2631.Metal2 1.05577e-05f
Cred_7937 di_tg_ctrl_n.$413.Metal3 v_b.P17.pSD 0.00781394f
Cred_7938 di_tg_ctrl_n.$413.Metal3 v_b.P19.pSD 2.61228e-05f
Cred_7939 di_tg_ctrl_n.$413.Metal3 VDD.$134.Metal1 8.72362e-06f
Cred_7940 di_tg_ctrl_n.$413.Metal3 VDD.$143.Metal1 0.000308215f
Cred_7941 di_tg_ctrl_n.$413.Metal3 VDD.$151.Metal1 0.000277436f
Cred_7942 di_tg_ctrl_n.$413.Metal3 VDD.$464.Metal2 1.98243e-05f
Cred_7943 di_tg_ctrl_n.$413.Metal3 VDD.$472.Metal2 0.000179645f
Cred_7944 di_tg_ctrl_n.$413.Metal3 VDD.$476.Metal2 0.000175265f
Cred_7945 di_tg_ctrl_n.$413.Metal3 VDD.$480.Metal2 6.90888e-05f
Cred_7946 di_tg_ctrl_n.$413.Metal3 VDD.$704.Metal3 0.00500116f
Cred_7947 di_tg_ctrl_n.$413.Metal3 VDD.$708.Metal3 0.0435286f
Cred_7948 di_tg_ctrl_n.$413.Metal3 VDD.$714.Metal3 0.00853236f
Cred_7949 di_tg_ctrl_n.$413.Metal3 VDD.P0.nSD 4.84711e-07f
Cred_7950 di_tg_ctrl_n.$417.Metal3 VSS 0.000194641f
Cred_7951 di_tg_ctrl_n.$417.Metal3 v_a.$1682.Metal2 0.00332993f
Cred_7952 di_tg_ctrl_n.$417.Metal3 v_a.$1756.Metal2 7.21912e-10f
Cred_7953 di_tg_ctrl_n.$417.Metal3 v_a.$1758.Metal2 3.38113e-07f
Cred_7954 di_tg_ctrl_n.$417.Metal3 v_a.$2462.Metal3 0.0162931f
Cred_7955 di_tg_ctrl_n.$417.Metal3 v_a.$2501.Metal3 4.48278e-06f
Cred_7956 di_tg_ctrl_n.$417.Metal3 v_a.$611.Metal1 0.00141622f
Cred_7957 di_tg_ctrl_n.$417.Metal3 v_a.$683.Metal1 5.63807e-08f
Cred_7958 di_tg_ctrl_n.$417.Metal3 v_a.P18.pSD 0.00227327f
Cred_7959 di_tg_ctrl_n.$417.Metal3 v_a.P20.pSD 2.60809e-08f
Cred_7960 di_tg_ctrl_n.$417.Metal3 v_b.$2631.Metal2 0.00395535f
Cred_7961 di_tg_ctrl_n.$417.Metal3 v_b.P19.pSD 0.011591f
Cred_7962 di_tg_ctrl_n.$417.Metal3 VDD.$143.Metal1 0.000277426f
Cred_7963 di_tg_ctrl_n.$417.Metal3 VDD.$151.Metal1 0.00159641f
Cred_7964 di_tg_ctrl_n.$417.Metal3 VDD.$476.Metal2 0.00011368f
Cred_7965 di_tg_ctrl_n.$417.Metal3 VDD.$480.Metal2 0.000316883f
Cred_7966 di_tg_ctrl_n.$417.Metal3 VDD.$484.Metal2 6.95552e-05f
Cred_7967 di_tg_ctrl_n.$417.Metal3 VDD.$708.Metal3 0.014103f
Cred_7968 di_tg_ctrl_n.$417.Metal3 VDD.$714.Metal3 0.026841f
Cred_7969 di_tg_ctrl_n.$417.Metal3 VDD.P0.nSD 4.70217e-07f
Cred_7970 di_tg_ctrl_n.$419.Metal3 VSS 0.000237656f
Cred_7971 di_tg_ctrl_n.$419.Metal3 v_a.$1756.Metal2 8.42495e-06f
Cred_7972 di_tg_ctrl_n.$419.Metal3 v_a.$1758.Metal2 0.00394589f
Cred_7973 di_tg_ctrl_n.$419.Metal3 v_a.$2497.Metal3 0.000242234f
Cred_7974 di_tg_ctrl_n.$419.Metal3 v_a.$2501.Metal3 0.0523156f
Cred_7975 di_tg_ctrl_n.$419.Metal3 v_a.$2527.Metal3 4.13939e-05f
Cred_7976 di_tg_ctrl_n.$419.Metal3 v_a.$683.Metal1 0.000657982f
Cred_7977 di_tg_ctrl_n.$419.Metal3 v_a.P20.pSD 0.000304372f
Cred_7978 di_tg_ctrl_n.$419.Metal3 v_b.$2631.Metal2 0.000508849f
Cred_7979 di_tg_ctrl_n.$419.Metal3 v_b.$2691.Metal2 0.000508849f
Cred_7980 di_tg_ctrl_n.$419.Metal3 v_b.P21.nSD 5.63069e-06f
Cred_7981 di_tg_ctrl_n.$419.Metal3 v_b.P21.pSD 0.00296767f
Cred_7982 di_tg_ctrl_n.$419.Metal3 VDD.$151.Metal1 0.000776701f
Cred_7983 di_tg_ctrl_n.$419.Metal3 VDD.$161.Metal1 0.000387147f
Cred_7984 di_tg_ctrl_n.$419.Metal3 VDD.$484.Metal2 4.0893e-06f
Cred_7985 di_tg_ctrl_n.$419.Metal3 VDD.$488.Metal2 7.5753e-05f
Cred_7986 di_tg_ctrl_n.$419.Metal3 VDD.$496.Metal2 5.14011e-08f
Cred_7987 di_tg_ctrl_n.$419.Metal3 VDD.$714.Metal3 0.0290233f
Cred_7988 di_tg_ctrl_n.$419.Metal3 VDD.$718.Metal3 0.0132102f
Cred_7989 di_tg_ctrl_n.$419.Metal3 VDD.$722.Metal3 6.41089e-06f
Cred_7990 di_tg_ctrl_n.$419.Metal3 VDD.P0.nSD 1.97093e-06f
Cred_7991 di_tg_ctrl_n.$42.GatPoly VSS 0.00995367f
Cred_7992 di_tg_ctrl_n.$42.GatPoly v_a.$1682.Metal2 0.00176123f
Cred_7993 di_tg_ctrl_n.$42.GatPoly v_a.$2387.Metal3 0.00365465f
Cred_7994 di_tg_ctrl_n.$42.GatPoly v_a.$2447.Metal3 0.00365465f
Cred_7995 di_tg_ctrl_n.$42.GatPoly v_a.$2462.Metal3 0.00227778f
Cred_7996 di_tg_ctrl_n.$42.GatPoly v_a.$611.Metal1 0.00203386f
Cred_7997 di_tg_ctrl_n.$42.GatPoly v_a.P16.nSD 3.29602e-05f
Cred_7998 di_tg_ctrl_n.$42.GatPoly v_a.P16.pSD 0.0168435f
Cred_7999 di_tg_ctrl_n.$42.GatPoly v_a.P18.pSD 0.00490635f
Cred_8000 di_tg_ctrl_n.$42.GatPoly v_b.$2601.Metal2 0.00721483f
Cred_8001 di_tg_ctrl_n.$42.GatPoly v_b.P17.pSD 0.0250306f
Cred_8002 di_tg_ctrl_n.$42.GatPoly VDD.$129.Metal1 0.000393586f
Cred_8003 di_tg_ctrl_n.$42.GatPoly VDD.$134.Metal1 0.00582102f
Cred_8004 di_tg_ctrl_n.$42.GatPoly VDD.$143.Metal1 0.00269799f
Cred_8005 di_tg_ctrl_n.$42.GatPoly VDD.$151.Metal1 0.000172397f
Cred_8006 di_tg_ctrl_n.$42.GatPoly VDD.$464.Metal2 1.99821e-06f
Cred_8007 di_tg_ctrl_n.$42.GatPoly VDD.$472.Metal2 1.03132e-05f
Cred_8008 di_tg_ctrl_n.$42.GatPoly VDD.$476.Metal2 1.75484e-06f
Cred_8009 di_tg_ctrl_n.$42.GatPoly VDD.$480.Metal2 4.21415e-07f
Cred_8010 di_tg_ctrl_n.$42.GatPoly VDD.P0.nSD 3.01792e-06f
Cred_8011 di_tg_ctrl_n.$423.Metal3 VSS 0.000360951f
Cred_8012 di_tg_ctrl_n.$423.Metal3 v_a.$1756.Metal2 1.29717e-06f
Cred_8013 di_tg_ctrl_n.$423.Metal3 v_a.$1758.Metal2 0.000607538f
Cred_8014 di_tg_ctrl_n.$423.Metal3 v_a.$1814.Metal2 7.49821e-06f
Cred_8015 di_tg_ctrl_n.$423.Metal3 v_a.$1816.Metal2 0.00351007f
Cred_8016 di_tg_ctrl_n.$423.Metal3 v_a.$2497.Metal3 0.000170497f
Cred_8017 di_tg_ctrl_n.$423.Metal3 v_a.$2501.Metal3 0.00805488f
Cred_8018 di_tg_ctrl_n.$423.Metal3 v_a.$2527.Metal3 0.000150871f
Cred_8019 di_tg_ctrl_n.$423.Metal3 v_a.$2531.Metal3 0.0464024f
Cred_8020 di_tg_ctrl_n.$423.Metal3 v_a.$683.Metal1 0.000101308f
Cred_8021 di_tg_ctrl_n.$423.Metal3 v_a.$746.Metal1 0.000585604f
Cred_8022 di_tg_ctrl_n.$423.Metal3 v_a.P20.pSD 4.68633e-05f
Cred_8023 di_tg_ctrl_n.$423.Metal3 v_a.P22.pSD 0.000298072f
Cred_8024 di_tg_ctrl_n.$423.Metal3 v_b.$2631.Metal2 0.00125653f
Cred_8025 di_tg_ctrl_n.$423.Metal3 v_b.$2691.Metal2 0.00254605f
Cred_8026 di_tg_ctrl_n.$423.Metal3 v_b.P21.nSD 1.39042e-05f
Cred_8027 di_tg_ctrl_n.$423.Metal3 v_b.P21.pSD 0.0080714f
Cred_8028 di_tg_ctrl_n.$423.Metal3 v_b.P23.pSD 0.00371123f
Cred_8029 di_tg_ctrl_n.$423.Metal3 VDD.$161.Metal1 1.67094e-05f
Cred_8030 di_tg_ctrl_n.$423.Metal3 VDD.$165.Metal1 2.34079e-05f
Cred_8031 di_tg_ctrl_n.$423.Metal3 VDD.$169.Metal1 0.00075757f
Cred_8032 di_tg_ctrl_n.$423.Metal3 VDD.$173.Metal1 0.000407728f
Cred_8033 di_tg_ctrl_n.$423.Metal3 VDD.$488.Metal2 0.000120066f
Cred_8034 di_tg_ctrl_n.$423.Metal3 VDD.$496.Metal2 0.00023189f
Cred_8035 di_tg_ctrl_n.$423.Metal3 VDD.$504.Metal2 1.03447e-05f
Cred_8036 di_tg_ctrl_n.$423.Metal3 VDD.$714.Metal3 0.00510533f
Cred_8037 di_tg_ctrl_n.$423.Metal3 VDD.$718.Metal3 0.0402608f
Cred_8038 di_tg_ctrl_n.$423.Metal3 VDD.$722.Metal3 0.0230929f
Cred_8039 di_tg_ctrl_n.$423.Metal3 VDD.$726.Metal3 0.00129021f
Cred_8040 di_tg_ctrl_n.$429.Metal3 VSS 8.87231e-05f
Cred_8041 di_tg_ctrl_n.$429.Metal3 v_a.$1814.Metal2 2.18437e-06f
Cred_8042 di_tg_ctrl_n.$429.Metal3 v_a.$1816.Metal2 0.00102307f
Cred_8043 di_tg_ctrl_n.$429.Metal3 v_a.$1872.Metal2 9.3859e-06f
Cred_8044 di_tg_ctrl_n.$429.Metal3 v_a.$1874.Metal2 0.00436907f
Cred_8045 di_tg_ctrl_n.$429.Metal3 v_a.$1930.Metal2 1.04313e-06f
Cred_8046 di_tg_ctrl_n.$429.Metal3 v_a.$1932.Metal2 0.00048856f
Cred_8047 di_tg_ctrl_n.$429.Metal3 v_a.$2531.Metal3 0.0135641f
Cred_8048 di_tg_ctrl_n.$429.Metal3 v_a.$2557.Metal3 8.01423e-05f
Cred_8049 di_tg_ctrl_n.$429.Metal3 v_a.$2561.Metal3 0.0559178f
Cred_8050 di_tg_ctrl_n.$429.Metal3 v_a.$2591.Metal3 0.00647745f
Cred_8051 di_tg_ctrl_n.$429.Metal3 v_a.$746.Metal1 0.000170598f
Cred_8052 di_tg_ctrl_n.$429.Metal3 v_a.$809.Metal1 0.000733031f
Cred_8053 di_tg_ctrl_n.$429.Metal3 v_a.$872.Metal1 8.14679e-05f
Cred_8054 di_tg_ctrl_n.$429.Metal3 v_a.P22.pSD 7.89158e-05f
Cred_8055 di_tg_ctrl_n.$429.Metal3 v_a.P24.pSD 0.000371541f
Cred_8056 di_tg_ctrl_n.$429.Metal3 v_a.P26.pSD 3.76858e-05f
Cred_8057 di_tg_ctrl_n.$429.Metal3 v_b.$2691.Metal2 0.00349748f
Cred_8058 di_tg_ctrl_n.$429.Metal3 v_b.$2751.Metal2 0.000869195f
Cred_8059 di_tg_ctrl_n.$429.Metal3 v_b.P23.pSD 0.00756416f
Cred_8060 di_tg_ctrl_n.$429.Metal3 v_b.P25.nSD 9.61811e-06f
Cred_8061 di_tg_ctrl_n.$429.Metal3 v_b.P25.pSD 0.00536152f
Cred_8062 di_tg_ctrl_n.$429.Metal3 VDD.$169.Metal1 0.000371755f
Cred_8063 di_tg_ctrl_n.$429.Metal3 VDD.$173.Metal1 0.00141056f
Cred_8064 di_tg_ctrl_n.$429.Metal3 VDD.$179.Metal1 0.000590755f
Cred_8065 di_tg_ctrl_n.$429.Metal3 VDD.$183.Metal1 1.62659e-08f
Cred_8066 di_tg_ctrl_n.$429.Metal3 VDD.$496.Metal2 2.47334e-05f
Cred_8067 di_tg_ctrl_n.$429.Metal3 VDD.$504.Metal2 0.000295411f
Cred_8068 di_tg_ctrl_n.$429.Metal3 VDD.$512.Metal2 8.27e-05f
Cred_8069 di_tg_ctrl_n.$429.Metal3 VDD.$718.Metal3 0.00308481f
Cred_8070 di_tg_ctrl_n.$429.Metal3 VDD.$722.Metal3 0.0305417f
Cred_8071 di_tg_ctrl_n.$429.Metal3 VDD.$726.Metal3 0.0400111f
Cred_8072 di_tg_ctrl_n.$429.Metal3 VDD.$730.Metal3 0.00866069f
Cred_8073 di_tg_ctrl_n.$429.Metal3 VDD.P0.nSD 9.81532e-07f
Cred_8074 di_tg_ctrl_n.$432.Metal3 v_a.$1872.Metal2 7.97689e-07f
Cred_8075 di_tg_ctrl_n.$432.Metal3 v_a.$1874.Metal2 0.000373604f
Cred_8076 di_tg_ctrl_n.$432.Metal3 v_a.$1930.Metal2 9.05449e-06f
Cred_8077 di_tg_ctrl_n.$432.Metal3 v_a.$1932.Metal2 0.00421689f
Cred_8078 di_tg_ctrl_n.$432.Metal3 v_a.$2561.Metal3 0.00495333f
Cred_8079 di_tg_ctrl_n.$432.Metal3 v_a.$2587.Metal3 4.12116e-05f
Cred_8080 di_tg_ctrl_n.$432.Metal3 v_a.$2591.Metal3 0.0541254f
Cred_8081 di_tg_ctrl_n.$432.Metal3 v_a.$809.Metal1 6.22988e-05f
Cred_8082 di_tg_ctrl_n.$432.Metal3 v_a.$872.Metal1 0.000707149f
Cred_8083 di_tg_ctrl_n.$432.Metal3 v_a.P24.pSD 2.88185e-05f
Cred_8084 di_tg_ctrl_n.$432.Metal3 v_a.P26.pSD 0.00035476f
Cred_8085 di_tg_ctrl_n.$432.Metal3 v_b.$2691.Metal2 0.000750454f
Cred_8086 di_tg_ctrl_n.$432.Metal3 v_b.$2751.Metal2 0.00269124f
Cred_8087 di_tg_ctrl_n.$432.Metal3 v_b.P25.nSD 8.30417e-06f
Cred_8088 di_tg_ctrl_n.$432.Metal3 v_b.P25.pSD 0.00498003f
Cred_8089 di_tg_ctrl_n.$432.Metal3 v_b.P27.pSD 0.00549133f
Cred_8090 di_tg_ctrl_n.$432.Metal3 VDD 3.21404e-07f
Cred_8091 di_tg_ctrl_n.$432.Metal3 VDD.$189.Metal1 0.00129984f
Cred_8092 di_tg_ctrl_n.$432.Metal3 VDD.$193.Metal1 0.000636797f
Cred_8093 di_tg_ctrl_n.$432.Metal3 VDD.$512.Metal2 0.000147581f
Cred_8094 di_tg_ctrl_n.$432.Metal3 VDD.$520.Metal2 0.000223266f
Cred_8095 di_tg_ctrl_n.$432.Metal3 VDD.$726.Metal3 0.014794f
Cred_8096 di_tg_ctrl_n.$432.Metal3 VDD.$730.Metal3 0.0417108f
Cred_8097 di_tg_ctrl_n.$432.Metal3 VDD.$734.Metal3 0.0128802f
Cred_8098 di_tg_ctrl_n.$434.Metal3 v_a.$1990.Metal2 0.00433006f
Cred_8099 di_tg_ctrl_n.$434.Metal3 v_a.$2046.Metal2 1.1045e-06f
Cred_8100 di_tg_ctrl_n.$434.Metal3 v_a.$2048.Metal2 0.000517299f
Cred_8101 di_tg_ctrl_n.$434.Metal3 v_a.$2617.Metal3 8.37315e-05f
Cred_8102 di_tg_ctrl_n.$434.Metal3 v_a.$2621.Metal3 0.0560537f
Cred_8103 di_tg_ctrl_n.$434.Metal3 v_a.$2651.Metal3 0.00685848f
Cred_8104 di_tg_ctrl_n.$434.Metal3 v_a.$936.Metal1 0.000850764f
Cred_8105 di_tg_ctrl_n.$434.Metal3 v_a.$998.Metal1 8.62602e-05f
Cred_8106 di_tg_ctrl_n.$434.Metal3 v_a.P28.pSD 0.000335312f
Cred_8107 di_tg_ctrl_n.$434.Metal3 v_a.P30.pSD 3.99027e-05f
Cred_8108 di_tg_ctrl_n.$434.Metal3 v_b.$2751.Metal2 0.0028169f
Cred_8109 di_tg_ctrl_n.$434.Metal3 v_b.$2811.Metal2 0.000876112f
Cred_8110 di_tg_ctrl_n.$434.Metal3 v_b.P27.pSD 0.00549133f
Cred_8111 di_tg_ctrl_n.$434.Metal3 v_b.P29.nSD 9.69464e-06f
Cred_8112 di_tg_ctrl_n.$434.Metal3 v_b.P29.pSD 0.00538374f
Cred_8113 di_tg_ctrl_n.$434.Metal3 VDD.$193.Metal1 0.000636834f
Cred_8114 di_tg_ctrl_n.$434.Metal3 VDD.$197.Metal1 0.00105457f
Cred_8115 di_tg_ctrl_n.$434.Metal3 VDD.$203.Metal1 6.65414e-06f
Cred_8116 di_tg_ctrl_n.$434.Metal3 VDD.$207.Metal1 0.000344152f
Cred_8117 di_tg_ctrl_n.$434.Metal3 VDD.$520.Metal2 0.000117332f
Cred_8118 di_tg_ctrl_n.$434.Metal3 VDD.$528.Metal2 0.000235245f
Cred_8119 di_tg_ctrl_n.$434.Metal3 VDD.$536.Metal2 1.05776e-05f
Cred_8120 di_tg_ctrl_n.$434.Metal3 VDD.$730.Metal3 0.00478437f
Cred_8121 di_tg_ctrl_n.$434.Metal3 VDD.$734.Metal3 0.0392727f
Cred_8122 di_tg_ctrl_n.$434.Metal3 VDD.$738.Metal3 0.0238528f
Cred_8123 di_tg_ctrl_n.$434.Metal3 VDD.$742.Metal3 0.00131927f
Cred_8124 di_tg_ctrl_n.$434.Metal3 VDD.P0.nSD 1.12699e-08f
Cred_8125 di_tg_ctrl_n.$437.Metal3 v_a.$1062.Metal1 0.000778384f
Cred_8126 di_tg_ctrl_n.$437.Metal3 v_a.$1990.Metal2 0.00034096f
Cred_8127 di_tg_ctrl_n.$437.Metal3 v_a.$2046.Metal2 8.95063e-06f
Cred_8128 di_tg_ctrl_n.$437.Metal3 v_a.$2048.Metal2 0.00416947f
Cred_8129 di_tg_ctrl_n.$437.Metal3 v_a.$2106.Metal2 0.00398627f
Cred_8130 di_tg_ctrl_n.$437.Metal3 v_a.$2621.Metal3 0.00457164f
Cred_8131 di_tg_ctrl_n.$437.Metal3 v_a.$2647.Metal3 4.12179e-05f
Cred_8132 di_tg_ctrl_n.$437.Metal3 v_a.$2651.Metal3 0.0535867f
Cred_8133 di_tg_ctrl_n.$437.Metal3 v_a.$2657.Metal3 0.0243906f
Cred_8134 di_tg_ctrl_n.$437.Metal3 v_a.$2677.Metal3 9.84663e-05f
Cred_8135 di_tg_ctrl_n.$437.Metal3 v_a.$2681.Metal3 0.0534484f
Cred_8136 di_tg_ctrl_n.$437.Metal3 v_a.$936.Metal1 6.65781e-05f
Cred_8137 di_tg_ctrl_n.$437.Metal3 v_a.$998.Metal1 0.000699036f
Cred_8138 di_tg_ctrl_n.$437.Metal3 v_a.P28.pSD 2.28336e-05f
Cred_8139 di_tg_ctrl_n.$437.Metal3 v_a.P30.pSD 0.000350992f
Cred_8140 di_tg_ctrl_n.$437.Metal3 v_a.P32.pSD 0.000317305f
Cred_8141 di_tg_ctrl_n.$437.Metal3 v_a.P34.nSD 0.000160384f
Cred_8142 di_tg_ctrl_n.$437.Metal3 v_a.P34.pSD 0.0191436f
Cred_8143 di_tg_ctrl_n.$437.Metal3 v_b.$2751.Metal2 0.000716236f
Cred_8144 di_tg_ctrl_n.$437.Metal3 v_b.$2811.Metal2 0.00611266f
Cred_8145 di_tg_ctrl_n.$437.Metal3 v_b.$2871.Metal2 0.00176808f
Cred_8146 di_tg_ctrl_n.$437.Metal3 v_b.P29.nSD 7.92553e-06f
Cred_8147 di_tg_ctrl_n.$437.Metal3 v_b.P29.pSD 0.00487009f
Cred_8148 di_tg_ctrl_n.$437.Metal3 v_b.P31.pSD 0.0100196f
Cred_8149 di_tg_ctrl_n.$437.Metal3 v_b.P33.nSD 1.95647e-05f
Cred_8150 di_tg_ctrl_n.$437.Metal3 v_b.P33.pSD 0.0105335f
Cred_8151 di_tg_ctrl_n.$437.Metal3 VDD.$207.Metal1 0.000694873f
Cred_8152 di_tg_ctrl_n.$437.Metal3 VDD.$211.Metal1 0.00131896f
Cred_8153 di_tg_ctrl_n.$437.Metal3 VDD.$215.Metal1 0.00118503f
Cred_8154 di_tg_ctrl_n.$437.Metal3 VDD.$225.Metal1 0.000613247f
Cred_8155 di_tg_ctrl_n.$437.Metal3 VDD.$230.Metal1 0.000830475f
Cred_8156 di_tg_ctrl_n.$437.Metal3 VDD.$238.Metal1 1.06404e-05f
Cred_8157 di_tg_ctrl_n.$437.Metal3 VDD.$528.Metal2 2.68128e-05f
Cred_8158 di_tg_ctrl_n.$437.Metal3 VDD.$536.Metal2 0.000299863f
Cred_8159 di_tg_ctrl_n.$437.Metal3 VDD.$544.Metal2 0.000332578f
Cred_8160 di_tg_ctrl_n.$437.Metal3 VDD.$548.Metal2 0.000893144f
Cred_8161 di_tg_ctrl_n.$437.Metal3 VDD.$552.Metal2 0.00167145f
Cred_8162 di_tg_ctrl_n.$437.Metal3 VDD.$560.Metal2 0.000415701f
Cred_8163 di_tg_ctrl_n.$437.Metal3 VDD.$734.Metal3 0.00334417f
Cred_8164 di_tg_ctrl_n.$437.Metal3 VDD.$738.Metal3 0.0311969f
Cred_8165 di_tg_ctrl_n.$437.Metal3 VDD.$742.Metal3 0.0758204f
Cred_8166 di_tg_ctrl_n.$437.Metal3 VDD.$750.Metal3 0.0544061f
Cred_8167 di_tg_ctrl_n.$437.Metal3 VDD.P0.nSD 9.22136e-07f
Cred_8168 di_tg_ctrl_n.$443.Metal3 VSS 0.00659804f
Cred_8169 di_tg_ctrl_n.$443.Metal3 v_b.$2871.Metal2 6.70308e-06f
Cred_8170 di_tg_ctrl_n.$443.Metal3 v_b.$2962.Metal2 0.00817972f
Cred_8171 di_tg_ctrl_n.$443.Metal3 v_b.$3053.Metal2 1.8031e-06f
Cred_8172 di_tg_ctrl_n.$443.Metal3 v_b.$3056.Metal2 0.000135957f
Cred_8173 di_tg_ctrl_n.$443.Metal3 v_b.$3779.Metal3 0.0486981f
Cred_8174 di_tg_ctrl_n.$443.Metal3 v_b.$3785.Metal3 0.0311066f
Cred_8175 di_tg_ctrl_n.$443.Metal3 v_b.P37.nSD 0.00526192f
Cred_8176 di_tg_ctrl_n.$443.Metal3 v_b.P37.pSD 0.000122866f
Cred_8177 di_tg_ctrl_n.$443.Metal3 v_b.P39.nSD 0.00472058f
Cred_8178 di_tg_ctrl_n.$443.Metal3 v_b.P41.nSD 0.00223071f
Cred_8179 di_tg_ctrl_n.$443.Metal3 v_b.P43.nSD 5.7548e-05f
Cred_8180 di_tg_ctrl_n.$443.Metal3 VSS.$17.Metal1 2.56287e-10f
Cred_8181 di_tg_ctrl_n.$443.Metal3 VSS.$221.Metal1 0.000915317f
Cred_8182 di_tg_ctrl_n.$443.Metal3 VSS.$231.Metal1 0.00136794f
Cred_8183 di_tg_ctrl_n.$443.Metal3 VSS.$301.Metal1 2.77986e-09f
Cred_8184 di_tg_ctrl_n.$443.Metal3 VSS.$526.Metal2 0.000217481f
Cred_8185 di_tg_ctrl_n.$443.Metal3 VSS.$534.Metal2 0.000644293f
Cred_8186 di_tg_ctrl_n.$443.Metal3 VSS.$542.Metal2 4.22519e-05f
Cred_8187 di_tg_ctrl_n.$443.Metal3 VSS.$606.Metal2 2.93724e-10f
Cred_8188 di_tg_ctrl_n.$443.Metal3 VSS.$716.Metal3 0.00937496f
Cred_8189 di_tg_ctrl_n.$443.Metal3 VSS.$724.Metal3 0.0469159f
Cred_8190 di_tg_ctrl_n.$443.Metal3 VSS.$728.Metal3 0.00538813f
Cred_8191 di_tg_ctrl_n.$443.Metal3 VSS.$760.Metal3 1.73793e-11f
Cred_8192 di_tg_ctrl_n.$443.Metal3 VSS.P0.pSD 2.66071e-06f
Cred_8193 di_tg_ctrl_n.$447.Metal3 VSS 0.0042372f
Cred_8194 di_tg_ctrl_n.$447.Metal3 v_b.$2962.Metal2 0.000152119f
Cred_8195 di_tg_ctrl_n.$447.Metal3 v_b.$3053.Metal2 7.81532e-06f
Cred_8196 di_tg_ctrl_n.$447.Metal3 v_b.$3056.Metal2 0.00750494f
Cred_8197 di_tg_ctrl_n.$447.Metal3 v_b.$3089.Metal2 2.92237e-06f
Cred_8198 di_tg_ctrl_n.$447.Metal3 v_b.$3785.Metal3 0.0358054f
Cred_8199 di_tg_ctrl_n.$447.Metal3 v_b.$3821.Metal3 0.0166115f
Cred_8200 di_tg_ctrl_n.$447.Metal3 v_b.P39.nSD 7.14942e-05f
Cred_8201 di_tg_ctrl_n.$447.Metal3 v_b.P41.nSD 0.00248846f
Cred_8202 di_tg_ctrl_n.$447.Metal3 v_b.P43.nSD 0.0037271f
Cred_8203 di_tg_ctrl_n.$447.Metal3 v_b.P45.nSD 0.00108666f
Cred_8204 di_tg_ctrl_n.$447.Metal3 VSS.$239.Metal1 0.000406754f
Cred_8205 di_tg_ctrl_n.$447.Metal3 VSS.$253.Metal1 0.000194964f
Cred_8206 di_tg_ctrl_n.$447.Metal3 VSS.$542.Metal2 5.12751e-05f
Cred_8207 di_tg_ctrl_n.$447.Metal3 VSS.$550.Metal2 5.46586e-05f
Cred_8208 di_tg_ctrl_n.$447.Metal3 VSS.$554.Metal2 2.72188e-05f
Cred_8209 di_tg_ctrl_n.$447.Metal3 VSS.$724.Metal3 0.00769569f
Cred_8210 di_tg_ctrl_n.$447.Metal3 VSS.$728.Metal3 0.0351671f
Cred_8211 di_tg_ctrl_n.$447.Metal3 VSS.$734.Metal3 0.00320725f
Cred_8212 di_tg_ctrl_n.$447.Metal3 VSS.P0.pSD 1.55341e-06f
Cred_8213 di_tg_ctrl_n.$451.Metal3 VSS 0.00286358f
Cred_8214 di_tg_ctrl_n.$451.Metal3 v_b.$3053.Metal2 1.13477e-06f
Cred_8215 di_tg_ctrl_n.$451.Metal3 v_b.$3056.Metal2 2.94087e-06f
Cred_8216 di_tg_ctrl_n.$451.Metal3 v_b.$3089.Metal2 6.0172e-06f
Cred_8217 di_tg_ctrl_n.$451.Metal3 v_b.$3153.Metal2 3.75874e-05f
Cred_8218 di_tg_ctrl_n.$451.Metal3 v_b.$3785.Metal3 0.000412997f
Cred_8219 di_tg_ctrl_n.$451.Metal3 v_b.$3821.Metal3 0.049466f
Cred_8220 di_tg_ctrl_n.$451.Metal3 v_b.$3857.Metal3 0.000893575f
Cred_8221 di_tg_ctrl_n.$451.Metal3 v_b.P41.nSD 4.40048e-07f
Cred_8222 di_tg_ctrl_n.$451.Metal3 v_b.P43.nSD 0.000790161f
Cred_8223 di_tg_ctrl_n.$451.Metal3 v_b.P45.nSD 0.00370393f
Cred_8224 di_tg_ctrl_n.$451.Metal3 v_b.P47.nSD 0.00155236f
Cred_8225 di_tg_ctrl_n.$451.Metal3 VSS.$17.Metal1 4.44484e-11f
Cred_8226 di_tg_ctrl_n.$451.Metal3 VSS.$239.Metal1 0.000904711f
Cred_8227 di_tg_ctrl_n.$451.Metal3 VSS.$253.Metal1 0.000949122f
Cred_8228 di_tg_ctrl_n.$451.Metal3 VSS.$301.Metal1 1.34479e-09f
Cred_8229 di_tg_ctrl_n.$451.Metal3 VSS.$550.Metal2 0.000143173f
Cred_8230 di_tg_ctrl_n.$451.Metal3 VSS.$554.Metal2 0.000310135f
Cred_8231 di_tg_ctrl_n.$451.Metal3 VSS.$606.Metal2 1.42093e-10f
Cred_8232 di_tg_ctrl_n.$451.Metal3 VSS.$728.Metal3 0.0156955f
Cred_8233 di_tg_ctrl_n.$451.Metal3 VSS.$734.Metal3 0.0171659f
Cred_8234 di_tg_ctrl_n.$451.Metal3 VSS.$760.Metal3 8.40746e-12f
Cred_8235 di_tg_ctrl_n.$451.Metal3 VSS.P0.pSD 5.14592e-06f
Cred_8236 di_tg_ctrl_n.$453.Metal3 VSS 0.00279689f
Cred_8237 di_tg_ctrl_n.$453.Metal3 v_b.$3053.Metal2 1.15539e-09f
Cred_8238 di_tg_ctrl_n.$453.Metal3 v_b.$3056.Metal2 2.99432e-09f
Cred_8239 di_tg_ctrl_n.$453.Metal3 v_b.$3089.Metal2 1.54051e-06f
Cred_8240 di_tg_ctrl_n.$453.Metal3 v_b.$3153.Metal2 0.00785804f
Cred_8241 di_tg_ctrl_n.$453.Metal3 v_b.$3247.Metal2 1.04822e-05f
Cred_8242 di_tg_ctrl_n.$453.Metal3 v_b.$3785.Metal3 1.2092e-05f
Cred_8243 di_tg_ctrl_n.$453.Metal3 v_b.$3821.Metal3 0.0013459f
Cred_8244 di_tg_ctrl_n.$453.Metal3 v_b.$3857.Metal3 0.0179964f
Cred_8245 di_tg_ctrl_n.$453.Metal3 v_b.$3890.Metal3 0.0155673f
Cred_8246 di_tg_ctrl_n.$453.Metal3 v_b.$3903.Metal3 4.1742e-06f
Cred_8247 di_tg_ctrl_n.$453.Metal3 v_b.P41.nSD 8.88497e-07f
Cred_8248 di_tg_ctrl_n.$453.Metal3 v_b.P45.nSD 5.05184e-06f
Cred_8249 di_tg_ctrl_n.$453.Metal3 v_b.P47.nSD 0.00306446f
Cred_8250 di_tg_ctrl_n.$453.Metal3 v_b.P49.nSD 0.0023473f
Cred_8251 di_tg_ctrl_n.$453.Metal3 v_b.P49.pSD 6.76542e-05f
Cred_8252 di_tg_ctrl_n.$453.Metal3 v_b.P51.nSD 5.3184e-06f
Cred_8253 di_tg_ctrl_n.$453.Metal3 v_b.P53.nSD 3.17601e-07f
Cred_8254 di_tg_ctrl_n.$453.Metal3 VSS.$550.Metal2 6.25493e-06f
Cred_8255 di_tg_ctrl_n.$453.Metal3 VSS.$554.Metal2 1.256e-05f
Cred_8256 di_tg_ctrl_n.$453.Metal3 VSS.$562.Metal2 4.13025e-05f
Cred_8257 di_tg_ctrl_n.$453.Metal3 VSS.$728.Metal3 0.000780132f
Cred_8258 di_tg_ctrl_n.$453.Metal3 VSS.$734.Metal3 0.0289739f
Cred_8259 di_tg_ctrl_n.$453.Metal3 VSS.$738.Metal3 0.00516082f
Cred_8260 di_tg_ctrl_n.$457.Metal3 VSS 0.00391209f
Cred_8261 di_tg_ctrl_n.$457.Metal3 v_b.$3247.Metal2 0.00778523f
Cred_8262 di_tg_ctrl_n.$457.Metal3 v_b.$3294.Metal2 1.98548e-06f
Cred_8263 di_tg_ctrl_n.$457.Metal3 v_b.$3857.Metal3 0.0154067f
Cred_8264 di_tg_ctrl_n.$457.Metal3 v_b.$3890.Metal3 0.0197071f
Cred_8265 di_tg_ctrl_n.$457.Metal3 v_b.$3903.Metal3 0.0177709f
Cred_8266 di_tg_ctrl_n.$457.Metal3 v_b.P49.nSD 0.00243923f
Cred_8267 di_tg_ctrl_n.$457.Metal3 v_b.P49.pSD 7.0304e-05f
Cred_8268 di_tg_ctrl_n.$457.Metal3 v_b.P51.nSD 0.00378681f
Cred_8269 di_tg_ctrl_n.$457.Metal3 v_b.P53.nSD 0.00122385f
Cred_8270 di_tg_ctrl_n.$457.Metal3 VSS.$261.Metal1 0.00127765f
Cred_8271 di_tg_ctrl_n.$457.Metal3 VSS.$271.Metal1 0.000352287f
Cred_8272 di_tg_ctrl_n.$457.Metal3 VSS.$562.Metal2 5.07456e-05f
Cred_8273 di_tg_ctrl_n.$457.Metal3 VSS.$570.Metal2 7.81853e-05f
Cred_8274 di_tg_ctrl_n.$457.Metal3 VSS.$578.Metal2 3.73971e-05f
Cred_8275 di_tg_ctrl_n.$457.Metal3 VSS.$734.Metal3 0.00747841f
Cred_8276 di_tg_ctrl_n.$457.Metal3 VSS.$738.Metal3 0.0341496f
Cred_8277 di_tg_ctrl_n.$457.Metal3 VSS.$746.Metal3 0.00233678f
Cred_8278 di_tg_ctrl_n.$457.Metal3 VSS.P0.pSD 1.22992e-06f
Cred_8279 di_tg_ctrl_n.$46.GatPoly VSS 0.00829178f
Cred_8280 di_tg_ctrl_n.$46.GatPoly v_a.$1682.Metal2 0.00601524f
Cred_8281 di_tg_ctrl_n.$46.GatPoly v_a.$2462.Metal3 0.00777945f
Cred_8282 di_tg_ctrl_n.$46.GatPoly v_a.$611.Metal1 0.00694636f
Cred_8283 di_tg_ctrl_n.$46.GatPoly v_a.P18.pSD 0.016757f
Cred_8284 di_tg_ctrl_n.$46.GatPoly v_b.$2601.Metal2 0.00167314f
Cred_8285 di_tg_ctrl_n.$46.GatPoly v_b.$2631.Metal2 0.00644329f
Cred_8286 di_tg_ctrl_n.$46.GatPoly v_b.P17.pSD 0.0058384f
Cred_8287 di_tg_ctrl_n.$46.GatPoly v_b.P19.pSD 0.0225177f
Cred_8288 di_tg_ctrl_n.$46.GatPoly VDD.$134.Metal1 0.000308463f
Cred_8289 di_tg_ctrl_n.$46.GatPoly VDD.$143.Metal1 0.00337571f
Cred_8290 di_tg_ctrl_n.$46.GatPoly VDD.$151.Metal1 0.00358697f
Cred_8291 di_tg_ctrl_n.$46.GatPoly VDD.$161.Metal1 0.000122011f
Cred_8292 di_tg_ctrl_n.$46.GatPoly VDD.$472.Metal2 2.37875e-06f
Cred_8293 di_tg_ctrl_n.$46.GatPoly VDD.$476.Metal2 7.65305e-06f
Cred_8294 di_tg_ctrl_n.$46.GatPoly VDD.$480.Metal2 7.97628e-06f
Cred_8295 di_tg_ctrl_n.$46.GatPoly VDD.$484.Metal2 1.70558e-06f
Cred_8296 di_tg_ctrl_n.$46.GatPoly VDD.$488.Metal2 7.57094e-07f
Cred_8297 di_tg_ctrl_n.$46.GatPoly VDD.P0.nSD 3.20965e-06f
Cred_8298 di_tg_ctrl_n.$460.Metal3 VSS 0.00525855f
Cred_8299 di_tg_ctrl_n.$460.Metal3 v_b.$3247.Metal2 2.26946e-06f
Cred_8300 di_tg_ctrl_n.$460.Metal3 v_b.$3294.Metal2 1.67472e-05f
Cred_8301 di_tg_ctrl_n.$460.Metal3 v_b.$3344.Metal2 0.00565346f
Cred_8302 di_tg_ctrl_n.$460.Metal3 v_b.$3435.Metal2 9.89561e-06f
Cred_8303 di_tg_ctrl_n.$460.Metal3 v_b.$3438.Metal2 0.00186644f
Cred_8304 di_tg_ctrl_n.$460.Metal3 v_b.$3529.Metal2 5.55364e-07f
Cred_8305 di_tg_ctrl_n.$460.Metal3 v_b.$3890.Metal3 0.000470009f
Cred_8306 di_tg_ctrl_n.$460.Metal3 v_b.$3903.Metal3 0.0490573f
Cred_8307 di_tg_ctrl_n.$460.Metal3 v_b.$3934.Metal3 0.0337603f
Cred_8308 di_tg_ctrl_n.$460.Metal3 v_b.$3970.Metal3 0.000448074f
Cred_8309 di_tg_ctrl_n.$460.Metal3 v_b.P51.nSD 0.000797632f
Cred_8310 di_tg_ctrl_n.$460.Metal3 v_b.P53.nSD 0.003561f
Cred_8311 di_tg_ctrl_n.$460.Metal3 v_b.P55.nSD 0.00378059f
Cred_8312 di_tg_ctrl_n.$460.Metal3 v_b.P57.nSD 0.00238687f
Cred_8313 di_tg_ctrl_n.$460.Metal3 v_b.P59.nSD 0.000727962f
Cred_8314 di_tg_ctrl_n.$460.Metal3 VSS.$17.Metal1 2.68143e-11f
Cred_8315 di_tg_ctrl_n.$460.Metal3 VSS.$261.Metal1 0.000454251f
Cred_8316 di_tg_ctrl_n.$460.Metal3 VSS.$271.Metal1 0.00138619f
Cred_8317 di_tg_ctrl_n.$460.Metal3 VSS.$279.Metal1 0.000171108f
Cred_8318 di_tg_ctrl_n.$460.Metal3 VSS.$293.Metal1 9.17405e-05f
Cred_8319 di_tg_ctrl_n.$460.Metal3 VSS.$301.Metal1 2.26648e-09f
Cred_8320 di_tg_ctrl_n.$460.Metal3 VSS.$570.Metal2 0.000428321f
Cred_8321 di_tg_ctrl_n.$460.Metal3 VSS.$578.Metal2 0.000470382f
Cred_8322 di_tg_ctrl_n.$460.Metal3 VSS.$586.Metal2 6.42503e-05f
Cred_8323 di_tg_ctrl_n.$460.Metal3 VSS.$590.Metal2 1.29655e-05f
Cred_8324 di_tg_ctrl_n.$460.Metal3 VSS.$606.Metal2 2.3948e-10f
Cred_8325 di_tg_ctrl_n.$460.Metal3 VSS.$738.Metal3 0.0242853f
Cred_8326 di_tg_ctrl_n.$460.Metal3 VSS.$746.Metal3 0.0387579f
Cred_8327 di_tg_ctrl_n.$460.Metal3 VSS.$752.Metal3 0.00152885f
Cred_8328 di_tg_ctrl_n.$460.Metal3 VSS.$760.Metal3 1.41697e-11f
Cred_8329 di_tg_ctrl_n.$460.Metal3 VSS.P0.pSD 2.3639e-06f
Cred_8330 di_tg_ctrl_n.$464.Metal3 VSS 0.00612955f
Cred_8331 di_tg_ctrl_n.$464.Metal3 v_b.$3294.Metal2 5.09118e-07f
Cred_8332 di_tg_ctrl_n.$464.Metal3 v_b.$3344.Metal2 0.00183053f
Cred_8333 di_tg_ctrl_n.$464.Metal3 v_b.$3435.Metal2 1.33711e-05f
Cred_8334 di_tg_ctrl_n.$464.Metal3 v_b.$3438.Metal2 0.00576225f
Cred_8335 di_tg_ctrl_n.$464.Metal3 v_b.$3529.Metal2 8.87257e-06f
Cred_8336 di_tg_ctrl_n.$464.Metal3 v_b.$3535.Metal2 0.00239635f
Cred_8337 di_tg_ctrl_n.$464.Metal3 v_b.$3565.Metal2 3.68636e-06f
Cred_8338 di_tg_ctrl_n.$464.Metal3 v_b.$3903.Metal3 0.0004323f
Cred_8339 di_tg_ctrl_n.$464.Metal3 v_b.$3934.Metal3 0.0331309f
Cred_8340 di_tg_ctrl_n.$464.Metal3 v_b.$3970.Metal3 0.0567279f
Cred_8341 di_tg_ctrl_n.$464.Metal3 v_b.$4009.Metal3 0.00364703f
Cred_8342 di_tg_ctrl_n.$464.Metal3 v_b.P55.nSD 0.000699007f
Cred_8343 di_tg_ctrl_n.$464.Metal3 v_b.P57.nSD 0.00234196f
Cred_8344 di_tg_ctrl_n.$464.Metal3 v_b.P59.nSD 0.00377378f
Cred_8345 di_tg_ctrl_n.$464.Metal3 v_b.P61.nSD 0.00408792f
Cred_8346 di_tg_ctrl_n.$464.Metal3 v_b.P63.nSD 0.00199202f
Cred_8347 di_tg_ctrl_n.$464.Metal3 v_b.P65.nSD 0.000176839f
Cred_8348 di_tg_ctrl_n.$464.Metal3 VSS.$17.Metal1 1.72957e-11f
Cred_8349 di_tg_ctrl_n.$464.Metal3 VSS.$271.Metal1 2.06639e-06f
Cred_8350 di_tg_ctrl_n.$464.Metal3 VSS.$279.Metal1 0.00100807f
Cred_8351 di_tg_ctrl_n.$464.Metal3 VSS.$293.Metal1 0.00178783f
Cred_8352 di_tg_ctrl_n.$464.Metal3 VSS.$301.Metal1 1.07953e-07f
Cred_8353 di_tg_ctrl_n.$464.Metal3 VSS.$570.Metal2 2.79936e-05f
Cred_8354 di_tg_ctrl_n.$464.Metal3 VSS.$578.Metal2 9.99099e-05f
Cred_8355 di_tg_ctrl_n.$464.Metal3 VSS.$586.Metal2 0.000208902f
Cred_8356 di_tg_ctrl_n.$464.Metal3 VSS.$590.Metal2 0.000329471f
Cred_8357 di_tg_ctrl_n.$464.Metal3 VSS.$598.Metal2 5.27135e-05f
Cred_8358 di_tg_ctrl_n.$464.Metal3 VSS.$606.Metal2 2.61212e-05f
Cred_8359 di_tg_ctrl_n.$464.Metal3 VSS.$738.Metal3 0.0017492f
Cred_8360 di_tg_ctrl_n.$464.Metal3 VSS.$746.Metal3 0.0341843f
Cred_8361 di_tg_ctrl_n.$464.Metal3 VSS.$752.Metal3 0.0376354f
Cred_8362 di_tg_ctrl_n.$464.Metal3 VSS.$760.Metal3 0.00163218f
Cred_8363 di_tg_ctrl_n.$464.Metal3 VSS.P0.pSD 6.34941e-06f
Cred_8364 di_tg_ctrl_n.$467.Metal3 VSS 0.0130431f
Cred_8365 di_tg_ctrl_n.$467.Metal3 v_b 7.20131e-06f
Cred_8366 di_tg_ctrl_n.$467.Metal3 v_b.$3529.Metal2 1.92232e-06f
Cred_8367 di_tg_ctrl_n.$467.Metal3 v_b.$3535.Metal2 0.00483247f
Cred_8368 di_tg_ctrl_n.$467.Metal3 v_b.$3565.Metal2 1.14126e-05f
Cred_8369 di_tg_ctrl_n.$467.Metal3 v_b.$3629.Metal2 0.00759029f
Cred_8370 di_tg_ctrl_n.$467.Metal3 v_b.$3970.Metal3 0.0109934f
Cred_8371 di_tg_ctrl_n.$467.Metal3 v_b.$4009.Metal3 0.0629735f
Cred_8372 di_tg_ctrl_n.$467.Metal3 v_b.$4042.Metal3 0.0458699f
Cred_8373 di_tg_ctrl_n.$467.Metal3 v_b.$4053.Metal3 0.000832001f
Cred_8374 di_tg_ctrl_n.$467.Metal3 v_b.P61.nSD 0.000719857f
Cred_8375 di_tg_ctrl_n.$467.Metal3 v_b.P63.nSD 0.00241159f
Cred_8376 di_tg_ctrl_n.$467.Metal3 v_b.P65.nSD 0.00467165f
Cred_8377 di_tg_ctrl_n.$467.Metal3 v_b.P67.nSD 0.00440923f
Cred_8378 di_tg_ctrl_n.$467.Metal3 v_b.P69.nSD 0.00502744f
Cred_8379 di_tg_ctrl_n.$467.Metal3 VSS.$17.Metal1 4.43862e-09f
Cred_8380 di_tg_ctrl_n.$467.Metal3 VSS.$279.Metal1 3.03805e-05f
Cred_8381 di_tg_ctrl_n.$467.Metal3 VSS.$293.Metal1 0.0003515f
Cred_8382 di_tg_ctrl_n.$467.Metal3 VSS.$301.Metal1 0.00214399f
Cred_8383 di_tg_ctrl_n.$467.Metal3 VSS.$586.Metal2 2.24723e-06f
Cred_8384 di_tg_ctrl_n.$467.Metal3 VSS.$590.Metal2 4.51298e-06f
Cred_8385 di_tg_ctrl_n.$467.Metal3 VSS.$598.Metal2 0.000485605f
Cred_8386 di_tg_ctrl_n.$467.Metal3 VSS.$606.Metal2 0.00107759f
Cred_8387 di_tg_ctrl_n.$467.Metal3 VSS.$746.Metal3 0.000251057f
Cred_8388 di_tg_ctrl_n.$467.Metal3 VSS.$752.Metal3 0.0363751f
Cred_8389 di_tg_ctrl_n.$467.Metal3 VSS.$760.Metal3 0.0588965f
Cred_8390 di_tg_ctrl_n.$467.Metal3 VSS.P0.pSD 9.34771e-05f
Cred_8391 di_tg_ctrl_n.$471.Metal4 VSS 0.0449867f
Cred_8392 di_tg_ctrl_n.$471.Metal4 v_a.$1514.Metal2 3.31515e-06f
Cred_8393 di_tg_ctrl_n.$471.Metal4 v_a.$1516.Metal2 6.65689e-06f
Cred_8394 di_tg_ctrl_n.$471.Metal4 v_a.$1518.Metal2 3.31515e-06f
Cred_8395 di_tg_ctrl_n.$471.Metal4 v_a.$1572.Metal2 2.91216e-05f
Cred_8396 di_tg_ctrl_n.$471.Metal4 v_a.$1574.Metal2 5.53263e-05f
Cred_8397 di_tg_ctrl_n.$471.Metal4 v_a.$1576.Metal2 0.00291099f
Cred_8398 di_tg_ctrl_n.$471.Metal4 v_a.$1682.Metal2 0.0365246f
Cred_8399 di_tg_ctrl_n.$471.Metal4 v_a.$1746.Metal2 6.92477e-05f
Cred_8400 di_tg_ctrl_n.$471.Metal4 v_a.$1748.Metal2 9.69031e-05f
Cred_8401 di_tg_ctrl_n.$471.Metal4 v_a.$1750.Metal2 5.82265e-05f
Cred_8402 di_tg_ctrl_n.$471.Metal4 v_a.$1754.Metal2 2.96292e-05f
Cred_8403 di_tg_ctrl_n.$471.Metal4 v_a.$1756.Metal2 4.16043e-05f
Cred_8404 di_tg_ctrl_n.$471.Metal4 v_a.$1758.Metal2 0.00106689f
Cred_8405 di_tg_ctrl_n.$471.Metal4 v_a.$1804.Metal2 4.9182e-05f
Cred_8406 di_tg_ctrl_n.$471.Metal4 v_a.$1806.Metal2 6.68287e-05f
Cred_8407 di_tg_ctrl_n.$471.Metal4 v_a.$1808.Metal2 3.32809e-05f
Cred_8408 di_tg_ctrl_n.$471.Metal4 v_a.$1862.Metal2 4.9182e-05f
Cred_8409 di_tg_ctrl_n.$471.Metal4 v_a.$1864.Metal2 6.68287e-05f
Cred_8410 di_tg_ctrl_n.$471.Metal4 v_a.$1866.Metal2 3.32809e-05f
Cred_8411 di_tg_ctrl_n.$471.Metal4 v_a.$1920.Metal2 4.9182e-05f
Cred_8412 di_tg_ctrl_n.$471.Metal4 v_a.$1922.Metal2 6.68287e-05f
Cred_8413 di_tg_ctrl_n.$471.Metal4 v_a.$1924.Metal2 3.32809e-05f
Cred_8414 di_tg_ctrl_n.$471.Metal4 v_a.$1978.Metal2 4.9182e-05f
Cred_8415 di_tg_ctrl_n.$471.Metal4 v_a.$1980.Metal2 6.68287e-05f
Cred_8416 di_tg_ctrl_n.$471.Metal4 v_a.$1982.Metal2 3.32809e-05f
Cred_8417 di_tg_ctrl_n.$471.Metal4 v_a.$2036.Metal2 3.19907e-05f
Cred_8418 di_tg_ctrl_n.$471.Metal4 v_a.$2038.Metal2 4.61864e-05f
Cred_8419 di_tg_ctrl_n.$471.Metal4 v_a.$2040.Metal2 2.3001e-05f
Cred_8420 di_tg_ctrl_n.$471.Metal4 v_a.$2094.Metal2 3.2921e-05f
Cred_8421 di_tg_ctrl_n.$471.Metal4 v_a.$2096.Metal2 4.47331e-05f
Cred_8422 di_tg_ctrl_n.$471.Metal4 v_a.$2098.Metal2 2.22772e-05f
Cred_8423 di_tg_ctrl_n.$471.Metal4 v_a.$2373.Metal3 0.000413475f
Cred_8424 di_tg_ctrl_n.$471.Metal4 v_a.$2377.Metal3 0.000413475f
Cred_8425 di_tg_ctrl_n.$471.Metal4 v_a.$2387.Metal3 0.0805167f
Cred_8426 di_tg_ctrl_n.$471.Metal4 v_a.$2403.Metal3 0.00363213f
Cred_8427 di_tg_ctrl_n.$471.Metal4 v_a.$2407.Metal3 0.032008f
Cred_8428 di_tg_ctrl_n.$471.Metal4 v_a.$2447.Metal3 0.0805167f
Cred_8429 di_tg_ctrl_n.$471.Metal4 v_a.$2458.Metal3 0.0222366f
Cred_8430 di_tg_ctrl_n.$471.Metal4 v_a.$2462.Metal3 0.23349f
Cred_8431 di_tg_ctrl_n.$471.Metal4 v_a.$2488.Metal3 0.0118315f
Cred_8432 di_tg_ctrl_n.$471.Metal4 v_a.$2493.Metal3 0.00863677f
Cred_8433 di_tg_ctrl_n.$471.Metal4 v_a.$2497.Metal3 0.0134541f
Cred_8434 di_tg_ctrl_n.$471.Metal4 v_a.$2501.Metal3 0.0365404f
Cred_8435 di_tg_ctrl_n.$471.Metal4 v_a.$2518.Metal3 0.0118315f
Cred_8436 di_tg_ctrl_n.$471.Metal4 v_a.$2523.Metal3 0.00613412f
Cred_8437 di_tg_ctrl_n.$471.Metal4 v_a.$2527.Metal3 0.00415089f
Cred_8438 di_tg_ctrl_n.$471.Metal4 v_a.$2531.Metal3 0.011584f
Cred_8439 di_tg_ctrl_n.$471.Metal4 v_a.$2548.Metal3 0.0118315f
Cred_8440 di_tg_ctrl_n.$471.Metal4 v_a.$2553.Metal3 0.00613412f
Cred_8441 di_tg_ctrl_n.$471.Metal4 v_a.$2557.Metal3 0.00415089f
Cred_8442 di_tg_ctrl_n.$471.Metal4 v_a.$2561.Metal3 0.011584f
Cred_8443 di_tg_ctrl_n.$471.Metal4 v_a.$2578.Metal3 0.0118315f
Cred_8444 di_tg_ctrl_n.$471.Metal4 v_a.$2583.Metal3 0.00613412f
Cred_8445 di_tg_ctrl_n.$471.Metal4 v_a.$2587.Metal3 0.00415089f
Cred_8446 di_tg_ctrl_n.$471.Metal4 v_a.$2591.Metal3 0.011584f
Cred_8447 di_tg_ctrl_n.$471.Metal4 v_a.$2608.Metal3 0.0118315f
Cred_8448 di_tg_ctrl_n.$471.Metal4 v_a.$2613.Metal3 0.00613412f
Cred_8449 di_tg_ctrl_n.$471.Metal4 v_a.$2617.Metal3 0.00415089f
Cred_8450 di_tg_ctrl_n.$471.Metal4 v_a.$2621.Metal3 0.011584f
Cred_8451 di_tg_ctrl_n.$471.Metal4 v_a.$2638.Metal3 0.00950305f
Cred_8452 di_tg_ctrl_n.$471.Metal4 v_a.$2643.Metal3 0.00398998f
Cred_8453 di_tg_ctrl_n.$471.Metal4 v_a.$2647.Metal3 0.00286875f
Cred_8454 di_tg_ctrl_n.$471.Metal4 v_a.$2651.Metal3 0.00775396f
Cred_8455 di_tg_ctrl_n.$471.Metal4 v_a.$2657.Metal3 0.0147183f
Cred_8456 di_tg_ctrl_n.$471.Metal4 v_a.$2668.Metal3 0.00791963f
Cred_8457 di_tg_ctrl_n.$471.Metal4 v_a.$2673.Metal3 0.004106f
Cred_8458 di_tg_ctrl_n.$471.Metal4 v_a.$2677.Metal3 0.00277848f
Cred_8459 di_tg_ctrl_n.$471.Metal4 v_a.$2681.Metal3 0.00775396f
Cred_8460 di_tg_ctrl_n.$471.Metal4 v_a.$489.Metal1 0.000669963f
Cred_8461 di_tg_ctrl_n.$471.Metal4 v_a.$611.Metal1 0.0144749f
Cred_8462 di_tg_ctrl_n.$471.Metal4 v_a.$683.Metal1 0.000165964f
Cred_8463 di_tg_ctrl_n.$471.Metal4 v_a.P14.pSD 0.000743033f
Cred_8464 di_tg_ctrl_n.$471.Metal4 v_a.P16.nSD 0.000726156f
Cred_8465 di_tg_ctrl_n.$471.Metal4 v_a.P16.pSD 0.0837449f
Cred_8466 di_tg_ctrl_n.$471.Metal4 v_a.P18.pSD 0.0221808f
Cred_8467 di_tg_ctrl_n.$471.Metal4 v_a.P20.pSD 7.61874e-05f
Cred_8468 di_tg_ctrl_n.$471.Metal4 v_a.P34.nSD 9.67829e-05f
Cred_8469 di_tg_ctrl_n.$471.Metal4 v_a.P34.pSD 0.00743431f
Cred_8470 di_tg_ctrl_n.$471.Metal4 v_b.$1992.Metal1 2.56784e-08f
Cred_8471 di_tg_ctrl_n.$471.Metal4 v_b.$2541.Metal2 0.00151463f
Cred_8472 di_tg_ctrl_n.$471.Metal4 v_b.$2601.Metal2 0.0294119f
Cred_8473 di_tg_ctrl_n.$471.Metal4 v_b.$2631.Metal2 0.00963998f
Cred_8474 di_tg_ctrl_n.$471.Metal4 v_b.$2691.Metal2 0.00792097f
Cred_8475 di_tg_ctrl_n.$471.Metal4 v_b.$2751.Metal2 0.00780784f
Cred_8476 di_tg_ctrl_n.$471.Metal4 v_b.$2811.Metal2 0.00587586f
Cred_8477 di_tg_ctrl_n.$471.Metal4 v_b.$2871.Metal2 0.00439332f
Cred_8478 di_tg_ctrl_n.$471.Metal4 v_b.$2962.Metal2 0.00249142f
Cred_8479 di_tg_ctrl_n.$471.Metal4 v_b.$3053.Metal2 8.81284e-07f
Cred_8480 di_tg_ctrl_n.$471.Metal4 v_b.$3056.Metal2 0.00278508f
Cred_8481 di_tg_ctrl_n.$471.Metal4 v_b.$3089.Metal2 1.84539e-06f
Cred_8482 di_tg_ctrl_n.$471.Metal4 v_b.$3153.Metal2 0.00472346f
Cred_8483 di_tg_ctrl_n.$471.Metal4 v_b.$3247.Metal2 0.00148678f
Cred_8484 di_tg_ctrl_n.$471.Metal4 v_b.$3344.Metal2 0.000239837f
Cred_8485 di_tg_ctrl_n.$471.Metal4 v_b.$3435.Metal2 5.66503e-06f
Cred_8486 di_tg_ctrl_n.$471.Metal4 v_b.$3438.Metal2 0.000165271f
Cred_8487 di_tg_ctrl_n.$471.Metal4 v_b.$3487.Metal2 2.21069e-06f
Cred_8488 di_tg_ctrl_n.$471.Metal4 v_b.$3529.Metal2 3.54075e-06f
Cred_8489 di_tg_ctrl_n.$471.Metal4 v_b.$3779.Metal3 0.0131136f
Cred_8490 di_tg_ctrl_n.$471.Metal4 v_b.$3785.Metal3 0.00169048f
Cred_8491 di_tg_ctrl_n.$471.Metal4 v_b.$3821.Metal3 0.0378797f
Cred_8492 di_tg_ctrl_n.$471.Metal4 v_b.$3857.Metal3 0.0262264f
Cred_8493 di_tg_ctrl_n.$471.Metal4 v_b.$3890.Metal3 0.0245054f
Cred_8494 di_tg_ctrl_n.$471.Metal4 v_b.$3903.Metal3 0.00806336f
Cred_8495 di_tg_ctrl_n.$471.Metal4 v_b.$3934.Metal3 0.00440924f
Cred_8496 di_tg_ctrl_n.$471.Metal4 v_b.$3970.Metal3 0.00296191f
Cred_8497 di_tg_ctrl_n.$471.Metal4 v_b.$3980.Metal3 9.39143e-05f
Cred_8498 di_tg_ctrl_n.$471.Metal4 v_b.P10.pSD 0.00285705f
Cred_8499 di_tg_ctrl_n.$471.Metal4 v_b.P11.pSD 0.00343325f
Cred_8500 di_tg_ctrl_n.$471.Metal4 v_b.P13.pSD 0.00398193f
Cred_8501 di_tg_ctrl_n.$471.Metal4 v_b.P15.nSD 1.67602e-05f
Cred_8502 di_tg_ctrl_n.$471.Metal4 v_b.P15.pSD 0.0101801f
Cred_8503 di_tg_ctrl_n.$471.Metal4 v_b.P17.pSD 0.0916649f
Cred_8504 di_tg_ctrl_n.$471.Metal4 v_b.P19.pSD 0.0258916f
Cred_8505 di_tg_ctrl_n.$471.Metal4 v_b.P21.nSD 2.20206e-05f
Cred_8506 di_tg_ctrl_n.$471.Metal4 v_b.P21.pSD 0.0137798f
Cred_8507 di_tg_ctrl_n.$471.Metal4 v_b.P23.pSD 0.0128538f
Cred_8508 di_tg_ctrl_n.$471.Metal4 v_b.P25.nSD 2.15286e-05f
Cred_8509 di_tg_ctrl_n.$471.Metal4 v_b.P25.pSD 0.0125087f
Cred_8510 di_tg_ctrl_n.$471.Metal4 v_b.P27.pSD 0.0119892f
Cred_8511 di_tg_ctrl_n.$471.Metal4 v_b.P29.nSD 2.13574e-05f
Cred_8512 di_tg_ctrl_n.$471.Metal4 v_b.P29.pSD 0.0112434f
Cred_8513 di_tg_ctrl_n.$471.Metal4 v_b.P31.pSD 0.00738265f
Cred_8514 di_tg_ctrl_n.$471.Metal4 v_b.P33.nSD 1.46807e-05f
Cred_8515 di_tg_ctrl_n.$471.Metal4 v_b.P33.pSD 0.00714871f
Cred_8516 di_tg_ctrl_n.$471.Metal4 v_b.P35.pSD 0.00612254f
Cred_8517 di_tg_ctrl_n.$471.Metal4 v_b.P37.nSD 1.56783e-05f
Cred_8518 di_tg_ctrl_n.$471.Metal4 v_b.P37.pSD 0.00631575f
Cred_8519 di_tg_ctrl_n.$471.Metal4 v_b.P39.pSD 0.00445695f
Cred_8520 di_tg_ctrl_n.$471.Metal4 v_b.P41.pSD 0.000561192f
Cred_8521 di_tg_ctrl_n.$471.Metal4 v_b.P43.pSD 0.00664233f
Cred_8522 di_tg_ctrl_n.$471.Metal4 v_b.P45.pSD 0.00762165f
Cred_8523 di_tg_ctrl_n.$471.Metal4 v_b.P47.pSD 0.00739298f
Cred_8524 di_tg_ctrl_n.$471.Metal4 v_b.P49.nSD 4.01139e-05f
Cred_8525 di_tg_ctrl_n.$471.Metal4 v_b.P49.pSD 0.0122268f
Cred_8526 di_tg_ctrl_n.$471.Metal4 v_b.P5.pSD 0.00105697f
Cred_8527 di_tg_ctrl_n.$471.Metal4 v_b.P51.pSD 0.00139213f
Cred_8528 di_tg_ctrl_n.$471.Metal4 v_b.P53.pSD 0.00199557f
Cred_8529 di_tg_ctrl_n.$471.Metal4 v_b.P55.pSD 0.000659797f
Cred_8530 di_tg_ctrl_n.$471.Metal4 v_b.P57.pSD 0.000656432f
Cred_8531 di_tg_ctrl_n.$471.Metal4 v_b.P59.pSD 0.000571222f
Cred_8532 di_tg_ctrl_n.$471.Metal4 v_b.P61.pSD 7.98807e-10f
Cred_8533 di_tg_ctrl_n.$471.Metal4 v_b.P63.pSD 0.000460324f
Cred_8534 di_tg_ctrl_n.$471.Metal4 v_b.P67.pSD 0.000378666f
Cred_8535 di_tg_ctrl_n.$471.Metal4 v_b.P7.pSD 0.00233987f
Cred_8536 di_tg_ctrl_n.$471.Metal4 v_b.P71.pSD 0.000238904f
Cred_8537 di_tg_ctrl_n.$471.Metal4 VDD.$134.Metal1 1.03338e-07f
Cred_8538 di_tg_ctrl_n.$471.Metal4 VDD.$143.Metal1 2.59699e-06f
Cred_8539 di_tg_ctrl_n.$471.Metal4 VDD.$151.Metal1 2.59709e-06f
Cred_8540 di_tg_ctrl_n.$471.Metal4 VDD.$340.Metal1 7.70281e-06f
Cred_8541 di_tg_ctrl_n.$471.Metal4 VDD.$388.Metal2 2.86874e-09f
Cred_8542 di_tg_ctrl_n.$471.Metal4 VDD.$42.Metal1 1.347e-07f
Cred_8543 di_tg_ctrl_n.$471.Metal4 VDD.$464.Metal2 1.28887e-05f
Cred_8544 di_tg_ctrl_n.$471.Metal4 VDD.$472.Metal2 1.28887e-05f
Cred_8545 di_tg_ctrl_n.$471.Metal4 VDD.$476.Metal2 2.54889e-05f
Cred_8546 di_tg_ctrl_n.$471.Metal4 VDD.$480.Metal2 1.96364e-05f
Cred_8547 di_tg_ctrl_n.$471.Metal4 VDD.$666.Metal3 1.26297e-10f
Cred_8548 di_tg_ctrl_n.$471.Metal4 VDD.$704.Metal3 0.00666399f
Cred_8549 di_tg_ctrl_n.$471.Metal4 VDD.$708.Metal3 0.0115389f
Cred_8550 di_tg_ctrl_n.$471.Metal4 VDD.$714.Metal3 0.00244831f
Cred_8551 di_tg_ctrl_n.$471.Metal4 VDD.P0.nSD 0.000764771f
Cred_8552 di_tg_ctrl_n.$483.Metal4 VSS 0.0262462f
Cred_8553 di_tg_ctrl_n.$483.Metal4 v_a.$1756.Metal2 1.02822e-08f
Cred_8554 di_tg_ctrl_n.$483.Metal4 v_a.$1758.Metal2 4.81576e-06f
Cred_8555 di_tg_ctrl_n.$483.Metal4 v_a.$1814.Metal2 1.25895e-07f
Cred_8556 di_tg_ctrl_n.$483.Metal4 v_a.$1816.Metal2 5.89637e-05f
Cred_8557 di_tg_ctrl_n.$483.Metal4 v_a.$2497.Metal3 0.00448665f
Cred_8558 di_tg_ctrl_n.$483.Metal4 v_a.$2501.Metal3 6.38485e-05f
Cred_8559 di_tg_ctrl_n.$483.Metal4 v_a.$2527.Metal3 0.0214124f
Cred_8560 di_tg_ctrl_n.$483.Metal4 v_a.$2531.Metal3 0.000781755f
Cred_8561 di_tg_ctrl_n.$483.Metal4 v_a.$683.Metal1 8.03033e-07f
Cred_8562 di_tg_ctrl_n.$483.Metal4 v_a.$746.Metal1 9.83227e-06f
Cred_8563 di_tg_ctrl_n.$483.Metal4 v_a.P20.pSD 3.71471e-07f
Cred_8564 di_tg_ctrl_n.$483.Metal4 v_a.P22.pSD 4.54826e-06f
Cred_8565 di_tg_ctrl_n.$483.Metal4 v_b.$2631.Metal2 0.000750616f
Cred_8566 di_tg_ctrl_n.$483.Metal4 v_b.$2691.Metal2 0.00355737f
Cred_8567 di_tg_ctrl_n.$483.Metal4 v_b.P21.nSD 8.30596e-06f
Cred_8568 di_tg_ctrl_n.$483.Metal4 v_b.P21.pSD 0.00514735f
Cred_8569 di_tg_ctrl_n.$483.Metal4 v_b.P23.pSD 0.00845426f
Cred_8570 di_tg_ctrl_n.$483.Metal4 VDD.$169.Metal1 2.14258e-05f
Cred_8571 di_tg_ctrl_n.$483.Metal4 VDD.$173.Metal1 2.33505e-05f
Cred_8572 di_tg_ctrl_n.$483.Metal4 VDD.$488.Metal2 8.87581e-06f
Cred_8573 di_tg_ctrl_n.$483.Metal4 VDD.$496.Metal2 2.49387e-05f
Cred_8574 di_tg_ctrl_n.$483.Metal4 VDD.$504.Metal2 4.61721e-06f
Cred_8575 di_tg_ctrl_n.$483.Metal4 VDD.$714.Metal3 0.00150381f
Cred_8576 di_tg_ctrl_n.$483.Metal4 VDD.$718.Metal3 0.00822691f
Cred_8577 di_tg_ctrl_n.$483.Metal4 VDD.$722.Metal3 0.0105839f
Cred_8578 di_tg_ctrl_n.$483.Metal4 VDD.$726.Metal3 0.000575872f
Cred_8579 di_tg_ctrl_n.$488.Metal4 VSS 0.0440813f
Cred_8580 di_tg_ctrl_n.$488.Metal4 v_b.$2962.Metal2 0.00400301f
Cred_8581 di_tg_ctrl_n.$488.Metal4 v_b.$3053.Metal2 2.42422e-06f
Cred_8582 di_tg_ctrl_n.$488.Metal4 v_b.$3056.Metal2 0.00502699f
Cred_8583 di_tg_ctrl_n.$488.Metal4 v_b.$3089.Metal2 4.57219e-06f
Cred_8584 di_tg_ctrl_n.$488.Metal4 v_b.$3153.Metal2 0.000943337f
Cred_8585 di_tg_ctrl_n.$488.Metal4 v_b.$3785.Metal3 0.0198158f
Cred_8586 di_tg_ctrl_n.$488.Metal4 v_b.$3821.Metal3 0.0178311f
Cred_8587 di_tg_ctrl_n.$488.Metal4 v_b.$3857.Metal3 0.000777144f
Cred_8588 di_tg_ctrl_n.$488.Metal4 v_b.P39.nSD 0.00188137f
Cred_8589 di_tg_ctrl_n.$488.Metal4 v_b.P41.nSD 0.000832344f
Cred_8590 di_tg_ctrl_n.$488.Metal4 v_b.P43.nSD 0.00347018f
Cred_8591 di_tg_ctrl_n.$488.Metal4 v_b.P45.nSD 0.00015181f
Cred_8592 di_tg_ctrl_n.$488.Metal4 v_b.P47.nSD 0.000946181f
Cred_8593 di_tg_ctrl_n.$488.Metal4 VSS.$239.Metal1 7.76491e-06f
Cred_8594 di_tg_ctrl_n.$488.Metal4 VSS.$253.Metal1 3.72185e-06f
Cred_8595 di_tg_ctrl_n.$488.Metal4 VSS.$542.Metal2 1.75385e-05f
Cred_8596 di_tg_ctrl_n.$488.Metal4 VSS.$550.Metal2 3.31796e-05f
Cred_8597 di_tg_ctrl_n.$488.Metal4 VSS.$554.Metal2 2.80644e-05f
Cred_8598 di_tg_ctrl_n.$488.Metal4 VSS.$724.Metal3 0.00617104f
Cred_8599 di_tg_ctrl_n.$488.Metal4 VSS.$728.Metal3 0.0107113f
Cred_8600 di_tg_ctrl_n.$488.Metal4 VSS.$734.Metal3 0.00471968f
Cred_8601 di_tg_ctrl_n.$488.Metal4 VSS.P0.pSD 2.96546e-08f
Cred_8602 di_tg_ctrl_n.$49.GatPoly VSS 0.00685292f
Cred_8603 di_tg_ctrl_n.$49.GatPoly v_a.$1752.Metal2 8.84469e-06f
Cred_8604 di_tg_ctrl_n.$49.GatPoly v_a.$1754.Metal2 2.76734e-06f
Cred_8605 di_tg_ctrl_n.$49.GatPoly v_a.$1756.Metal2 0.000192736f
Cred_8606 di_tg_ctrl_n.$49.GatPoly v_a.$1758.Metal2 0.00686658f
Cred_8607 di_tg_ctrl_n.$49.GatPoly v_a.$2501.Metal3 0.00178972f
Cred_8608 di_tg_ctrl_n.$49.GatPoly v_a.$681.Metal1 0.00159966f
Cred_8609 di_tg_ctrl_n.$49.GatPoly v_a.$683.Metal1 0.0153028f
Cred_8610 di_tg_ctrl_n.$49.GatPoly v_a.P20.pSD 0.0067627f
Cred_8611 di_tg_ctrl_n.$49.GatPoly v_b.$2631.Metal2 0.00678997f
Cred_8612 di_tg_ctrl_n.$49.GatPoly v_b.$2691.Metal2 0.00034668f
Cred_8613 di_tg_ctrl_n.$49.GatPoly v_b.P19.pSD 0.0225177f
Cred_8614 di_tg_ctrl_n.$49.GatPoly v_b.P21.nSD 3.8362e-06f
Cred_8615 di_tg_ctrl_n.$49.GatPoly v_b.P21.pSD 0.00249734f
Cred_8616 di_tg_ctrl_n.$49.GatPoly VDD.$143.Metal1 0.000266315f
Cred_8617 di_tg_ctrl_n.$49.GatPoly VDD.$151.Metal1 0.00395735f
Cred_8618 di_tg_ctrl_n.$49.GatPoly VDD.$161.Metal1 0.00168347f
Cred_8619 di_tg_ctrl_n.$49.GatPoly VDD.$476.Metal2 7.01068e-07f
Cred_8620 di_tg_ctrl_n.$49.GatPoly VDD.$480.Metal2 2.76138e-06f
Cred_8621 di_tg_ctrl_n.$49.GatPoly VDD.$484.Metal2 1.48877e-05f
Cred_8622 di_tg_ctrl_n.$49.GatPoly VDD.$488.Metal2 1.04461e-05f
Cred_8623 di_tg_ctrl_n.$49.GatPoly VDD.P0.nSD 7.01287e-06f
Cred_8624 di_tg_ctrl_n.$491.Metal4 VSS 0.0685973f
Cred_8625 di_tg_ctrl_n.$491.Metal4 v_a.$1514.Metal2 1.76526e-06f
Cred_8626 di_tg_ctrl_n.$491.Metal4 v_a.$1516.Metal2 3.54468e-06f
Cred_8627 di_tg_ctrl_n.$491.Metal4 v_a.$1518.Metal2 1.76526e-06f
Cred_8628 di_tg_ctrl_n.$491.Metal4 v_a.$1572.Metal2 6.56209e-06f
Cred_8629 di_tg_ctrl_n.$491.Metal4 v_a.$1574.Metal2 9.55121e-06f
Cred_8630 di_tg_ctrl_n.$491.Metal4 v_a.$1576.Metal2 4.74853e-05f
Cred_8631 di_tg_ctrl_n.$491.Metal4 v_a.$1682.Metal2 0.00224559f
Cred_8632 di_tg_ctrl_n.$491.Metal4 v_a.$1746.Metal2 2.82338e-05f
Cred_8633 di_tg_ctrl_n.$491.Metal4 v_a.$1748.Metal2 3.85692e-05f
Cred_8634 di_tg_ctrl_n.$491.Metal4 v_a.$1750.Metal2 2.00036e-05f
Cred_8635 di_tg_ctrl_n.$491.Metal4 v_a.$1754.Metal2 2.36606e-06f
Cred_8636 di_tg_ctrl_n.$491.Metal4 v_a.$1756.Metal2 3.15265e-06f
Cred_8637 di_tg_ctrl_n.$491.Metal4 v_a.$1758.Metal2 2.36606e-06f
Cred_8638 di_tg_ctrl_n.$491.Metal4 v_a.$1804.Metal2 2.66037e-05f
Cred_8639 di_tg_ctrl_n.$491.Metal4 v_a.$1806.Metal2 3.61492e-05f
Cred_8640 di_tg_ctrl_n.$491.Metal4 v_a.$1808.Metal2 1.80024e-05f
Cred_8641 di_tg_ctrl_n.$491.Metal4 v_a.$1862.Metal2 2.66037e-05f
Cred_8642 di_tg_ctrl_n.$491.Metal4 v_a.$1864.Metal2 3.61492e-05f
Cred_8643 di_tg_ctrl_n.$491.Metal4 v_a.$1866.Metal2 1.80024e-05f
Cred_8644 di_tg_ctrl_n.$491.Metal4 v_a.$1920.Metal2 2.66037e-05f
Cred_8645 di_tg_ctrl_n.$491.Metal4 v_a.$1922.Metal2 3.61492e-05f
Cred_8646 di_tg_ctrl_n.$491.Metal4 v_a.$1924.Metal2 1.80024e-05f
Cred_8647 di_tg_ctrl_n.$491.Metal4 v_a.$1978.Metal2 2.66037e-05f
Cred_8648 di_tg_ctrl_n.$491.Metal4 v_a.$1980.Metal2 3.61492e-05f
Cred_8649 di_tg_ctrl_n.$491.Metal4 v_a.$1982.Metal2 1.80024e-05f
Cred_8650 di_tg_ctrl_n.$491.Metal4 v_a.$2036.Metal2 3.81138e-05f
Cred_8651 di_tg_ctrl_n.$491.Metal4 v_a.$2038.Metal2 5.30292e-05f
Cred_8652 di_tg_ctrl_n.$491.Metal4 v_a.$2040.Metal2 2.64087e-05f
Cred_8653 di_tg_ctrl_n.$491.Metal4 v_a.$2094.Metal2 4.28648e-05f
Cred_8654 di_tg_ctrl_n.$491.Metal4 v_a.$2096.Metal2 5.82448e-05f
Cred_8655 di_tg_ctrl_n.$491.Metal4 v_a.$2098.Metal2 2.90061e-05f
Cred_8656 di_tg_ctrl_n.$491.Metal4 v_a.$2373.Metal3 0.000220168f
Cred_8657 di_tg_ctrl_n.$491.Metal4 v_a.$2377.Metal3 0.000220168f
Cred_8658 di_tg_ctrl_n.$491.Metal4 v_a.$2387.Metal3 0.00486679f
Cred_8659 di_tg_ctrl_n.$491.Metal4 v_a.$2403.Metal3 0.000818442f
Cred_8660 di_tg_ctrl_n.$491.Metal4 v_a.$2407.Metal3 0.00153717f
Cred_8661 di_tg_ctrl_n.$491.Metal4 v_a.$2447.Metal3 0.00486679f
Cred_8662 di_tg_ctrl_n.$491.Metal4 v_a.$2458.Metal3 0.0103224f
Cred_8663 di_tg_ctrl_n.$491.Metal4 v_a.$2462.Metal3 0.0167743f
Cred_8664 di_tg_ctrl_n.$491.Metal4 v_a.$2488.Metal3 0.00639993f
Cred_8665 di_tg_ctrl_n.$491.Metal4 v_a.$2493.Metal3 0.0035214f
Cred_8666 di_tg_ctrl_n.$491.Metal4 v_a.$2497.Metal3 0.00298937f
Cred_8667 di_tg_ctrl_n.$491.Metal4 v_a.$2501.Metal3 0.00669145f
Cred_8668 di_tg_ctrl_n.$491.Metal4 v_a.$2518.Metal3 0.00639993f
Cred_8669 di_tg_ctrl_n.$491.Metal4 v_a.$2523.Metal3 0.00331809f
Cred_8670 di_tg_ctrl_n.$491.Metal4 v_a.$2527.Metal3 0.00224532f
Cred_8671 di_tg_ctrl_n.$491.Metal4 v_a.$2531.Metal3 0.00626604f
Cred_8672 di_tg_ctrl_n.$491.Metal4 v_a.$2548.Metal3 0.00639993f
Cred_8673 di_tg_ctrl_n.$491.Metal4 v_a.$2553.Metal3 0.00331809f
Cred_8674 di_tg_ctrl_n.$491.Metal4 v_a.$2557.Metal3 0.00224532f
Cred_8675 di_tg_ctrl_n.$491.Metal4 v_a.$2561.Metal3 0.00626604f
Cred_8676 di_tg_ctrl_n.$491.Metal4 v_a.$2578.Metal3 0.00639993f
Cred_8677 di_tg_ctrl_n.$491.Metal4 v_a.$2583.Metal3 0.00331809f
Cred_8678 di_tg_ctrl_n.$491.Metal4 v_a.$2587.Metal3 0.00224532f
Cred_8679 di_tg_ctrl_n.$491.Metal4 v_a.$2591.Metal3 0.00626604f
Cred_8680 di_tg_ctrl_n.$491.Metal4 v_a.$2597.Metal3 0.00481609f
Cred_8681 di_tg_ctrl_n.$491.Metal4 v_a.$2608.Metal3 0.00639993f
Cred_8682 di_tg_ctrl_n.$491.Metal4 v_a.$2613.Metal3 0.00331809f
Cred_8683 di_tg_ctrl_n.$491.Metal4 v_a.$2617.Metal3 0.00224532f
Cred_8684 di_tg_ctrl_n.$491.Metal4 v_a.$2621.Metal3 0.00626604f
Cred_8685 di_tg_ctrl_n.$491.Metal4 v_a.$2635.Metal3 0.00167089f
Cred_8686 di_tg_ctrl_n.$491.Metal4 v_a.$2638.Metal3 0.0123735f
Cred_8687 di_tg_ctrl_n.$491.Metal4 v_a.$2643.Metal3 0.00475367f
Cred_8688 di_tg_ctrl_n.$491.Metal4 v_a.$2647.Metal3 0.00329377f
Cred_8689 di_tg_ctrl_n.$491.Metal4 v_a.$2651.Metal3 0.010096f
Cred_8690 di_tg_ctrl_n.$491.Metal4 v_a.$2657.Metal3 0.0239801f
Cred_8691 di_tg_ctrl_n.$491.Metal4 v_a.$2668.Metal3 0.0103118f
Cred_8692 di_tg_ctrl_n.$491.Metal4 v_a.$2673.Metal3 0.00534621f
Cred_8693 di_tg_ctrl_n.$491.Metal4 v_a.$2677.Metal3 0.00361772f
Cred_8694 di_tg_ctrl_n.$491.Metal4 v_a.$2681.Metal3 0.010096f
Cred_8695 di_tg_ctrl_n.$491.Metal4 v_a.$489.Metal1 8.81236e-06f
Cred_8696 di_tg_ctrl_n.$491.Metal4 v_a.$611.Metal1 0.000853204f
Cred_8697 di_tg_ctrl_n.$491.Metal4 v_a.P14.pSD 9.46297e-06f
Cred_8698 di_tg_ctrl_n.$491.Metal4 v_a.P16.nSD 4.38922e-05f
Cred_8699 di_tg_ctrl_n.$491.Metal4 v_a.P16.pSD 0.00406823f
Cred_8700 di_tg_ctrl_n.$491.Metal4 v_a.P18.pSD 0.0012718f
Cred_8701 di_tg_ctrl_n.$491.Metal4 v_a.P30.nSD 4.34349e-05f
Cred_8702 di_tg_ctrl_n.$491.Metal4 v_a.P34.nSD 0.000126016f
Cred_8703 di_tg_ctrl_n.$491.Metal4 v_a.P34.pSD 0.00967984f
Cred_8704 di_tg_ctrl_n.$491.Metal4 v_b.$1992.Metal1 1.37559e-07f
Cred_8705 di_tg_ctrl_n.$491.Metal4 v_b.$2541.Metal2 6.99593e-05f
Cred_8706 di_tg_ctrl_n.$491.Metal4 v_b.$2601.Metal2 0.00349587f
Cred_8707 di_tg_ctrl_n.$491.Metal4 v_b.$2631.Metal2 0.00344375f
Cred_8708 di_tg_ctrl_n.$491.Metal4 v_b.$2691.Metal2 0.00428464f
Cred_8709 di_tg_ctrl_n.$491.Metal4 v_b.$2751.Metal2 0.00422345f
Cred_8710 di_tg_ctrl_n.$491.Metal4 v_b.$2811.Metal2 0.00618163f
Cred_8711 di_tg_ctrl_n.$491.Metal4 v_b.$2871.Metal2 0.00869756f
Cred_8712 di_tg_ctrl_n.$491.Metal4 v_b.$2962.Metal2 0.00443122f
Cred_8713 di_tg_ctrl_n.$491.Metal4 v_b.$3053.Metal2 0.00010068f
Cred_8714 di_tg_ctrl_n.$491.Metal4 v_b.$3056.Metal2 0.00656679f
Cred_8715 di_tg_ctrl_n.$491.Metal4 v_b.$3089.Metal2 2.44501e-05f
Cred_8716 di_tg_ctrl_n.$491.Metal4 v_b.$3153.Metal2 0.0347295f
Cred_8717 di_tg_ctrl_n.$491.Metal4 v_b.$3247.Metal2 0.0205442f
Cred_8718 di_tg_ctrl_n.$491.Metal4 v_b.$3344.Metal2 0.0029749f
Cred_8719 di_tg_ctrl_n.$491.Metal4 v_b.$3435.Metal2 0.000173302f
Cred_8720 di_tg_ctrl_n.$491.Metal4 v_b.$3438.Metal2 0.00228993f
Cred_8721 di_tg_ctrl_n.$491.Metal4 v_b.$3487.Metal2 1.18427e-05f
Cred_8722 di_tg_ctrl_n.$491.Metal4 v_b.$3529.Metal2 0.000108317f
Cred_8723 di_tg_ctrl_n.$491.Metal4 v_b.$3779.Metal3 0.0186142f
Cred_8724 di_tg_ctrl_n.$491.Metal4 v_b.$3785.Metal3 0.0512968f
Cred_8725 di_tg_ctrl_n.$491.Metal4 v_b.$3821.Metal3 0.226088f
Cred_8726 di_tg_ctrl_n.$491.Metal4 v_b.$3857.Metal3 0.247733f
Cred_8727 di_tg_ctrl_n.$491.Metal4 v_b.$3890.Metal3 0.216919f
Cred_8728 di_tg_ctrl_n.$491.Metal4 v_b.$3903.Metal3 0.0862323f
Cred_8729 di_tg_ctrl_n.$491.Metal4 v_b.$3934.Metal3 0.0776299f
Cred_8730 di_tg_ctrl_n.$491.Metal4 v_b.$3970.Metal3 0.0892518f
Cred_8731 di_tg_ctrl_n.$491.Metal4 v_b.$3980.Metal3 0.000503099f
Cred_8732 di_tg_ctrl_n.$491.Metal4 v_b.P10.pSD 0.000126208f
Cred_8733 di_tg_ctrl_n.$491.Metal4 v_b.P11.pSD 0.000151661f
Cred_8734 di_tg_ctrl_n.$491.Metal4 v_b.P13.pSD 0.000175899f
Cred_8735 di_tg_ctrl_n.$491.Metal4 v_b.P15.nSD 7.74137e-07f
Cred_8736 di_tg_ctrl_n.$491.Metal4 v_b.P15.pSD 0.000431759f
Cred_8737 di_tg_ctrl_n.$491.Metal4 v_b.P17.pSD 0.00611251f
Cred_8738 di_tg_ctrl_n.$491.Metal4 v_b.P19.pSD 0.00832392f
Cred_8739 di_tg_ctrl_n.$491.Metal4 v_b.P21.nSD 1.19115e-05f
Cred_8740 di_tg_ctrl_n.$491.Metal4 v_b.P21.pSD 0.00546667f
Cred_8741 di_tg_ctrl_n.$491.Metal4 v_b.P23.pSD 0.0052388f
Cred_8742 di_tg_ctrl_n.$491.Metal4 v_b.P25.nSD 1.16453e-05f
Cred_8743 di_tg_ctrl_n.$491.Metal4 v_b.P25.pSD 0.00533942f
Cred_8744 di_tg_ctrl_n.$491.Metal4 v_b.P27.pSD 0.00531664f
Cred_8745 di_tg_ctrl_n.$491.Metal4 v_b.P29.nSD 0.0010962f
Cred_8746 di_tg_ctrl_n.$491.Metal4 v_b.P29.pSD 0.00559352f
Cred_8747 di_tg_ctrl_n.$491.Metal4 v_b.P31.nSD 0.00132677f
Cred_8748 di_tg_ctrl_n.$491.Metal4 v_b.P31.pSD 0.00961259f
Cred_8749 di_tg_ctrl_n.$491.Metal4 v_b.P33.nSD 0.00164295f
Cred_8750 di_tg_ctrl_n.$491.Metal4 v_b.P33.pSD 0.00930798f
Cred_8751 di_tg_ctrl_n.$491.Metal4 v_b.P35.nSD 0.00206123f
Cred_8752 di_tg_ctrl_n.$491.Metal4 v_b.P35.pSD 0.00797186f
Cred_8753 di_tg_ctrl_n.$491.Metal4 v_b.P37.nSD 0.000124133f
Cred_8754 di_tg_ctrl_n.$491.Metal4 v_b.P37.pSD 0.00822774f
Cred_8755 di_tg_ctrl_n.$491.Metal4 v_b.P39.nSD 0.00242785f
Cred_8756 di_tg_ctrl_n.$491.Metal4 v_b.P39.pSD 0.00580317f
Cred_8757 di_tg_ctrl_n.$491.Metal4 v_b.P41.nSD 0.000680061f
Cred_8758 di_tg_ctrl_n.$491.Metal4 v_b.P41.pSD 0.000730701f
Cred_8759 di_tg_ctrl_n.$491.Metal4 v_b.P43.nSD 0.00277023f
Cred_8760 di_tg_ctrl_n.$491.Metal4 v_b.P43.pSD 0.0113873f
Cred_8761 di_tg_ctrl_n.$491.Metal4 v_b.P45.nSD 0.00425704f
Cred_8762 di_tg_ctrl_n.$491.Metal4 v_b.P45.pSD 0.021648f
Cred_8763 di_tg_ctrl_n.$491.Metal4 v_b.P47.nSD 0.00692376f
Cred_8764 di_tg_ctrl_n.$491.Metal4 v_b.P47.pSD 0.0204836f
Cred_8765 di_tg_ctrl_n.$491.Metal4 v_b.P49.nSD 0.00849462f
Cred_8766 di_tg_ctrl_n.$491.Metal4 v_b.P49.pSD 0.0489242f
Cred_8767 di_tg_ctrl_n.$491.Metal4 v_b.P5.pSD 8.44047e-05f
Cred_8768 di_tg_ctrl_n.$491.Metal4 v_b.P51.nSD 0.00620281f
Cred_8769 di_tg_ctrl_n.$491.Metal4 v_b.P51.pSD 0.00745765f
Cred_8770 di_tg_ctrl_n.$491.Metal4 v_b.P53.nSD 0.00253636f
Cred_8771 di_tg_ctrl_n.$491.Metal4 v_b.P53.pSD 0.0088917f
Cred_8772 di_tg_ctrl_n.$491.Metal4 v_b.P55.nSD 0.00281977f
Cred_8773 di_tg_ctrl_n.$491.Metal4 v_b.P55.pSD 0.00353453f
Cred_8774 di_tg_ctrl_n.$491.Metal4 v_b.P57.nSD 0.000478766f
Cred_8775 di_tg_ctrl_n.$491.Metal4 v_b.P57.pSD 0.00271487f
Cred_8776 di_tg_ctrl_n.$491.Metal4 v_b.P59.nSD 0.00244362f
Cred_8777 di_tg_ctrl_n.$491.Metal4 v_b.P59.pSD 0.00306004f
Cred_8778 di_tg_ctrl_n.$491.Metal4 v_b.P61.nSD 3.82526e-05f
Cred_8779 di_tg_ctrl_n.$491.Metal4 v_b.P61.pSD 4.2792e-09f
Cred_8780 di_tg_ctrl_n.$491.Metal4 v_b.P63.nSD 0.00197449f
Cred_8781 di_tg_ctrl_n.$491.Metal4 v_b.P63.pSD 0.00246596f
Cred_8782 di_tg_ctrl_n.$491.Metal4 v_b.P67.nSD 0.00162423f
Cred_8783 di_tg_ctrl_n.$491.Metal4 v_b.P67.pSD 0.00202851f
Cred_8784 di_tg_ctrl_n.$491.Metal4 v_b.P7.pSD 0.000103362f
Cred_8785 di_tg_ctrl_n.$491.Metal4 v_b.P71.nSD 0.00102474f
Cred_8786 di_tg_ctrl_n.$491.Metal4 v_b.P71.pSD 0.00127981f
Cred_8787 di_tg_ctrl_n.$491.Metal4 VDD.$340.Metal1 4.12639e-05f
Cred_8788 di_tg_ctrl_n.$491.Metal4 VDD.$388.Metal2 1.53678e-08f
Cred_8789 di_tg_ctrl_n.$491.Metal4 VDD.$42.Metal1 7.21588e-07f
Cred_8790 di_tg_ctrl_n.$491.Metal4 VDD.$666.Metal3 6.76575e-10f
Cred_8791 di_tg_ctrl_n.$491.Metal4 VDD.P0.nSD 0.00409685f
Cred_8792 di_tg_ctrl_n.$491.Metal4 VSS.$550.Metal2 4.34723e-06f
Cred_8793 di_tg_ctrl_n.$491.Metal4 VSS.$554.Metal2 8.72931e-06f
Cred_8794 di_tg_ctrl_n.$491.Metal4 VSS.$562.Metal2 1.9023e-05f
Cred_8795 di_tg_ctrl_n.$491.Metal4 VSS.$728.Metal3 0.000542199f
Cred_8796 di_tg_ctrl_n.$491.Metal4 VSS.$734.Metal3 0.00680249f
Cred_8797 di_tg_ctrl_n.$491.Metal4 VSS.$738.Metal3 0.00631585f
Cred_8798 di_tg_ctrl_n.$52.GatPoly VSS 0.00995367f
Cred_8799 di_tg_ctrl_n.$52.GatPoly v_a.$1752.Metal2 6.59459e-06f
Cred_8800 di_tg_ctrl_n.$52.GatPoly v_a.$1754.Metal2 2.06333e-06f
Cred_8801 di_tg_ctrl_n.$52.GatPoly v_a.$1756.Metal2 0.000147651f
Cred_8802 di_tg_ctrl_n.$52.GatPoly v_a.$1758.Metal2 0.00528965f
Cred_8803 di_tg_ctrl_n.$52.GatPoly v_a.$1810.Metal2 2.99558e-06f
Cred_8804 di_tg_ctrl_n.$52.GatPoly v_a.$1812.Metal2 9.37263e-07f
Cred_8805 di_tg_ctrl_n.$52.GatPoly v_a.$1814.Metal2 7.12807e-05f
Cred_8806 di_tg_ctrl_n.$52.GatPoly v_a.$1816.Metal2 0.0025841f
Cred_8807 di_tg_ctrl_n.$52.GatPoly v_a.$2497.Metal3 8.13842e-06f
Cred_8808 di_tg_ctrl_n.$52.GatPoly v_a.$2501.Metal3 0.00138181f
Cred_8809 di_tg_ctrl_n.$52.GatPoly v_a.$2531.Metal3 0.000678253f
Cred_8810 di_tg_ctrl_n.$52.GatPoly v_a.$681.Metal1 0.00119271f
Cred_8811 di_tg_ctrl_n.$52.GatPoly v_a.$683.Metal1 0.011718f
Cred_8812 di_tg_ctrl_n.$52.GatPoly v_a.$744.Metal1 0.000541785f
Cred_8813 di_tg_ctrl_n.$52.GatPoly v_a.$746.Metal1 0.00565172f
Cred_8814 di_tg_ctrl_n.$52.GatPoly v_a.P20.pSD 0.00522061f
Cred_8815 di_tg_ctrl_n.$52.GatPoly v_a.P22.pSD 0.00255169f
Cred_8816 di_tg_ctrl_n.$52.GatPoly v_b.$2631.Metal2 0.0039215f
Cred_8817 di_tg_ctrl_n.$52.GatPoly v_b.$2691.Metal2 0.0039215f
Cred_8818 di_tg_ctrl_n.$52.GatPoly v_b.P21.nSD 4.33934e-05f
Cred_8819 di_tg_ctrl_n.$52.GatPoly v_b.P21.pSD 0.0278232f
Cred_8820 di_tg_ctrl_n.$52.GatPoly VDD.$151.Metal1 0.00174442f
Cred_8821 di_tg_ctrl_n.$52.GatPoly VDD.$161.Metal1 0.00534765f
Cred_8822 di_tg_ctrl_n.$52.GatPoly VDD.$165.Metal1 0.00123129f
Cred_8823 di_tg_ctrl_n.$52.GatPoly VDD.$169.Metal1 0.000370655f
Cred_8824 di_tg_ctrl_n.$52.GatPoly VDD.$484.Metal2 9.18432e-06f
Cred_8825 di_tg_ctrl_n.$52.GatPoly VDD.$488.Metal2 1.91517e-05f
Cred_8826 di_tg_ctrl_n.$52.GatPoly VDD.$496.Metal2 3.17158e-06f
Cred_8827 di_tg_ctrl_n.$52.GatPoly VDD.$718.Metal3 1.48117e-08f
Cred_8828 di_tg_ctrl_n.$52.GatPoly VDD.P0.nSD 7.27854e-06f
Cred_8829 di_tg_ctrl_n.$56.GatPoly VSS 0.00829178f
Cred_8830 di_tg_ctrl_n.$56.GatPoly v_a.$1810.Metal2 1.0231e-05f
Cred_8831 di_tg_ctrl_n.$56.GatPoly v_a.$1812.Metal2 3.2011e-06f
Cred_8832 di_tg_ctrl_n.$56.GatPoly v_a.$1814.Metal2 0.000248743f
Cred_8833 di_tg_ctrl_n.$56.GatPoly v_a.$1816.Metal2 0.00905358f
Cred_8834 di_tg_ctrl_n.$56.GatPoly v_a.$2531.Metal3 0.00238006f
Cred_8835 di_tg_ctrl_n.$56.GatPoly v_a.$744.Metal1 0.00185039f
Cred_8836 di_tg_ctrl_n.$56.GatPoly v_a.$746.Metal1 0.0197161f
Cred_8837 di_tg_ctrl_n.$56.GatPoly v_a.P22.pSD 0.0089453f
Cred_8838 di_tg_ctrl_n.$56.GatPoly v_b.$2631.Metal2 0.000912516f
Cred_8839 di_tg_ctrl_n.$56.GatPoly v_b.$2691.Metal2 0.00735581f
Cred_8840 di_tg_ctrl_n.$56.GatPoly v_b.P21.nSD 1.00975e-05f
Cred_8841 di_tg_ctrl_n.$56.GatPoly v_b.P21.pSD 0.0065092f
Cred_8842 di_tg_ctrl_n.$56.GatPoly v_b.P23.pSD 0.0225177f
Cred_8843 di_tg_ctrl_n.$56.GatPoly VDD.$161.Metal1 0.000616617f
Cred_8844 di_tg_ctrl_n.$56.GatPoly VDD.$165.Metal1 0.00179323f
Cred_8845 di_tg_ctrl_n.$56.GatPoly VDD.$169.Metal1 0.00240574f
Cred_8846 di_tg_ctrl_n.$56.GatPoly VDD.$173.Metal1 0.00233618f
Cred_8847 di_tg_ctrl_n.$56.GatPoly VDD.$179.Metal1 0.000183266f
Cred_8848 di_tg_ctrl_n.$56.GatPoly VDD.$488.Metal2 4.60092e-07f
Cred_8849 di_tg_ctrl_n.$56.GatPoly VDD.$496.Metal2 7.32161e-06f
Cred_8850 di_tg_ctrl_n.$56.GatPoly VDD.$504.Metal2 3.68306e-06f
Cred_8851 di_tg_ctrl_n.$56.GatPoly VDD.$718.Metal3 3.68891e-09f
Cred_8852 di_tg_ctrl_n.$56.GatPoly VDD.$722.Metal3 1.87521e-08f
Cred_8853 di_tg_ctrl_n.$56.GatPoly VDD.P0.nSD 3.10142e-07f
Cred_8854 di_tg_ctrl_n.$59.GatPoly VSS 0.00685292f
Cred_8855 di_tg_ctrl_n.$59.GatPoly v_a.$1868.Metal2 8.84469e-06f
Cred_8856 di_tg_ctrl_n.$59.GatPoly v_a.$1870.Metal2 2.76734e-06f
Cred_8857 di_tg_ctrl_n.$59.GatPoly v_a.$1872.Metal2 0.000216368f
Cred_8858 di_tg_ctrl_n.$59.GatPoly v_a.$1874.Metal2 0.00788405f
Cred_8859 di_tg_ctrl_n.$59.GatPoly v_a.$2561.Metal3 0.00207352f
Cred_8860 di_tg_ctrl_n.$59.GatPoly v_a.$807.Metal1 0.00159966f
Cred_8861 di_tg_ctrl_n.$59.GatPoly v_a.$809.Metal1 0.0171484f
Cred_8862 di_tg_ctrl_n.$59.GatPoly v_a.P24.pSD 0.00779106f
Cred_8863 di_tg_ctrl_n.$59.GatPoly v_b.$2691.Metal2 0.00678997f
Cred_8864 di_tg_ctrl_n.$59.GatPoly v_b.$2751.Metal2 0.00034668f
Cred_8865 di_tg_ctrl_n.$59.GatPoly v_b.P23.pSD 0.0225177f
Cred_8866 di_tg_ctrl_n.$59.GatPoly v_b.P25.nSD 3.8362e-06f
Cred_8867 di_tg_ctrl_n.$59.GatPoly v_b.P25.pSD 0.00249734f
Cred_8868 di_tg_ctrl_n.$59.GatPoly VDD.$169.Metal1 0.000521466f
Cred_8869 di_tg_ctrl_n.$59.GatPoly VDD.$173.Metal1 0.00289028f
Cred_8870 di_tg_ctrl_n.$59.GatPoly VDD.$179.Metal1 0.00243572f
Cred_8871 di_tg_ctrl_n.$59.GatPoly VDD.$183.Metal1 6.23583e-05f
Cred_8872 di_tg_ctrl_n.$59.GatPoly VDD.$496.Metal2 1.07001e-06f
Cred_8873 di_tg_ctrl_n.$59.GatPoly VDD.$504.Metal2 1.18036e-05f
Cred_8874 di_tg_ctrl_n.$59.GatPoly VDD.$512.Metal2 1.86116e-07f
Cred_8875 di_tg_ctrl_n.$59.GatPoly VDD.$722.Metal3 8.57909e-09f
Cred_8876 di_tg_ctrl_n.$59.GatPoly VDD.$726.Metal3 1.49223e-09f
Cred_8877 di_tg_ctrl_n.$59.GatPoly VDD.P0.nSD 2.43351e-06f
Cred_8878 di_tg_ctrl_n.$6.GatPoly VSS 0.00829184f
Cred_8879 di_tg_ctrl_n.$6.GatPoly v_a.$114.Metal1 0.0018504f
Cred_8880 di_tg_ctrl_n.$6.GatPoly v_a.$116.Metal1 0.000289479f
Cred_8881 di_tg_ctrl_n.$6.GatPoly v_a.$118.Metal1 0.0256f
Cred_8882 di_tg_ctrl_n.$6.GatPoly v_a.$1230.Metal2 1.02311e-05f
Cred_8883 di_tg_ctrl_n.$6.GatPoly v_a.$1232.Metal2 3.20112e-06f
Cred_8884 di_tg_ctrl_n.$6.GatPoly v_a.$1238.Metal2 0.000514032f
Cred_8885 di_tg_ctrl_n.$6.GatPoly v_a.$1240.Metal2 0.00748082f
Cred_8886 di_tg_ctrl_n.$6.GatPoly v_a.$2227.Metal3 4.70173e-08f
Cred_8887 di_tg_ctrl_n.$6.GatPoly v_a.$2233.Metal3 0.0009098f
Cred_8888 di_tg_ctrl_n.$6.GatPoly v_a.P2.pSD 0.00618777f
Cred_8889 di_tg_ctrl_n.$6.GatPoly v_b.$2361.Metal2 0.00507121f
Cred_8890 di_tg_ctrl_n.$6.GatPoly v_b.$2421.Metal2 0.00320345f
Cred_8891 di_tg_ctrl_n.$6.GatPoly v_b.P1.pSD 0.00654252f
Cred_8892 di_tg_ctrl_n.$6.GatPoly v_b.P3.nSD 3.54479e-05f
Cred_8893 di_tg_ctrl_n.$6.GatPoly v_b.P3.pSD 0.022745f
Cred_8894 di_tg_ctrl_n.$6.GatPoly VDD.$388.Metal2 1.40159e-06f
Cred_8895 di_tg_ctrl_n.$6.GatPoly VDD.$392.Metal2 4.44013e-06f
Cred_8896 di_tg_ctrl_n.$6.GatPoly VDD.$400.Metal2 1.14094e-05f
Cred_8897 di_tg_ctrl_n.$6.GatPoly VDD.$404.Metal2 2.69902e-06f
Cred_8898 di_tg_ctrl_n.$6.GatPoly VDD.$42.Metal1 0.000181729f
Cred_8899 di_tg_ctrl_n.$6.GatPoly VDD.$55.Metal1 0.00222368f
Cred_8900 di_tg_ctrl_n.$6.GatPoly VDD.$59.Metal1 0.00378655f
Cred_8901 di_tg_ctrl_n.$6.GatPoly VDD.$67.Metal1 0.00143539f
Cred_8902 di_tg_ctrl_n.$6.GatPoly VDD.$670.Metal3 1.30107e-08f
Cred_8903 di_tg_ctrl_n.$6.GatPoly VDD.P0.nSD 3.03703e-06f
Cred_8904 di_tg_ctrl_n.$62.GatPoly VSS 0.00995367f
Cred_8905 di_tg_ctrl_n.$62.GatPoly v_a.$1868.Metal2 6.59459e-06f
Cred_8906 di_tg_ctrl_n.$62.GatPoly v_a.$1870.Metal2 2.06333e-06f
Cred_8907 di_tg_ctrl_n.$62.GatPoly v_a.$1872.Metal2 0.000161324f
Cred_8908 di_tg_ctrl_n.$62.GatPoly v_a.$1874.Metal2 0.00587834f
Cred_8909 di_tg_ctrl_n.$62.GatPoly v_a.$1926.Metal2 2.99558e-06f
Cred_8910 di_tg_ctrl_n.$62.GatPoly v_a.$1928.Metal2 9.37263e-07f
Cred_8911 di_tg_ctrl_n.$62.GatPoly v_a.$1930.Metal2 7.3281e-05f
Cred_8912 di_tg_ctrl_n.$62.GatPoly v_a.$1932.Metal2 0.00267023f
Cred_8913 di_tg_ctrl_n.$62.GatPoly v_a.$2557.Metal3 7.94264e-06f
Cred_8914 di_tg_ctrl_n.$62.GatPoly v_a.$2561.Metal3 0.00154602f
Cred_8915 di_tg_ctrl_n.$62.GatPoly v_a.$2591.Metal3 0.000702276f
Cred_8916 di_tg_ctrl_n.$62.GatPoly v_a.$807.Metal1 0.00119271f
Cred_8917 di_tg_ctrl_n.$62.GatPoly v_a.$809.Metal1 0.0127858f
Cred_8918 di_tg_ctrl_n.$62.GatPoly v_a.$870.Metal1 0.000541785f
Cred_8919 di_tg_ctrl_n.$62.GatPoly v_a.$872.Metal1 0.00580794f
Cred_8920 di_tg_ctrl_n.$62.GatPoly v_a.P24.pSD 0.00581477f
Cred_8921 di_tg_ctrl_n.$62.GatPoly v_a.P26.pSD 0.00263873f
Cred_8922 di_tg_ctrl_n.$62.GatPoly v_b.$2691.Metal2 0.00392149f
Cred_8923 di_tg_ctrl_n.$62.GatPoly v_b.$2751.Metal2 0.00392149f
Cred_8924 di_tg_ctrl_n.$62.GatPoly v_b.P25.nSD 4.33934e-05f
Cred_8925 di_tg_ctrl_n.$62.GatPoly v_b.P25.pSD 0.0278221f
Cred_8926 di_tg_ctrl_n.$62.GatPoly VDD 0.00127092f
Cred_8927 di_tg_ctrl_n.$62.GatPoly VDD.$173.Metal1 0.000425966f
Cred_8928 di_tg_ctrl_n.$62.GatPoly VDD.$179.Metal1 0.00403633f
Cred_8929 di_tg_ctrl_n.$62.GatPoly VDD.$183.Metal1 0.00261226f
Cred_8930 di_tg_ctrl_n.$62.GatPoly VDD.$189.Metal1 0.00043282f
Cred_8931 di_tg_ctrl_n.$62.GatPoly VDD.$504.Metal2 2.99843e-06f
Cred_8932 di_tg_ctrl_n.$62.GatPoly VDD.$512.Metal2 5.21865e-06f
Cred_8933 di_tg_ctrl_n.$62.GatPoly VDD.$520.Metal2 6.459e-07f
Cred_8934 di_tg_ctrl_n.$62.GatPoly VDD.$726.Metal3 5.41717e-09f
Cred_8935 di_tg_ctrl_n.$62.GatPoly VDD.$730.Metal3 5.17869e-09f
Cred_8936 di_tg_ctrl_n.$62.GatPoly VDD.P0.nSD 5.35912e-07f
Cred_8937 di_tg_ctrl_n.$66.GatPoly VSS 0.00829178f
Cred_8938 di_tg_ctrl_n.$66.GatPoly v_a.$1926.Metal2 1.0231e-05f
Cred_8939 di_tg_ctrl_n.$66.GatPoly v_a.$1928.Metal2 3.2011e-06f
Cred_8940 di_tg_ctrl_n.$66.GatPoly v_a.$1930.Metal2 0.000250281f
Cred_8941 di_tg_ctrl_n.$66.GatPoly v_a.$1932.Metal2 0.00911981f
Cred_8942 di_tg_ctrl_n.$66.GatPoly v_a.$2591.Metal3 0.00239853f
Cred_8943 di_tg_ctrl_n.$66.GatPoly v_a.$870.Metal1 0.00185039f
Cred_8944 di_tg_ctrl_n.$66.GatPoly v_a.$872.Metal1 0.0198362f
Cred_8945 di_tg_ctrl_n.$66.GatPoly v_a.P26.pSD 0.00901224f
Cred_8946 di_tg_ctrl_n.$66.GatPoly v_b.$2691.Metal2 0.000912516f
Cred_8947 di_tg_ctrl_n.$66.GatPoly v_b.$2751.Metal2 0.00735581f
Cred_8948 di_tg_ctrl_n.$66.GatPoly v_b.P25.nSD 1.00975e-05f
Cred_8949 di_tg_ctrl_n.$66.GatPoly v_b.P25.pSD 0.0065092f
Cred_8950 di_tg_ctrl_n.$66.GatPoly v_b.P27.pSD 0.0225177f
Cred_8951 di_tg_ctrl_n.$66.GatPoly VDD 0.00161863f
Cred_8952 di_tg_ctrl_n.$66.GatPoly VDD.$183.Metal1 0.00060626f
Cred_8953 di_tg_ctrl_n.$66.GatPoly VDD.$189.Metal1 0.00231219f
Cred_8954 di_tg_ctrl_n.$66.GatPoly VDD.$193.Metal1 0.00234088f
Cred_8955 di_tg_ctrl_n.$66.GatPoly VDD.$197.Metal1 0.000389345f
Cred_8956 di_tg_ctrl_n.$66.GatPoly VDD.$512.Metal2 3.23197e-06f
Cred_8957 di_tg_ctrl_n.$66.GatPoly VDD.$520.Metal2 6.19893e-06f
Cred_8958 di_tg_ctrl_n.$66.GatPoly VDD.$528.Metal2 7.26279e-08f
Cred_8959 di_tg_ctrl_n.$66.GatPoly VDD.$730.Metal3 1.76871e-08f
Cred_8960 di_tg_ctrl_n.$66.GatPoly VDD.$734.Metal3 5.82315e-10f
Cred_8961 di_tg_ctrl_n.$69.GatPoly VSS 0.00685292f
Cred_8962 di_tg_ctrl_n.$69.GatPoly v_a.$1982.Metal2 1.36048e-06f
Cred_8963 di_tg_ctrl_n.$69.GatPoly v_a.$1984.Metal2 1.73699e-05f
Cred_8964 di_tg_ctrl_n.$69.GatPoly v_a.$1990.Metal2 0.00673667f
Cred_8965 di_tg_ctrl_n.$69.GatPoly v_a.$2621.Metal3 0.00187886f
Cred_8966 di_tg_ctrl_n.$69.GatPoly v_a.$932.Metal1 0.000667873f
Cred_8967 di_tg_ctrl_n.$69.GatPoly v_a.$934.Metal1 0.00117038f
Cred_8968 di_tg_ctrl_n.$69.GatPoly v_a.$936.Metal1 0.0195638f
Cred_8969 di_tg_ctrl_n.$69.GatPoly v_a.P28.pSD 0.00668838f
Cred_8970 di_tg_ctrl_n.$69.GatPoly v_b.$2751.Metal2 0.00678997f
Cred_8971 di_tg_ctrl_n.$69.GatPoly v_b.$2811.Metal2 0.00034668f
Cred_8972 di_tg_ctrl_n.$69.GatPoly v_b.P27.pSD 0.0225177f
Cred_8973 di_tg_ctrl_n.$69.GatPoly v_b.P29.nSD 3.8362e-06f
Cred_8974 di_tg_ctrl_n.$69.GatPoly v_b.P29.pSD 0.00249734f
Cred_8975 di_tg_ctrl_n.$69.GatPoly VDD.$189.Metal1 0.000412265f
Cred_8976 di_tg_ctrl_n.$69.GatPoly VDD.$193.Metal1 0.00134208f
Cred_8977 di_tg_ctrl_n.$69.GatPoly VDD.$197.Metal1 0.00357511f
Cred_8978 di_tg_ctrl_n.$69.GatPoly VDD.$203.Metal1 0.000571308f
Cred_8979 di_tg_ctrl_n.$69.GatPoly VDD.$520.Metal2 2.52567e-06f
Cred_8980 di_tg_ctrl_n.$69.GatPoly VDD.$528.Metal2 3.703e-06f
Cred_8981 di_tg_ctrl_n.$69.GatPoly VDD.$734.Metal3 4.71179e-09f
Cred_8982 di_tg_ctrl_n.$69.GatPoly VDD.P0.nSD 7.18768e-07f
Cred_8983 di_tg_ctrl_n.$72.GatPoly VSS 0.00995367f
Cred_8984 di_tg_ctrl_n.$72.GatPoly v_a.$1982.Metal2 1.01437e-06f
Cred_8985 di_tg_ctrl_n.$72.GatPoly v_a.$1984.Metal2 1.2951e-05f
Cred_8986 di_tg_ctrl_n.$72.GatPoly v_a.$1990.Metal2 0.00502286f
Cred_8987 di_tg_ctrl_n.$72.GatPoly v_a.$2042.Metal2 2.99558e-06f
Cred_8988 di_tg_ctrl_n.$72.GatPoly v_a.$2044.Metal2 9.37263e-07f
Cred_8989 di_tg_ctrl_n.$72.GatPoly v_a.$2046.Metal2 7.3281e-05f
Cred_8990 di_tg_ctrl_n.$72.GatPoly v_a.$2048.Metal2 0.00267023f
Cred_8991 di_tg_ctrl_n.$72.GatPoly v_a.$2617.Metal3 7.71908e-06f
Cred_8992 di_tg_ctrl_n.$72.GatPoly v_a.$2621.Metal3 0.00140088f
Cred_8993 di_tg_ctrl_n.$72.GatPoly v_a.$2651.Metal3 0.000702276f
Cred_8994 di_tg_ctrl_n.$72.GatPoly v_a.$932.Metal1 0.000497966f
Cred_8995 di_tg_ctrl_n.$72.GatPoly v_a.$934.Metal1 0.000872634f
Cred_8996 di_tg_ctrl_n.$72.GatPoly v_a.$936.Metal1 0.0145867f
Cred_8997 di_tg_ctrl_n.$72.GatPoly v_a.$996.Metal1 0.000541785f
Cred_8998 di_tg_ctrl_n.$72.GatPoly v_a.$998.Metal1 0.00580794f
Cred_8999 di_tg_ctrl_n.$72.GatPoly v_a.P28.pSD 0.00498685f
Cred_9000 di_tg_ctrl_n.$72.GatPoly v_a.P30.pSD 0.00263873f
Cred_9001 di_tg_ctrl_n.$72.GatPoly v_b.$2751.Metal2 0.00392149f
Cred_9002 di_tg_ctrl_n.$72.GatPoly v_b.$2811.Metal2 0.00392149f
Cred_9003 di_tg_ctrl_n.$72.GatPoly v_b.P29.nSD 4.33934e-05f
Cred_9004 di_tg_ctrl_n.$72.GatPoly v_b.P29.pSD 0.0278209f
Cred_9005 di_tg_ctrl_n.$72.GatPoly VDD.$193.Metal1 4.64943e-05f
Cred_9006 di_tg_ctrl_n.$72.GatPoly VDD.$197.Metal1 0.0024567f
Cred_9007 di_tg_ctrl_n.$72.GatPoly VDD.$203.Metal1 0.0043905f
Cred_9008 di_tg_ctrl_n.$72.GatPoly VDD.$207.Metal1 0.00146292f
Cred_9009 di_tg_ctrl_n.$72.GatPoly VDD.$211.Metal1 0.000469497f
Cred_9010 di_tg_ctrl_n.$72.GatPoly VDD.$520.Metal2 1.38768e-07f
Cred_9011 di_tg_ctrl_n.$72.GatPoly VDD.$528.Metal2 1.48651e-05f
Cred_9012 di_tg_ctrl_n.$72.GatPoly VDD.$536.Metal2 3.56547e-06f
Cred_9013 di_tg_ctrl_n.$72.GatPoly VDD.$734.Metal3 1.11261e-09f
Cred_9014 di_tg_ctrl_n.$72.GatPoly VDD.$738.Metal3 1.79698e-08f
Cred_9015 di_tg_ctrl_n.$72.GatPoly VDD.P0.nSD 2.89857e-06f
Cred_9016 di_tg_ctrl_n.$76.GatPoly VSS 0.00829178f
Cred_9017 di_tg_ctrl_n.$76.GatPoly v_a.$2042.Metal2 1.0231e-05f
Cred_9018 di_tg_ctrl_n.$76.GatPoly v_a.$2044.Metal2 3.2011e-06f
Cred_9019 di_tg_ctrl_n.$76.GatPoly v_a.$2046.Metal2 0.000250281f
Cred_9020 di_tg_ctrl_n.$76.GatPoly v_a.$2048.Metal2 0.00911981f
Cred_9021 di_tg_ctrl_n.$76.GatPoly v_a.$2651.Metal3 0.00239853f
Cred_9022 di_tg_ctrl_n.$76.GatPoly v_a.$996.Metal1 0.00185039f
Cred_9023 di_tg_ctrl_n.$76.GatPoly v_a.$998.Metal1 0.0198362f
Cred_9024 di_tg_ctrl_n.$76.GatPoly v_a.P30.pSD 0.00901224f
Cred_9025 di_tg_ctrl_n.$76.GatPoly v_b.$2751.Metal2 0.000912516f
Cred_9026 di_tg_ctrl_n.$76.GatPoly v_b.$2811.Metal2 0.00735581f
Cred_9027 di_tg_ctrl_n.$76.GatPoly v_b.P29.nSD 1.00975e-05f
Cred_9028 di_tg_ctrl_n.$76.GatPoly v_b.P29.pSD 0.0065092f
Cred_9029 di_tg_ctrl_n.$76.GatPoly v_b.P31.pSD 0.0225177f
Cred_9030 di_tg_ctrl_n.$76.GatPoly VDD.$203.Metal1 0.000556954f
Cred_9031 di_tg_ctrl_n.$76.GatPoly VDD.$207.Metal1 0.00156972f
Cred_9032 di_tg_ctrl_n.$76.GatPoly VDD.$211.Metal1 0.00232613f
Cred_9033 di_tg_ctrl_n.$76.GatPoly VDD.$215.Metal1 0.0026149f
Cred_9034 di_tg_ctrl_n.$76.GatPoly VDD.$225.Metal1 0.000126881f
Cred_9035 di_tg_ctrl_n.$76.GatPoly VDD.$528.Metal2 6.2336e-07f
Cred_9036 di_tg_ctrl_n.$76.GatPoly VDD.$536.Metal2 6.89843e-06f
Cred_9037 di_tg_ctrl_n.$76.GatPoly VDD.$544.Metal2 3.40521e-06f
Cred_9038 di_tg_ctrl_n.$76.GatPoly VDD.$548.Metal2 6.68024e-07f
Cred_9039 di_tg_ctrl_n.$76.GatPoly VDD.$738.Metal3 4.99796e-09f
Cred_9040 di_tg_ctrl_n.$76.GatPoly VDD.$742.Metal3 1.40501e-08f
Cred_9041 di_tg_ctrl_n.$76.GatPoly VDD.P0.nSD 6.46059e-07f
Cred_9042 di_tg_ctrl_n.$79.GatPoly VSS 0.00829184f
Cred_9043 di_tg_ctrl_n.$79.GatPoly v_a.$1058.Metal1 0.00077256f
Cred_9044 di_tg_ctrl_n.$79.GatPoly v_a.$1060.Metal1 0.00135383f
Cred_9045 di_tg_ctrl_n.$79.GatPoly v_a.$1062.Metal1 0.0226303f
Cred_9046 di_tg_ctrl_n.$79.GatPoly v_a.$2098.Metal2 1.57373e-06f
Cred_9047 di_tg_ctrl_n.$79.GatPoly v_a.$2100.Metal2 2.00926e-05f
Cred_9048 di_tg_ctrl_n.$79.GatPoly v_a.$2106.Metal2 0.00779263f
Cred_9049 di_tg_ctrl_n.$79.GatPoly v_a.$2677.Metal3 4.70173e-08f
Cred_9050 di_tg_ctrl_n.$79.GatPoly v_a.$2681.Metal3 0.00217337f
Cred_9051 di_tg_ctrl_n.$79.GatPoly v_a.P32.pSD 0.00773676f
Cred_9052 di_tg_ctrl_n.$79.GatPoly v_b.$2811.Metal2 0.00735583f
Cred_9053 di_tg_ctrl_n.$79.GatPoly v_b.$2871.Metal2 0.000912539f
Cred_9054 di_tg_ctrl_n.$79.GatPoly v_b.P31.pSD 0.0225177f
Cred_9055 di_tg_ctrl_n.$79.GatPoly v_b.P33.nSD 1.00977e-05f
Cred_9056 di_tg_ctrl_n.$79.GatPoly v_b.P33.pSD 0.00650936f
Cred_9057 di_tg_ctrl_n.$79.GatPoly VDD.$211.Metal1 0.000385239f
Cred_9058 di_tg_ctrl_n.$79.GatPoly VDD.$215.Metal1 0.00408155f
Cred_9059 di_tg_ctrl_n.$79.GatPoly VDD.$225.Metal1 0.00258069f
Cred_9060 di_tg_ctrl_n.$79.GatPoly VDD.$230.Metal1 5.58606e-05f
Cred_9061 di_tg_ctrl_n.$79.GatPoly VDD.$536.Metal2 9.34205e-07f
Cred_9062 di_tg_ctrl_n.$79.GatPoly VDD.$544.Metal2 1.84917e-05f
Cred_9063 di_tg_ctrl_n.$79.GatPoly VDD.$548.Metal2 1.2659e-05f
Cred_9064 di_tg_ctrl_n.$79.GatPoly VDD.$552.Metal2 4.30872e-07f
Cred_9065 di_tg_ctrl_n.$79.GatPoly VDD.$742.Metal3 7.49025e-09f
Cred_9066 di_tg_ctrl_n.$79.GatPoly VDD.P0.nSD 8.21118e-06f
Cred_9067 di_tg_ctrl_n.$83.GatPoly VSS 0.0128704f
Cred_9068 di_tg_ctrl_n.$83.GatPoly v_a.$1058.Metal1 0.000226209f
Cred_9069 di_tg_ctrl_n.$83.GatPoly v_a.$1060.Metal1 0.000396409f
Cred_9070 di_tg_ctrl_n.$83.GatPoly v_a.$1062.Metal1 0.00662628f
Cred_9071 di_tg_ctrl_n.$83.GatPoly v_a.$2098.Metal2 4.60797e-07f
Cred_9072 di_tg_ctrl_n.$83.GatPoly v_a.$2100.Metal2 5.88321e-06f
Cred_9073 di_tg_ctrl_n.$83.GatPoly v_a.$2106.Metal2 0.00228172f
Cred_9074 di_tg_ctrl_n.$83.GatPoly v_a.$2657.Metal3 0.0187151f
Cred_9075 di_tg_ctrl_n.$83.GatPoly v_a.$2677.Metal3 1.01596e-07f
Cred_9076 di_tg_ctrl_n.$83.GatPoly v_a.$2681.Metal3 0.000636374f
Cred_9077 di_tg_ctrl_n.$83.GatPoly v_a.P32.pSD 0.00226536f
Cred_9078 di_tg_ctrl_n.$83.GatPoly v_a.P34.nSD 0.000123065f
Cred_9079 di_tg_ctrl_n.$83.GatPoly v_a.P34.pSD 0.0393469f
Cred_9080 di_tg_ctrl_n.$83.GatPoly v_b.$2811.Metal2 0.0045904f
Cred_9081 di_tg_ctrl_n.$83.GatPoly v_b.$2871.Metal2 0.00903063f
Cred_9082 di_tg_ctrl_n.$83.GatPoly v_b.P33.nSD 5.07952e-05f
Cred_9083 di_tg_ctrl_n.$83.GatPoly v_b.P33.pSD 0.0327058f
Cred_9084 di_tg_ctrl_n.$83.GatPoly v_b.P35.pSD 0.0156846f
Cred_9085 di_tg_ctrl_n.$83.GatPoly VDD.$215.Metal1 0.00075179f
Cred_9086 di_tg_ctrl_n.$83.GatPoly VDD.$225.Metal1 0.00508315f
Cred_9087 di_tg_ctrl_n.$83.GatPoly VDD.$230.Metal1 0.00511287f
Cred_9088 di_tg_ctrl_n.$83.GatPoly VDD.$238.Metal1 0.000406622f
Cred_9089 di_tg_ctrl_n.$83.GatPoly VDD.$544.Metal2 4.66496e-06f
Cred_9090 di_tg_ctrl_n.$83.GatPoly VDD.$548.Metal2 7.57978e-06f
Cred_9091 di_tg_ctrl_n.$83.GatPoly VDD.$552.Metal2 8.83313e-06f
Cred_9092 di_tg_ctrl_n.$83.GatPoly VDD.$560.Metal2 3.13572e-06f
Cred_9093 di_tg_ctrl_n.$83.GatPoly VDD.P0.nSD 5.3315e-06f
Cred_9094 di_tg_ctrl_n.$86.GatPoly VSS 0.0607581f
Cred_9095 di_tg_ctrl_n.$86.GatPoly v_b.$2871.Metal2 0.00268766f
Cred_9096 di_tg_ctrl_n.$86.GatPoly v_b.$2962.Metal2 0.00213403f
Cred_9097 di_tg_ctrl_n.$86.GatPoly v_b.$3779.Metal3 0.00866144f
Cred_9098 di_tg_ctrl_n.$86.GatPoly v_b.P35.nSD 0.00249734f
Cred_9099 di_tg_ctrl_n.$86.GatPoly v_b.P37.nSD 0.00999895f
Cred_9100 di_tg_ctrl_n.$86.GatPoly v_b.P37.pSD 2.42422e-05f
Cred_9101 di_tg_ctrl_n.$86.GatPoly v_b.P39.nSD 0.00197331f
Cred_9102 di_tg_ctrl_n.$86.GatPoly VSS.$17.Metal1 8.4647e-09f
Cred_9103 di_tg_ctrl_n.$86.GatPoly VSS.$221.Metal1 0.00554284f
Cred_9104 di_tg_ctrl_n.$86.GatPoly VSS.$231.Metal1 0.00128268f
Cred_9105 di_tg_ctrl_n.$86.GatPoly VSS.$301.Metal1 9.18138e-08f
Cred_9106 di_tg_ctrl_n.$86.GatPoly VSS.$526.Metal2 3.64693e-07f
Cred_9107 di_tg_ctrl_n.$86.GatPoly VSS.$534.Metal2 1.20684e-05f
Cred_9108 di_tg_ctrl_n.$86.GatPoly VSS.$606.Metal2 9.70118e-09f
Cred_9109 di_tg_ctrl_n.$86.GatPoly VSS.$716.Metal3 1.78186e-08f
Cred_9110 di_tg_ctrl_n.$86.GatPoly VSS.$724.Metal3 3.57005e-08f
Cred_9111 di_tg_ctrl_n.$86.GatPoly VSS.$760.Metal3 5.74006e-10f
Cred_9112 di_tg_ctrl_n.$86.GatPoly VSS.P0.pSD 8.45891e-06f
Cred_9113 di_tg_ctrl_n.$89.GatPoly VSS 0.0519833f
Cred_9114 di_tg_ctrl_n.$89.GatPoly v_b.$2871.Metal2 0.000211486f
Cred_9115 di_tg_ctrl_n.$89.GatPoly v_b.$2962.Metal2 0.00500037f
Cred_9116 di_tg_ctrl_n.$89.GatPoly v_b.$3056.Metal2 0.00033411f
Cred_9117 di_tg_ctrl_n.$89.GatPoly v_b.$3779.Metal3 0.00210545f
Cred_9118 di_tg_ctrl_n.$89.GatPoly v_b.$3785.Metal3 0.00436789f
Cred_9119 di_tg_ctrl_n.$89.GatPoly v_b.P35.nSD 0.000195892f
Cred_9120 di_tg_ctrl_n.$89.GatPoly v_b.P37.nSD 0.00243405f
Cred_9121 di_tg_ctrl_n.$89.GatPoly v_b.P37.pSD 5.89287e-06f
Cred_9122 di_tg_ctrl_n.$89.GatPoly v_b.P39.nSD 0.00462556f
Cred_9123 di_tg_ctrl_n.$89.GatPoly v_b.P41.nSD 0.00587098f
Cred_9124 di_tg_ctrl_n.$89.GatPoly v_b.P43.nSD 0.000310225f
Cred_9125 di_tg_ctrl_n.$89.GatPoly VSS.$17.Metal1 8.64609e-09f
Cred_9126 di_tg_ctrl_n.$89.GatPoly VSS.$221.Metal1 0.000524902f
Cred_9127 di_tg_ctrl_n.$89.GatPoly VSS.$231.Metal1 0.00553847f
Cred_9128 di_tg_ctrl_n.$89.GatPoly VSS.$239.Metal1 0.000812204f
Cred_9129 di_tg_ctrl_n.$89.GatPoly VSS.$301.Metal1 1.31983e-07f
Cred_9130 di_tg_ctrl_n.$89.GatPoly VSS.$534.Metal2 4.04785e-06f
Cred_9131 di_tg_ctrl_n.$89.GatPoly VSS.$542.Metal2 6.26437e-06f
Cred_9132 di_tg_ctrl_n.$89.GatPoly VSS.$606.Metal2 1.39455e-08f
Cred_9133 di_tg_ctrl_n.$89.GatPoly VSS.$760.Metal3 8.25135e-10f
Cred_9134 di_tg_ctrl_n.$89.GatPoly VSS.P0.pSD 9.73062e-06f
Cred_9135 di_tg_ctrl_n.$9.GatPoly VSS 0.00829178f
Cred_9136 di_tg_ctrl_n.$9.GatPoly v_a.$1286.Metal2 4.24505e-06f
Cred_9137 di_tg_ctrl_n.$9.GatPoly v_a.$1290.Metal2 4.24505e-06f
Cred_9138 di_tg_ctrl_n.$9.GatPoly v_a.$1294.Metal2 0.00771021f
Cred_9139 di_tg_ctrl_n.$9.GatPoly v_a.$177.Metal1 0.00156484f
Cred_9140 di_tg_ctrl_n.$9.GatPoly v_a.$178.Metal1 0.000582981f
Cred_9141 di_tg_ctrl_n.$9.GatPoly v_a.$180.Metal1 0.023261f
Cred_9142 di_tg_ctrl_n.$9.GatPoly v_a.$2257.Metal3 8.10378e-08f
Cred_9143 di_tg_ctrl_n.$9.GatPoly v_a.$2261.Metal3 0.00211626f
Cred_9144 di_tg_ctrl_n.$9.GatPoly v_a.P4.pSD 0.00760171f
Cred_9145 di_tg_ctrl_n.$9.GatPoly v_b.$2361.Metal2 0.00319632f
Cred_9146 di_tg_ctrl_n.$9.GatPoly v_b.$2421.Metal2 0.00506825f
Cred_9147 di_tg_ctrl_n.$9.GatPoly v_b.P3.nSD 3.5369e-05f
Cred_9148 di_tg_ctrl_n.$9.GatPoly v_b.P3.pSD 0.0227593f
Cred_9149 di_tg_ctrl_n.$9.GatPoly v_b.P5.pSD 0.00653815f
Cred_9150 di_tg_ctrl_n.$9.GatPoly VDD.$400.Metal2 3.4469e-06f
Cred_9151 di_tg_ctrl_n.$9.GatPoly VDD.$404.Metal2 6.75719e-06f
Cred_9152 di_tg_ctrl_n.$9.GatPoly VDD.$412.Metal2 1.86325e-06f
Cred_9153 di_tg_ctrl_n.$9.GatPoly VDD.$59.Metal1 0.00107831f
Cred_9154 di_tg_ctrl_n.$9.GatPoly VDD.$67.Metal1 0.00349481f
Cred_9155 di_tg_ctrl_n.$9.GatPoly VDD.$676.Metal3 4.25943e-09f
Cred_9156 di_tg_ctrl_n.$9.GatPoly VDD.$71.Metal1 0.002085f
Cred_9157 di_tg_ctrl_n.$9.GatPoly VDD.$77.Metal1 0.000236128f
Cred_9158 di_tg_ctrl_n.$9.GatPoly VDD.P0.nSD 1.53225e-06f
Cred_9159 di_tg_ctrl_n.$93.GatPoly VSS 0.0442322f
Cred_9160 di_tg_ctrl_n.$93.GatPoly v_b.$2962.Metal2 0.00033411f
Cred_9161 di_tg_ctrl_n.$93.GatPoly v_b.$3056.Metal2 0.00384062f
Cred_9162 di_tg_ctrl_n.$93.GatPoly v_b.$3785.Metal3 0.00433901f
Cred_9163 di_tg_ctrl_n.$93.GatPoly v_b.P39.nSD 0.000310225f
Cred_9164 di_tg_ctrl_n.$93.GatPoly v_b.P41.nSD 0.00582403f
Cred_9165 di_tg_ctrl_n.$93.GatPoly v_b.P43.nSD 0.00355623f
Cred_9166 di_tg_ctrl_n.$93.GatPoly VSS.$17.Metal1 7.35137e-09f
Cred_9167 di_tg_ctrl_n.$93.GatPoly VSS.$231.Metal1 0.000814035f
Cred_9168 di_tg_ctrl_n.$93.GatPoly VSS.$239.Metal1 0.00415675f
Cred_9169 di_tg_ctrl_n.$93.GatPoly VSS.$253.Metal1 0.000125986f
Cred_9170 di_tg_ctrl_n.$93.GatPoly VSS.$301.Metal1 1.3314e-07f
Cred_9171 di_tg_ctrl_n.$93.GatPoly VSS.$542.Metal2 6.27892e-06f
Cred_9172 di_tg_ctrl_n.$93.GatPoly VSS.$550.Metal2 1.95314e-06f
Cred_9173 di_tg_ctrl_n.$93.GatPoly VSS.$554.Metal2 9.71735e-07f
Cred_9174 di_tg_ctrl_n.$93.GatPoly VSS.$606.Metal2 1.40678e-08f
Cred_9175 di_tg_ctrl_n.$93.GatPoly VSS.$760.Metal3 8.3237e-10f
Cred_9176 di_tg_ctrl_n.$93.GatPoly VSS.P0.pSD 8.95475e-06f
Cred_9177 di_tg_ctrl_n.$95.GatPoly VSS 0.04671f
Cred_9178 di_tg_ctrl_n.$95.GatPoly v_b.$3056.Metal2 0.00404118f
Cred_9179 di_tg_ctrl_n.$95.GatPoly v_b.$3153.Metal2 0.00113819f
Cred_9180 di_tg_ctrl_n.$95.GatPoly v_b.$3821.Metal3 0.00586381f
Cred_9181 di_tg_ctrl_n.$95.GatPoly v_b.P43.nSD 0.00373707f
Cred_9182 di_tg_ctrl_n.$95.GatPoly v_b.P45.nSD 0.00787949f
Cred_9183 di_tg_ctrl_n.$95.GatPoly v_b.P47.nSD 0.0010526f
Cred_9184 di_tg_ctrl_n.$95.GatPoly VSS.$239.Metal1 0.0031264f
Cred_9185 di_tg_ctrl_n.$95.GatPoly VSS.$253.Metal1 0.00170912f
Cred_9186 di_tg_ctrl_n.$95.GatPoly VSS.$550.Metal2 1.65242e-05f
Cred_9187 di_tg_ctrl_n.$95.GatPoly VSS.$554.Metal2 1.31825e-05f
Cred_9188 di_tg_ctrl_n.$95.GatPoly VSS.P0.pSD 9.84404e-06f
Cred_9189 di_tg_ctrl_n.$99.GatPoly VSS 0.0575561f
Cred_9190 di_tg_ctrl_n.$99.GatPoly v_b.$3153.Metal2 0.00529809f
Cred_9191 di_tg_ctrl_n.$99.GatPoly v_b.$3247.Metal2 0.00033411f
Cred_9192 di_tg_ctrl_n.$99.GatPoly v_b.$3821.Metal3 0.00166577f
Cred_9193 di_tg_ctrl_n.$99.GatPoly v_b.$3857.Metal3 0.00203974f
Cred_9194 di_tg_ctrl_n.$99.GatPoly v_b.$3890.Metal3 0.00214173f
Cred_9195 di_tg_ctrl_n.$99.GatPoly v_b.P45.nSD 0.0022383f
Cred_9196 di_tg_ctrl_n.$99.GatPoly v_b.P47.nSD 0.00490064f
Cred_9197 di_tg_ctrl_n.$99.GatPoly v_b.P49.nSD 0.00564041f
Cred_9198 di_tg_ctrl_n.$99.GatPoly v_b.P49.pSD 9.30778e-06f
Cred_9199 di_tg_ctrl_n.$99.GatPoly v_b.P51.nSD 0.000310225f
Cred_9200 di_tg_ctrl_n.$99.GatPoly VSS.$17.Metal1 5.31884e-09f
Cred_9201 di_tg_ctrl_n.$99.GatPoly VSS.$239.Metal1 0.000691226f
Cred_9202 di_tg_ctrl_n.$99.GatPoly VSS.$253.Metal1 0.00608709f
Cred_9203 di_tg_ctrl_n.$99.GatPoly VSS.$261.Metal1 0.000811321f
Cred_9204 di_tg_ctrl_n.$99.GatPoly VSS.$301.Metal1 2.26611e-07f
Cred_9205 di_tg_ctrl_n.$99.GatPoly VSS.$550.Metal2 5.33056e-06f
Cred_9206 di_tg_ctrl_n.$99.GatPoly VSS.$554.Metal2 8.27787e-06f
Cred_9207 di_tg_ctrl_n.$99.GatPoly VSS.$562.Metal2 6.25744e-06f
Cred_9208 di_tg_ctrl_n.$99.GatPoly VSS.$606.Metal2 2.3944e-08f
Cred_9209 di_tg_ctrl_n.$99.GatPoly VSS.$760.Metal3 1.41674e-09f
Cred_9210 di_tg_ctrl_n.$99.GatPoly VSS.P0.pSD 1.29858e-05f
Cred_9211 di_tg_ctrl_n.P0.GatPoly VSS 0.0146335f
Cred_9212 di_tg_ctrl_n.P0.GatPoly v_b.$2871.Metal2 0.0280026f
Cred_9213 di_tg_ctrl_n.P0.GatPoly v_b.$3779.Metal3 0.0136884f
Cred_9214 di_tg_ctrl_n.P0.GatPoly v_b.P35.nSD 0.0138937f
Cred_9215 di_tg_ctrl_n.P0.GatPoly v_b.P37.nSD 0.0165108f
Cred_9216 di_tg_ctrl_n.P0.GatPoly v_b.P37.pSD 3.83121e-05f
Cred_9217 di_tg_ctrl_n.P0.GatPoly VSS.$17.Metal1 4.83287e-06f
Cred_9218 di_tg_ctrl_n.P0.GatPoly VSS.$221.Metal1 0.0036431f
Cred_9219 di_tg_ctrl_n.P0.GatPoly VSS.$301.Metal1 4.4193e-05f
Cred_9220 di_tg_ctrl_n.P0.GatPoly VSS.$526.Metal2 0.00148829f
Cred_9221 di_tg_ctrl_n.P0.GatPoly VSS.$534.Metal2 0.00148829f
Cred_9222 di_tg_ctrl_n.P0.GatPoly VSS.$606.Metal2 4.6695e-06f
Cred_9223 di_tg_ctrl_n.P0.GatPoly VSS.$716.Metal3 0.000692232f
Cred_9224 di_tg_ctrl_n.P0.GatPoly VSS.$724.Metal3 0.000692232f
Cred_9225 di_tg_ctrl_n.P0.GatPoly VSS.$760.Metal3 2.76288e-07f
Cred_9226 di_tg_ctrl_n.P0.GatPoly VSS.P0.pSD 0.00281276f
Cred_9227 di_tg_ctrl_n.P1.GatPoly VSS 0.0132902f
Cred_9228 di_tg_ctrl_n.P1.GatPoly v_b.$2871.Metal2 0.00176849f
Cred_9229 di_tg_ctrl_n.P1.GatPoly v_b.$2962.Metal2 0.0282005f
Cred_9230 di_tg_ctrl_n.P1.GatPoly v_b.$3779.Metal3 0.0136061f
Cred_9231 di_tg_ctrl_n.P1.GatPoly v_b.P35.nSD 2.37458e-05f
Cred_9232 di_tg_ctrl_n.P1.GatPoly v_b.P37.nSD 0.0156671f
Cred_9233 di_tg_ctrl_n.P1.GatPoly v_b.P37.pSD 3.39596e-05f
Cred_9234 di_tg_ctrl_n.P1.GatPoly v_b.P39.nSD 0.012583f
Cred_9235 di_tg_ctrl_n.P1.GatPoly VSS.$17.Metal1 4.37749e-06f
Cred_9236 di_tg_ctrl_n.P1.GatPoly VSS.$221.Metal1 3.33378e-05f
Cred_9237 di_tg_ctrl_n.P1.GatPoly VSS.$231.Metal1 3.33322e-05f
Cred_9238 di_tg_ctrl_n.P1.GatPoly VSS.$301.Metal1 4.74812e-05f
Cred_9239 di_tg_ctrl_n.P1.GatPoly VSS.$534.Metal2 2.57089e-07f
Cred_9240 di_tg_ctrl_n.P1.GatPoly VSS.$606.Metal2 5.01694e-06f
Cred_9241 di_tg_ctrl_n.P1.GatPoly VSS.$760.Metal3 2.96845e-07f
Cred_9242 di_tg_ctrl_n.P1.GatPoly VSS.P0.pSD 0.00277167f
Cred_9243 di_tg_ctrl_n.P10.GatPoly VSS 0.0125453f
Cred_9244 di_tg_ctrl_n.P10.GatPoly v_b.$3294.Metal2 3.40996e-07f
Cred_9245 di_tg_ctrl_n.P10.GatPoly v_b.$3344.Metal2 0.0228891f
Cred_9246 di_tg_ctrl_n.P10.GatPoly v_b.$3435.Metal2 0.0059295f
Cred_9247 di_tg_ctrl_n.P10.GatPoly v_b.$3903.Metal3 0.000289545f
Cred_9248 di_tg_ctrl_n.P10.GatPoly v_b.$3934.Metal3 0.013603f
Cred_9249 di_tg_ctrl_n.P10.GatPoly v_b.P55.nSD 0.0125059f
Cred_9250 di_tg_ctrl_n.P10.GatPoly v_b.P57.nSD 0.0150235f
Cred_9251 di_tg_ctrl_n.P10.GatPoly VSS.$17.Metal1 1.31859e-06f
Cred_9252 di_tg_ctrl_n.P10.GatPoly VSS.$301.Metal1 0.000157022f
Cred_9253 di_tg_ctrl_n.P10.GatPoly VSS.$606.Metal2 1.65912e-05f
Cred_9254 di_tg_ctrl_n.P10.GatPoly VSS.$760.Metal3 9.81677e-07f
Cred_9255 di_tg_ctrl_n.P10.GatPoly VSS.P0.pSD 0.00265285f
Cred_9256 di_tg_ctrl_n.P11.GatPoly VSS 0.0125453f
Cred_9257 di_tg_ctrl_n.P11.GatPoly v_b.$3435.Metal2 0.0150208f
Cred_9258 di_tg_ctrl_n.P11.GatPoly v_b.$3438.Metal2 0.0150469f
Cred_9259 di_tg_ctrl_n.P11.GatPoly v_b.$3529.Metal2 3.67754e-07f
Cred_9260 di_tg_ctrl_n.P11.GatPoly v_b.$3934.Metal3 0.0135608f
Cred_9261 di_tg_ctrl_n.P11.GatPoly v_b.$3970.Metal3 0.000296708f
Cred_9262 di_tg_ctrl_n.P11.GatPoly v_b.P57.nSD 0.0150245f
Cred_9263 di_tg_ctrl_n.P11.GatPoly v_b.P59.nSD 0.0125059f
Cred_9264 di_tg_ctrl_n.P11.GatPoly VSS.$17.Metal1 1.21005e-06f
Cred_9265 di_tg_ctrl_n.P11.GatPoly VSS.$301.Metal1 0.00017105f
Cred_9266 di_tg_ctrl_n.P11.GatPoly VSS.$606.Metal2 1.80734e-05f
Cred_9267 di_tg_ctrl_n.P11.GatPoly VSS.$760.Metal3 1.06938e-06f
Cred_9268 di_tg_ctrl_n.P11.GatPoly VSS.P0.pSD 0.00263736f
Cred_9269 di_tg_ctrl_n.P12.GatPoly VSS 0.0123426f
Cred_9270 di_tg_ctrl_n.P12.GatPoly v_b.$3435.Metal2 1.7638e-06f
Cred_9271 di_tg_ctrl_n.P12.GatPoly v_b.$3438.Metal2 0.0269257f
Cred_9272 di_tg_ctrl_n.P12.GatPoly v_b.$3529.Metal2 0.0032026f
Cred_9273 di_tg_ctrl_n.P12.GatPoly v_b.$3934.Metal3 0.000572662f
Cred_9274 di_tg_ctrl_n.P12.GatPoly v_b.$3970.Metal3 0.0132367f
Cred_9275 di_tg_ctrl_n.P12.GatPoly v_b.P59.nSD 0.0124532f
Cred_9276 di_tg_ctrl_n.P12.GatPoly v_b.P61.nSD 0.0149361f
Cred_9277 di_tg_ctrl_n.P12.GatPoly VSS.$17.Metal1 1.01888e-06f
Cred_9278 di_tg_ctrl_n.P12.GatPoly VSS.$301.Metal1 0.000202981f
Cred_9279 di_tg_ctrl_n.P12.GatPoly VSS.$606.Metal2 2.14473e-05f
Cred_9280 di_tg_ctrl_n.P12.GatPoly VSS.$760.Metal3 1.26901e-06f
Cred_9281 di_tg_ctrl_n.P12.GatPoly VSS.P0.pSD 0.00260204f
Cred_9282 di_tg_ctrl_n.P13.GatPoly VSS 0.0139636f
Cred_9283 di_tg_ctrl_n.P13.GatPoly v_b.$3529.Metal2 0.00272828f
Cred_9284 di_tg_ctrl_n.P13.GatPoly v_b.$3535.Metal2 0.0275968f
Cred_9285 di_tg_ctrl_n.P13.GatPoly v_b.$3565.Metal2 1.67255e-06f
Cred_9286 di_tg_ctrl_n.P13.GatPoly v_b.$3970.Metal3 0.0134173f
Cred_9287 di_tg_ctrl_n.P13.GatPoly v_b.$4009.Metal3 0.000600199f
Cred_9288 di_tg_ctrl_n.P13.GatPoly v_b.P61.nSD 0.0152197f
Cred_9289 di_tg_ctrl_n.P13.GatPoly v_b.P63.nSD 0.0126195f
Cred_9290 di_tg_ctrl_n.P13.GatPoly VSS.$17.Metal1 9.34833e-07f
Cred_9291 di_tg_ctrl_n.P13.GatPoly VSS.$279.Metal1 1.38347e-05f
Cred_9292 di_tg_ctrl_n.P13.GatPoly VSS.$293.Metal1 0.000144964f
Cred_9293 di_tg_ctrl_n.P13.GatPoly VSS.$301.Metal1 0.000221118f
Cred_9294 di_tg_ctrl_n.P13.GatPoly VSS.$586.Metal2 1.067e-07f
Cred_9295 di_tg_ctrl_n.P13.GatPoly VSS.$590.Metal2 2.14484e-07f
Cred_9296 di_tg_ctrl_n.P13.GatPoly VSS.$606.Metal2 2.33637e-05f
Cred_9297 di_tg_ctrl_n.P13.GatPoly VSS.$760.Metal3 1.3824e-06f
Cred_9298 di_tg_ctrl_n.P13.GatPoly VSS.P0.pSD 0.00258207f
Cred_9299 di_tg_ctrl_n.P14.GatPoly VSS 0.0125453f
Cred_9300 di_tg_ctrl_n.P14.GatPoly v_b.$3529.Metal2 3.36742e-07f
Cred_9301 di_tg_ctrl_n.P14.GatPoly v_b.$3535.Metal2 0.0150468f
Cred_9302 di_tg_ctrl_n.P14.GatPoly v_b.$3565.Metal2 0.0150227f
Cred_9303 di_tg_ctrl_n.P14.GatPoly v_b.$3970.Metal3 0.000268443f
Cred_9304 di_tg_ctrl_n.P14.GatPoly v_b.$4009.Metal3 0.0135895f
Cred_9305 di_tg_ctrl_n.P14.GatPoly v_b.P63.nSD 0.0125059f
Cred_9306 di_tg_ctrl_n.P14.GatPoly v_b.P65.nSD 0.0150246f
Cred_9307 di_tg_ctrl_n.P14.GatPoly VSS.$17.Metal1 7.86745e-07f
Cred_9308 di_tg_ctrl_n.P14.GatPoly VSS.$301.Metal1 0.000262402f
Cred_9309 di_tg_ctrl_n.P14.GatPoly VSS.$606.Metal2 2.77258e-05f
Cred_9310 di_tg_ctrl_n.P14.GatPoly VSS.$760.Metal3 1.6405e-06f
Cred_9311 di_tg_ctrl_n.P14.GatPoly VSS.P0.pSD 0.0025362f
Cred_9312 di_tg_ctrl_n.P15.GatPoly VSS 0.0125453f
Cred_9313 di_tg_ctrl_n.P15.GatPoly v_b.$3565.Metal2 0.00620864f
Cred_9314 di_tg_ctrl_n.P15.GatPoly v_b.$3629.Metal2 0.0238232f
Cred_9315 di_tg_ctrl_n.P15.GatPoly v_b.$4009.Metal3 0.0133789f
Cred_9316 di_tg_ctrl_n.P15.GatPoly v_b.$4042.Metal3 0.000518236f
Cred_9317 di_tg_ctrl_n.P15.GatPoly v_b.P65.nSD 0.0150246f
Cred_9318 di_tg_ctrl_n.P15.GatPoly v_b.P67.nSD 0.0125059f
Cred_9319 di_tg_ctrl_n.P15.GatPoly VSS.$17.Metal1 7.21615e-07f
Cred_9320 di_tg_ctrl_n.P15.GatPoly VSS.$301.Metal1 0.000285852f
Cred_9321 di_tg_ctrl_n.P15.GatPoly VSS.$606.Metal2 3.02035e-05f
Cred_9322 di_tg_ctrl_n.P15.GatPoly VSS.$760.Metal3 1.7871e-06f
Cred_9323 di_tg_ctrl_n.P15.GatPoly VSS.P0.pSD 0.0025102f
Cred_9324 di_tg_ctrl_n.P16.GatPoly VSS 0.013717f
Cred_9325 di_tg_ctrl_n.P16.GatPoly v_b 0.00206324f
Cred_9326 di_tg_ctrl_n.P16.GatPoly v_b.$3629.Metal2 0.0284541f
Cred_9327 di_tg_ctrl_n.P16.GatPoly v_b.$4042.Metal3 0.0133527f
Cred_9328 di_tg_ctrl_n.P16.GatPoly v_b.$4053.Metal3 0.00023964f
Cred_9329 di_tg_ctrl_n.P16.GatPoly v_b.P67.nSD 0.0125167f
Cred_9330 di_tg_ctrl_n.P16.GatPoly v_b.P69.nSD 0.0156105f
Cred_9331 di_tg_ctrl_n.P16.GatPoly v_b.P71.nSD 4.62983e-05f
Cred_9332 di_tg_ctrl_n.P16.GatPoly VSS.$17.Metal1 6.41858e-07f
Cred_9333 di_tg_ctrl_n.P16.GatPoly VSS.$301.Metal1 0.000434319f
Cred_9334 di_tg_ctrl_n.P16.GatPoly VSS.$606.Metal2 4.34783e-05f
Cred_9335 di_tg_ctrl_n.P16.GatPoly VSS.$760.Metal3 2.53698e-06f
Cred_9336 di_tg_ctrl_n.P16.GatPoly VSS.P0.pSD 0.00259727f
Cred_9337 di_tg_ctrl_n.P17.GatPoly VSS 0.020667f
Cred_9338 di_tg_ctrl_n.P17.GatPoly v_b 0.0245719f
Cred_9339 di_tg_ctrl_n.P17.GatPoly v_b.$3629.Metal2 3.94221e-05f
Cred_9340 di_tg_ctrl_n.P17.GatPoly v_b.$4042.Metal3 0.013749f
Cred_9341 di_tg_ctrl_n.P17.GatPoly v_b.$4053.Metal3 0.000277357f
Cred_9342 di_tg_ctrl_n.P17.GatPoly v_b.P67.nSD 3.66038e-05f
Cred_9343 di_tg_ctrl_n.P17.GatPoly v_b.P69.nSD 0.0168541f
Cred_9344 di_tg_ctrl_n.P17.GatPoly v_b.P71.nSD 0.0164459f
Cred_9345 di_tg_ctrl_n.P17.GatPoly VSS.$17.Metal1 5.93516e-07f
Cred_9346 di_tg_ctrl_n.P17.GatPoly VSS.$301.Metal1 0.00784462f
Cred_9347 di_tg_ctrl_n.P17.GatPoly VSS.$606.Metal2 0.00332251f
Cred_9348 di_tg_ctrl_n.P17.GatPoly VSS.$760.Metal3 0.00154098f
Cred_9349 di_tg_ctrl_n.P17.GatPoly VSS.P0.pSD 0.00304145f
Cred_9350 di_tg_ctrl_n.P18.GatPoly VSS 0.00231899f
Cred_9351 di_tg_ctrl_n.P18.GatPoly v_a 0.000352569f
Cred_9352 di_tg_ctrl_n.P18.GatPoly v_a.$1152.Metal2 0.000326681f
Cred_9353 di_tg_ctrl_n.P18.GatPoly v_a.$1154.Metal2 2.13729e-05f
Cred_9354 di_tg_ctrl_n.P18.GatPoly v_a.$1156.Metal2 6.96958e-05f
Cred_9355 di_tg_ctrl_n.P18.GatPoly v_a.$1158.Metal2 7.54503e-05f
Cred_9356 di_tg_ctrl_n.P18.GatPoly v_a.$1160.Metal2 1.40376e-05f
Cred_9357 di_tg_ctrl_n.P18.GatPoly v_a.$1162.Metal2 3.3001e-05f
Cred_9358 di_tg_ctrl_n.P18.GatPoly v_a.$1164.Metal2 3.11889e-05f
Cred_9359 di_tg_ctrl_n.P18.GatPoly v_a.$1166.Metal2 1.74593e-05f
Cred_9360 di_tg_ctrl_n.P18.GatPoly v_a.$1168.Metal2 0.000314584f
Cred_9361 di_tg_ctrl_n.P18.GatPoly v_a.$1170.Metal2 0.00509824f
Cred_9362 di_tg_ctrl_n.P18.GatPoly v_a.$2187.Metal3 0.000745841f
Cred_9363 di_tg_ctrl_n.P18.GatPoly v_a.$2197.Metal3 0.00216999f
Cred_9364 di_tg_ctrl_n.P18.GatPoly v_a.$39.Metal1 0.0127577f
Cred_9365 di_tg_ctrl_n.P18.GatPoly v_a.$41.Metal1 0.0332679f
Cred_9366 di_tg_ctrl_n.P18.GatPoly v_a.$44.Metal1 0.00954049f
Cred_9367 di_tg_ctrl_n.P18.GatPoly v_a.$46.Metal1 0.00766745f
Cred_9368 di_tg_ctrl_n.P18.GatPoly v_a.$48.Metal1 0.0225062f
Cred_9369 di_tg_ctrl_n.P18.GatPoly v_a.P0.pSD 0.00668657f
Cred_9370 di_tg_ctrl_n.P18.GatPoly v_b.$2361.Metal2 0.0331329f
Cred_9371 di_tg_ctrl_n.P18.GatPoly v_b.P0.nSD 0.000297868f
Cred_9372 di_tg_ctrl_n.P18.GatPoly v_b.P0.pSD 0.0619789f
Cred_9373 di_tg_ctrl_n.P18.GatPoly v_b.P1.pSD 8.8028e-05f
Cred_9374 di_tg_ctrl_n.P18.GatPoly VDD.$340.Metal1 1.85546e-07f
Cred_9375 di_tg_ctrl_n.P18.GatPoly VDD.$388.Metal2 0.00410525f
Cred_9376 di_tg_ctrl_n.P18.GatPoly VDD.$392.Metal2 9.52928e-06f
Cred_9377 di_tg_ctrl_n.P18.GatPoly VDD.$42.Metal1 0.015488f
Cred_9378 di_tg_ctrl_n.P18.GatPoly VDD.$55.Metal1 0.00163479f
Cred_9379 di_tg_ctrl_n.P18.GatPoly VDD.$666.Metal3 0.00205488f
Cred_9380 di_tg_ctrl_n.P18.GatPoly VDD.P0.nSD 0.00376542f
Cred_9381 di_tg_ctrl_n.P19.GatPoly VSS 5.49285e-05f
Cred_9382 di_tg_ctrl_n.P19.GatPoly v_a 0.0098947f
Cred_9383 di_tg_ctrl_n.P19.GatPoly v_a.$1152.Metal2 0.000767621f
Cred_9384 di_tg_ctrl_n.P19.GatPoly v_a.$1154.Metal2 2.13729e-05f
Cred_9385 di_tg_ctrl_n.P19.GatPoly v_a.$1156.Metal2 6.96958e-05f
Cred_9386 di_tg_ctrl_n.P19.GatPoly v_a.$1158.Metal2 7.54503e-05f
Cred_9387 di_tg_ctrl_n.P19.GatPoly v_a.$1160.Metal2 1.40376e-05f
Cred_9388 di_tg_ctrl_n.P19.GatPoly v_a.$1162.Metal2 3.3001e-05f
Cred_9389 di_tg_ctrl_n.P19.GatPoly v_a.$1164.Metal2 3.11889e-05f
Cred_9390 di_tg_ctrl_n.P19.GatPoly v_a.$1166.Metal2 1.74593e-05f
Cred_9391 di_tg_ctrl_n.P19.GatPoly v_a.$1168.Metal2 0.000306979f
Cred_9392 di_tg_ctrl_n.P19.GatPoly v_a.$1170.Metal2 0.00483908f
Cred_9393 di_tg_ctrl_n.P19.GatPoly v_a.$2187.Metal3 0.0208592f
Cred_9394 di_tg_ctrl_n.P19.GatPoly v_a.$2197.Metal3 0.00203469f
Cred_9395 di_tg_ctrl_n.P19.GatPoly v_a.$39.Metal1 0.0127788f
Cred_9396 di_tg_ctrl_n.P19.GatPoly v_a.$41.Metal1 0.00953463f
Cred_9397 di_tg_ctrl_n.P19.GatPoly v_a.$44.Metal1 0.00954049f
Cred_9398 di_tg_ctrl_n.P19.GatPoly v_a.$46.Metal1 0.00766745f
Cred_9399 di_tg_ctrl_n.P19.GatPoly v_a.$48.Metal1 0.0220979f
Cred_9400 di_tg_ctrl_n.P19.GatPoly v_a.P0.pSD 0.0063206f
Cred_9401 di_tg_ctrl_n.P19.GatPoly v_b.$2361.Metal2 0.0398243f
Cred_9402 di_tg_ctrl_n.P19.GatPoly v_b.P0.nSD 3.45742e-07f
Cred_9403 di_tg_ctrl_n.P19.GatPoly v_b.P0.pSD 0.000173724f
Cred_9404 di_tg_ctrl_n.P19.GatPoly v_b.P1.pSD 0.0540663f
Cred_9405 di_tg_ctrl_n.P19.GatPoly VDD.$340.Metal1 2.10304e-07f
Cred_9406 di_tg_ctrl_n.P19.GatPoly VDD.$388.Metal2 3.05495e-06f
Cred_9407 di_tg_ctrl_n.P19.GatPoly VDD.$392.Metal2 3.36621e-08f
Cred_9408 di_tg_ctrl_n.P19.GatPoly VDD.$42.Metal1 0.000173455f
Cred_9409 di_tg_ctrl_n.P19.GatPoly VDD.$55.Metal1 5.77488e-06f
Cred_9410 di_tg_ctrl_n.P19.GatPoly VDD.$666.Metal3 1.31055e-07f
Cred_9411 di_tg_ctrl_n.P19.GatPoly VDD.P0.nSD 0.00390942f
Cred_9412 di_tg_ctrl_n.P2.GatPoly VSS 0.0127817f
Cred_9413 di_tg_ctrl_n.P2.GatPoly v_b.$2962.Metal2 0.023404f
Cred_9414 di_tg_ctrl_n.P2.GatPoly v_b.$3053.Metal2 0.00590692f
Cred_9415 di_tg_ctrl_n.P2.GatPoly v_b.$3056.Metal2 7.32522e-06f
Cred_9416 di_tg_ctrl_n.P2.GatPoly v_b.$3779.Metal3 0.000517603f
Cred_9417 di_tg_ctrl_n.P2.GatPoly v_b.$3785.Metal3 0.0134077f
Cred_9418 di_tg_ctrl_n.P2.GatPoly v_b.P39.nSD 0.0125127f
Cred_9419 di_tg_ctrl_n.P2.GatPoly v_b.P41.nSD 0.0150648f
Cred_9420 di_tg_ctrl_n.P2.GatPoly v_b.P43.nSD 6.80155e-06f
Cred_9421 di_tg_ctrl_n.P2.GatPoly VSS.$17.Metal1 3.68843e-06f
Cred_9422 di_tg_ctrl_n.P2.GatPoly VSS.$231.Metal1 1.74466e-05f
Cred_9423 di_tg_ctrl_n.P2.GatPoly VSS.$239.Metal1 1.74477e-05f
Cred_9424 di_tg_ctrl_n.P2.GatPoly VSS.$301.Metal1 5.63039e-05f
Cred_9425 di_tg_ctrl_n.P2.GatPoly VSS.$542.Metal2 1.34571e-07f
Cred_9426 di_tg_ctrl_n.P2.GatPoly VSS.$606.Metal2 5.94916e-06f
Cred_9427 di_tg_ctrl_n.P2.GatPoly VSS.$760.Metal3 3.52004e-07f
Cred_9428 di_tg_ctrl_n.P2.GatPoly VSS.P0.pSD 0.00276251f
Cred_9429 di_tg_ctrl_n.P20.GatPoly VSS 9.53058e-05f
Cred_9430 di_tg_ctrl_n.P20.GatPoly v_a.$102.Metal1 0.012747f
Cred_9431 di_tg_ctrl_n.P20.GatPoly v_a.$104.Metal1 0.00578062f
Cred_9432 di_tg_ctrl_n.P20.GatPoly v_a.$105.Metal1 0.00762434f
Cred_9433 di_tg_ctrl_n.P20.GatPoly v_a.$108.Metal1 0.00953374f
Cred_9434 di_tg_ctrl_n.P20.GatPoly v_a.$110.Metal1 0.00577834f
Cred_9435 di_tg_ctrl_n.P20.GatPoly v_a.$111.Metal1 0.00761813f
Cred_9436 di_tg_ctrl_n.P20.GatPoly v_a.$114.Metal1 0.00956049f
Cred_9437 di_tg_ctrl_n.P20.GatPoly v_a.$116.Metal1 0.00767103f
Cred_9438 di_tg_ctrl_n.P20.GatPoly v_a.$118.Metal1 0.00779228f
Cred_9439 di_tg_ctrl_n.P20.GatPoly v_a.$1208.Metal2 0.000302548f
Cred_9440 di_tg_ctrl_n.P20.GatPoly v_a.$1210.Metal2 2.85616e-05f
Cred_9441 di_tg_ctrl_n.P20.GatPoly v_a.$1212.Metal2 2.39448e-05f
Cred_9442 di_tg_ctrl_n.P20.GatPoly v_a.$1216.Metal2 7.91398e-05f
Cred_9443 di_tg_ctrl_n.P20.GatPoly v_a.$1218.Metal2 6.63104e-05f
Cred_9444 di_tg_ctrl_n.P20.GatPoly v_a.$1220.Metal2 2.44253e-05f
Cred_9445 di_tg_ctrl_n.P20.GatPoly v_a.$1222.Metal2 2.70391e-05f
Cred_9446 di_tg_ctrl_n.P20.GatPoly v_a.$1224.Metal2 7.40587e-06f
Cred_9447 di_tg_ctrl_n.P20.GatPoly v_a.$1226.Metal2 7.30492e-05f
Cred_9448 di_tg_ctrl_n.P20.GatPoly v_a.$1228.Metal2 7.24099e-05f
Cred_9449 di_tg_ctrl_n.P20.GatPoly v_a.$1230.Metal2 1.84054e-05f
Cred_9450 di_tg_ctrl_n.P20.GatPoly v_a.$1232.Metal2 3.0735e-05f
Cred_9451 di_tg_ctrl_n.P20.GatPoly v_a.$1234.Metal2 3.3414e-05f
Cred_9452 di_tg_ctrl_n.P20.GatPoly v_a.$1236.Metal2 1.31415e-05f
Cred_9453 di_tg_ctrl_n.P20.GatPoly v_a.$1238.Metal2 4.08913e-05f
Cred_9454 di_tg_ctrl_n.P20.GatPoly v_a.$1240.Metal2 0.000195735f
Cred_9455 di_tg_ctrl_n.P20.GatPoly v_a.$2215.Metal3 0.0320336f
Cred_9456 di_tg_ctrl_n.P20.GatPoly v_a.$2219.Metal3 4.90975e-08f
Cred_9457 di_tg_ctrl_n.P20.GatPoly v_a.$2227.Metal3 2.66061e-09f
Cred_9458 di_tg_ctrl_n.P20.GatPoly v_a.$2233.Metal3 2.06176e-05f
Cred_9459 di_tg_ctrl_n.P20.GatPoly v_a.P2.pSD 0.000602299f
Cred_9460 di_tg_ctrl_n.P20.GatPoly v_b.$2361.Metal2 0.0398538f
Cred_9461 di_tg_ctrl_n.P20.GatPoly v_b.P1.pSD 0.0543032f
Cred_9462 di_tg_ctrl_n.P20.GatPoly VDD.$340.Metal1 2.39183e-07f
Cred_9463 di_tg_ctrl_n.P20.GatPoly VDD.$388.Metal2 2.42165e-06f
Cred_9464 di_tg_ctrl_n.P20.GatPoly VDD.$392.Metal2 1.87601e-07f
Cred_9465 di_tg_ctrl_n.P20.GatPoly VDD.$400.Metal2 2.81703e-08f
Cred_9466 di_tg_ctrl_n.P20.GatPoly VDD.$42.Metal1 0.000120267f
Cred_9467 di_tg_ctrl_n.P20.GatPoly VDD.$55.Metal1 5.75833e-05f
Cred_9468 di_tg_ctrl_n.P20.GatPoly VDD.$59.Metal1 1.25846e-05f
Cred_9469 di_tg_ctrl_n.P20.GatPoly VDD.$666.Metal3 1.03122e-07f
Cred_9470 di_tg_ctrl_n.P20.GatPoly VDD.$670.Metal3 2.25863e-10f
Cred_9471 di_tg_ctrl_n.P20.GatPoly VDD.P0.nSD 0.00377189f
Cred_9472 di_tg_ctrl_n.P21.GatPoly v_a.$102.Metal1 0.012747f
Cred_9473 di_tg_ctrl_n.P21.GatPoly v_a.$104.Metal1 0.00578062f
Cred_9474 di_tg_ctrl_n.P21.GatPoly v_a.$105.Metal1 0.00762434f
Cred_9475 di_tg_ctrl_n.P21.GatPoly v_a.$108.Metal1 0.00953374f
Cred_9476 di_tg_ctrl_n.P21.GatPoly v_a.$110.Metal1 0.00577834f
Cred_9477 di_tg_ctrl_n.P21.GatPoly v_a.$111.Metal1 0.00761813f
Cred_9478 di_tg_ctrl_n.P21.GatPoly v_a.$114.Metal1 0.00953691f
Cred_9479 di_tg_ctrl_n.P21.GatPoly v_a.$116.Metal1 0.00766734f
Cred_9480 di_tg_ctrl_n.P21.GatPoly v_a.$118.Metal1 0.0074593f
Cred_9481 di_tg_ctrl_n.P21.GatPoly v_a.$1208.Metal2 0.000302548f
Cred_9482 di_tg_ctrl_n.P21.GatPoly v_a.$1210.Metal2 2.85616e-05f
Cred_9483 di_tg_ctrl_n.P21.GatPoly v_a.$1212.Metal2 2.39448e-05f
Cred_9484 di_tg_ctrl_n.P21.GatPoly v_a.$1216.Metal2 7.91398e-05f
Cred_9485 di_tg_ctrl_n.P21.GatPoly v_a.$1218.Metal2 6.63104e-05f
Cred_9486 di_tg_ctrl_n.P21.GatPoly v_a.$1220.Metal2 2.44253e-05f
Cred_9487 di_tg_ctrl_n.P21.GatPoly v_a.$1222.Metal2 2.70391e-05f
Cred_9488 di_tg_ctrl_n.P21.GatPoly v_a.$1224.Metal2 7.40587e-06f
Cred_9489 di_tg_ctrl_n.P21.GatPoly v_a.$1226.Metal2 7.30492e-05f
Cred_9490 di_tg_ctrl_n.P21.GatPoly v_a.$1228.Metal2 7.24099e-05f
Cred_9491 di_tg_ctrl_n.P21.GatPoly v_a.$1230.Metal2 1.8275e-05f
Cred_9492 di_tg_ctrl_n.P21.GatPoly v_a.$1232.Metal2 3.06942e-05f
Cred_9493 di_tg_ctrl_n.P21.GatPoly v_a.$1234.Metal2 3.3414e-05f
Cred_9494 di_tg_ctrl_n.P21.GatPoly v_a.$1236.Metal2 1.31415e-05f
Cred_9495 di_tg_ctrl_n.P21.GatPoly v_a.$1238.Metal2 3.42053e-05f
Cred_9496 di_tg_ctrl_n.P21.GatPoly v_a.$1240.Metal2 0.000103759f
Cred_9497 di_tg_ctrl_n.P21.GatPoly v_a.$2215.Metal3 0.0315556f
Cred_9498 di_tg_ctrl_n.P21.GatPoly v_a.$2219.Metal3 4.90975e-08f
Cred_9499 di_tg_ctrl_n.P21.GatPoly v_a.$2233.Metal3 9.7297e-06f
Cred_9500 di_tg_ctrl_n.P21.GatPoly v_a.P2.pSD 0.000526366f
Cred_9501 di_tg_ctrl_n.P21.GatPoly v_b.$2361.Metal2 0.019569f
Cred_9502 di_tg_ctrl_n.P21.GatPoly v_b.$2421.Metal2 0.019569f
Cred_9503 di_tg_ctrl_n.P21.GatPoly v_b.P3.nSD 0.000216542f
Cred_9504 di_tg_ctrl_n.P21.GatPoly v_b.P3.pSD 0.0543265f
Cred_9505 di_tg_ctrl_n.P21.GatPoly VDD.$340.Metal1 2.60397e-07f
Cred_9506 di_tg_ctrl_n.P21.GatPoly VDD.$388.Metal2 2.15019e-06f
Cred_9507 di_tg_ctrl_n.P21.GatPoly VDD.$42.Metal1 0.000100961f
Cred_9508 di_tg_ctrl_n.P21.GatPoly VDD.$666.Metal3 9.46629e-08f
Cred_9509 di_tg_ctrl_n.P21.GatPoly VDD.P0.nSD 0.00378102f
Cred_9510 di_tg_ctrl_n.P22.GatPoly v_a.$1268.Metal2 0.000631383f
Cred_9511 di_tg_ctrl_n.P22.GatPoly v_a.$1270.Metal2 2.13729e-05f
Cred_9512 di_tg_ctrl_n.P22.GatPoly v_a.$1272.Metal2 3.86136e-05f
Cred_9513 di_tg_ctrl_n.P22.GatPoly v_a.$1276.Metal2 3.60219e-05f
Cred_9514 di_tg_ctrl_n.P22.GatPoly v_a.$1278.Metal2 2.44253e-05f
Cred_9515 di_tg_ctrl_n.P22.GatPoly v_a.$1280.Metal2 2.70391e-05f
Cred_9516 di_tg_ctrl_n.P22.GatPoly v_a.$1282.Metal2 3.58528e-05f
Cred_9517 di_tg_ctrl_n.P22.GatPoly v_a.$1284.Metal2 6.4113e-06f
Cred_9518 di_tg_ctrl_n.P22.GatPoly v_a.$1286.Metal2 4.20424e-05f
Cred_9519 di_tg_ctrl_n.P22.GatPoly v_a.$1290.Metal2 3.06286e-05f
Cred_9520 di_tg_ctrl_n.P22.GatPoly v_a.$1292.Metal2 2.35269e-05f
Cred_9521 di_tg_ctrl_n.P22.GatPoly v_a.$1294.Metal2 0.000464531f
Cred_9522 di_tg_ctrl_n.P22.GatPoly v_a.$138.Metal1 0.00768446f
Cred_9523 di_tg_ctrl_n.P22.GatPoly v_a.$165.Metal1 0.0127723f
Cred_9524 di_tg_ctrl_n.P22.GatPoly v_a.$167.Metal1 0.00772429f
Cred_9525 di_tg_ctrl_n.P22.GatPoly v_a.$171.Metal1 0.00764134f
Cred_9526 di_tg_ctrl_n.P22.GatPoly v_a.$173.Metal1 0.00769508f
Cred_9527 di_tg_ctrl_n.P22.GatPoly v_a.$175.Metal1 0.00767964f
Cred_9528 di_tg_ctrl_n.P22.GatPoly v_a.$177.Metal1 0.00577976f
Cred_9529 di_tg_ctrl_n.P22.GatPoly v_a.$178.Metal1 0.00577879f
Cred_9530 di_tg_ctrl_n.P22.GatPoly v_a.$180.Metal1 0.0105913f
Cred_9531 di_tg_ctrl_n.P22.GatPoly v_a.$2237.Metal3 0.0163974f
Cred_9532 di_tg_ctrl_n.P22.GatPoly v_a.$2247.Metal3 0.0146447f
Cred_9533 di_tg_ctrl_n.P22.GatPoly v_a.$2257.Metal3 7.32096e-08f
Cred_9534 di_tg_ctrl_n.P22.GatPoly v_a.$2261.Metal3 8.81741e-05f
Cred_9535 di_tg_ctrl_n.P22.GatPoly v_a.P4.pSD 0.000729279f
Cred_9536 di_tg_ctrl_n.P22.GatPoly v_b.$2361.Metal2 0.019569f
Cred_9537 di_tg_ctrl_n.P22.GatPoly v_b.$2421.Metal2 0.019569f
Cred_9538 di_tg_ctrl_n.P22.GatPoly v_b.P3.nSD 0.000216542f
Cred_9539 di_tg_ctrl_n.P22.GatPoly v_b.P3.pSD 0.0543265f
Cred_9540 di_tg_ctrl_n.P22.GatPoly VDD.$340.Metal1 3.08725e-07f
Cred_9541 di_tg_ctrl_n.P22.GatPoly VDD.$388.Metal2 1.81191e-06f
Cred_9542 di_tg_ctrl_n.P22.GatPoly VDD.$42.Metal1 8.50772e-05f
Cred_9543 di_tg_ctrl_n.P22.GatPoly VDD.$666.Metal3 7.977e-08f
Cred_9544 di_tg_ctrl_n.P22.GatPoly VDD.P0.nSD 0.00379721f
Cred_9545 di_tg_ctrl_n.P23.GatPoly VSS 9.53025e-05f
Cred_9546 di_tg_ctrl_n.P23.GatPoly v_a.$1268.Metal2 0.000633299f
Cred_9547 di_tg_ctrl_n.P23.GatPoly v_a.$1270.Metal2 2.13729e-05f
Cred_9548 di_tg_ctrl_n.P23.GatPoly v_a.$1272.Metal2 3.86136e-05f
Cred_9549 di_tg_ctrl_n.P23.GatPoly v_a.$1276.Metal2 3.60219e-05f
Cred_9550 di_tg_ctrl_n.P23.GatPoly v_a.$1278.Metal2 2.44253e-05f
Cred_9551 di_tg_ctrl_n.P23.GatPoly v_a.$1280.Metal2 2.70391e-05f
Cred_9552 di_tg_ctrl_n.P23.GatPoly v_a.$1282.Metal2 3.58528e-05f
Cred_9553 di_tg_ctrl_n.P23.GatPoly v_a.$1284.Metal2 6.4113e-06f
Cred_9554 di_tg_ctrl_n.P23.GatPoly v_a.$1286.Metal2 4.20965e-05f
Cred_9555 di_tg_ctrl_n.P23.GatPoly v_a.$1290.Metal2 3.06827e-05f
Cred_9556 di_tg_ctrl_n.P23.GatPoly v_a.$1292.Metal2 2.35269e-05f
Cred_9557 di_tg_ctrl_n.P23.GatPoly v_a.$1294.Metal2 0.000564801f
Cred_9558 di_tg_ctrl_n.P23.GatPoly v_a.$138.Metal1 0.00768446f
Cred_9559 di_tg_ctrl_n.P23.GatPoly v_a.$165.Metal1 0.0127724f
Cred_9560 di_tg_ctrl_n.P23.GatPoly v_a.$167.Metal1 0.00772429f
Cred_9561 di_tg_ctrl_n.P23.GatPoly v_a.$171.Metal1 0.00764134f
Cred_9562 di_tg_ctrl_n.P23.GatPoly v_a.$173.Metal1 0.00769508f
Cred_9563 di_tg_ctrl_n.P23.GatPoly v_a.$175.Metal1 0.00767964f
Cred_9564 di_tg_ctrl_n.P23.GatPoly v_a.$177.Metal1 0.0057997f
Cred_9565 di_tg_ctrl_n.P23.GatPoly v_a.$178.Metal1 0.00578622f
Cred_9566 di_tg_ctrl_n.P23.GatPoly v_a.$180.Metal1 0.010882f
Cred_9567 di_tg_ctrl_n.P23.GatPoly v_a.$2237.Metal3 0.0164953f
Cred_9568 di_tg_ctrl_n.P23.GatPoly v_a.$2247.Metal3 0.0147321f
Cred_9569 di_tg_ctrl_n.P23.GatPoly v_a.$2257.Metal3 7.42421e-08f
Cred_9570 di_tg_ctrl_n.P23.GatPoly v_a.$2261.Metal3 0.000116155f
Cred_9571 di_tg_ctrl_n.P23.GatPoly v_a.P4.pSD 0.000828751f
Cred_9572 di_tg_ctrl_n.P23.GatPoly v_b.$2421.Metal2 0.0405204f
Cred_9573 di_tg_ctrl_n.P23.GatPoly v_b.P5.pSD 0.0544096f
Cred_9574 di_tg_ctrl_n.P23.GatPoly VDD.$340.Metal1 3.36193e-07f
Cred_9575 di_tg_ctrl_n.P23.GatPoly VDD.$388.Metal2 1.66329e-06f
Cred_9576 di_tg_ctrl_n.P23.GatPoly VDD.$400.Metal2 4.80467e-09f
Cred_9577 di_tg_ctrl_n.P23.GatPoly VDD.$404.Metal2 2.88696e-08f
Cred_9578 di_tg_ctrl_n.P23.GatPoly VDD.$412.Metal2 8.7804e-08f
Cred_9579 di_tg_ctrl_n.P23.GatPoly VDD.$42.Metal1 7.80991e-05f
Cred_9580 di_tg_ctrl_n.P23.GatPoly VDD.$59.Metal1 1.50306e-06f
Cred_9581 di_tg_ctrl_n.P23.GatPoly VDD.$666.Metal3 7.32272e-08f
Cred_9582 di_tg_ctrl_n.P23.GatPoly VDD.$67.Metal1 1.30422e-05f
Cred_9583 di_tg_ctrl_n.P23.GatPoly VDD.$676.Metal3 9.96505e-11f
Cred_9584 di_tg_ctrl_n.P23.GatPoly VDD.$71.Metal1 5.49657e-05f
Cred_9585 di_tg_ctrl_n.P23.GatPoly VDD.$77.Metal1 1.3362e-05f
Cred_9586 di_tg_ctrl_n.P23.GatPoly VDD.P0.nSD 0.00380434f
Cred_9587 di_tg_ctrl_n.P24.GatPoly VSS 1.38799e-05f
Cred_9588 di_tg_ctrl_n.P24.GatPoly v_a.$1324.Metal2 0.000302548f
Cred_9589 di_tg_ctrl_n.P24.GatPoly v_a.$1326.Metal2 2.85616e-05f
Cred_9590 di_tg_ctrl_n.P24.GatPoly v_a.$1328.Metal2 2.39448e-05f
Cred_9591 di_tg_ctrl_n.P24.GatPoly v_a.$1332.Metal2 4.10824e-05f
Cred_9592 di_tg_ctrl_n.P24.GatPoly v_a.$1334.Metal2 1.40376e-05f
Cred_9593 di_tg_ctrl_n.P24.GatPoly v_a.$1336.Metal2 3.3001e-05f
Cred_9594 di_tg_ctrl_n.P24.GatPoly v_a.$1338.Metal2 3.11889e-05f
Cred_9595 di_tg_ctrl_n.P24.GatPoly v_a.$1340.Metal2 1.74593e-05f
Cred_9596 di_tg_ctrl_n.P24.GatPoly v_a.$1342.Metal2 7.30492e-05f
Cred_9597 di_tg_ctrl_n.P24.GatPoly v_a.$1344.Metal2 7.24099e-05f
Cred_9598 di_tg_ctrl_n.P24.GatPoly v_a.$1346.Metal2 1.83269e-05f
Cred_9599 di_tg_ctrl_n.P24.GatPoly v_a.$1348.Metal2 3.07104e-05f
Cred_9600 di_tg_ctrl_n.P24.GatPoly v_a.$1350.Metal2 0.000106758f
Cred_9601 di_tg_ctrl_n.P24.GatPoly v_a.$1352.Metal2 0.00102064f
Cred_9602 di_tg_ctrl_n.P24.GatPoly v_a.$2275.Metal3 0.0313683f
Cred_9603 di_tg_ctrl_n.P24.GatPoly v_a.$2279.Metal3 4.90975e-08f
Cred_9604 di_tg_ctrl_n.P24.GatPoly v_a.$228.Metal1 0.012747f
Cred_9605 di_tg_ctrl_n.P24.GatPoly v_a.$2291.Metal3 0.000186543f
Cred_9606 di_tg_ctrl_n.P24.GatPoly v_a.$230.Metal1 0.00578062f
Cred_9607 di_tg_ctrl_n.P24.GatPoly v_a.$231.Metal1 0.00578294f
Cred_9608 di_tg_ctrl_n.P24.GatPoly v_a.$233.Metal1 0.00767374f
Cred_9609 di_tg_ctrl_n.P24.GatPoly v_a.$235.Metal1 0.00766745f
Cred_9610 di_tg_ctrl_n.P24.GatPoly v_a.$237.Metal1 0.00953743f
Cred_9611 di_tg_ctrl_n.P24.GatPoly v_a.$240.Metal1 0.0095463f
Cred_9612 di_tg_ctrl_n.P24.GatPoly v_a.$242.Metal1 0.0133969f
Cred_9613 di_tg_ctrl_n.P24.GatPoly v_a.P6.pSD 0.00130486f
Cred_9614 di_tg_ctrl_n.P24.GatPoly v_b.$2421.Metal2 0.0404547f
Cred_9615 di_tg_ctrl_n.P24.GatPoly v_b.P5.pSD 0.0541817f
Cred_9616 di_tg_ctrl_n.P24.GatPoly VDD.$340.Metal1 3.98744e-07f
Cred_9617 di_tg_ctrl_n.P24.GatPoly VDD.$388.Metal2 1.40166e-06f
Cred_9618 di_tg_ctrl_n.P24.GatPoly VDD.$412.Metal2 9.81175e-09f
Cred_9619 di_tg_ctrl_n.P24.GatPoly VDD.$42.Metal1 6.5814e-05f
Cred_9620 di_tg_ctrl_n.P24.GatPoly VDD.$420.Metal2 9.81175e-09f
Cred_9621 di_tg_ctrl_n.P24.GatPoly VDD.$666.Metal3 6.17085e-08f
Cred_9622 di_tg_ctrl_n.P24.GatPoly VDD.$680.Metal3 7.86684e-11f
Cred_9623 di_tg_ctrl_n.P24.GatPoly VDD.$77.Metal1 9.56346e-06f
Cred_9624 di_tg_ctrl_n.P24.GatPoly VDD.$81.Metal1 4.57383e-06f
Cred_9625 di_tg_ctrl_n.P24.GatPoly VDD.P0.nSD 0.00381681f
Cred_9626 di_tg_ctrl_n.P25.GatPoly v_a.$1324.Metal2 0.000302548f
Cred_9627 di_tg_ctrl_n.P25.GatPoly v_a.$1326.Metal2 2.85616e-05f
Cred_9628 di_tg_ctrl_n.P25.GatPoly v_a.$1328.Metal2 2.39448e-05f
Cred_9629 di_tg_ctrl_n.P25.GatPoly v_a.$1332.Metal2 4.10824e-05f
Cred_9630 di_tg_ctrl_n.P25.GatPoly v_a.$1334.Metal2 1.40376e-05f
Cred_9631 di_tg_ctrl_n.P25.GatPoly v_a.$1336.Metal2 3.3001e-05f
Cred_9632 di_tg_ctrl_n.P25.GatPoly v_a.$1338.Metal2 3.11889e-05f
Cred_9633 di_tg_ctrl_n.P25.GatPoly v_a.$1340.Metal2 1.74593e-05f
Cred_9634 di_tg_ctrl_n.P25.GatPoly v_a.$1342.Metal2 7.30492e-05f
Cred_9635 di_tg_ctrl_n.P25.GatPoly v_a.$1344.Metal2 7.24099e-05f
Cred_9636 di_tg_ctrl_n.P25.GatPoly v_a.$1346.Metal2 1.8275e-05f
Cred_9637 di_tg_ctrl_n.P25.GatPoly v_a.$1348.Metal2 3.06942e-05f
Cred_9638 di_tg_ctrl_n.P25.GatPoly v_a.$1350.Metal2 0.000105446f
Cred_9639 di_tg_ctrl_n.P25.GatPoly v_a.$1352.Metal2 0.000974803f
Cred_9640 di_tg_ctrl_n.P25.GatPoly v_a.$2275.Metal3 0.0315556f
Cred_9641 di_tg_ctrl_n.P25.GatPoly v_a.$2279.Metal3 4.90975e-08f
Cred_9642 di_tg_ctrl_n.P25.GatPoly v_a.$228.Metal1 0.012747f
Cred_9643 di_tg_ctrl_n.P25.GatPoly v_a.$2291.Metal3 0.000174744f
Cred_9644 di_tg_ctrl_n.P25.GatPoly v_a.$230.Metal1 0.00578062f
Cred_9645 di_tg_ctrl_n.P25.GatPoly v_a.$231.Metal1 0.00578294f
Cred_9646 di_tg_ctrl_n.P25.GatPoly v_a.$233.Metal1 0.00767374f
Cred_9647 di_tg_ctrl_n.P25.GatPoly v_a.$235.Metal1 0.00766745f
Cred_9648 di_tg_ctrl_n.P25.GatPoly v_a.$237.Metal1 0.00953743f
Cred_9649 di_tg_ctrl_n.P25.GatPoly v_a.$240.Metal1 0.00953691f
Cred_9650 di_tg_ctrl_n.P25.GatPoly v_a.$242.Metal1 0.013293f
Cred_9651 di_tg_ctrl_n.P25.GatPoly v_a.P6.pSD 0.00125987f
Cred_9652 di_tg_ctrl_n.P25.GatPoly v_b.$2421.Metal2 0.019569f
Cred_9653 di_tg_ctrl_n.P25.GatPoly v_b.$2481.Metal2 0.019569f
Cred_9654 di_tg_ctrl_n.P25.GatPoly v_b.P7.nSD 0.000216542f
Cred_9655 di_tg_ctrl_n.P25.GatPoly v_b.P7.pSD 0.0543265f
Cred_9656 di_tg_ctrl_n.P25.GatPoly VDD.$340.Metal1 4.34286e-07f
Cred_9657 di_tg_ctrl_n.P25.GatPoly VDD.$388.Metal2 1.28671e-06f
Cred_9658 di_tg_ctrl_n.P25.GatPoly VDD.$42.Metal1 6.0417e-05f
Cred_9659 di_tg_ctrl_n.P25.GatPoly VDD.$666.Metal3 5.66481e-08f
Cred_9660 di_tg_ctrl_n.P25.GatPoly VDD.P0.nSD 0.0038223f
Cred_9661 di_tg_ctrl_n.P26.GatPoly v_a.$1384.Metal2 0.000631383f
Cred_9662 di_tg_ctrl_n.P26.GatPoly v_a.$1386.Metal2 2.13729e-05f
Cred_9663 di_tg_ctrl_n.P26.GatPoly v_a.$1388.Metal2 6.96958e-05f
Cred_9664 di_tg_ctrl_n.P26.GatPoly v_a.$1390.Metal2 7.54503e-05f
Cred_9665 di_tg_ctrl_n.P26.GatPoly v_a.$1392.Metal2 1.40376e-05f
Cred_9666 di_tg_ctrl_n.P26.GatPoly v_a.$1394.Metal2 3.3001e-05f
Cred_9667 di_tg_ctrl_n.P26.GatPoly v_a.$1396.Metal2 3.11889e-05f
Cred_9668 di_tg_ctrl_n.P26.GatPoly v_a.$1398.Metal2 1.74593e-05f
Cred_9669 di_tg_ctrl_n.P26.GatPoly v_a.$1400.Metal2 7.30492e-05f
Cred_9670 di_tg_ctrl_n.P26.GatPoly v_a.$1402.Metal2 7.24099e-05f
Cred_9671 di_tg_ctrl_n.P26.GatPoly v_a.$1404.Metal2 1.8275e-05f
Cred_9672 di_tg_ctrl_n.P26.GatPoly v_a.$1406.Metal2 3.06942e-05f
Cred_9673 di_tg_ctrl_n.P26.GatPoly v_a.$1408.Metal2 0.000105446f
Cred_9674 di_tg_ctrl_n.P26.GatPoly v_a.$1410.Metal2 0.000974803f
Cred_9675 di_tg_ctrl_n.P26.GatPoly v_a.$2297.Metal3 0.0163974f
Cred_9676 di_tg_ctrl_n.P26.GatPoly v_a.$2307.Metal3 0.0146447f
Cred_9677 di_tg_ctrl_n.P26.GatPoly v_a.$2321.Metal3 0.000174744f
Cred_9678 di_tg_ctrl_n.P26.GatPoly v_a.$291.Metal1 0.0127723f
Cred_9679 di_tg_ctrl_n.P26.GatPoly v_a.$293.Metal1 0.00953463f
Cred_9680 di_tg_ctrl_n.P26.GatPoly v_a.$296.Metal1 0.00954049f
Cred_9681 di_tg_ctrl_n.P26.GatPoly v_a.$298.Metal1 0.00766745f
Cred_9682 di_tg_ctrl_n.P26.GatPoly v_a.$300.Metal1 0.00953743f
Cred_9683 di_tg_ctrl_n.P26.GatPoly v_a.$303.Metal1 0.00953691f
Cred_9684 di_tg_ctrl_n.P26.GatPoly v_a.$305.Metal1 0.013293f
Cred_9685 di_tg_ctrl_n.P26.GatPoly v_a.P8.pSD 0.0013212f
Cred_9686 di_tg_ctrl_n.P26.GatPoly v_b.$2421.Metal2 0.019569f
Cred_9687 di_tg_ctrl_n.P26.GatPoly v_b.$2481.Metal2 0.019569f
Cred_9688 di_tg_ctrl_n.P26.GatPoly v_b.P7.nSD 0.000216542f
Cred_9689 di_tg_ctrl_n.P26.GatPoly v_b.P7.pSD 0.0543265f
Cred_9690 di_tg_ctrl_n.P26.GatPoly VDD.$340.Metal1 5.15208e-07f
Cred_9691 di_tg_ctrl_n.P26.GatPoly VDD.$388.Metal2 1.08436e-06f
Cred_9692 di_tg_ctrl_n.P26.GatPoly VDD.$42.Metal1 5.09158e-05f
Cred_9693 di_tg_ctrl_n.P26.GatPoly VDD.$666.Metal3 4.77396e-08f
Cred_9694 di_tg_ctrl_n.P26.GatPoly VDD.P0.nSD 0.00383193f
Cred_9695 di_tg_ctrl_n.P27.GatPoly VSS 1.38799e-05f
Cred_9696 di_tg_ctrl_n.P27.GatPoly v_a.$1384.Metal2 0.000633299f
Cred_9697 di_tg_ctrl_n.P27.GatPoly v_a.$1386.Metal2 2.13729e-05f
Cred_9698 di_tg_ctrl_n.P27.GatPoly v_a.$1388.Metal2 6.96958e-05f
Cred_9699 di_tg_ctrl_n.P27.GatPoly v_a.$1390.Metal2 7.54503e-05f
Cred_9700 di_tg_ctrl_n.P27.GatPoly v_a.$1392.Metal2 1.40376e-05f
Cred_9701 di_tg_ctrl_n.P27.GatPoly v_a.$1394.Metal2 3.3001e-05f
Cred_9702 di_tg_ctrl_n.P27.GatPoly v_a.$1396.Metal2 3.11889e-05f
Cred_9703 di_tg_ctrl_n.P27.GatPoly v_a.$1398.Metal2 1.74593e-05f
Cred_9704 di_tg_ctrl_n.P27.GatPoly v_a.$1400.Metal2 7.30492e-05f
Cred_9705 di_tg_ctrl_n.P27.GatPoly v_a.$1402.Metal2 7.24099e-05f
Cred_9706 di_tg_ctrl_n.P27.GatPoly v_a.$1404.Metal2 1.83269e-05f
Cred_9707 di_tg_ctrl_n.P27.GatPoly v_a.$1406.Metal2 3.07104e-05f
Cred_9708 di_tg_ctrl_n.P27.GatPoly v_a.$1408.Metal2 0.000106726f
Cred_9709 di_tg_ctrl_n.P27.GatPoly v_a.$1410.Metal2 0.00102152f
Cred_9710 di_tg_ctrl_n.P27.GatPoly v_a.$2297.Metal3 0.0164953f
Cred_9711 di_tg_ctrl_n.P27.GatPoly v_a.$2307.Metal3 0.0147321f
Cred_9712 di_tg_ctrl_n.P27.GatPoly v_a.$2321.Metal3 0.000187037f
Cred_9713 di_tg_ctrl_n.P27.GatPoly v_a.$291.Metal1 0.0127724f
Cred_9714 di_tg_ctrl_n.P27.GatPoly v_a.$293.Metal1 0.00953463f
Cred_9715 di_tg_ctrl_n.P27.GatPoly v_a.$296.Metal1 0.00954049f
Cred_9716 di_tg_ctrl_n.P27.GatPoly v_a.$298.Metal1 0.00766745f
Cred_9717 di_tg_ctrl_n.P27.GatPoly v_a.$300.Metal1 0.00953743f
Cred_9718 di_tg_ctrl_n.P27.GatPoly v_a.$303.Metal1 0.0095463f
Cred_9719 di_tg_ctrl_n.P27.GatPoly v_a.$305.Metal1 0.0133944f
Cred_9720 di_tg_ctrl_n.P27.GatPoly v_a.P8.pSD 0.00136738f
Cred_9721 di_tg_ctrl_n.P27.GatPoly v_b.$2481.Metal2 0.0404548f
Cred_9722 di_tg_ctrl_n.P27.GatPoly v_b.P10.pSD 0.0541816f
Cred_9723 di_tg_ctrl_n.P27.GatPoly VDD.$340.Metal1 5.61182e-07f
Cred_9724 di_tg_ctrl_n.P27.GatPoly VDD.$388.Metal2 9.95473e-07f
Cred_9725 di_tg_ctrl_n.P27.GatPoly VDD.$42.Metal1 4.67419e-05f
Cred_9726 di_tg_ctrl_n.P27.GatPoly VDD.$420.Metal2 2.74015e-09f
Cred_9727 di_tg_ctrl_n.P27.GatPoly VDD.$428.Metal2 3.41186e-08f
Cred_9728 di_tg_ctrl_n.P27.GatPoly VDD.$432.Metal2 1.29458e-08f
Cred_9729 di_tg_ctrl_n.P27.GatPoly VDD.$666.Metal3 4.38261e-08f
Cred_9730 di_tg_ctrl_n.P27.GatPoly VDD.$684.Metal3 2.19699e-11f
Cred_9731 di_tg_ctrl_n.P27.GatPoly VDD.$85.Metal1 1.17515e-06f
Cred_9732 di_tg_ctrl_n.P27.GatPoly VDD.$89.Metal1 8.47921e-06f
Cred_9733 di_tg_ctrl_n.P27.GatPoly VDD.$99.Metal1 2.37407e-06f
Cred_9734 di_tg_ctrl_n.P27.GatPoly VDD.P0.nSD 0.00383616f
Cred_9735 di_tg_ctrl_n.P28.GatPoly VSS 9.53025e-05f
Cred_9736 di_tg_ctrl_n.P28.GatPoly v_a.$1442.Metal2 0.000631383f
Cred_9737 di_tg_ctrl_n.P28.GatPoly v_a.$1444.Metal2 2.13729e-05f
Cred_9738 di_tg_ctrl_n.P28.GatPoly v_a.$1446.Metal2 6.96958e-05f
Cred_9739 di_tg_ctrl_n.P28.GatPoly v_a.$1448.Metal2 7.54503e-05f
Cred_9740 di_tg_ctrl_n.P28.GatPoly v_a.$1450.Metal2 1.40376e-05f
Cred_9741 di_tg_ctrl_n.P28.GatPoly v_a.$1452.Metal2 3.3001e-05f
Cred_9742 di_tg_ctrl_n.P28.GatPoly v_a.$1454.Metal2 3.11889e-05f
Cred_9743 di_tg_ctrl_n.P28.GatPoly v_a.$1456.Metal2 1.74593e-05f
Cred_9744 di_tg_ctrl_n.P28.GatPoly v_a.$1458.Metal2 7.30492e-05f
Cred_9745 di_tg_ctrl_n.P28.GatPoly v_a.$1460.Metal2 7.24099e-05f
Cred_9746 di_tg_ctrl_n.P28.GatPoly v_a.$1462.Metal2 1.84054e-05f
Cred_9747 di_tg_ctrl_n.P28.GatPoly v_a.$1464.Metal2 3.0735e-05f
Cred_9748 di_tg_ctrl_n.P28.GatPoly v_a.$1466.Metal2 0.000108742f
Cred_9749 di_tg_ctrl_n.P28.GatPoly v_a.$1468.Metal2 0.00108992f
Cred_9750 di_tg_ctrl_n.P28.GatPoly v_a.$2327.Metal3 0.0163974f
Cred_9751 di_tg_ctrl_n.P28.GatPoly v_a.$2337.Metal3 0.0146447f
Cred_9752 di_tg_ctrl_n.P28.GatPoly v_a.$2351.Metal3 0.000204376f
Cred_9753 di_tg_ctrl_n.P28.GatPoly v_a.$354.Metal1 0.0127723f
Cred_9754 di_tg_ctrl_n.P28.GatPoly v_a.$356.Metal1 0.00953463f
Cred_9755 di_tg_ctrl_n.P28.GatPoly v_a.$359.Metal1 0.00954049f
Cred_9756 di_tg_ctrl_n.P28.GatPoly v_a.$361.Metal1 0.00766745f
Cred_9757 di_tg_ctrl_n.P28.GatPoly v_a.$363.Metal1 0.00953743f
Cred_9758 di_tg_ctrl_n.P28.GatPoly v_a.$366.Metal1 0.00956049f
Cred_9759 di_tg_ctrl_n.P28.GatPoly v_a.$368.Metal1 0.0135541f
Cred_9760 di_tg_ctrl_n.P28.GatPoly v_a.P10.pSD 0.0014342f
Cred_9761 di_tg_ctrl_n.P28.GatPoly v_b.$2481.Metal2 0.0405202f
Cred_9762 di_tg_ctrl_n.P28.GatPoly v_b.P10.pSD 0.0544099f
Cred_9763 di_tg_ctrl_n.P28.GatPoly VDD.$107.Metal1 6.43014e-06f
Cred_9764 di_tg_ctrl_n.P28.GatPoly VDD.$340.Metal1 6.65843e-07f
Cred_9765 di_tg_ctrl_n.P28.GatPoly VDD.$388.Metal2 8.38992e-07f
Cred_9766 di_tg_ctrl_n.P28.GatPoly VDD.$42.Metal1 3.93944e-05f
Cred_9767 di_tg_ctrl_n.P28.GatPoly VDD.$428.Metal2 6.94858e-08f
Cred_9768 di_tg_ctrl_n.P28.GatPoly VDD.$432.Metal2 1.5923e-07f
Cred_9769 di_tg_ctrl_n.P28.GatPoly VDD.$436.Metal2 6.78937e-08f
Cred_9770 di_tg_ctrl_n.P28.GatPoly VDD.$440.Metal2 1.81363e-08f
Cred_9771 di_tg_ctrl_n.P28.GatPoly VDD.$666.Metal3 3.6937e-08f
Cred_9772 di_tg_ctrl_n.P28.GatPoly VDD.$89.Metal1 1.15481e-05f
Cred_9773 di_tg_ctrl_n.P28.GatPoly VDD.$99.Metal1 5.92898e-05f
Cred_9774 di_tg_ctrl_n.P28.GatPoly VDD.P0.nSD 0.00384362f
Cred_9775 di_tg_ctrl_n.P29.GatPoly v_a.$1442.Metal2 0.000633299f
Cred_9776 di_tg_ctrl_n.P29.GatPoly v_a.$1444.Metal2 2.13729e-05f
Cred_9777 di_tg_ctrl_n.P29.GatPoly v_a.$1446.Metal2 6.96958e-05f
Cred_9778 di_tg_ctrl_n.P29.GatPoly v_a.$1448.Metal2 7.54503e-05f
Cred_9779 di_tg_ctrl_n.P29.GatPoly v_a.$1450.Metal2 1.40376e-05f
Cred_9780 di_tg_ctrl_n.P29.GatPoly v_a.$1452.Metal2 3.3001e-05f
Cred_9781 di_tg_ctrl_n.P29.GatPoly v_a.$1454.Metal2 3.11889e-05f
Cred_9782 di_tg_ctrl_n.P29.GatPoly v_a.$1456.Metal2 1.74593e-05f
Cred_9783 di_tg_ctrl_n.P29.GatPoly v_a.$1458.Metal2 7.30492e-05f
Cred_9784 di_tg_ctrl_n.P29.GatPoly v_a.$1460.Metal2 7.24099e-05f
Cred_9785 di_tg_ctrl_n.P29.GatPoly v_a.$1462.Metal2 1.8275e-05f
Cred_9786 di_tg_ctrl_n.P29.GatPoly v_a.$1464.Metal2 3.06942e-05f
Cred_9787 di_tg_ctrl_n.P29.GatPoly v_a.$1466.Metal2 0.000105446f
Cred_9788 di_tg_ctrl_n.P29.GatPoly v_a.$1468.Metal2 0.000974803f
Cred_9789 di_tg_ctrl_n.P29.GatPoly v_a.$2327.Metal3 0.0164953f
Cred_9790 di_tg_ctrl_n.P29.GatPoly v_a.$2337.Metal3 0.0147321f
Cred_9791 di_tg_ctrl_n.P29.GatPoly v_a.$2351.Metal3 0.000174744f
Cred_9792 di_tg_ctrl_n.P29.GatPoly v_a.$354.Metal1 0.0127724f
Cred_9793 di_tg_ctrl_n.P29.GatPoly v_a.$356.Metal1 0.00953463f
Cred_9794 di_tg_ctrl_n.P29.GatPoly v_a.$359.Metal1 0.00954049f
Cred_9795 di_tg_ctrl_n.P29.GatPoly v_a.$361.Metal1 0.00766745f
Cred_9796 di_tg_ctrl_n.P29.GatPoly v_a.$363.Metal1 0.00953743f
Cred_9797 di_tg_ctrl_n.P29.GatPoly v_a.$366.Metal1 0.00953691f
Cred_9798 di_tg_ctrl_n.P29.GatPoly v_a.$368.Metal1 0.013293f
Cred_9799 di_tg_ctrl_n.P29.GatPoly v_a.P10.pSD 0.00132121f
Cred_9800 di_tg_ctrl_n.P29.GatPoly v_b.$2481.Metal2 0.019569f
Cred_9801 di_tg_ctrl_n.P29.GatPoly v_b.$2541.Metal2 0.019569f
Cred_9802 di_tg_ctrl_n.P29.GatPoly v_b.P11.nSD 0.000216542f
Cred_9803 di_tg_ctrl_n.P29.GatPoly v_b.P11.pSD 0.0543265f
Cred_9804 di_tg_ctrl_n.P29.GatPoly VDD.$340.Metal1 7.25297e-07f
Cred_9805 di_tg_ctrl_n.P29.GatPoly VDD.$388.Metal2 7.70255e-07f
Cred_9806 di_tg_ctrl_n.P29.GatPoly VDD.$42.Metal1 3.61669e-05f
Cred_9807 di_tg_ctrl_n.P29.GatPoly VDD.$666.Metal3 3.39108e-08f
Cred_9808 di_tg_ctrl_n.P29.GatPoly VDD.P0.nSD 0.00384679f
Cred_9809 di_tg_ctrl_n.P3.GatPoly VSS 0.0127122f
Cred_9810 di_tg_ctrl_n.P3.GatPoly v_b.$2962.Metal2 7.32522e-06f
Cred_9811 di_tg_ctrl_n.P3.GatPoly v_b.$3053.Metal2 0.0130462f
Cred_9812 di_tg_ctrl_n.P3.GatPoly v_b.$3056.Metal2 0.0150542f
Cred_9813 di_tg_ctrl_n.P3.GatPoly v_b.$3089.Metal2 3.36742e-07f
Cred_9814 di_tg_ctrl_n.P3.GatPoly v_b.$3785.Metal3 0.0136187f
Cred_9815 di_tg_ctrl_n.P3.GatPoly v_b.$3821.Metal3 0.000268443f
Cred_9816 di_tg_ctrl_n.P3.GatPoly v_b.P39.nSD 6.80155e-06f
Cred_9817 di_tg_ctrl_n.P3.GatPoly v_b.P41.nSD 0.0150638f
Cred_9818 di_tg_ctrl_n.P3.GatPoly v_b.P43.nSD 0.0125127f
Cred_9819 di_tg_ctrl_n.P3.GatPoly VSS.$17.Metal1 3.33823e-06f
Cred_9820 di_tg_ctrl_n.P3.GatPoly VSS.$231.Metal1 1.74466e-05f
Cred_9821 di_tg_ctrl_n.P3.GatPoly VSS.$239.Metal1 1.74477e-05f
Cred_9822 di_tg_ctrl_n.P3.GatPoly VSS.$301.Metal1 6.04582e-05f
Cred_9823 di_tg_ctrl_n.P3.GatPoly VSS.$542.Metal2 1.34571e-07f
Cred_9824 di_tg_ctrl_n.P3.GatPoly VSS.$606.Metal2 6.38811e-06f
Cred_9825 di_tg_ctrl_n.P3.GatPoly VSS.$760.Metal3 3.77976e-07f
Cred_9826 di_tg_ctrl_n.P3.GatPoly VSS.P0.pSD 0.00271859f
Cred_9827 di_tg_ctrl_n.P30.GatPoly v_a.$1500.Metal2 0.000310389f
Cred_9828 di_tg_ctrl_n.P30.GatPoly v_a.$1502.Metal2 2.13729e-05f
Cred_9829 di_tg_ctrl_n.P30.GatPoly v_a.$1504.Metal2 6.96958e-05f
Cred_9830 di_tg_ctrl_n.P30.GatPoly v_a.$1506.Metal2 7.54503e-05f
Cred_9831 di_tg_ctrl_n.P30.GatPoly v_a.$1508.Metal2 1.40376e-05f
Cred_9832 di_tg_ctrl_n.P30.GatPoly v_a.$1510.Metal2 3.3001e-05f
Cred_9833 di_tg_ctrl_n.P30.GatPoly v_a.$1512.Metal2 3.11889e-05f
Cred_9834 di_tg_ctrl_n.P30.GatPoly v_a.$1514.Metal2 1.74593e-05f
Cred_9835 di_tg_ctrl_n.P30.GatPoly v_a.$1516.Metal2 7.30492e-05f
Cred_9836 di_tg_ctrl_n.P30.GatPoly v_a.$1518.Metal2 7.24099e-05f
Cred_9837 di_tg_ctrl_n.P30.GatPoly v_a.$1520.Metal2 1.8275e-05f
Cred_9838 di_tg_ctrl_n.P30.GatPoly v_a.$1522.Metal2 3.06942e-05f
Cred_9839 di_tg_ctrl_n.P30.GatPoly v_a.$1524.Metal2 0.000105446f
Cred_9840 di_tg_ctrl_n.P30.GatPoly v_a.$1526.Metal2 0.000974803f
Cred_9841 di_tg_ctrl_n.P30.GatPoly v_a.$2365.Metal3 0.0313761f
Cred_9842 di_tg_ctrl_n.P30.GatPoly v_a.$2367.Metal3 2.6793e-06f
Cred_9843 di_tg_ctrl_n.P30.GatPoly v_a.$2381.Metal3 0.000174744f
Cred_9844 di_tg_ctrl_n.P30.GatPoly v_a.$417.Metal1 0.0127569f
Cred_9845 di_tg_ctrl_n.P30.GatPoly v_a.$419.Metal1 0.00953463f
Cred_9846 di_tg_ctrl_n.P30.GatPoly v_a.$422.Metal1 0.00954049f
Cred_9847 di_tg_ctrl_n.P30.GatPoly v_a.$424.Metal1 0.00766745f
Cred_9848 di_tg_ctrl_n.P30.GatPoly v_a.$426.Metal1 0.00953743f
Cred_9849 di_tg_ctrl_n.P30.GatPoly v_a.$429.Metal1 0.00953691f
Cred_9850 di_tg_ctrl_n.P30.GatPoly v_a.$431.Metal1 0.013293f
Cred_9851 di_tg_ctrl_n.P30.GatPoly v_a.P12.pSD 0.00132083f
Cred_9852 di_tg_ctrl_n.P30.GatPoly v_b.$2481.Metal2 0.019569f
Cred_9853 di_tg_ctrl_n.P30.GatPoly v_b.$2541.Metal2 0.019569f
Cred_9854 di_tg_ctrl_n.P30.GatPoly v_b.P11.nSD 0.000216542f
Cred_9855 di_tg_ctrl_n.P30.GatPoly v_b.P11.pSD 0.0543265f
Cred_9856 di_tg_ctrl_n.P30.GatPoly VDD.$340.Metal1 8.60638e-07f
Cred_9857 di_tg_ctrl_n.P30.GatPoly VDD.$388.Metal2 6.49264e-07f
Cred_9858 di_tg_ctrl_n.P30.GatPoly VDD.$42.Metal1 3.04859e-05f
Cred_9859 di_tg_ctrl_n.P30.GatPoly VDD.$666.Metal3 2.85841e-08f
Cred_9860 di_tg_ctrl_n.P30.GatPoly VDD.P0.nSD 0.00385247f
Cred_9861 di_tg_ctrl_n.P31.GatPoly VSS 1.38799e-05f
Cred_9862 di_tg_ctrl_n.P31.GatPoly v_a.$1500.Metal2 0.000310389f
Cred_9863 di_tg_ctrl_n.P31.GatPoly v_a.$1502.Metal2 2.13729e-05f
Cred_9864 di_tg_ctrl_n.P31.GatPoly v_a.$1504.Metal2 6.96958e-05f
Cred_9865 di_tg_ctrl_n.P31.GatPoly v_a.$1506.Metal2 7.54503e-05f
Cred_9866 di_tg_ctrl_n.P31.GatPoly v_a.$1508.Metal2 1.40376e-05f
Cred_9867 di_tg_ctrl_n.P31.GatPoly v_a.$1510.Metal2 3.3001e-05f
Cred_9868 di_tg_ctrl_n.P31.GatPoly v_a.$1512.Metal2 3.11889e-05f
Cred_9869 di_tg_ctrl_n.P31.GatPoly v_a.$1514.Metal2 1.74593e-05f
Cred_9870 di_tg_ctrl_n.P31.GatPoly v_a.$1516.Metal2 7.30492e-05f
Cred_9871 di_tg_ctrl_n.P31.GatPoly v_a.$1518.Metal2 7.24099e-05f
Cred_9872 di_tg_ctrl_n.P31.GatPoly v_a.$1520.Metal2 1.83269e-05f
Cred_9873 di_tg_ctrl_n.P31.GatPoly v_a.$1522.Metal2 3.07104e-05f
Cred_9874 di_tg_ctrl_n.P31.GatPoly v_a.$1524.Metal2 0.000106691f
Cred_9875 di_tg_ctrl_n.P31.GatPoly v_a.$1526.Metal2 0.00102002f
Cred_9876 di_tg_ctrl_n.P31.GatPoly v_a.$2365.Metal3 0.0315634f
Cred_9877 di_tg_ctrl_n.P31.GatPoly v_a.$2367.Metal3 2.6793e-06f
Cred_9878 di_tg_ctrl_n.P31.GatPoly v_a.$2381.Metal3 0.000186621f
Cred_9879 di_tg_ctrl_n.P31.GatPoly v_a.$417.Metal1 0.0127569f
Cred_9880 di_tg_ctrl_n.P31.GatPoly v_a.$419.Metal1 0.00953463f
Cred_9881 di_tg_ctrl_n.P31.GatPoly v_a.$422.Metal1 0.00954049f
Cred_9882 di_tg_ctrl_n.P31.GatPoly v_a.$424.Metal1 0.00766745f
Cred_9883 di_tg_ctrl_n.P31.GatPoly v_a.$426.Metal1 0.00953743f
Cred_9884 di_tg_ctrl_n.P31.GatPoly v_a.$429.Metal1 0.0095463f
Cred_9885 di_tg_ctrl_n.P31.GatPoly v_a.$431.Metal1 0.0133917f
Cred_9886 di_tg_ctrl_n.P31.GatPoly v_a.P12.pSD 0.00136549f
Cred_9887 di_tg_ctrl_n.P31.GatPoly v_b.$2541.Metal2 0.0404548f
Cred_9888 di_tg_ctrl_n.P31.GatPoly v_b.P13.pSD 0.0541816f
Cred_9889 di_tg_ctrl_n.P31.GatPoly VDD.$107.Metal1 1.12825e-06f
Cred_9890 di_tg_ctrl_n.P31.GatPoly VDD.$111.Metal1 8.56757e-06f
Cred_9891 di_tg_ctrl_n.P31.GatPoly VDD.$121.Metal1 2.33441e-06f
Cred_9892 di_tg_ctrl_n.P31.GatPoly VDD.$340.Metal1 9.37517e-07f
Cred_9893 di_tg_ctrl_n.P31.GatPoly VDD.$388.Metal2 5.96123e-07f
Cred_9894 di_tg_ctrl_n.P31.GatPoly VDD.$42.Metal1 2.79906e-05f
Cred_9895 di_tg_ctrl_n.P31.GatPoly VDD.$440.Metal2 2.73601e-09f
Cred_9896 di_tg_ctrl_n.P31.GatPoly VDD.$448.Metal2 3.31458e-08f
Cred_9897 di_tg_ctrl_n.P31.GatPoly VDD.$452.Metal2 1.22906e-08f
Cred_9898 di_tg_ctrl_n.P31.GatPoly VDD.$666.Metal3 2.62446e-08f
Cred_9899 di_tg_ctrl_n.P31.GatPoly VDD.$694.Metal3 2.19367e-11f
Cred_9900 di_tg_ctrl_n.P31.GatPoly VDD.P0.nSD 0.00385495f
Cred_9901 di_tg_ctrl_n.P32.GatPoly VSS 9.53025e-05f
Cred_9902 di_tg_ctrl_n.P32.GatPoly v_a.$1558.Metal2 0.000631383f
Cred_9903 di_tg_ctrl_n.P32.GatPoly v_a.$1560.Metal2 2.13729e-05f
Cred_9904 di_tg_ctrl_n.P32.GatPoly v_a.$1562.Metal2 6.96958e-05f
Cred_9905 di_tg_ctrl_n.P32.GatPoly v_a.$1564.Metal2 7.54503e-05f
Cred_9906 di_tg_ctrl_n.P32.GatPoly v_a.$1566.Metal2 1.40376e-05f
Cred_9907 di_tg_ctrl_n.P32.GatPoly v_a.$1568.Metal2 3.3001e-05f
Cred_9908 di_tg_ctrl_n.P32.GatPoly v_a.$1570.Metal2 3.11889e-05f
Cred_9909 di_tg_ctrl_n.P32.GatPoly v_a.$1572.Metal2 1.74593e-05f
Cred_9910 di_tg_ctrl_n.P32.GatPoly v_a.$1574.Metal2 0.000307543f
Cred_9911 di_tg_ctrl_n.P32.GatPoly v_a.$1576.Metal2 0.00484424f
Cred_9912 di_tg_ctrl_n.P32.GatPoly v_a.$2387.Metal3 0.0163974f
Cred_9913 di_tg_ctrl_n.P32.GatPoly v_a.$2397.Metal3 0.0146447f
Cred_9914 di_tg_ctrl_n.P32.GatPoly v_a.$2407.Metal3 0.00199851f
Cred_9915 di_tg_ctrl_n.P32.GatPoly v_a.$480.Metal1 0.0127723f
Cred_9916 di_tg_ctrl_n.P32.GatPoly v_a.$482.Metal1 0.00953463f
Cred_9917 di_tg_ctrl_n.P32.GatPoly v_a.$485.Metal1 0.00954049f
Cred_9918 di_tg_ctrl_n.P32.GatPoly v_a.$487.Metal1 0.00766745f
Cred_9919 di_tg_ctrl_n.P32.GatPoly v_a.$489.Metal1 0.0221281f
Cred_9920 di_tg_ctrl_n.P32.GatPoly v_a.P14.pSD 0.00635736f
Cred_9921 di_tg_ctrl_n.P32.GatPoly v_b.$2541.Metal2 0.0405202f
Cred_9922 di_tg_ctrl_n.P32.GatPoly v_b.P13.pSD 0.0544099f
Cred_9923 di_tg_ctrl_n.P32.GatPoly VDD.$111.Metal1 1.15708e-05f
Cred_9924 di_tg_ctrl_n.P32.GatPoly VDD.$121.Metal1 6.02695e-05f
Cred_9925 di_tg_ctrl_n.P32.GatPoly VDD.$129.Metal1 6.96591e-06f
Cred_9926 di_tg_ctrl_n.P32.GatPoly VDD.$340.Metal1 1.11251e-06f
Cred_9927 di_tg_ctrl_n.P32.GatPoly VDD.$388.Metal2 5.02597e-07f
Cred_9928 di_tg_ctrl_n.P32.GatPoly VDD.$42.Metal1 2.35992e-05f
Cred_9929 di_tg_ctrl_n.P32.GatPoly VDD.$448.Metal2 7.17981e-08f
Cred_9930 di_tg_ctrl_n.P32.GatPoly VDD.$452.Metal2 1.61747e-07f
Cred_9931 di_tg_ctrl_n.P32.GatPoly VDD.$456.Metal2 7.22286e-08f
Cred_9932 di_tg_ctrl_n.P32.GatPoly VDD.$460.Metal2 1.83376e-08f
Cred_9933 di_tg_ctrl_n.P32.GatPoly VDD.$666.Metal3 2.21271e-08f
Cred_9934 di_tg_ctrl_n.P32.GatPoly VDD.P0.nSD 0.00385932f
Cred_9935 di_tg_ctrl_n.P33.GatPoly v_a.$1558.Metal2 0.000614758f
Cred_9936 di_tg_ctrl_n.P33.GatPoly v_a.$1560.Metal2 2.13729e-05f
Cred_9937 di_tg_ctrl_n.P33.GatPoly v_a.$1562.Metal2 6.96958e-05f
Cred_9938 di_tg_ctrl_n.P33.GatPoly v_a.$1564.Metal2 7.54503e-05f
Cred_9939 di_tg_ctrl_n.P33.GatPoly v_a.$1566.Metal2 1.40376e-05f
Cred_9940 di_tg_ctrl_n.P33.GatPoly v_a.$1568.Metal2 3.3001e-05f
Cred_9941 di_tg_ctrl_n.P33.GatPoly v_a.$1570.Metal2 3.11889e-05f
Cred_9942 di_tg_ctrl_n.P33.GatPoly v_a.$1572.Metal2 1.74593e-05f
Cred_9943 di_tg_ctrl_n.P33.GatPoly v_a.$1574.Metal2 0.000304965f
Cred_9944 di_tg_ctrl_n.P33.GatPoly v_a.$1576.Metal2 0.00473107f
Cred_9945 di_tg_ctrl_n.P33.GatPoly v_a.$2387.Metal3 0.0155482f
Cred_9946 di_tg_ctrl_n.P33.GatPoly v_a.$2397.Metal3 0.0138864f
Cred_9947 di_tg_ctrl_n.P33.GatPoly v_a.$2407.Metal3 0.00192792f
Cred_9948 di_tg_ctrl_n.P33.GatPoly v_a.$480.Metal1 0.0127715f
Cred_9949 di_tg_ctrl_n.P33.GatPoly v_a.$482.Metal1 0.00953463f
Cred_9950 di_tg_ctrl_n.P33.GatPoly v_a.$485.Metal1 0.00954049f
Cred_9951 di_tg_ctrl_n.P33.GatPoly v_a.$487.Metal1 0.00766745f
Cred_9952 di_tg_ctrl_n.P33.GatPoly v_a.$489.Metal1 0.0219897f
Cred_9953 di_tg_ctrl_n.P33.GatPoly v_a.P14.pSD 0.00618425f
Cred_9954 di_tg_ctrl_n.P33.GatPoly v_b.$2541.Metal2 0.019569f
Cred_9955 di_tg_ctrl_n.P33.GatPoly v_b.$2601.Metal2 0.019569f
Cred_9956 di_tg_ctrl_n.P33.GatPoly v_b.P15.nSD 0.000216542f
Cred_9957 di_tg_ctrl_n.P33.GatPoly v_b.P15.pSD 0.0543265f
Cred_9958 di_tg_ctrl_n.P33.GatPoly VDD.$340.Metal1 1.21192e-06f
Cred_9959 di_tg_ctrl_n.P33.GatPoly VDD.$388.Metal2 4.61527e-07f
Cred_9960 di_tg_ctrl_n.P33.GatPoly VDD.$42.Metal1 2.16708e-05f
Cred_9961 di_tg_ctrl_n.P33.GatPoly VDD.$666.Metal3 2.03189e-08f
Cred_9962 di_tg_ctrl_n.P33.GatPoly VDD.P0.nSD 0.00386113f
Cred_9963 di_tg_ctrl_n.P34.GatPoly v_a.$2387.Metal3 0.0241222f
Cred_9964 di_tg_ctrl_n.P34.GatPoly v_a.$2447.Metal3 0.0241222f
Cred_9965 di_tg_ctrl_n.P34.GatPoly v_a.P16.nSD 0.000217551f
Cred_9966 di_tg_ctrl_n.P34.GatPoly v_a.P16.pSD 0.0526866f
Cred_9967 di_tg_ctrl_n.P34.GatPoly v_b.$2541.Metal2 0.019569f
Cred_9968 di_tg_ctrl_n.P34.GatPoly v_b.$2601.Metal2 0.019569f
Cred_9969 di_tg_ctrl_n.P34.GatPoly v_b.P15.nSD 0.000216542f
Cred_9970 di_tg_ctrl_n.P34.GatPoly v_b.P15.pSD 0.0543265f
Cred_9971 di_tg_ctrl_n.P34.GatPoly VDD.$340.Metal1 1.43817e-06f
Cred_9972 di_tg_ctrl_n.P34.GatPoly VDD.$388.Metal2 3.89264e-07f
Cred_9973 di_tg_ctrl_n.P34.GatPoly VDD.$42.Metal1 1.82777e-05f
Cred_9974 di_tg_ctrl_n.P34.GatPoly VDD.$666.Metal3 1.71375e-08f
Cred_9975 di_tg_ctrl_n.P34.GatPoly VDD.P0.nSD 0.00386437f
Cred_9976 di_tg_ctrl_n.P35.GatPoly VSS 1.38799e-05f
Cred_9977 di_tg_ctrl_n.P35.GatPoly v_a.$2387.Metal3 0.0233157f
Cred_9978 di_tg_ctrl_n.P35.GatPoly v_a.$2447.Metal3 0.0233157f
Cred_9979 di_tg_ctrl_n.P35.GatPoly v_a.P16.nSD 0.000210277f
Cred_9980 di_tg_ctrl_n.P35.GatPoly v_a.P16.pSD 0.0526848f
Cred_9981 di_tg_ctrl_n.P35.GatPoly v_b.$2601.Metal2 0.0397839f
Cred_9982 di_tg_ctrl_n.P35.GatPoly v_b.P17.pSD 0.0540592f
Cred_9983 di_tg_ctrl_n.P35.GatPoly VDD.$129.Metal1 3.09767e-06f
Cred_9984 di_tg_ctrl_n.P35.GatPoly VDD.$134.Metal1 9.83113e-06f
Cred_9985 di_tg_ctrl_n.P35.GatPoly VDD.$340.Metal1 1.67371e-06f
Cred_9986 di_tg_ctrl_n.P35.GatPoly VDD.$388.Metal2 3.81965e-07f
Cred_9987 di_tg_ctrl_n.P35.GatPoly VDD.$42.Metal1 1.7935e-05f
Cred_9988 di_tg_ctrl_n.P35.GatPoly VDD.$464.Metal2 1.57266e-08f
Cred_9989 di_tg_ctrl_n.P35.GatPoly VDD.$666.Metal3 1.68162e-08f
Cred_9990 di_tg_ctrl_n.P35.GatPoly VDD.P0.nSD 0.00412984f
Cred_9991 di_tg_ctrl_n.P36.GatPoly VSS 9.53025e-05f
Cred_9992 di_tg_ctrl_n.P36.GatPoly v_a.$1674.Metal2 0.000705559f
Cred_9993 di_tg_ctrl_n.P36.GatPoly v_a.$1676.Metal2 2.13729e-05f
Cred_9994 di_tg_ctrl_n.P36.GatPoly v_a.$1678.Metal2 6.96958e-05f
Cred_9995 di_tg_ctrl_n.P36.GatPoly v_a.$1680.Metal2 7.54503e-05f
Cred_9996 di_tg_ctrl_n.P36.GatPoly v_a.$1682.Metal2 0.00643477f
Cred_9997 di_tg_ctrl_n.P36.GatPoly v_a.$2447.Metal3 0.0149018f
Cred_9998 di_tg_ctrl_n.P36.GatPoly v_a.$2458.Metal3 0.00881417f
Cred_9999 di_tg_ctrl_n.P36.GatPoly v_a.$2462.Metal3 0.00538543f
Cred_10000 di_tg_ctrl_n.P36.GatPoly v_a.$606.Metal1 0.012772f
Cred_10001 di_tg_ctrl_n.P36.GatPoly v_a.$608.Metal1 0.00953463f
Cred_10002 di_tg_ctrl_n.P36.GatPoly v_a.$611.Metal1 0.0280419f
Cred_10003 di_tg_ctrl_n.P36.GatPoly v_a.P18.pSD 0.0130572f
Cred_10004 di_tg_ctrl_n.P36.GatPoly v_b.$2601.Metal2 0.0398428f
Cred_10005 di_tg_ctrl_n.P36.GatPoly v_b.P17.pSD 0.0542633f
Cred_10006 di_tg_ctrl_n.P36.GatPoly VDD.$134.Metal1 1.74553e-05f
Cred_10007 di_tg_ctrl_n.P36.GatPoly VDD.$143.Metal1 5.5521e-05f
Cred_10008 di_tg_ctrl_n.P36.GatPoly VDD.$151.Metal1 7.50175e-06f
Cred_10009 di_tg_ctrl_n.P36.GatPoly VDD.$340.Metal1 1.96082e-06f
Cred_10010 di_tg_ctrl_n.P36.GatPoly VDD.$388.Metal2 3.18238e-07f
Cred_10011 di_tg_ctrl_n.P36.GatPoly VDD.$42.Metal1 1.49427e-05f
Cred_10012 di_tg_ctrl_n.P36.GatPoly VDD.$472.Metal2 1.34609e-07f
Cred_10013 di_tg_ctrl_n.P36.GatPoly VDD.$476.Metal2 7.63608e-08f
Cred_10014 di_tg_ctrl_n.P36.GatPoly VDD.$480.Metal2 1.83376e-08f
Cred_10015 di_tg_ctrl_n.P36.GatPoly VDD.$666.Metal3 1.40106e-08f
Cred_10016 di_tg_ctrl_n.P36.GatPoly VDD.P0.nSD 0.00407958f
Cred_10017 di_tg_ctrl_n.P37.GatPoly v_a.$1674.Metal2 0.000720965f
Cred_10018 di_tg_ctrl_n.P37.GatPoly v_a.$1676.Metal2 2.13729e-05f
Cred_10019 di_tg_ctrl_n.P37.GatPoly v_a.$1678.Metal2 6.96958e-05f
Cred_10020 di_tg_ctrl_n.P37.GatPoly v_a.$1680.Metal2 7.54503e-05f
Cred_10021 di_tg_ctrl_n.P37.GatPoly v_a.$1682.Metal2 0.00635814f
Cred_10022 di_tg_ctrl_n.P37.GatPoly v_a.$2447.Metal3 0.0154828f
Cred_10023 di_tg_ctrl_n.P37.GatPoly v_a.$2458.Metal3 0.00915776f
Cred_10024 di_tg_ctrl_n.P37.GatPoly v_a.$2462.Metal3 0.00528631f
Cred_10025 di_tg_ctrl_n.P37.GatPoly v_a.$606.Metal1 0.0127726f
Cred_10026 di_tg_ctrl_n.P37.GatPoly v_a.$608.Metal1 0.00953463f
Cred_10027 di_tg_ctrl_n.P37.GatPoly v_a.$611.Metal1 0.0279534f
Cred_10028 di_tg_ctrl_n.P37.GatPoly v_a.P18.pSD 0.0128437f
Cred_10029 di_tg_ctrl_n.P37.GatPoly v_b.$2631.Metal2 0.0397481f
Cred_10030 di_tg_ctrl_n.P37.GatPoly v_b.P19.pSD 0.053933f
Cred_10031 di_tg_ctrl_n.P37.GatPoly VDD.$340.Metal1 2.02538e-06f
Cred_10032 di_tg_ctrl_n.P37.GatPoly VDD.$388.Metal2 2.77269e-07f
Cred_10033 di_tg_ctrl_n.P37.GatPoly VDD.$42.Metal1 1.3019e-05f
Cred_10034 di_tg_ctrl_n.P37.GatPoly VDD.$666.Metal3 1.22069e-08f
Cred_10035 di_tg_ctrl_n.P37.GatPoly VDD.P0.nSD 0.00386916f
Cred_10036 di_tg_ctrl_n.P38.GatPoly v_a.$1732.Metal2 0.00031041f
Cred_10037 di_tg_ctrl_n.P38.GatPoly v_a.$1734.Metal2 2.13729e-05f
Cred_10038 di_tg_ctrl_n.P38.GatPoly v_a.$1736.Metal2 6.96958e-05f
Cred_10039 di_tg_ctrl_n.P38.GatPoly v_a.$1738.Metal2 7.54503e-05f
Cred_10040 di_tg_ctrl_n.P38.GatPoly v_a.$1740.Metal2 1.40376e-05f
Cred_10041 di_tg_ctrl_n.P38.GatPoly v_a.$1742.Metal2 3.3001e-05f
Cred_10042 di_tg_ctrl_n.P38.GatPoly v_a.$1744.Metal2 3.11889e-05f
Cred_10043 di_tg_ctrl_n.P38.GatPoly v_a.$1746.Metal2 1.74593e-05f
Cred_10044 di_tg_ctrl_n.P38.GatPoly v_a.$1748.Metal2 7.30492e-05f
Cred_10045 di_tg_ctrl_n.P38.GatPoly v_a.$1750.Metal2 7.24099e-05f
Cred_10046 di_tg_ctrl_n.P38.GatPoly v_a.$1752.Metal2 1.8275e-05f
Cred_10047 di_tg_ctrl_n.P38.GatPoly v_a.$1754.Metal2 3.06942e-05f
Cred_10048 di_tg_ctrl_n.P38.GatPoly v_a.$1756.Metal2 0.000105446f
Cred_10049 di_tg_ctrl_n.P38.GatPoly v_a.$1758.Metal2 0.000974803f
Cred_10050 di_tg_ctrl_n.P38.GatPoly v_a.$2485.Metal3 0.0270452f
Cred_10051 di_tg_ctrl_n.P38.GatPoly v_a.$2488.Metal3 1.77439e-06f
Cred_10052 di_tg_ctrl_n.P38.GatPoly v_a.$2501.Metal3 0.000174744f
Cred_10053 di_tg_ctrl_n.P38.GatPoly v_a.$669.Metal1 0.0127569f
Cred_10054 di_tg_ctrl_n.P38.GatPoly v_a.$671.Metal1 0.00953463f
Cred_10055 di_tg_ctrl_n.P38.GatPoly v_a.$674.Metal1 0.00954049f
Cred_10056 di_tg_ctrl_n.P38.GatPoly v_a.$676.Metal1 0.00766745f
Cred_10057 di_tg_ctrl_n.P38.GatPoly v_a.$678.Metal1 0.00953743f
Cred_10058 di_tg_ctrl_n.P38.GatPoly v_a.$681.Metal1 0.00953691f
Cred_10059 di_tg_ctrl_n.P38.GatPoly v_a.$683.Metal1 0.013293f
Cred_10060 di_tg_ctrl_n.P38.GatPoly v_a.P20.pSD 0.00132083f
Cred_10061 di_tg_ctrl_n.P38.GatPoly v_b.$2631.Metal2 0.0397481f
Cred_10062 di_tg_ctrl_n.P38.GatPoly v_b.P19.pSD 0.053933f
Cred_10063 di_tg_ctrl_n.P38.GatPoly VDD.$340.Metal1 2.40357e-06f
Cred_10064 di_tg_ctrl_n.P38.GatPoly VDD.$388.Metal2 2.34245e-07f
Cred_10065 di_tg_ctrl_n.P38.GatPoly VDD.$42.Metal1 1.09989e-05f
Cred_10066 di_tg_ctrl_n.P38.GatPoly VDD.$666.Metal3 1.03128e-08f
Cred_10067 di_tg_ctrl_n.P38.GatPoly VDD.P0.nSD 0.00387084f
Cred_10068 di_tg_ctrl_n.P39.GatPoly VSS 1.38799e-05f
Cred_10069 di_tg_ctrl_n.P39.GatPoly v_a.$1732.Metal2 0.00031041f
Cred_10070 di_tg_ctrl_n.P39.GatPoly v_a.$1734.Metal2 2.13729e-05f
Cred_10071 di_tg_ctrl_n.P39.GatPoly v_a.$1736.Metal2 6.96958e-05f
Cred_10072 di_tg_ctrl_n.P39.GatPoly v_a.$1738.Metal2 7.54503e-05f
Cred_10073 di_tg_ctrl_n.P39.GatPoly v_a.$1740.Metal2 1.40376e-05f
Cred_10074 di_tg_ctrl_n.P39.GatPoly v_a.$1742.Metal2 3.3001e-05f
Cred_10075 di_tg_ctrl_n.P39.GatPoly v_a.$1744.Metal2 3.11889e-05f
Cred_10076 di_tg_ctrl_n.P39.GatPoly v_a.$1746.Metal2 1.74593e-05f
Cred_10077 di_tg_ctrl_n.P39.GatPoly v_a.$1748.Metal2 7.30492e-05f
Cred_10078 di_tg_ctrl_n.P39.GatPoly v_a.$1750.Metal2 7.24099e-05f
Cred_10079 di_tg_ctrl_n.P39.GatPoly v_a.$1752.Metal2 1.83269e-05f
Cred_10080 di_tg_ctrl_n.P39.GatPoly v_a.$1754.Metal2 3.07104e-05f
Cred_10081 di_tg_ctrl_n.P39.GatPoly v_a.$1756.Metal2 0.000106608f
Cred_10082 di_tg_ctrl_n.P39.GatPoly v_a.$1758.Metal2 0.00101643f
Cred_10083 di_tg_ctrl_n.P39.GatPoly v_a.$2485.Metal3 0.0279858f
Cred_10084 di_tg_ctrl_n.P39.GatPoly v_a.$2488.Metal3 1.77439e-06f
Cred_10085 di_tg_ctrl_n.P39.GatPoly v_a.$2501.Metal3 0.000185619f
Cred_10086 di_tg_ctrl_n.P39.GatPoly v_a.$669.Metal1 0.0127569f
Cred_10087 di_tg_ctrl_n.P39.GatPoly v_a.$671.Metal1 0.00953463f
Cred_10088 di_tg_ctrl_n.P39.GatPoly v_a.$674.Metal1 0.00954049f
Cred_10089 di_tg_ctrl_n.P39.GatPoly v_a.$676.Metal1 0.00766745f
Cred_10090 di_tg_ctrl_n.P39.GatPoly v_a.$678.Metal1 0.00953743f
Cred_10091 di_tg_ctrl_n.P39.GatPoly v_a.$681.Metal1 0.0095463f
Cred_10092 di_tg_ctrl_n.P39.GatPoly v_a.$683.Metal1 0.0133852f
Cred_10093 di_tg_ctrl_n.P39.GatPoly v_a.P20.pSD 0.00136186f
Cred_10094 di_tg_ctrl_n.P39.GatPoly v_b.$2631.Metal2 0.0199167f
Cred_10095 di_tg_ctrl_n.P39.GatPoly v_b.$2691.Metal2 0.0199167f
Cred_10096 di_tg_ctrl_n.P39.GatPoly v_b.P21.nSD 0.000220389f
Cred_10097 di_tg_ctrl_n.P39.GatPoly v_b.P21.pSD 0.0545811f
Cred_10098 di_tg_ctrl_n.P39.GatPoly VDD.$151.Metal1 6.08298e-06f
Cred_10099 di_tg_ctrl_n.P39.GatPoly VDD.$161.Metal1 5.92026e-06f
Cred_10100 di_tg_ctrl_n.P39.GatPoly VDD.$340.Metal1 2.61839e-06f
Cred_10101 di_tg_ctrl_n.P39.GatPoly VDD.$388.Metal2 2.15386e-07f
Cred_10102 di_tg_ctrl_n.P39.GatPoly VDD.$42.Metal1 1.01133e-05f
Cred_10103 di_tg_ctrl_n.P39.GatPoly VDD.$484.Metal2 3.20266e-08f
Cred_10104 di_tg_ctrl_n.P39.GatPoly VDD.$488.Metal2 3.67359e-08f
Cred_10105 di_tg_ctrl_n.P39.GatPoly VDD.$666.Metal3 9.48245e-09f
Cred_10106 di_tg_ctrl_n.P39.GatPoly VDD.P0.nSD 0.00387155f
Cred_10107 di_tg_ctrl_n.P4.GatPoly VSS 0.0123426f
Cred_10108 di_tg_ctrl_n.P4.GatPoly v_b.$3053.Metal2 1.66823e-06f
Cred_10109 di_tg_ctrl_n.P4.GatPoly v_b.$3056.Metal2 0.0245432f
Cred_10110 di_tg_ctrl_n.P4.GatPoly v_b.$3089.Metal2 0.00209744f
Cred_10111 di_tg_ctrl_n.P4.GatPoly v_b.$3785.Metal3 0.000598646f
Cred_10112 di_tg_ctrl_n.P4.GatPoly v_b.$3821.Metal3 0.013204f
Cred_10113 di_tg_ctrl_n.P4.GatPoly v_b.P43.nSD 0.0124532f
Cred_10114 di_tg_ctrl_n.P4.GatPoly v_b.P45.nSD 0.0149361f
Cred_10115 di_tg_ctrl_n.P4.GatPoly VSS.$17.Metal1 2.85264e-06f
Cred_10116 di_tg_ctrl_n.P4.GatPoly VSS.$301.Metal1 7.27344e-05f
Cred_10117 di_tg_ctrl_n.P4.GatPoly VSS.$606.Metal2 7.68523e-06f
Cred_10118 di_tg_ctrl_n.P4.GatPoly VSS.$760.Metal3 4.54725e-07f
Cred_10119 di_tg_ctrl_n.P4.GatPoly VSS.P0.pSD 0.00274503f
Cred_10120 di_tg_ctrl_n.P40.GatPoly VSS 9.53025e-05f
Cred_10121 di_tg_ctrl_n.P40.GatPoly v_a.$1790.Metal2 0.000768799f
Cred_10122 di_tg_ctrl_n.P40.GatPoly v_a.$1792.Metal2 2.13729e-05f
Cred_10123 di_tg_ctrl_n.P40.GatPoly v_a.$1794.Metal2 6.96958e-05f
Cred_10124 di_tg_ctrl_n.P40.GatPoly v_a.$1796.Metal2 7.54503e-05f
Cred_10125 di_tg_ctrl_n.P40.GatPoly v_a.$1798.Metal2 1.40376e-05f
Cred_10126 di_tg_ctrl_n.P40.GatPoly v_a.$1800.Metal2 3.3001e-05f
Cred_10127 di_tg_ctrl_n.P40.GatPoly v_a.$1802.Metal2 3.11889e-05f
Cred_10128 di_tg_ctrl_n.P40.GatPoly v_a.$1804.Metal2 1.74593e-05f
Cred_10129 di_tg_ctrl_n.P40.GatPoly v_a.$1806.Metal2 7.30492e-05f
Cred_10130 di_tg_ctrl_n.P40.GatPoly v_a.$1808.Metal2 7.24099e-05f
Cred_10131 di_tg_ctrl_n.P40.GatPoly v_a.$1810.Metal2 1.84054e-05f
Cred_10132 di_tg_ctrl_n.P40.GatPoly v_a.$1812.Metal2 3.0735e-05f
Cred_10133 di_tg_ctrl_n.P40.GatPoly v_a.$1814.Metal2 0.000108547f
Cred_10134 di_tg_ctrl_n.P40.GatPoly v_a.$1816.Metal2 0.00108725f
Cred_10135 di_tg_ctrl_n.P40.GatPoly v_a.$2507.Metal3 0.0172867f
Cred_10136 di_tg_ctrl_n.P40.GatPoly v_a.$2518.Metal3 0.0102245f
Cred_10137 di_tg_ctrl_n.P40.GatPoly v_a.$2531.Metal3 0.000204258f
Cred_10138 di_tg_ctrl_n.P40.GatPoly v_a.$732.Metal1 0.0127745f
Cred_10139 di_tg_ctrl_n.P40.GatPoly v_a.$734.Metal1 0.00953463f
Cred_10140 di_tg_ctrl_n.P40.GatPoly v_a.$737.Metal1 0.00954049f
Cred_10141 di_tg_ctrl_n.P40.GatPoly v_a.$739.Metal1 0.00766745f
Cred_10142 di_tg_ctrl_n.P40.GatPoly v_a.$741.Metal1 0.00953743f
Cred_10143 di_tg_ctrl_n.P40.GatPoly v_a.$744.Metal1 0.00956049f
Cred_10144 di_tg_ctrl_n.P40.GatPoly v_a.$746.Metal1 0.0135389f
Cred_10145 di_tg_ctrl_n.P40.GatPoly v_a.P22.pSD 0.00143229f
Cred_10146 di_tg_ctrl_n.P40.GatPoly v_b.$2631.Metal2 0.0199487f
Cred_10147 di_tg_ctrl_n.P40.GatPoly v_b.$2691.Metal2 0.0199487f
Cred_10148 di_tg_ctrl_n.P40.GatPoly v_b.P21.nSD 0.000220743f
Cred_10149 di_tg_ctrl_n.P40.GatPoly v_b.P21.pSD 0.0548081f
Cred_10150 di_tg_ctrl_n.P40.GatPoly VDD.$161.Metal1 3.48931e-05f
Cred_10151 di_tg_ctrl_n.P40.GatPoly VDD.$165.Metal1 3.11662e-05f
Cred_10152 di_tg_ctrl_n.P40.GatPoly VDD.$169.Metal1 1.61288e-05f
Cred_10153 di_tg_ctrl_n.P40.GatPoly VDD.$340.Metal1 3.10734e-06f
Cred_10154 di_tg_ctrl_n.P40.GatPoly VDD.$388.Metal2 1.82278e-07f
Cred_10155 di_tg_ctrl_n.P40.GatPoly VDD.$42.Metal1 8.55878e-06f
Cred_10156 di_tg_ctrl_n.P40.GatPoly VDD.$488.Metal2 2.60357e-08f
Cred_10157 di_tg_ctrl_n.P40.GatPoly VDD.$496.Metal2 8.36584e-08f
Cred_10158 di_tg_ctrl_n.P40.GatPoly VDD.$666.Metal3 8.02488e-09f
Cred_10159 di_tg_ctrl_n.P40.GatPoly VDD.$718.Metal3 2.08748e-10f
Cred_10160 di_tg_ctrl_n.P40.GatPoly VDD.P0.nSD 0.00387263f
Cred_10161 di_tg_ctrl_n.P41.GatPoly v_a.$1790.Metal2 0.000768799f
Cred_10162 di_tg_ctrl_n.P41.GatPoly v_a.$1792.Metal2 2.13729e-05f
Cred_10163 di_tg_ctrl_n.P41.GatPoly v_a.$1794.Metal2 6.96958e-05f
Cred_10164 di_tg_ctrl_n.P41.GatPoly v_a.$1796.Metal2 7.54503e-05f
Cred_10165 di_tg_ctrl_n.P41.GatPoly v_a.$1798.Metal2 1.40376e-05f
Cred_10166 di_tg_ctrl_n.P41.GatPoly v_a.$1800.Metal2 3.3001e-05f
Cred_10167 di_tg_ctrl_n.P41.GatPoly v_a.$1802.Metal2 3.11889e-05f
Cred_10168 di_tg_ctrl_n.P41.GatPoly v_a.$1804.Metal2 1.74593e-05f
Cred_10169 di_tg_ctrl_n.P41.GatPoly v_a.$1806.Metal2 7.30492e-05f
Cred_10170 di_tg_ctrl_n.P41.GatPoly v_a.$1808.Metal2 7.24099e-05f
Cred_10171 di_tg_ctrl_n.P41.GatPoly v_a.$1810.Metal2 1.8275e-05f
Cred_10172 di_tg_ctrl_n.P41.GatPoly v_a.$1812.Metal2 3.06942e-05f
Cred_10173 di_tg_ctrl_n.P41.GatPoly v_a.$1814.Metal2 0.000105446f
Cred_10174 di_tg_ctrl_n.P41.GatPoly v_a.$1816.Metal2 0.000974803f
Cred_10175 di_tg_ctrl_n.P41.GatPoly v_a.$2507.Metal3 0.0172867f
Cred_10176 di_tg_ctrl_n.P41.GatPoly v_a.$2518.Metal3 0.0102245f
Cred_10177 di_tg_ctrl_n.P41.GatPoly v_a.$2531.Metal3 0.000174744f
Cred_10178 di_tg_ctrl_n.P41.GatPoly v_a.$732.Metal1 0.0127745f
Cred_10179 di_tg_ctrl_n.P41.GatPoly v_a.$734.Metal1 0.00953463f
Cred_10180 di_tg_ctrl_n.P41.GatPoly v_a.$737.Metal1 0.00954049f
Cred_10181 di_tg_ctrl_n.P41.GatPoly v_a.$739.Metal1 0.00766745f
Cred_10182 di_tg_ctrl_n.P41.GatPoly v_a.$741.Metal1 0.00953743f
Cred_10183 di_tg_ctrl_n.P41.GatPoly v_a.$744.Metal1 0.00953691f
Cred_10184 di_tg_ctrl_n.P41.GatPoly v_a.$746.Metal1 0.013293f
Cred_10185 di_tg_ctrl_n.P41.GatPoly v_a.P22.pSD 0.00132126f
Cred_10186 di_tg_ctrl_n.P41.GatPoly v_b.$2691.Metal2 0.0397481f
Cred_10187 di_tg_ctrl_n.P41.GatPoly v_b.P23.pSD 0.053933f
Cred_10188 di_tg_ctrl_n.P41.GatPoly VDD.$340.Metal1 3.38506e-06f
Cred_10189 di_tg_ctrl_n.P41.GatPoly VDD.$388.Metal2 1.67788e-07f
Cred_10190 di_tg_ctrl_n.P41.GatPoly VDD.$42.Metal1 7.87838e-06f
Cred_10191 di_tg_ctrl_n.P41.GatPoly VDD.$666.Metal3 7.38692e-09f
Cred_10192 di_tg_ctrl_n.P41.GatPoly VDD.P0.nSD 0.00387305f
Cred_10193 di_tg_ctrl_n.P42.GatPoly v_a.$1848.Metal2 0.00031041f
Cred_10194 di_tg_ctrl_n.P42.GatPoly v_a.$1850.Metal2 2.13729e-05f
Cred_10195 di_tg_ctrl_n.P42.GatPoly v_a.$1852.Metal2 6.96958e-05f
Cred_10196 di_tg_ctrl_n.P42.GatPoly v_a.$1854.Metal2 7.54503e-05f
Cred_10197 di_tg_ctrl_n.P42.GatPoly v_a.$1856.Metal2 1.40376e-05f
Cred_10198 di_tg_ctrl_n.P42.GatPoly v_a.$1858.Metal2 3.3001e-05f
Cred_10199 di_tg_ctrl_n.P42.GatPoly v_a.$1860.Metal2 3.11889e-05f
Cred_10200 di_tg_ctrl_n.P42.GatPoly v_a.$1862.Metal2 1.74593e-05f
Cred_10201 di_tg_ctrl_n.P42.GatPoly v_a.$1864.Metal2 7.30492e-05f
Cred_10202 di_tg_ctrl_n.P42.GatPoly v_a.$1866.Metal2 7.24099e-05f
Cred_10203 di_tg_ctrl_n.P42.GatPoly v_a.$1868.Metal2 1.8275e-05f
Cred_10204 di_tg_ctrl_n.P42.GatPoly v_a.$1870.Metal2 3.06942e-05f
Cred_10205 di_tg_ctrl_n.P42.GatPoly v_a.$1872.Metal2 0.000105446f
Cred_10206 di_tg_ctrl_n.P42.GatPoly v_a.$1874.Metal2 0.000974803f
Cred_10207 di_tg_ctrl_n.P42.GatPoly v_a.$2545.Metal3 0.0279858f
Cred_10208 di_tg_ctrl_n.P42.GatPoly v_a.$2548.Metal3 1.77439e-06f
Cred_10209 di_tg_ctrl_n.P42.GatPoly v_a.$2561.Metal3 0.000174744f
Cred_10210 di_tg_ctrl_n.P42.GatPoly v_a.$795.Metal1 0.0127569f
Cred_10211 di_tg_ctrl_n.P42.GatPoly v_a.$797.Metal1 0.00953463f
Cred_10212 di_tg_ctrl_n.P42.GatPoly v_a.$800.Metal1 0.00954049f
Cred_10213 di_tg_ctrl_n.P42.GatPoly v_a.$802.Metal1 0.00766745f
Cred_10214 di_tg_ctrl_n.P42.GatPoly v_a.$804.Metal1 0.00953743f
Cred_10215 di_tg_ctrl_n.P42.GatPoly v_a.$807.Metal1 0.00953691f
Cred_10216 di_tg_ctrl_n.P42.GatPoly v_a.$809.Metal1 0.013293f
Cred_10217 di_tg_ctrl_n.P42.GatPoly v_a.P24.pSD 0.00132083f
Cred_10218 di_tg_ctrl_n.P42.GatPoly v_b.$2691.Metal2 0.0397481f
Cred_10219 di_tg_ctrl_n.P42.GatPoly v_b.P23.pSD 0.053933f
Cred_10220 di_tg_ctrl_n.P42.GatPoly VDD.$340.Metal1 4.01719e-06f
Cred_10221 di_tg_ctrl_n.P42.GatPoly VDD.$388.Metal2 1.42401e-07f
Cred_10222 di_tg_ctrl_n.P42.GatPoly VDD.$42.Metal1 6.68634e-06f
Cred_10223 di_tg_ctrl_n.P42.GatPoly VDD.$666.Metal3 6.26924e-09f
Cred_10224 di_tg_ctrl_n.P42.GatPoly VDD.P0.nSD 0.00387364f
Cred_10225 di_tg_ctrl_n.P43.GatPoly VSS 1.38799e-05f
Cred_10226 di_tg_ctrl_n.P43.GatPoly v_a.$1848.Metal2 0.00031041f
Cred_10227 di_tg_ctrl_n.P43.GatPoly v_a.$1850.Metal2 2.13729e-05f
Cred_10228 di_tg_ctrl_n.P43.GatPoly v_a.$1852.Metal2 6.96958e-05f
Cred_10229 di_tg_ctrl_n.P43.GatPoly v_a.$1854.Metal2 7.54503e-05f
Cred_10230 di_tg_ctrl_n.P43.GatPoly v_a.$1856.Metal2 1.40376e-05f
Cred_10231 di_tg_ctrl_n.P43.GatPoly v_a.$1858.Metal2 3.3001e-05f
Cred_10232 di_tg_ctrl_n.P43.GatPoly v_a.$1860.Metal2 3.11889e-05f
Cred_10233 di_tg_ctrl_n.P43.GatPoly v_a.$1862.Metal2 1.74593e-05f
Cred_10234 di_tg_ctrl_n.P43.GatPoly v_a.$1864.Metal2 7.30492e-05f
Cred_10235 di_tg_ctrl_n.P43.GatPoly v_a.$1866.Metal2 7.24099e-05f
Cred_10236 di_tg_ctrl_n.P43.GatPoly v_a.$1868.Metal2 1.83269e-05f
Cred_10237 di_tg_ctrl_n.P43.GatPoly v_a.$1870.Metal2 3.07104e-05f
Cred_10238 di_tg_ctrl_n.P43.GatPoly v_a.$1872.Metal2 0.000106715f
Cred_10239 di_tg_ctrl_n.P43.GatPoly v_a.$1874.Metal2 0.00102107f
Cred_10240 di_tg_ctrl_n.P43.GatPoly v_a.$2545.Metal3 0.0279858f
Cred_10241 di_tg_ctrl_n.P43.GatPoly v_a.$2548.Metal3 1.77439e-06f
Cred_10242 di_tg_ctrl_n.P43.GatPoly v_a.$2561.Metal3 0.000186912f
Cred_10243 di_tg_ctrl_n.P43.GatPoly v_a.$795.Metal1 0.0127569f
Cred_10244 di_tg_ctrl_n.P43.GatPoly v_a.$797.Metal1 0.00953463f
Cred_10245 di_tg_ctrl_n.P43.GatPoly v_a.$800.Metal1 0.00954049f
Cred_10246 di_tg_ctrl_n.P43.GatPoly v_a.$802.Metal1 0.00766745f
Cred_10247 di_tg_ctrl_n.P43.GatPoly v_a.$804.Metal1 0.00953743f
Cred_10248 di_tg_ctrl_n.P43.GatPoly v_a.$807.Metal1 0.0095463f
Cred_10249 di_tg_ctrl_n.P43.GatPoly v_a.$809.Metal1 0.0133936f
Cred_10250 di_tg_ctrl_n.P43.GatPoly v_a.P24.pSD 0.00136654f
Cred_10251 di_tg_ctrl_n.P43.GatPoly v_b.$2691.Metal2 0.0199167f
Cred_10252 di_tg_ctrl_n.P43.GatPoly v_b.$2751.Metal2 0.0199167f
Cred_10253 di_tg_ctrl_n.P43.GatPoly v_b.P25.nSD 0.000220389f
Cred_10254 di_tg_ctrl_n.P43.GatPoly v_b.P25.pSD 0.0545811f
Cred_10255 di_tg_ctrl_n.P43.GatPoly VDD.$173.Metal1 3.35251e-06f
Cred_10256 di_tg_ctrl_n.P43.GatPoly VDD.$179.Metal1 8.34719e-06f
Cred_10257 di_tg_ctrl_n.P43.GatPoly VDD.$183.Metal1 3.65927e-07f
Cred_10258 di_tg_ctrl_n.P43.GatPoly VDD.$340.Metal1 4.37624e-06f
Cred_10259 di_tg_ctrl_n.P43.GatPoly VDD.$388.Metal2 1.31318e-07f
Cred_10260 di_tg_ctrl_n.P43.GatPoly VDD.$42.Metal1 6.16596e-06f
Cred_10261 di_tg_ctrl_n.P43.GatPoly VDD.$504.Metal2 1.93734e-08f
Cred_10262 di_tg_ctrl_n.P43.GatPoly VDD.$512.Metal2 1.09215e-09f
Cred_10263 di_tg_ctrl_n.P43.GatPoly VDD.$666.Metal3 5.78132e-09f
Cred_10264 di_tg_ctrl_n.P43.GatPoly VDD.$726.Metal3 8.75664e-12f
Cred_10265 di_tg_ctrl_n.P43.GatPoly VDD.P0.nSD 0.00387381f
Cred_10266 di_tg_ctrl_n.P44.GatPoly VSS 9.53025e-05f
Cred_10267 di_tg_ctrl_n.P44.GatPoly v_a.$1906.Metal2 0.000768799f
Cred_10268 di_tg_ctrl_n.P44.GatPoly v_a.$1908.Metal2 2.13729e-05f
Cred_10269 di_tg_ctrl_n.P44.GatPoly v_a.$1910.Metal2 6.96958e-05f
Cred_10270 di_tg_ctrl_n.P44.GatPoly v_a.$1912.Metal2 7.54503e-05f
Cred_10271 di_tg_ctrl_n.P44.GatPoly v_a.$1914.Metal2 1.40376e-05f
Cred_10272 di_tg_ctrl_n.P44.GatPoly v_a.$1916.Metal2 3.3001e-05f
Cred_10273 di_tg_ctrl_n.P44.GatPoly v_a.$1918.Metal2 3.11889e-05f
Cred_10274 di_tg_ctrl_n.P44.GatPoly v_a.$1920.Metal2 1.74593e-05f
Cred_10275 di_tg_ctrl_n.P44.GatPoly v_a.$1922.Metal2 7.30492e-05f
Cred_10276 di_tg_ctrl_n.P44.GatPoly v_a.$1924.Metal2 7.24099e-05f
Cred_10277 di_tg_ctrl_n.P44.GatPoly v_a.$1926.Metal2 1.84054e-05f
Cred_10278 di_tg_ctrl_n.P44.GatPoly v_a.$1928.Metal2 3.0735e-05f
Cred_10279 di_tg_ctrl_n.P44.GatPoly v_a.$1930.Metal2 0.000108634f
Cred_10280 di_tg_ctrl_n.P44.GatPoly v_a.$1932.Metal2 0.001091f
Cred_10281 di_tg_ctrl_n.P44.GatPoly v_a.$2567.Metal3 0.0172867f
Cred_10282 di_tg_ctrl_n.P44.GatPoly v_a.$2578.Metal3 0.0102245f
Cred_10283 di_tg_ctrl_n.P44.GatPoly v_a.$2591.Metal3 0.000205303f
Cred_10284 di_tg_ctrl_n.P44.GatPoly v_a.$858.Metal1 0.0127745f
Cred_10285 di_tg_ctrl_n.P44.GatPoly v_a.$860.Metal1 0.00953463f
Cred_10286 di_tg_ctrl_n.P44.GatPoly v_a.$863.Metal1 0.00954049f
Cred_10287 di_tg_ctrl_n.P44.GatPoly v_a.$865.Metal1 0.00766745f
Cred_10288 di_tg_ctrl_n.P44.GatPoly v_a.$867.Metal1 0.00953743f
Cred_10289 di_tg_ctrl_n.P44.GatPoly v_a.$870.Metal1 0.00956049f
Cred_10290 di_tg_ctrl_n.P44.GatPoly v_a.$872.Metal1 0.0135457f
Cred_10291 di_tg_ctrl_n.P44.GatPoly v_a.P26.pSD 0.00143608f
Cred_10292 di_tg_ctrl_n.P44.GatPoly v_b.$2691.Metal2 0.0199487f
Cred_10293 di_tg_ctrl_n.P44.GatPoly v_b.$2751.Metal2 0.0199487f
Cred_10294 di_tg_ctrl_n.P44.GatPoly v_b.P25.nSD 0.000220743f
Cred_10295 di_tg_ctrl_n.P44.GatPoly v_b.P25.pSD 0.0548081f
Cred_10296 di_tg_ctrl_n.P44.GatPoly VDD 3.05912e-05f
Cred_10297 di_tg_ctrl_n.P44.GatPoly VDD.$183.Metal1 3.4307e-05f
Cred_10298 di_tg_ctrl_n.P44.GatPoly VDD.$189.Metal1 1.88339e-05f
Cred_10299 di_tg_ctrl_n.P44.GatPoly VDD.$340.Metal1 4.76738e-06f
Cred_10300 di_tg_ctrl_n.P44.GatPoly VDD.$388.Metal2 1.21198e-07f
Cred_10301 di_tg_ctrl_n.P44.GatPoly VDD.$42.Metal1 5.69079e-06f
Cred_10302 di_tg_ctrl_n.P44.GatPoly VDD.$512.Metal2 8.61641e-08f
Cred_10303 di_tg_ctrl_n.P44.GatPoly VDD.$520.Metal2 2.8106e-08f
Cred_10304 di_tg_ctrl_n.P44.GatPoly VDD.$666.Metal3 5.33579e-09f
Cred_10305 di_tg_ctrl_n.P44.GatPoly VDD.$730.Metal3 2.25347e-10f
Cred_10306 di_tg_ctrl_n.P44.GatPoly VDD.P0.nSD 0.00387391f
Cred_10307 di_tg_ctrl_n.P45.GatPoly v_a.$1906.Metal2 0.000768799f
Cred_10308 di_tg_ctrl_n.P45.GatPoly v_a.$1908.Metal2 2.13729e-05f
Cred_10309 di_tg_ctrl_n.P45.GatPoly v_a.$1910.Metal2 6.96958e-05f
Cred_10310 di_tg_ctrl_n.P45.GatPoly v_a.$1912.Metal2 7.54503e-05f
Cred_10311 di_tg_ctrl_n.P45.GatPoly v_a.$1914.Metal2 1.40376e-05f
Cred_10312 di_tg_ctrl_n.P45.GatPoly v_a.$1916.Metal2 3.3001e-05f
Cred_10313 di_tg_ctrl_n.P45.GatPoly v_a.$1918.Metal2 3.11889e-05f
Cred_10314 di_tg_ctrl_n.P45.GatPoly v_a.$1920.Metal2 1.74593e-05f
Cred_10315 di_tg_ctrl_n.P45.GatPoly v_a.$1922.Metal2 7.30492e-05f
Cred_10316 di_tg_ctrl_n.P45.GatPoly v_a.$1924.Metal2 7.24099e-05f
Cred_10317 di_tg_ctrl_n.P45.GatPoly v_a.$1926.Metal2 1.8275e-05f
Cred_10318 di_tg_ctrl_n.P45.GatPoly v_a.$1928.Metal2 3.06942e-05f
Cred_10319 di_tg_ctrl_n.P45.GatPoly v_a.$1930.Metal2 0.000105446f
Cred_10320 di_tg_ctrl_n.P45.GatPoly v_a.$1932.Metal2 0.000974803f
Cred_10321 di_tg_ctrl_n.P45.GatPoly v_a.$2567.Metal3 0.0172867f
Cred_10322 di_tg_ctrl_n.P45.GatPoly v_a.$2578.Metal3 0.0102245f
Cred_10323 di_tg_ctrl_n.P45.GatPoly v_a.$2591.Metal3 0.000174744f
Cred_10324 di_tg_ctrl_n.P45.GatPoly v_a.$858.Metal1 0.0127745f
Cred_10325 di_tg_ctrl_n.P45.GatPoly v_a.$860.Metal1 0.00953463f
Cred_10326 di_tg_ctrl_n.P45.GatPoly v_a.$863.Metal1 0.00954049f
Cred_10327 di_tg_ctrl_n.P45.GatPoly v_a.$865.Metal1 0.00766745f
Cred_10328 di_tg_ctrl_n.P45.GatPoly v_a.$867.Metal1 0.00953743f
Cred_10329 di_tg_ctrl_n.P45.GatPoly v_a.$870.Metal1 0.00953691f
Cred_10330 di_tg_ctrl_n.P45.GatPoly v_a.$872.Metal1 0.013293f
Cred_10331 di_tg_ctrl_n.P45.GatPoly v_a.P26.pSD 0.00132126f
Cred_10332 di_tg_ctrl_n.P45.GatPoly v_b.$2751.Metal2 0.0397481f
Cred_10333 di_tg_ctrl_n.P45.GatPoly v_b.P27.pSD 0.053933f
Cred_10334 di_tg_ctrl_n.P45.GatPoly VDD.$340.Metal1 5.59452e-06f
Cred_10335 di_tg_ctrl_n.P45.GatPoly VDD.$388.Metal2 1.03279e-07f
Cred_10336 di_tg_ctrl_n.P45.GatPoly VDD.$42.Metal1 4.84942e-06f
Cred_10337 di_tg_ctrl_n.P45.GatPoly VDD.$666.Metal3 4.54691e-09f
Cred_10338 di_tg_ctrl_n.P45.GatPoly VDD.P0.nSD 0.00387394f
Cred_10339 di_tg_ctrl_n.P46.GatPoly v_a.$1964.Metal2 0.000768799f
Cred_10340 di_tg_ctrl_n.P46.GatPoly v_a.$1966.Metal2 2.13729e-05f
Cred_10341 di_tg_ctrl_n.P46.GatPoly v_a.$1968.Metal2 6.96958e-05f
Cred_10342 di_tg_ctrl_n.P46.GatPoly v_a.$1970.Metal2 7.54503e-05f
Cred_10343 di_tg_ctrl_n.P46.GatPoly v_a.$1972.Metal2 1.40376e-05f
Cred_10344 di_tg_ctrl_n.P46.GatPoly v_a.$1974.Metal2 3.3001e-05f
Cred_10345 di_tg_ctrl_n.P46.GatPoly v_a.$1976.Metal2 3.11889e-05f
Cred_10346 di_tg_ctrl_n.P46.GatPoly v_a.$1978.Metal2 1.74593e-05f
Cred_10347 di_tg_ctrl_n.P46.GatPoly v_a.$1980.Metal2 3.82998e-05f
Cred_10348 di_tg_ctrl_n.P46.GatPoly v_a.$1982.Metal2 7.47731e-06f
Cred_10349 di_tg_ctrl_n.P46.GatPoly v_a.$1984.Metal2 3.6258e-05f
Cred_10350 di_tg_ctrl_n.P46.GatPoly v_a.$1986.Metal2 2.67936e-05f
Cred_10351 di_tg_ctrl_n.P46.GatPoly v_a.$1988.Metal2 2.35269e-05f
Cred_10352 di_tg_ctrl_n.P46.GatPoly v_a.$1990.Metal2 0.000464531f
Cred_10353 di_tg_ctrl_n.P46.GatPoly v_a.$2597.Metal3 0.0172867f
Cred_10354 di_tg_ctrl_n.P46.GatPoly v_a.$2608.Metal3 0.0102245f
Cred_10355 di_tg_ctrl_n.P46.GatPoly v_a.$2621.Metal3 8.81741e-05f
Cred_10356 di_tg_ctrl_n.P46.GatPoly v_a.$921.Metal1 0.0127745f
Cred_10357 di_tg_ctrl_n.P46.GatPoly v_a.$923.Metal1 0.00953463f
Cred_10358 di_tg_ctrl_n.P46.GatPoly v_a.$926.Metal1 0.00954049f
Cred_10359 di_tg_ctrl_n.P46.GatPoly v_a.$928.Metal1 0.00766745f
Cred_10360 di_tg_ctrl_n.P46.GatPoly v_a.$930.Metal1 0.00767162f
Cred_10361 di_tg_ctrl_n.P46.GatPoly v_a.$932.Metal1 0.00770591f
Cred_10362 di_tg_ctrl_n.P46.GatPoly v_a.$934.Metal1 0.00769518f
Cred_10363 di_tg_ctrl_n.P46.GatPoly v_a.$936.Metal1 0.0105913f
Cred_10364 di_tg_ctrl_n.P46.GatPoly v_a.P28.pSD 0.000788872f
Cred_10365 di_tg_ctrl_n.P46.GatPoly v_b.$2751.Metal2 0.0397481f
Cred_10366 di_tg_ctrl_n.P46.GatPoly v_b.P27.pSD 0.053933f
Cred_10367 di_tg_ctrl_n.P46.GatPoly VDD.$340.Metal1 6.57322e-06f
Cred_10368 di_tg_ctrl_n.P46.GatPoly VDD.$388.Metal2 8.70273e-08f
Cred_10369 di_tg_ctrl_n.P46.GatPoly VDD.$42.Metal1 4.08632e-06f
Cred_10370 di_tg_ctrl_n.P46.GatPoly VDD.$666.Metal3 3.83141e-09f
Cred_10371 di_tg_ctrl_n.P46.GatPoly VDD.P0.nSD 0.00387374f
Cred_10372 di_tg_ctrl_n.P47.GatPoly VSS 1.38799e-05f
Cred_10373 di_tg_ctrl_n.P47.GatPoly v_a.$1964.Metal2 0.000768799f
Cred_10374 di_tg_ctrl_n.P47.GatPoly v_a.$1966.Metal2 2.13729e-05f
Cred_10375 di_tg_ctrl_n.P47.GatPoly v_a.$1968.Metal2 6.96958e-05f
Cred_10376 di_tg_ctrl_n.P47.GatPoly v_a.$1970.Metal2 7.54503e-05f
Cred_10377 di_tg_ctrl_n.P47.GatPoly v_a.$1972.Metal2 1.40376e-05f
Cred_10378 di_tg_ctrl_n.P47.GatPoly v_a.$1974.Metal2 3.3001e-05f
Cred_10379 di_tg_ctrl_n.P47.GatPoly v_a.$1976.Metal2 3.11889e-05f
Cred_10380 di_tg_ctrl_n.P47.GatPoly v_a.$1978.Metal2 1.74593e-05f
Cred_10381 di_tg_ctrl_n.P47.GatPoly v_a.$1980.Metal2 3.82998e-05f
Cred_10382 di_tg_ctrl_n.P47.GatPoly v_a.$1982.Metal2 7.48529e-06f
Cred_10383 di_tg_ctrl_n.P47.GatPoly v_a.$1984.Metal2 3.636e-05f
Cred_10384 di_tg_ctrl_n.P47.GatPoly v_a.$1986.Metal2 2.67936e-05f
Cred_10385 di_tg_ctrl_n.P47.GatPoly v_a.$1988.Metal2 2.35269e-05f
Cred_10386 di_tg_ctrl_n.P47.GatPoly v_a.$1990.Metal2 0.000504063f
Cred_10387 di_tg_ctrl_n.P47.GatPoly v_a.$2597.Metal3 0.0172867f
Cred_10388 di_tg_ctrl_n.P47.GatPoly v_a.$2608.Metal3 0.0102245f
Cred_10389 di_tg_ctrl_n.P47.GatPoly v_a.$2621.Metal3 9.91996e-05f
Cred_10390 di_tg_ctrl_n.P47.GatPoly v_a.$921.Metal1 0.0127745f
Cred_10391 di_tg_ctrl_n.P47.GatPoly v_a.$923.Metal1 0.00953463f
Cred_10392 di_tg_ctrl_n.P47.GatPoly v_a.$926.Metal1 0.00954049f
Cred_10393 di_tg_ctrl_n.P47.GatPoly v_a.$928.Metal1 0.00766745f
Cred_10394 di_tg_ctrl_n.P47.GatPoly v_a.$930.Metal1 0.00767162f
Cred_10395 di_tg_ctrl_n.P47.GatPoly v_a.$932.Metal1 0.00770983f
Cred_10396 di_tg_ctrl_n.P47.GatPoly v_a.$934.Metal1 0.00770205f
Cred_10397 di_tg_ctrl_n.P47.GatPoly v_a.$936.Metal1 0.0107061f
Cred_10398 di_tg_ctrl_n.P47.GatPoly v_a.P28.pSD 0.000828121f
Cred_10399 di_tg_ctrl_n.P47.GatPoly v_b.$2751.Metal2 0.0199167f
Cred_10400 di_tg_ctrl_n.P47.GatPoly v_b.$2811.Metal2 0.0199167f
Cred_10401 di_tg_ctrl_n.P47.GatPoly v_b.P29.nSD 0.000220389f
Cred_10402 di_tg_ctrl_n.P47.GatPoly v_b.P29.pSD 0.0545811f
Cred_10403 di_tg_ctrl_n.P47.GatPoly VDD.$193.Metal1 3.65927e-07f
Cred_10404 di_tg_ctrl_n.P47.GatPoly VDD.$197.Metal1 8.34719e-06f
Cred_10405 di_tg_ctrl_n.P47.GatPoly VDD.$203.Metal1 3.35251e-06f
Cred_10406 di_tg_ctrl_n.P47.GatPoly VDD.$340.Metal1 7.13301e-06f
Cred_10407 di_tg_ctrl_n.P47.GatPoly VDD.$388.Metal2 7.98871e-08f
Cred_10408 di_tg_ctrl_n.P47.GatPoly VDD.$42.Metal1 3.75106e-06f
Cred_10409 di_tg_ctrl_n.P47.GatPoly VDD.$520.Metal2 1.09215e-09f
Cred_10410 di_tg_ctrl_n.P47.GatPoly VDD.$528.Metal2 1.93734e-08f
Cred_10411 di_tg_ctrl_n.P47.GatPoly VDD.$666.Metal3 3.51706e-09f
Cred_10412 di_tg_ctrl_n.P47.GatPoly VDD.$734.Metal3 8.75664e-12f
Cred_10413 di_tg_ctrl_n.P47.GatPoly VDD.P0.nSD 0.00387353f
Cred_10414 di_tg_ctrl_n.P48.GatPoly VSS 9.53025e-05f
Cred_10415 di_tg_ctrl_n.P48.GatPoly v_a.$2022.Metal2 0.00031041f
Cred_10416 di_tg_ctrl_n.P48.GatPoly v_a.$2024.Metal2 2.13729e-05f
Cred_10417 di_tg_ctrl_n.P48.GatPoly v_a.$2026.Metal2 6.96958e-05f
Cred_10418 di_tg_ctrl_n.P48.GatPoly v_a.$2028.Metal2 7.54503e-05f
Cred_10419 di_tg_ctrl_n.P48.GatPoly v_a.$2030.Metal2 1.40376e-05f
Cred_10420 di_tg_ctrl_n.P48.GatPoly v_a.$2032.Metal2 3.3001e-05f
Cred_10421 di_tg_ctrl_n.P48.GatPoly v_a.$2034.Metal2 3.11889e-05f
Cred_10422 di_tg_ctrl_n.P48.GatPoly v_a.$2036.Metal2 1.74593e-05f
Cred_10423 di_tg_ctrl_n.P48.GatPoly v_a.$2038.Metal2 7.30492e-05f
Cred_10424 di_tg_ctrl_n.P48.GatPoly v_a.$2040.Metal2 7.24099e-05f
Cred_10425 di_tg_ctrl_n.P48.GatPoly v_a.$2042.Metal2 1.84054e-05f
Cred_10426 di_tg_ctrl_n.P48.GatPoly v_a.$2044.Metal2 3.0735e-05f
Cred_10427 di_tg_ctrl_n.P48.GatPoly v_a.$2046.Metal2 0.000108634f
Cred_10428 di_tg_ctrl_n.P48.GatPoly v_a.$2048.Metal2 0.001091f
Cred_10429 di_tg_ctrl_n.P48.GatPoly v_a.$2635.Metal3 0.0279858f
Cred_10430 di_tg_ctrl_n.P48.GatPoly v_a.$2638.Metal3 1.77439e-06f
Cred_10431 di_tg_ctrl_n.P48.GatPoly v_a.$2651.Metal3 0.000205303f
Cred_10432 di_tg_ctrl_n.P48.GatPoly v_a.$984.Metal1 0.0127569f
Cred_10433 di_tg_ctrl_n.P48.GatPoly v_a.$986.Metal1 0.00953463f
Cred_10434 di_tg_ctrl_n.P48.GatPoly v_a.$989.Metal1 0.00954049f
Cred_10435 di_tg_ctrl_n.P48.GatPoly v_a.$991.Metal1 0.00766745f
Cred_10436 di_tg_ctrl_n.P48.GatPoly v_a.$993.Metal1 0.00953743f
Cred_10437 di_tg_ctrl_n.P48.GatPoly v_a.$996.Metal1 0.00956049f
Cred_10438 di_tg_ctrl_n.P48.GatPoly v_a.$998.Metal1 0.0135457f
Cred_10439 di_tg_ctrl_n.P48.GatPoly v_a.P30.pSD 0.00143565f
Cred_10440 di_tg_ctrl_n.P48.GatPoly v_b.$2751.Metal2 0.0199487f
Cred_10441 di_tg_ctrl_n.P48.GatPoly v_b.$2811.Metal2 0.0199487f
Cred_10442 di_tg_ctrl_n.P48.GatPoly v_b.P29.nSD 0.000220743f
Cred_10443 di_tg_ctrl_n.P48.GatPoly v_b.P29.pSD 0.0548081f
Cred_10444 di_tg_ctrl_n.P48.GatPoly VDD.$203.Metal1 3.15169e-05f
Cred_10445 di_tg_ctrl_n.P48.GatPoly VDD.$207.Metal1 3.33199e-05f
Cred_10446 di_tg_ctrl_n.P48.GatPoly VDD.$211.Metal1 2.04299e-05f
Cred_10447 di_tg_ctrl_n.P48.GatPoly VDD.$340.Metal1 8.41399e-06f
Cred_10448 di_tg_ctrl_n.P48.GatPoly VDD.$388.Metal2 6.73163e-08f
Cred_10449 di_tg_ctrl_n.P48.GatPoly VDD.$42.Metal1 3.1608e-06f
Cred_10450 di_tg_ctrl_n.P48.GatPoly VDD.$528.Metal2 3.52747e-08f
Cred_10451 di_tg_ctrl_n.P48.GatPoly VDD.$536.Metal2 9.28974e-08f
Cred_10452 di_tg_ctrl_n.P48.GatPoly VDD.$666.Metal3 2.96363e-09f
Cred_10453 di_tg_ctrl_n.P48.GatPoly VDD.$738.Metal3 2.82825e-10f
Cred_10454 di_tg_ctrl_n.P48.GatPoly VDD.P0.nSD 0.00387284f
Cred_10455 di_tg_ctrl_n.P49.GatPoly v_a.$2022.Metal2 0.00031041f
Cred_10456 di_tg_ctrl_n.P49.GatPoly v_a.$2024.Metal2 2.13729e-05f
Cred_10457 di_tg_ctrl_n.P49.GatPoly v_a.$2026.Metal2 6.96958e-05f
Cred_10458 di_tg_ctrl_n.P49.GatPoly v_a.$2028.Metal2 7.54503e-05f
Cred_10459 di_tg_ctrl_n.P49.GatPoly v_a.$2030.Metal2 1.40376e-05f
Cred_10460 di_tg_ctrl_n.P49.GatPoly v_a.$2032.Metal2 3.3001e-05f
Cred_10461 di_tg_ctrl_n.P49.GatPoly v_a.$2034.Metal2 3.11889e-05f
Cred_10462 di_tg_ctrl_n.P49.GatPoly v_a.$2036.Metal2 1.74593e-05f
Cred_10463 di_tg_ctrl_n.P49.GatPoly v_a.$2038.Metal2 7.30492e-05f
Cred_10464 di_tg_ctrl_n.P49.GatPoly v_a.$2040.Metal2 7.24099e-05f
Cred_10465 di_tg_ctrl_n.P49.GatPoly v_a.$2042.Metal2 1.8275e-05f
Cred_10466 di_tg_ctrl_n.P49.GatPoly v_a.$2044.Metal2 3.06942e-05f
Cred_10467 di_tg_ctrl_n.P49.GatPoly v_a.$2046.Metal2 0.000105446f
Cred_10468 di_tg_ctrl_n.P49.GatPoly v_a.$2048.Metal2 0.000974803f
Cred_10469 di_tg_ctrl_n.P49.GatPoly v_a.$2635.Metal3 0.0279858f
Cred_10470 di_tg_ctrl_n.P49.GatPoly v_a.$2638.Metal3 1.77439e-06f
Cred_10471 di_tg_ctrl_n.P49.GatPoly v_a.$2651.Metal3 0.000174744f
Cred_10472 di_tg_ctrl_n.P49.GatPoly v_a.$984.Metal1 0.0127569f
Cred_10473 di_tg_ctrl_n.P49.GatPoly v_a.$986.Metal1 0.00953463f
Cred_10474 di_tg_ctrl_n.P49.GatPoly v_a.$989.Metal1 0.00954049f
Cred_10475 di_tg_ctrl_n.P49.GatPoly v_a.$991.Metal1 0.00766745f
Cred_10476 di_tg_ctrl_n.P49.GatPoly v_a.$993.Metal1 0.00953743f
Cred_10477 di_tg_ctrl_n.P49.GatPoly v_a.$996.Metal1 0.00953691f
Cred_10478 di_tg_ctrl_n.P49.GatPoly v_a.$998.Metal1 0.013293f
Cred_10479 di_tg_ctrl_n.P49.GatPoly v_a.P30.pSD 0.00132083f
Cred_10480 di_tg_ctrl_n.P49.GatPoly v_b.$2811.Metal2 0.0397481f
Cred_10481 di_tg_ctrl_n.P49.GatPoly v_b.P31.pSD 0.053933f
Cred_10482 di_tg_ctrl_n.P49.GatPoly VDD.$340.Metal1 9.14458e-06f
Cred_10483 di_tg_ctrl_n.P49.GatPoly VDD.$388.Metal2 6.17935e-08f
Cred_10484 di_tg_ctrl_n.P49.GatPoly VDD.$42.Metal1 2.90148e-06f
Cred_10485 di_tg_ctrl_n.P49.GatPoly VDD.$666.Metal3 2.72048e-09f
Cred_10486 di_tg_ctrl_n.P49.GatPoly VDD.P0.nSD 0.00387238f
Cred_10487 di_tg_ctrl_n.P5.GatPoly VSS 0.0139636f
Cred_10488 di_tg_ctrl_n.P5.GatPoly v_b.$3089.Metal2 0.00238558f
Cred_10489 di_tg_ctrl_n.P5.GatPoly v_b.$3153.Metal2 0.0240599f
Cred_10490 di_tg_ctrl_n.P5.GatPoly v_b.$3821.Metal3 0.0132882f
Cred_10491 di_tg_ctrl_n.P5.GatPoly v_b.$3857.Metal3 0.000720904f
Cred_10492 di_tg_ctrl_n.P5.GatPoly v_b.P45.nSD 0.0152074f
Cred_10493 di_tg_ctrl_n.P5.GatPoly v_b.P47.nSD 0.0126191f
Cred_10494 di_tg_ctrl_n.P5.GatPoly VSS.$17.Metal1 2.61843e-06f
Cred_10495 di_tg_ctrl_n.P5.GatPoly VSS.$239.Metal1 6.29631e-05f
Cred_10496 di_tg_ctrl_n.P5.GatPoly VSS.$253.Metal1 8.82328e-05f
Cred_10497 di_tg_ctrl_n.P5.GatPoly VSS.$301.Metal1 7.9221e-05f
Cred_10498 di_tg_ctrl_n.P5.GatPoly VSS.$550.Metal2 4.85555e-07f
Cred_10499 di_tg_ctrl_n.P5.GatPoly VSS.$554.Metal2 6.80544e-07f
Cred_10500 di_tg_ctrl_n.P5.GatPoly VSS.$606.Metal2 8.37061e-06f
Cred_10501 di_tg_ctrl_n.P5.GatPoly VSS.$760.Metal3 4.95278e-07f
Cred_10502 di_tg_ctrl_n.P5.GatPoly VSS.P0.pSD 0.00273843f
Cred_10503 di_tg_ctrl_n.P50.GatPoly v_a.$1047.Metal1 0.0127745f
Cred_10504 di_tg_ctrl_n.P50.GatPoly v_a.$1049.Metal1 0.00953463f
Cred_10505 di_tg_ctrl_n.P50.GatPoly v_a.$1052.Metal1 0.00954049f
Cred_10506 di_tg_ctrl_n.P50.GatPoly v_a.$1054.Metal1 0.00766745f
Cred_10507 di_tg_ctrl_n.P50.GatPoly v_a.$1056.Metal1 0.00767162f
Cred_10508 di_tg_ctrl_n.P50.GatPoly v_a.$1058.Metal1 0.00770591f
Cred_10509 di_tg_ctrl_n.P50.GatPoly v_a.$1060.Metal1 0.00769518f
Cred_10510 di_tg_ctrl_n.P50.GatPoly v_a.$1062.Metal1 0.0105913f
Cred_10511 di_tg_ctrl_n.P50.GatPoly v_a.$2080.Metal2 0.000769032f
Cred_10512 di_tg_ctrl_n.P50.GatPoly v_a.$2082.Metal2 2.13729e-05f
Cred_10513 di_tg_ctrl_n.P50.GatPoly v_a.$2084.Metal2 6.96958e-05f
Cred_10514 di_tg_ctrl_n.P50.GatPoly v_a.$2086.Metal2 7.54503e-05f
Cred_10515 di_tg_ctrl_n.P50.GatPoly v_a.$2088.Metal2 1.40376e-05f
Cred_10516 di_tg_ctrl_n.P50.GatPoly v_a.$2090.Metal2 3.3001e-05f
Cred_10517 di_tg_ctrl_n.P50.GatPoly v_a.$2092.Metal2 3.11889e-05f
Cred_10518 di_tg_ctrl_n.P50.GatPoly v_a.$2094.Metal2 1.74593e-05f
Cred_10519 di_tg_ctrl_n.P50.GatPoly v_a.$2096.Metal2 3.82998e-05f
Cred_10520 di_tg_ctrl_n.P50.GatPoly v_a.$2098.Metal2 7.47731e-06f
Cred_10521 di_tg_ctrl_n.P50.GatPoly v_a.$2100.Metal2 3.6258e-05f
Cred_10522 di_tg_ctrl_n.P50.GatPoly v_a.$2102.Metal2 2.67936e-05f
Cred_10523 di_tg_ctrl_n.P50.GatPoly v_a.$2104.Metal2 2.35269e-05f
Cred_10524 di_tg_ctrl_n.P50.GatPoly v_a.$2106.Metal2 0.000464531f
Cred_10525 di_tg_ctrl_n.P50.GatPoly v_a.$2657.Metal3 0.0172955f
Cred_10526 di_tg_ctrl_n.P50.GatPoly v_a.$2668.Metal3 0.0102297f
Cred_10527 di_tg_ctrl_n.P50.GatPoly v_a.$2681.Metal3 8.81741e-05f
Cred_10528 di_tg_ctrl_n.P50.GatPoly v_a.P32.pSD 0.000788872f
Cred_10529 di_tg_ctrl_n.P50.GatPoly v_b.$2811.Metal2 0.0397481f
Cred_10530 di_tg_ctrl_n.P50.GatPoly v_b.P31.pSD 0.053933f
Cred_10531 di_tg_ctrl_n.P50.GatPoly VDD.$340.Metal1 1.08128e-05f
Cred_10532 di_tg_ctrl_n.P50.GatPoly VDD.$388.Metal2 5.207e-08f
Cred_10533 di_tg_ctrl_n.P50.GatPoly VDD.$42.Metal1 2.44492e-06f
Cred_10534 di_tg_ctrl_n.P50.GatPoly VDD.$666.Metal3 2.29241e-09f
Cred_10535 di_tg_ctrl_n.P50.GatPoly VDD.P0.nSD 0.00387118f
Cred_10536 di_tg_ctrl_n.P51.GatPoly VSS 9.53058e-05f
Cred_10537 di_tg_ctrl_n.P51.GatPoly v_a.$1047.Metal1 0.0127744f
Cred_10538 di_tg_ctrl_n.P51.GatPoly v_a.$1049.Metal1 0.00953463f
Cred_10539 di_tg_ctrl_n.P51.GatPoly v_a.$1052.Metal1 0.00954049f
Cred_10540 di_tg_ctrl_n.P51.GatPoly v_a.$1054.Metal1 0.00766745f
Cred_10541 di_tg_ctrl_n.P51.GatPoly v_a.$1056.Metal1 0.00767162f
Cred_10542 di_tg_ctrl_n.P51.GatPoly v_a.$1058.Metal1 0.00771575f
Cred_10543 di_tg_ctrl_n.P51.GatPoly v_a.$1060.Metal1 0.00771243f
Cred_10544 di_tg_ctrl_n.P51.GatPoly v_a.$1062.Metal1 0.0108797f
Cred_10545 di_tg_ctrl_n.P51.GatPoly v_a.$2080.Metal2 0.000768416f
Cred_10546 di_tg_ctrl_n.P51.GatPoly v_a.$2082.Metal2 2.13729e-05f
Cred_10547 di_tg_ctrl_n.P51.GatPoly v_a.$2084.Metal2 6.96958e-05f
Cred_10548 di_tg_ctrl_n.P51.GatPoly v_a.$2086.Metal2 7.54503e-05f
Cred_10549 di_tg_ctrl_n.P51.GatPoly v_a.$2088.Metal2 1.40376e-05f
Cred_10550 di_tg_ctrl_n.P51.GatPoly v_a.$2090.Metal2 3.3001e-05f
Cred_10551 di_tg_ctrl_n.P51.GatPoly v_a.$2092.Metal2 3.11889e-05f
Cred_10552 di_tg_ctrl_n.P51.GatPoly v_a.$2094.Metal2 1.74593e-05f
Cred_10553 di_tg_ctrl_n.P51.GatPoly v_a.$2096.Metal2 3.82998e-05f
Cred_10554 di_tg_ctrl_n.P51.GatPoly v_a.$2098.Metal2 7.49736e-06f
Cred_10555 di_tg_ctrl_n.P51.GatPoly v_a.$2100.Metal2 3.6514e-05f
Cred_10556 di_tg_ctrl_n.P51.GatPoly v_a.$2102.Metal2 2.67936e-05f
Cred_10557 di_tg_ctrl_n.P51.GatPoly v_a.$2104.Metal2 2.35269e-05f
Cred_10558 di_tg_ctrl_n.P51.GatPoly v_a.$2106.Metal2 0.000563817f
Cred_10559 di_tg_ctrl_n.P51.GatPoly v_a.$2657.Metal3 0.0172723f
Cred_10560 di_tg_ctrl_n.P51.GatPoly v_a.$2668.Metal3 0.010216f
Cred_10561 di_tg_ctrl_n.P51.GatPoly v_a.$2677.Metal3 2.66061e-09f
Cred_10562 di_tg_ctrl_n.P51.GatPoly v_a.$2681.Metal3 0.000115865f
Cred_10563 di_tg_ctrl_n.P51.GatPoly v_a.P32.pSD 0.000887446f
Cred_10564 di_tg_ctrl_n.P51.GatPoly v_b.$2811.Metal2 0.0195702f
Cred_10565 di_tg_ctrl_n.P51.GatPoly v_b.$2871.Metal2 0.0195702f
Cred_10566 di_tg_ctrl_n.P51.GatPoly v_b.P33.nSD 0.000216554f
Cred_10567 di_tg_ctrl_n.P51.GatPoly v_b.P33.pSD 0.0546774f
Cred_10568 di_tg_ctrl_n.P51.GatPoly VDD.$215.Metal1 2.56083e-05f
Cred_10569 di_tg_ctrl_n.P51.GatPoly VDD.$225.Metal1 5.37621e-05f
Cred_10570 di_tg_ctrl_n.P51.GatPoly VDD.$230.Metal1 3.16104e-06f
Cred_10571 di_tg_ctrl_n.P51.GatPoly VDD.$340.Metal1 1.17626e-05f
Cred_10572 di_tg_ctrl_n.P51.GatPoly VDD.$388.Metal2 4.77982e-08f
Cred_10573 di_tg_ctrl_n.P51.GatPoly VDD.$42.Metal1 2.24434e-06f
Cred_10574 di_tg_ctrl_n.P51.GatPoly VDD.$544.Metal2 1.58903e-07f
Cred_10575 di_tg_ctrl_n.P51.GatPoly VDD.$548.Metal2 2.30528e-07f
Cred_10576 di_tg_ctrl_n.P51.GatPoly VDD.$552.Metal2 2.43822e-08f
Cred_10577 di_tg_ctrl_n.P51.GatPoly VDD.$666.Metal3 2.10433e-09f
Cred_10578 di_tg_ctrl_n.P51.GatPoly VDD.P0.nSD 0.00387054f
Cred_10579 di_tg_ctrl_n.P52.GatPoly VSS 3.6835e-05f
Cred_10580 di_tg_ctrl_n.P52.GatPoly v_a.$2657.Metal3 0.0466387f
Cred_10581 di_tg_ctrl_n.P52.GatPoly v_a.P34.nSD 0.000306681f
Cred_10582 di_tg_ctrl_n.P52.GatPoly v_a.P34.pSD 0.0574876f
Cred_10583 di_tg_ctrl_n.P52.GatPoly v_b.$2811.Metal2 0.0190629f
Cred_10584 di_tg_ctrl_n.P52.GatPoly v_b.$2871.Metal2 0.0190979f
Cred_10585 di_tg_ctrl_n.P52.GatPoly v_b.P33.nSD 0.000210941f
Cred_10586 di_tg_ctrl_n.P52.GatPoly v_b.P33.pSD 0.0543232f
Cred_10587 di_tg_ctrl_n.P52.GatPoly v_b.P35.pSD 0.000123444f
Cred_10588 di_tg_ctrl_n.P52.GatPoly VDD.$225.Metal1 1.85245e-07f
Cred_10589 di_tg_ctrl_n.P52.GatPoly VDD.$230.Metal1 3.12497e-05f
Cred_10590 di_tg_ctrl_n.P52.GatPoly VDD.$238.Metal1 3.20027e-06f
Cred_10591 di_tg_ctrl_n.P52.GatPoly VDD.$340.Metal1 1.39287e-05f
Cred_10592 di_tg_ctrl_n.P52.GatPoly VDD.$388.Metal2 4.02772e-08f
Cred_10593 di_tg_ctrl_n.P52.GatPoly VDD.$42.Metal1 1.89119e-06f
Cred_10594 di_tg_ctrl_n.P52.GatPoly VDD.$552.Metal2 4.52822e-10f
Cred_10595 di_tg_ctrl_n.P52.GatPoly VDD.$560.Metal2 2.46793e-08f
Cred_10596 di_tg_ctrl_n.P52.GatPoly VDD.$666.Metal3 1.77322e-09f
Cred_10597 di_tg_ctrl_n.P52.GatPoly VDD.P0.nSD 0.00386864f
Cred_10598 di_tg_ctrl_n.P53.GatPoly VSS 0.000138466f
Cred_10599 di_tg_ctrl_n.P53.GatPoly v_a.$2657.Metal3 0.0286112f
Cred_10600 di_tg_ctrl_n.P53.GatPoly v_a.P34.nSD 0.000188138f
Cred_10601 di_tg_ctrl_n.P53.GatPoly v_a.P34.pSD 0.0690412f
Cred_10602 di_tg_ctrl_n.P53.GatPoly v_b.$2811.Metal2 1.6452e-05f
Cred_10603 di_tg_ctrl_n.P53.GatPoly v_b.$2871.Metal2 0.0412591f
Cred_10604 di_tg_ctrl_n.P53.GatPoly v_b.P33.nSD 1.8205e-07f
Cred_10605 di_tg_ctrl_n.P53.GatPoly v_b.P33.pSD 0.000118904f
Cred_10606 di_tg_ctrl_n.P53.GatPoly v_b.P35.pSD 0.0552407f
Cred_10607 di_tg_ctrl_n.P53.GatPoly VDD.$225.Metal1 6.96353e-07f
Cred_10608 di_tg_ctrl_n.P53.GatPoly VDD.$230.Metal1 0.0042034f
Cred_10609 di_tg_ctrl_n.P53.GatPoly VDD.$238.Metal1 0.000849149f
Cred_10610 di_tg_ctrl_n.P53.GatPoly VDD.$340.Metal1 1.51608e-05f
Cred_10611 di_tg_ctrl_n.P53.GatPoly VDD.$388.Metal2 3.6973e-08f
Cred_10612 di_tg_ctrl_n.P53.GatPoly VDD.$42.Metal1 1.73605e-06f
Cred_10613 di_tg_ctrl_n.P53.GatPoly VDD.$552.Metal2 0.000529179f
Cred_10614 di_tg_ctrl_n.P53.GatPoly VDD.$560.Metal2 0.00345301f
Cred_10615 di_tg_ctrl_n.P53.GatPoly VDD.$568.Metal2 1.06928e-05f
Cred_10616 di_tg_ctrl_n.P53.GatPoly VDD.$666.Metal3 1.62775e-09f
Cred_10617 di_tg_ctrl_n.P53.GatPoly VDD.$750.Metal3 0.00203011f
Cred_10618 di_tg_ctrl_n.P53.GatPoly VDD.$758.Metal3 0.000668147f
Cred_10619 di_tg_ctrl_n.P53.GatPoly VDD.P0.nSD 0.00387185f
Cred_10620 di_tg_ctrl_n.P6.GatPoly VSS 0.0127828f
Cred_10621 di_tg_ctrl_n.P6.GatPoly v_b.$3153.Metal2 0.0229351f
Cred_10622 di_tg_ctrl_n.P6.GatPoly v_b.$3247.Metal2 0.00328311f
Cred_10623 di_tg_ctrl_n.P6.GatPoly v_b.$3857.Metal3 0.00753349f
Cred_10624 di_tg_ctrl_n.P6.GatPoly v_b.$3890.Metal3 0.00636634f
Cred_10625 di_tg_ctrl_n.P6.GatPoly v_b.P47.nSD 0.0125127f
Cred_10626 di_tg_ctrl_n.P6.GatPoly v_b.P49.nSD 0.0150709f
Cred_10627 di_tg_ctrl_n.P6.GatPoly v_b.P49.pSD 2.76029e-05f
Cred_10628 di_tg_ctrl_n.P6.GatPoly v_b.P51.nSD 6.80155e-06f
Cred_10629 di_tg_ctrl_n.P6.GatPoly VSS.$17.Metal1 2.85321e-06f
Cred_10630 di_tg_ctrl_n.P6.GatPoly VSS.$253.Metal1 1.74464e-05f
Cred_10631 di_tg_ctrl_n.P6.GatPoly VSS.$261.Metal1 1.74479e-05f
Cred_10632 di_tg_ctrl_n.P6.GatPoly VSS.$301.Metal1 0.000121562f
Cred_10633 di_tg_ctrl_n.P6.GatPoly VSS.$562.Metal2 1.3457e-07f
Cred_10634 di_tg_ctrl_n.P6.GatPoly VSS.$606.Metal2 1.28444e-05f
Cred_10635 di_tg_ctrl_n.P6.GatPoly VSS.$760.Metal3 7.59987e-07f
Cred_10636 di_tg_ctrl_n.P6.GatPoly VSS.P0.pSD 0.00352064f
Cred_10637 di_tg_ctrl_n.P7.GatPoly VSS 0.012736f
Cred_10638 di_tg_ctrl_n.P7.GatPoly v_b.$3153.Metal2 0.00329402f
Cred_10639 di_tg_ctrl_n.P7.GatPoly v_b.$3247.Metal2 0.0225995f
Cred_10640 di_tg_ctrl_n.P7.GatPoly v_b.$3857.Metal3 0.0060635f
Cred_10641 di_tg_ctrl_n.P7.GatPoly v_b.$3890.Metal3 0.00783562f
Cred_10642 di_tg_ctrl_n.P7.GatPoly v_b.P47.nSD 6.80155e-06f
Cred_10643 di_tg_ctrl_n.P7.GatPoly v_b.P49.nSD 0.015071f
Cred_10644 di_tg_ctrl_n.P7.GatPoly v_b.P49.pSD 2.76031e-05f
Cred_10645 di_tg_ctrl_n.P7.GatPoly v_b.P51.nSD 0.0125127f
Cred_10646 di_tg_ctrl_n.P7.GatPoly VSS.$17.Metal1 2.00591e-06f
Cred_10647 di_tg_ctrl_n.P7.GatPoly VSS.$253.Metal1 1.74464e-05f
Cred_10648 di_tg_ctrl_n.P7.GatPoly VSS.$261.Metal1 1.74479e-05f
Cred_10649 di_tg_ctrl_n.P7.GatPoly VSS.$301.Metal1 0.000101422f
Cred_10650 di_tg_ctrl_n.P7.GatPoly VSS.$562.Metal2 1.3457e-07f
Cred_10651 di_tg_ctrl_n.P7.GatPoly VSS.$606.Metal2 1.07164e-05f
Cred_10652 di_tg_ctrl_n.P7.GatPoly VSS.$760.Metal3 6.34075e-07f
Cred_10653 di_tg_ctrl_n.P7.GatPoly VSS.P0.pSD 0.00268759f
Cred_10654 di_tg_ctrl_n.P8.GatPoly VSS 0.0123426f
Cred_10655 di_tg_ctrl_n.P8.GatPoly v_b.$3247.Metal2 0.024117f
Cred_10656 di_tg_ctrl_n.P8.GatPoly v_b.$3294.Metal2 0.00222641f
Cred_10657 di_tg_ctrl_n.P8.GatPoly v_b.$3890.Metal3 0.000729411f
Cred_10658 di_tg_ctrl_n.P8.GatPoly v_b.$3903.Metal3 0.0130767f
Cred_10659 di_tg_ctrl_n.P8.GatPoly v_b.P51.nSD 0.0124532f
Cred_10660 di_tg_ctrl_n.P8.GatPoly v_b.P53.nSD 0.0149361f
Cred_10661 di_tg_ctrl_n.P8.GatPoly VSS.$17.Metal1 1.70575e-06f
Cred_10662 di_tg_ctrl_n.P8.GatPoly VSS.$301.Metal1 0.000121477f
Cred_10663 di_tg_ctrl_n.P8.GatPoly VSS.$606.Metal2 1.28354e-05f
Cred_10664 di_tg_ctrl_n.P8.GatPoly VSS.$760.Metal3 7.59456e-07f
Cred_10665 di_tg_ctrl_n.P8.GatPoly VSS.P0.pSD 0.00269198f
Cred_10666 di_tg_ctrl_n.P9.GatPoly VSS 0.0139636f
Cred_10667 di_tg_ctrl_n.P9.GatPoly v_b.$3294.Metal2 0.00246357f
Cred_10668 di_tg_ctrl_n.P9.GatPoly v_b.$3344.Metal2 0.0252703f
Cred_10669 di_tg_ctrl_n.P9.GatPoly v_b.$3435.Metal2 7.37228e-07f
Cred_10670 di_tg_ctrl_n.P9.GatPoly v_b.$3903.Metal3 0.0134237f
Cred_10671 di_tg_ctrl_n.P9.GatPoly v_b.$3934.Metal3 0.00058524f
Cred_10672 di_tg_ctrl_n.P9.GatPoly v_b.P53.nSD 0.0152101f
Cred_10673 di_tg_ctrl_n.P9.GatPoly v_b.P55.nSD 0.0126195f
Cred_10674 di_tg_ctrl_n.P9.GatPoly VSS.$17.Metal1 1.56553e-06f
Cred_10675 di_tg_ctrl_n.P9.GatPoly VSS.$261.Metal1 1.99987e-05f
Cred_10676 di_tg_ctrl_n.P9.GatPoly VSS.$271.Metal1 0.000135778f
Cred_10677 di_tg_ctrl_n.P9.GatPoly VSS.$301.Metal1 0.000132326f
Cred_10678 di_tg_ctrl_n.P9.GatPoly VSS.$570.Metal2 1.54226e-07f
Cred_10679 di_tg_ctrl_n.P9.GatPoly VSS.$606.Metal2 1.39818e-05f
Cred_10680 di_tg_ctrl_n.P9.GatPoly VSS.$760.Metal3 8.27283e-07f
Cred_10681 di_tg_ctrl_n.P9.GatPoly VSS.P0.pSD 0.00268011f
Cred_10682 VSS v_a 0.102832f
Cred_10683 VSS v_a.$1152.Metal2 0.000191631f
Cred_10684 VSS v_a.$2187.Metal3 0.0087412f
Cred_10685 VSS v_a.$2215.Metal3 0.00104712f
Cred_10686 VSS v_a.$2237.Metal3 0.0145429f
Cred_10687 VSS v_a.$2275.Metal3 0.00119143f
Cred_10688 VSS v_a.$2297.Metal3 0.0115247f
Cred_10689 VSS v_a.$2327.Metal3 0.0115247f
Cred_10690 VSS v_a.$2365.Metal3 0.00119143f
Cred_10691 VSS v_a.$2387.Metal3 0.0155079f
Cred_10692 VSS v_a.$2447.Metal3 0.0155079f
Cred_10693 VSS v_a.$2485.Metal3 0.00119143f
Cred_10694 VSS v_a.$2507.Metal3 0.0149588f
Cred_10695 VSS v_a.$2545.Metal3 0.00119143f
Cred_10696 VSS v_a.$2567.Metal3 0.0115247f
Cred_10697 VSS v_a.$2597.Metal3 0.0115247f
Cred_10698 VSS v_a.$2635.Metal3 0.00119143f
Cred_10699 VSS v_a.$2657.Metal3 0.0186537f
Cred_10700 VSS v_a.$39.Metal1 9.15627e-06f
Cred_10701 VSS v_a.P0.nSD 0.00368786f
Cred_10702 VSS v_a.P0.pSD 2.2617e-07f
Cred_10703 VSS v_a.P10.nSD 0.00243726f
Cred_10704 VSS v_a.P12.nSD 0.00246823f
Cred_10705 VSS v_a.P14.nSD 0.00243726f
Cred_10706 VSS v_a.P16.nSD 0.00247318f
Cred_10707 VSS v_a.P16.pSD 8.82845e-05f
Cred_10708 VSS v_a.P18.nSD 0.00243726f
Cred_10709 VSS v_a.P2.nSD 0.00246448f
Cred_10710 VSS v_a.P20.nSD 0.00246823f
Cred_10711 VSS v_a.P22.nSD 0.00243726f
Cred_10712 VSS v_a.P24.nSD 0.00246823f
Cred_10713 VSS v_a.P26.nSD 0.00243726f
Cred_10714 VSS v_a.P28.nSD 0.00243726f
Cred_10715 VSS v_a.P30.nSD 0.00246823f
Cred_10716 VSS v_a.P32.nSD 0.00243726f
Cred_10717 VSS v_a.P34.nSD 0.00272567f
Cred_10718 VSS v_a.P34.pSD 0.000109742f
Cred_10719 VSS v_a.P4.nSD 0.00243726f
Cred_10720 VSS v_a.P6.nSD 0.00246823f
Cred_10721 VSS v_a.P8.nSD 0.00243726f
Cred_10722 VSS v_b 0.264517f
Cred_10723 VSS v_b.$2361.Metal2 0.354339f
Cred_10724 VSS v_b.$2421.Metal2 0.0606241f
Cred_10725 VSS v_b.$2481.Metal2 0.0606241f
Cred_10726 VSS v_b.$2541.Metal2 0.0606241f
Cred_10727 VSS v_b.$2601.Metal2 0.0455853f
Cred_10728 VSS v_b.$2631.Metal2 0.0455853f
Cred_10729 VSS v_b.$2691.Metal2 0.0606241f
Cred_10730 VSS v_b.$2751.Metal2 0.0606241f
Cred_10731 VSS v_b.$2811.Metal2 0.0606241f
Cred_10732 VSS v_b.$2871.Metal2 0.0472487f
Cred_10733 VSS v_b.$2962.Metal2 0.0291053f
Cred_10734 VSS v_b.$3053.Metal2 0.011897f
Cred_10735 VSS v_b.$3056.Metal2 0.0172049f
Cred_10736 VSS v_b.$3089.Metal2 0.011876f
Cred_10737 VSS v_b.$3153.Metal2 0.0253458f
Cred_10738 VSS v_b.$3247.Metal2 0.0252647f
Cred_10739 VSS v_b.$3294.Metal2 0.0118833f
Cred_10740 VSS v_b.$3344.Metal2 0.0217425f
Cred_10741 VSS v_b.$3435.Metal2 0.0124487f
Cred_10742 VSS v_b.$3438.Metal2 0.016365f
Cred_10743 VSS v_b.$3529.Metal2 0.0118763f
Cred_10744 VSS v_b.$3535.Metal2 0.0172049f
Cred_10745 VSS v_b.$3565.Metal2 0.011897f
Cred_10746 VSS v_b.$3629.Metal2 0.0287991f
Cred_10747 VSS v_b.$3779.Metal3 0.00791668f
Cred_10748 VSS v_b.$3785.Metal3 0.00741203f
Cred_10749 VSS v_b.$3821.Metal3 0.00605073f
Cred_10750 VSS v_b.$3857.Metal3 0.00396358f
Cred_10751 VSS v_b.$3890.Metal3 0.00411706f
Cred_10752 VSS v_b.$3903.Metal3 0.00607046f
Cred_10753 VSS v_b.$3934.Metal3 0.00758909f
Cred_10754 VSS v_b.$3970.Metal3 0.00627889f
Cred_10755 VSS v_b.$4009.Metal3 0.00741203f
Cred_10756 VSS v_b.$4042.Metal3 0.0668283f
Cred_10757 VSS v_b.$4053.Metal3 0.012691f
Cred_10758 VSS v_b.P0.nSD 0.0545143f
Cred_10759 VSS v_b.P0.pSD 0.124994f
Cred_10760 VSS v_b.P1.nSD 0.00286617f
Cred_10761 VSS v_b.P10.nSD 0.00286723f
Cred_10762 VSS v_b.P11.nSD 0.00303365f
Cred_10763 VSS v_b.P11.pSD 0.000302411f
Cred_10764 VSS v_b.P13.nSD 0.00286723f
Cred_10765 VSS v_b.P15.nSD 0.00303365f
Cred_10766 VSS v_b.P15.pSD 0.000302411f
Cred_10767 VSS v_b.P17.nSD 0.00286723f
Cred_10768 VSS v_b.P19.nSD 0.00286723f
Cred_10769 VSS v_b.P21.nSD 0.00303365f
Cred_10770 VSS v_b.P21.pSD 0.000302411f
Cred_10771 VSS v_b.P23.nSD 0.00286723f
Cred_10772 VSS v_b.P25.nSD 0.00303365f
Cred_10773 VSS v_b.P25.pSD 0.000302411f
Cred_10774 VSS v_b.P27.nSD 0.00286723f
Cred_10775 VSS v_b.P29.nSD 0.00303365f
Cred_10776 VSS v_b.P29.pSD 0.000302411f
Cred_10777 VSS v_b.P3.nSD 0.00303365f
Cred_10778 VSS v_b.P3.pSD 0.000302411f
Cred_10779 VSS v_b.P31.nSD 0.00286723f
Cred_10780 VSS v_b.P33.nSD 0.00303365f
Cred_10781 VSS v_b.P33.pSD 0.000302411f
Cred_10782 VSS v_b.P35.nSD 0.0047343f
Cred_10783 VSS v_b.P37.nSD 0.0026842f
Cred_10784 VSS v_b.P37.pSD 1.76422e-05f
Cred_10785 VSS v_b.P39.nSD 0.00221068f
Cred_10786 VSS v_b.P41.nSD 0.00236946f
Cred_10787 VSS v_b.P43.nSD 0.00221096f
Cred_10788 VSS v_b.P45.nSD 0.00237084f
Cred_10789 VSS v_b.P47.nSD 0.00221135f
Cred_10790 VSS v_b.P49.nSD 0.00237468f
Cred_10791 VSS v_b.P49.pSD 1.28513e-05f
Cred_10792 VSS v_b.P5.nSD 0.00286723f
Cred_10793 VSS v_b.P51.nSD 0.00221209f
Cred_10794 VSS v_b.P53.nSD 0.00237084f
Cred_10795 VSS v_b.P55.nSD 0.00221209f
Cred_10796 VSS v_b.P57.nSD 0.00236945f
Cred_10797 VSS v_b.P59.nSD 0.00221135f
Cred_10798 VSS v_b.P61.nSD 0.00237084f
Cred_10799 VSS v_b.P63.nSD 0.00221096f
Cred_10800 VSS v_b.P65.nSD 0.00236946f
Cred_10801 VSS v_b.P67.nSD 0.00221068f
Cred_10802 VSS v_b.P69.nSD 0.00361963f
Cred_10803 VSS v_b.P7.nSD 0.00303365f
Cred_10804 VSS v_b.P7.pSD 0.000302411f
Cred_10805 VSS v_b.P71.nSD 0.0513977f
Cred_10806 VSS v_b.P71.pSD 0.120245f
Cred_10807 VSS VDD 0.0193641f
Cred_10808 VSS VDD.$107.Metal1 0.0303813f
Cred_10809 VSS VDD.$111.Metal1 0.0436969f
Cred_10810 VSS VDD.$121.Metal1 0.0524891f
Cred_10811 VSS VDD.$129.Metal1 0.040468f
Cred_10812 VSS VDD.$134.Metal1 0.0458372f
Cred_10813 VSS VDD.$143.Metal1 0.040468f
Cred_10814 VSS VDD.$151.Metal1 0.0524891f
Cred_10815 VSS VDD.$161.Metal1 0.0436969f
Cred_10816 VSS VDD.$165.Metal1 0.0202823f
Cred_10817 VSS VDD.$169.Metal1 0.0202875f
Cred_10818 VSS VDD.$173.Metal1 0.0311572f
Cred_10819 VSS VDD.$179.Metal1 0.0349601f
Cred_10820 VSS VDD.$183.Metal1 0.0200733f
Cred_10821 VSS VDD.$189.Metal1 0.0199344f
Cred_10822 VSS VDD.$193.Metal1 0.0202778f
Cred_10823 VSS VDD.$197.Metal1 0.0349601f
Cred_10824 VSS VDD.$203.Metal1 0.0311572f
Cred_10825 VSS VDD.$207.Metal1 0.0202875f
Cred_10826 VSS VDD.$211.Metal1 0.0202823f
Cred_10827 VSS VDD.$215.Metal1 0.0436969f
Cred_10828 VSS VDD.$225.Metal1 0.0459947f
Cred_10829 VSS VDD.$230.Metal1 0.0444711f
Cred_10830 VSS VDD.$238.Metal1 0.0484455f
Cred_10831 VSS VDD.$247.Metal1 0.0304022f
Cred_10832 VSS VDD.$251.Metal1 0.0406644f
Cred_10833 VSS VDD.$263.Metal1 0.055559f
Cred_10834 VSS VDD.$269.Metal1 0.0303996f
Cred_10835 VSS VDD.$273.Metal1 0.0409146f
Cred_10836 VSS VDD.$283.Metal1 0.0451918f
Cred_10837 VSS VDD.$287.Metal1 0.0203163f
Cred_10838 VSS VDD.$291.Metal1 0.0202835f
Cred_10839 VSS VDD.$295.Metal1 0.0202861f
Cred_10840 VSS VDD.$299.Metal1 0.042932f
Cred_10841 VSS VDD.$309.Metal1 0.0431865f
Cred_10842 VSS VDD.$313.Metal1 0.0202847f
Cred_10843 VSS VDD.$317.Metal1 0.0202847f
Cred_10844 VSS VDD.$321.Metal1 0.045651f
Cred_10845 VSS VDD.$332.Metal1 0.0626829f
Cred_10846 VSS VDD.$340.Metal1 0.204772f
Cred_10847 VSS VDD.$388.Metal2 0.10425f
Cred_10848 VSS VDD.$392.Metal2 0.0215952f
Cred_10849 VSS VDD.$400.Metal2 0.0215584f
Cred_10850 VSS VDD.$404.Metal2 0.0215279f
Cred_10851 VSS VDD.$412.Metal2 0.0286062f
Cred_10852 VSS VDD.$42.Metal1 0.253891f
Cred_10853 VSS VDD.$420.Metal2 0.0285758f
Cred_10854 VSS VDD.$428.Metal2 0.0215815f
Cred_10855 VSS VDD.$432.Metal2 0.0144244f
Cred_10856 VSS VDD.$436.Metal2 0.0144444f
Cred_10857 VSS VDD.$440.Metal2 0.0215518f
Cred_10858 VSS VDD.$448.Metal2 0.0215818f
Cred_10859 VSS VDD.$452.Metal2 0.0144221f
Cred_10860 VSS VDD.$456.Metal2 0.0144476f
Cred_10861 VSS VDD.$460.Metal2 0.0144505f
Cred_10862 VSS VDD.$464.Metal2 0.0214696f
Cred_10863 VSS VDD.$472.Metal2 0.0214696f
Cred_10864 VSS VDD.$476.Metal2 0.0144505f
Cred_10865 VSS VDD.$480.Metal2 0.0144476f
Cred_10866 VSS VDD.$484.Metal2 0.0144221f
Cred_10867 VSS VDD.$488.Metal2 0.0215818f
Cred_10868 VSS VDD.$496.Metal2 0.028575f
Cred_10869 VSS VDD.$504.Metal2 0.0286043f
Cred_10870 VSS VDD.$512.Metal2 0.0285572f
Cred_10871 VSS VDD.$520.Metal2 0.0285576f
Cred_10872 VSS VDD.$528.Metal2 0.0286043f
Cred_10873 VSS VDD.$536.Metal2 0.028575f
Cred_10874 VSS VDD.$544.Metal2 0.0216832f
Cred_10875 VSS VDD.$548.Metal2 0.0146258f
Cred_10876 VSS VDD.$55.Metal1 0.045651f
Cred_10877 VSS VDD.$552.Metal2 0.0215663f
Cred_10878 VSS VDD.$560.Metal2 0.0288026f
Cred_10879 VSS VDD.$568.Metal2 0.0288022f
Cred_10880 VSS VDD.$576.Metal2 0.0215561f
Cred_10881 VSS VDD.$580.Metal2 0.0144372f
Cred_10882 VSS VDD.$584.Metal2 0.0143909f
Cred_10883 VSS VDD.$588.Metal2 0.0215672f
Cred_10884 VSS VDD.$59.Metal1 0.0303832f
Cred_10885 VSS VDD.$596.Metal2 0.0216615f
Cred_10886 VSS VDD.$600.Metal2 0.0146407f
Cred_10887 VSS VDD.$604.Metal2 0.0215438f
Cred_10888 VSS VDD.$612.Metal2 0.0285758f
Cred_10889 VSS VDD.$620.Metal2 0.0216308f
Cred_10890 VSS VDD.$624.Metal2 0.0216318f
Cred_10891 VSS VDD.$632.Metal2 0.0285761f
Cred_10892 VSS VDD.$640.Metal2 0.0215952f
Cred_10893 VSS VDD.$644.Metal2 0.100178f
Cred_10894 VSS VDD.$666.Metal3 0.100684f
Cred_10895 VSS VDD.$67.Metal1 0.0303795f
Cred_10896 VSS VDD.$670.Metal3 0.0321303f
Cred_10897 VSS VDD.$676.Metal3 0.0321302f
Cred_10898 VSS VDD.$680.Metal3 0.0257667f
Cred_10899 VSS VDD.$684.Metal3 0.0257667f
Cred_10900 VSS VDD.$688.Metal3 0.0320733f
Cred_10901 VSS VDD.$694.Metal3 0.0321302f
Cred_10902 VSS VDD.$698.Metal3 0.0320733f
Cred_10903 VSS VDD.$704.Metal3 0.0321017f
Cred_10904 VSS VDD.$708.Metal3 0.0321017f
Cred_10905 VSS VDD.$71.Metal1 0.0345773f
Cred_10906 VSS VDD.$714.Metal3 0.0320733f
Cred_10907 VSS VDD.$718.Metal3 0.0257667f
Cred_10908 VSS VDD.$722.Metal3 0.0257667f
Cred_10909 VSS VDD.$726.Metal3 0.0257666f
Cred_10910 VSS VDD.$730.Metal3 0.0257667f
Cred_10911 VSS VDD.$734.Metal3 0.0257666f
Cred_10912 VSS VDD.$738.Metal3 0.0257667f
Cred_10913 VSS VDD.$742.Metal3 0.0384183f
Cred_10914 VSS VDD.$750.Metal3 0.0510981f
Cred_10915 VSS VDD.$758.Metal3 0.0384467f
Cred_10916 VSS VDD.$762.Metal3 0.0320733f
Cred_10917 VSS VDD.$768.Metal3 0.0447819f
Cred_10918 VSS VDD.$77.Metal1 0.0315352f
Cred_10919 VSS VDD.$776.Metal3 0.0384183f
Cred_10920 VSS VDD.$780.Metal3 0.0321303f
Cred_10921 VSS VDD.$786.Metal3 0.0321303f
Cred_10922 VSS VDD.$790.Metal3 0.0257667f
Cred_10923 VSS VDD.$794.Metal3 0.100505f
Cred_10924 VSS VDD.$81.Metal1 0.0202861f
Cred_10925 VSS VDD.$85.Metal1 0.0202835f
Cred_10926 VSS VDD.$89.Metal1 0.0434414f
Cred_10927 VSS VDD.$99.Metal1 0.0527413f
Cred_10928 VSS VDD.P0.nSD 0.789674f
Cred_10929 VSS VSS 0.0637659f
Cred_10930 VSS VSS.$101.Metal1 0.0842675f
Cred_10931 VSS VSS.$113.Metal1 0.0842259f
Cred_10932 VSS VSS.$123.Metal1 0.0842259f
Cred_10933 VSS VSS.$135.Metal1 0.0842675f
Cred_10934 VSS VSS.$145.Metal1 0.0675771f
Cred_10935 VSS VSS.$153.Metal1 0.0674172f
Cred_10936 VSS VSS.$163.Metal1 0.0629038f
Cred_10937 VSS VSS.$17.Metal1 0.371624f
Cred_10938 VSS VSS.$177.Metal1 0.0926862f
Cred_10939 VSS VSS.$191.Metal1 0.10076f
Cred_10940 VSS VSS.$205.Metal1 0.0843434f
Cred_10941 VSS VSS.$213.Metal1 0.0688353f
Cred_10942 VSS VSS.$221.Metal1 0.0702189f
Cred_10943 VSS VSS.$231.Metal1 0.0672681f
Cred_10944 VSS VSS.$239.Metal1 0.0843432f
Cred_10945 VSS VSS.$253.Metal1 0.0840744f
Cred_10946 VSS VSS.$261.Metal1 0.0676487f
Cred_10947 VSS VSS.$271.Metal1 0.067538f
Cred_10948 VSS VSS.$279.Metal1 0.0842085f
Cred_10949 VSS VSS.$293.Metal1 0.084235f
Cred_10950 VSS VSS.$301.Metal1 0.412102f
Cred_10951 VSS VSS.$366.Metal2 0.156483f
Cred_10952 VSS VSS.$370.Metal2 0.0242168f
Cred_10953 VSS VSS.$378.Metal2 0.0319411f
Cred_10954 VSS VSS.$386.Metal2 0.0321612f
Cred_10955 VSS VSS.$39.Metal1 0.142347f
Cred_10956 VSS VSS.$394.Metal2 0.0321627f
Cred_10957 VSS VSS.$402.Metal2 0.0242169f
Cred_10958 VSS VSS.$406.Metal2 0.0242169f
Cred_10959 VSS VSS.$414.Metal2 0.0319421f
Cred_10960 VSS VSS.$422.Metal2 0.0242169f
Cred_10961 VSS VSS.$426.Metal2 0.0242169f
Cred_10962 VSS VSS.$434.Metal2 0.031942f
Cred_10963 VSS VSS.$442.Metal2 0.0242165f
Cred_10964 VSS VSS.$446.Metal2 0.0242167f
Cred_10965 VSS VSS.$454.Metal2 0.0319421f
Cred_10966 VSS VSS.$462.Metal2 0.0321608f
Cred_10967 VSS VSS.$470.Metal2 0.0321611f
Cred_10968 VSS VSS.$478.Metal2 0.0241057f
Cred_10969 VSS VSS.$482.Metal2 0.0162902f
Cred_10970 VSS VSS.$486.Metal2 0.0242071f
Cred_10971 VSS VSS.$494.Metal2 0.0242176f
Cred_10972 VSS VSS.$498.Metal2 0.0242172f
Cred_10973 VSS VSS.$506.Metal2 0.024218f
Cred_10974 VSS VSS.$51.Metal1 0.0843936f
Cred_10975 VSS VSS.$510.Metal2 0.0242193f
Cred_10976 VSS VSS.$518.Metal2 0.0319402f
Cred_10977 VSS VSS.$526.Metal2 0.0339105f
Cred_10978 VSS VSS.$534.Metal2 0.0323377f
Cred_10979 VSS VSS.$542.Metal2 0.0318901f
Cred_10980 VSS VSS.$550.Metal2 0.0241892f
Cred_10981 VSS VSS.$554.Metal2 0.024218f
Cred_10982 VSS VSS.$562.Metal2 0.0319097f
Cred_10983 VSS VSS.$570.Metal2 0.0321527f
Cred_10984 VSS VSS.$578.Metal2 0.0321612f
Cred_10985 VSS VSS.$586.Metal2 0.0242189f
Cred_10986 VSS VSS.$590.Metal2 0.0242191f
Cred_10987 VSS VSS.$598.Metal2 0.0321612f
Cred_10988 VSS VSS.$606.Metal2 0.176458f
Cred_10989 VSS VSS.$61.Metal1 0.0674568f
Cred_10990 VSS VSS.$636.Metal3 0.164671f
Cred_10991 VSS VSS.$642.Metal3 0.0349856f
Cred_10992 VSS VSS.$646.Metal3 0.0418638f
Cred_10993 VSS VSS.$654.Metal3 0.0487926f
Cred_10994 VSS VSS.$660.Metal3 0.0349856f
Cred_10995 VSS VSS.$664.Metal3 0.0349856f
Cred_10996 VSS VSS.$670.Metal3 0.0349369f
Cred_10997 VSS VSS.$674.Metal3 0.0348907f
Cred_10998 VSS VSS.$680.Metal3 0.0349626f
Cred_10999 VSS VSS.$684.Metal3 0.0418433f
Cred_11000 VSS VSS.$69.Metal1 0.067538f
Cred_11001 VSS VSS.$692.Metal3 0.055577f
Cred_11002 VSS VSS.$700.Metal3 0.048761f
Cred_11003 VSS VSS.$706.Metal3 0.0419144f
Cred_11004 VSS VSS.$712.Metal3 0.0349856f
Cred_11005 VSS VSS.$716.Metal3 0.0427903f
Cred_11006 VSS VSS.$724.Metal3 0.0422467f
Cred_11007 VSS VSS.$728.Metal3 0.0349435f
Cred_11008 VSS VSS.$734.Metal3 0.0349786f
Cred_11009 VSS VSS.$738.Metal3 0.0418427f
Cred_11010 VSS VSS.$746.Metal3 0.0487926f
Cred_11011 VSS VSS.$752.Metal3 0.0487926f
Cred_11012 VSS VSS.$760.Metal3 0.143271f
Cred_11013 VSS VSS.$79.Metal1 0.0843093f
Cred_11014 VSS VSS.$91.Metal1 0.0841853f
Cred_11015 VSS VSS.P0.pSD 1.10706f
Cred_11016 v_a v_b.$2361.Metal2 0.942148f
Cred_11017 v_a v_b.$2421.Metal2 0.0877909f
Cred_11018 v_a v_b.P0.nSD 0.124691f
Cred_11019 v_a v_b.P0.pSD 0.00749099f
Cred_11020 v_a v_b.P1.nSD 0.142456f
Cred_11021 v_a v_b.P1.pSD 0.00322417f
Cred_11022 v_a v_b.P3.nSD 0.0493569f
Cred_11023 v_a v_b.P3.pSD 0.00176536f
Cred_11024 v_a VDD.$340.Metal1 1.91503e-07f
Cred_11025 v_a VDD.$388.Metal2 6.26756e-06f
Cred_11026 v_a VDD.$42.Metal1 0.00029429f
Cred_11027 v_a VDD.$666.Metal3 2.75932e-07f
Cred_11028 v_a VDD.P0.nSD 0.00531693f
Cred_11029 v_a VSS.$17.Metal1 0.00588172f
Cred_11030 v_a VSS.$301.Metal1 2.92749e-06f
Cred_11031 v_a VSS.$366.Metal2 0.00127167f
Cred_11032 v_a VSS.$39.Metal1 0.000541866f
Cred_11033 v_a VSS.$606.Metal2 3.09324e-07f
Cred_11034 v_a VSS.$636.Metal3 0.00505998f
Cred_11035 v_a VSS.$760.Metal3 1.83023e-08f
Cred_11036 v_a VSS.P0.pSD 0.017515f
Cred_11037 v_a.$102.Metal1 v_b.$2361.Metal2 0.0610298f
Cred_11038 v_a.$102.Metal1 v_b.$2421.Metal2 0.0199993f
Cred_11039 v_a.$102.Metal1 v_b.P1.pSD 0.0619782f
Cred_11040 v_a.$102.Metal1 v_b.P3.nSD 0.000221302f
Cred_11041 v_a.$102.Metal1 v_b.P3.pSD 0.0617751f
Cred_11042 v_a.$102.Metal1 VDD.$340.Metal1 4.94577e-07f
Cred_11043 v_a.$102.Metal1 VDD.$388.Metal2 4.48379e-06f
Cred_11044 v_a.$102.Metal1 VDD.$42.Metal1 0.000210534f
Cred_11045 v_a.$102.Metal1 VDD.$666.Metal3 1.974e-07f
Cred_11046 v_a.$102.Metal1 VDD.P0.nSD 0.00750671f
Cred_11047 v_a.$104.Metal1 v_b.$2361.Metal2 0.0261969f
Cred_11048 v_a.$104.Metal1 v_b.$2421.Metal2 0.00857892f
Cred_11049 v_a.$104.Metal1 v_b.P1.pSD 0.0290329f
Cred_11050 v_a.$104.Metal1 v_b.P3.nSD 9.49303e-05f
Cred_11051 v_a.$104.Metal1 v_b.P3.pSD 0.0288814f
Cred_11052 v_a.$1047.Metal1 v_b.$2811.Metal2 0.0670702f
Cred_11053 v_a.$1047.Metal1 v_b.$2871.Metal2 0.0212176f
Cred_11054 v_a.$1047.Metal1 v_b.$3779.Metal3 1.1872e-05f
Cred_11055 v_a.$1047.Metal1 v_b.P31.pSD 0.0661828f
Cred_11056 v_a.$1047.Metal1 v_b.P33.nSD 0.000234785f
Cred_11057 v_a.$1047.Metal1 v_b.P33.pSD 0.0622921f
Cred_11058 v_a.$1047.Metal1 v_b.P37.nSD 1.41939e-08f
Cred_11059 v_a.$1047.Metal1 v_b.P37.pSD 2.22661e-06f
Cred_11060 v_a.$1047.Metal1 VDD.$340.Metal1 2.25678e-05f
Cred_11061 v_a.$1047.Metal1 VDD.$388.Metal2 9.90309e-08f
Cred_11062 v_a.$1047.Metal1 VDD.$42.Metal1 4.64994e-06f
Cred_11063 v_a.$1047.Metal1 VDD.$666.Metal3 4.35988e-09f
Cred_11064 v_a.$1047.Metal1 VDD.P0.nSD 0.00770804f
Cred_11065 v_a.$1049.Metal1 v_b.$2811.Metal2 0.0440165f
Cred_11066 v_a.$1049.Metal1 v_b.$2871.Metal2 0.0138381f
Cred_11067 v_a.$1049.Metal1 v_b.P31.pSD 0.0512661f
Cred_11068 v_a.$1049.Metal1 v_b.P33.nSD 0.000153126f
Cred_11069 v_a.$1049.Metal1 v_b.P33.pSD 0.0480268f
Cred_11070 v_a.$105.Metal1 v_b.$2361.Metal2 0.032679f
Cred_11071 v_a.$105.Metal1 v_b.$2421.Metal2 0.0107496f
Cred_11072 v_a.$105.Metal1 v_b.P1.pSD 0.0393938f
Cred_11073 v_a.$105.Metal1 v_b.P3.nSD 0.00011895f
Cred_11074 v_a.$105.Metal1 v_b.P3.pSD 0.0394452f
Cred_11075 v_a.$1052.Metal1 v_b.$2811.Metal2 0.0408609f
Cred_11076 v_a.$1052.Metal1 v_b.$2871.Metal2 0.0128461f
Cred_11077 v_a.$1052.Metal1 v_b.P31.pSD 0.0534797f
Cred_11078 v_a.$1052.Metal1 v_b.P33.nSD 0.000142148f
Cred_11079 v_a.$1052.Metal1 v_b.P33.pSD 0.0500685f
Cred_11080 v_a.$1054.Metal1 v_b.$2811.Metal2 0.0302847f
Cred_11081 v_a.$1054.Metal1 v_b.$2871.Metal2 0.00950663f
Cred_11082 v_a.$1054.Metal1 v_b.P31.pSD 0.044717f
Cred_11083 v_a.$1054.Metal1 v_b.P33.nSD 0.000105196f
Cred_11084 v_a.$1054.Metal1 v_b.P33.pSD 0.0417395f
Cred_11085 v_a.$1056.Metal1 v_b.$2811.Metal2 0.028147f
Cred_11086 v_a.$1056.Metal1 v_b.$2871.Metal2 0.00875085f
Cred_11087 v_a.$1056.Metal1 v_b.P31.pSD 0.0461346f
Cred_11088 v_a.$1056.Metal1 v_b.P33.nSD 9.68328e-05f
Cred_11089 v_a.$1056.Metal1 v_b.P33.pSD 0.0424617f
Cred_11090 v_a.$1058.Metal1 v_b.$2811.Metal2 0.026446f
Cred_11091 v_a.$1058.Metal1 v_b.$2871.Metal2 0.00831422f
Cred_11092 v_a.$1058.Metal1 v_b.P31.pSD 0.0476919f
Cred_11093 v_a.$1058.Metal1 v_b.P33.nSD 9.20012e-05f
Cred_11094 v_a.$1058.Metal1 v_b.P33.pSD 0.0445866f
Cred_11095 v_a.$1060.Metal1 v_b.$2811.Metal2 0.0247489f
Cred_11096 v_a.$1060.Metal1 v_b.$2871.Metal2 0.0077807f
Cred_11097 v_a.$1060.Metal1 v_b.P31.pSD 0.0487637f
Cred_11098 v_a.$1060.Metal1 v_b.P33.nSD 8.60976e-05f
Cred_11099 v_a.$1060.Metal1 v_b.P33.pSD 0.0455742f
Cred_11100 v_a.$1062.Metal1 v_b.$2811.Metal2 0.0828064f
Cred_11101 v_a.$1062.Metal1 v_b.$2871.Metal2 0.0267468f
Cred_11102 v_a.$1062.Metal1 v_b.$3779.Metal3 0.000185687f
Cred_11103 v_a.$1062.Metal1 v_b.P31.pSD 0.177653f
Cred_11104 v_a.$1062.Metal1 v_b.P33.nSD 0.000295968f
Cred_11105 v_a.$1062.Metal1 v_b.P33.pSD 0.172561f
Cred_11106 v_a.$1062.Metal1 v_b.P37.nSD 2.22003e-07f
Cred_11107 v_a.$1062.Metal1 v_b.P37.pSD 0.000136131f
Cred_11108 v_a.$108.Metal1 v_b.$2361.Metal2 0.037733f
Cred_11109 v_a.$108.Metal1 v_b.$2421.Metal2 0.0124216f
Cred_11110 v_a.$108.Metal1 v_b.P1.pSD 0.0508968f
Cred_11111 v_a.$108.Metal1 v_b.P3.nSD 0.000137452f
Cred_11112 v_a.$108.Metal1 v_b.P3.pSD 0.0509907f
Cred_11113 v_a.$110.Metal1 v_b.$2361.Metal2 0.0215357f
Cred_11114 v_a.$110.Metal1 v_b.$2421.Metal2 0.00702729f
Cred_11115 v_a.$110.Metal1 v_b.P1.pSD 0.0323225f
Cred_11116 v_a.$110.Metal1 v_b.P3.nSD 7.77607e-05f
Cred_11117 v_a.$110.Metal1 v_b.P3.pSD 0.0319226f
Cred_11118 v_a.$111.Metal1 v_b.$2361.Metal2 0.0260811f
Cred_11119 v_a.$111.Metal1 v_b.$2421.Metal2 0.00851189f
Cred_11120 v_a.$111.Metal1 v_b.P1.pSD 0.0431826f
Cred_11121 v_a.$111.Metal1 v_b.P3.nSD 9.41886e-05f
Cred_11122 v_a.$111.Metal1 v_b.P3.pSD 0.0426698f
Cred_11123 v_a.$114.Metal1 v_b.$2361.Metal2 0.0303086f
Cred_11124 v_a.$114.Metal1 v_b.$2421.Metal2 0.0100139f
Cred_11125 v_a.$114.Metal1 v_b.P1.pSD 0.0550571f
Cred_11126 v_a.$114.Metal1 v_b.P3.nSD 0.000110809f
Cred_11127 v_a.$114.Metal1 v_b.P3.pSD 0.055396f
Cred_11128 v_a.$1152.Metal2 v_b.$2361.Metal2 0.184805f
Cred_11129 v_a.$1152.Metal2 v_b.P0.nSD 0.000756113f
Cred_11130 v_a.$1152.Metal2 v_b.P0.pSD 0.044718f
Cred_11131 v_a.$1152.Metal2 v_b.P1.pSD 0.0270583f
Cred_11132 v_a.$1152.Metal2 VDD.$340.Metal1 2.07467e-08f
Cred_11133 v_a.$1152.Metal2 VDD.$388.Metal2 3.93671e-07f
Cred_11134 v_a.$1152.Metal2 VDD.$42.Metal1 1.84846e-05f
Cred_11135 v_a.$1152.Metal2 VDD.$666.Metal3 1.73315e-08f
Cred_11136 v_a.$1152.Metal2 VDD.P0.nSD 0.00043739f
Cred_11137 v_a.$1154.Metal2 v_b.$2361.Metal2 0.0531667f
Cred_11138 v_a.$1154.Metal2 v_b.P0.nSD 0.000217005f
Cred_11139 v_a.$1154.Metal2 v_b.P0.pSD 0.0189446f
Cred_11140 v_a.$1154.Metal2 v_b.P1.pSD 0.0138021f
Cred_11141 v_a.$1156.Metal2 v_b.$2361.Metal2 0.0491064f
Cred_11142 v_a.$1156.Metal2 v_b.P0.nSD 0.000202716f
Cred_11143 v_a.$1156.Metal2 v_b.P0.pSD 0.020952f
Cred_11144 v_a.$1156.Metal2 v_b.P1.pSD 0.0157887f
Cred_11145 v_a.$1158.Metal2 v_b.$2361.Metal2 0.0462944f
Cred_11146 v_a.$1158.Metal2 v_b.P0.nSD 0.000188948f
Cred_11147 v_a.$1158.Metal2 v_b.P0.pSD 0.0225204f
Cred_11148 v_a.$1158.Metal2 v_b.P1.pSD 0.0179837f
Cred_11149 v_a.$116.Metal1 v_b.$2361.Metal2 0.0229086f
Cred_11150 v_a.$116.Metal1 v_b.$2421.Metal2 0.00754632f
Cred_11151 v_a.$116.Metal1 v_b.P1.pSD 0.0458773f
Cred_11152 v_a.$116.Metal1 v_b.P3.nSD 8.3504e-05f
Cred_11153 v_a.$116.Metal1 v_b.P3.pSD 0.0459364f
Cred_11154 v_a.$1160.Metal2 v_b.$2361.Metal2 0.0428737f
Cred_11155 v_a.$1160.Metal2 v_b.P0.nSD 0.00017503f
Cred_11156 v_a.$1160.Metal2 v_b.P0.pSD 0.0235319f
Cred_11157 v_a.$1160.Metal2 v_b.P1.pSD 0.0192904f
Cred_11158 v_a.$1162.Metal2 v_b.$2361.Metal2 0.039819f
Cred_11159 v_a.$1162.Metal2 v_b.P0.nSD 0.000164434f
Cred_11160 v_a.$1162.Metal2 v_b.P0.pSD 0.0248961f
Cred_11161 v_a.$1162.Metal2 v_b.P1.pSD 0.0204499f
Cred_11162 v_a.$1164.Metal2 v_b.$2361.Metal2 0.0378112f
Cred_11163 v_a.$1164.Metal2 v_b.P0.nSD 0.000154368f
Cred_11164 v_a.$1164.Metal2 v_b.P0.pSD 0.0259857f
Cred_11165 v_a.$1164.Metal2 v_b.P1.pSD 0.0221871f
Cred_11166 v_a.$1166.Metal2 v_b.$2361.Metal2 0.0356366f
Cred_11167 v_a.$1166.Metal2 v_b.P0.nSD 0.000145479f
Cred_11168 v_a.$1166.Metal2 v_b.P0.pSD 0.0269421f
Cred_11169 v_a.$1166.Metal2 v_b.P1.pSD 0.0233418f
Cred_11170 v_a.$1166.Metal2 VDD.$340.Metal1 6.43374e-11f
Cred_11171 v_a.$1166.Metal2 VDD.$388.Metal2 3.1287e-08f
Cred_11172 v_a.$1166.Metal2 VDD.$42.Metal1 1.46906e-06f
Cred_11173 v_a.$1166.Metal2 VDD.$666.Metal3 1.37742e-09f
Cred_11174 v_a.$1166.Metal2 VDD.P0.nSD 5.93025e-06f
Cred_11175 v_a.$1168.Metal2 v_b.$2361.Metal2 0.0356597f
Cred_11176 v_a.$1168.Metal2 v_b.P0.nSD 0.00014548f
Cred_11177 v_a.$1168.Metal2 v_b.P0.pSD 0.0309714f
Cred_11178 v_a.$1168.Metal2 v_b.P1.pSD 0.0274058f
Cred_11179 v_a.$1168.Metal2 VDD.$340.Metal1 1.29192e-10f
Cred_11180 v_a.$1168.Metal2 VDD.$388.Metal2 4.27773e-07f
Cred_11181 v_a.$1168.Metal2 VDD.$392.Metal2 9.45484e-11f
Cred_11182 v_a.$1168.Metal2 VDD.$42.Metal1 3.11111e-06f
Cred_11183 v_a.$1168.Metal2 VDD.$55.Metal1 1.62202e-08f
Cred_11184 v_a.$1168.Metal2 VDD.$666.Metal3 3.48739e-06f
Cred_11185 v_a.$1168.Metal2 VDD.P0.nSD 1.19085e-05f
Cred_11186 v_a.$1170.Metal2 v_b.$2361.Metal2 0.213703f
Cred_11187 v_a.$1170.Metal2 v_b.P0.nSD 0.00087182f
Cred_11188 v_a.$1170.Metal2 v_b.P0.pSD 0.263389f
Cred_11189 v_a.$1170.Metal2 v_b.P1.pSD 0.242071f
Cred_11190 v_a.$1170.Metal2 VDD.$340.Metal1 1.04088e-10f
Cred_11191 v_a.$1170.Metal2 VDD.$388.Metal2 9.80148e-05f
Cred_11192 v_a.$1170.Metal2 VDD.$392.Metal2 2.65972e-08f
Cred_11193 v_a.$1170.Metal2 VDD.$42.Metal1 4.773e-05f
Cred_11194 v_a.$1170.Metal2 VDD.$55.Metal1 4.56286e-06f
Cred_11195 v_a.$1170.Metal2 VDD.$666.Metal3 0.000767683f
Cred_11196 v_a.$1170.Metal2 VDD.P0.nSD 9.95557e-06f
Cred_11197 v_a.$118.Metal1 v_b.$2361.Metal2 0.068547f
Cred_11198 v_a.$118.Metal1 v_b.$2421.Metal2 0.0228447f
Cred_11199 v_a.$118.Metal1 v_b.P1.pSD 0.151456f
Cred_11200 v_a.$118.Metal1 v_b.P3.nSD 0.000252789f
Cred_11201 v_a.$118.Metal1 v_b.P3.pSD 0.154302f
Cred_11202 v_a.$1208.Metal2 v_b.$2361.Metal2 0.111839f
Cred_11203 v_a.$1208.Metal2 v_b.$2421.Metal2 0.0364905f
Cred_11204 v_a.$1208.Metal2 v_b.P1.pSD 0.0167297f
Cred_11205 v_a.$1208.Metal2 v_b.P3.nSD 0.000403787f
Cred_11206 v_a.$1208.Metal2 v_b.P3.pSD 0.0172611f
Cred_11207 v_a.$1208.Metal2 VDD.$340.Metal1 2.51794e-08f
Cred_11208 v_a.$1208.Metal2 VDD.$388.Metal2 2.28274e-07f
Cred_11209 v_a.$1208.Metal2 VDD.$42.Metal1 1.07185e-05f
Cred_11210 v_a.$1208.Metal2 VDD.$666.Metal3 1.00498e-08f
Cred_11211 v_a.$1208.Metal2 VDD.P0.nSD 0.000382173f
Cred_11212 v_a.$1210.Metal2 v_b.$2361.Metal2 0.046844f
Cred_11213 v_a.$1210.Metal2 v_b.$2421.Metal2 0.0154545f
Cred_11214 v_a.$1210.Metal2 v_b.P1.pSD 0.011529f
Cred_11215 v_a.$1210.Metal2 v_b.P3.nSD 0.000171012f
Cred_11216 v_a.$1210.Metal2 v_b.P3.pSD 0.0118416f
Cred_11217 v_a.$1212.Metal2 v_b.$2361.Metal2 0.0633108f
Cred_11218 v_a.$1212.Metal2 v_b.$2421.Metal2 0.020797f
Cred_11219 v_a.$1212.Metal2 v_b.P1.pSD 0.0216815f
Cred_11220 v_a.$1212.Metal2 v_b.P3.nSD 0.000230129f
Cred_11221 v_a.$1212.Metal2 v_b.P3.pSD 0.0219422f
Cred_11222 v_a.$1216.Metal2 v_b.$2361.Metal2 0.0576957f
Cred_11223 v_a.$1216.Metal2 v_b.$2421.Metal2 0.0189456f
Cred_11224 v_a.$1216.Metal2 v_b.P1.pSD 0.0258835f
Cred_11225 v_a.$1216.Metal2 v_b.P3.nSD 0.000209643f
Cred_11226 v_a.$1216.Metal2 v_b.P3.pSD 0.0261097f
Cred_11227 v_a.$1218.Metal2 v_b.$2361.Metal2 0.0352395f
Cred_11228 v_a.$1218.Metal2 v_b.$2421.Metal2 0.0116289f
Cred_11229 v_a.$1218.Metal2 v_b.P1.pSD 0.019603f
Cred_11230 v_a.$1218.Metal2 v_b.P3.nSD 0.00012868f
Cred_11231 v_a.$1218.Metal2 v_b.P3.pSD 0.0198447f
Cred_11232 v_a.$1220.Metal2 v_b.$2361.Metal2 0.0332922f
Cred_11233 v_a.$1220.Metal2 v_b.$2421.Metal2 0.0108349f
Cred_11234 v_a.$1220.Metal2 v_b.P1.pSD 0.0212872f
Cred_11235 v_a.$1220.Metal2 v_b.P3.nSD 0.000119894f
Cred_11236 v_a.$1220.Metal2 v_b.P3.pSD 0.0210822f
Cred_11237 v_a.$1222.Metal2 v_b.$2361.Metal2 0.0308124f
Cred_11238 v_a.$1222.Metal2 v_b.$2421.Metal2 0.0101653f
Cred_11239 v_a.$1222.Metal2 v_b.P1.pSD 0.0221685f
Cred_11240 v_a.$1222.Metal2 v_b.P3.nSD 0.000112485f
Cred_11241 v_a.$1222.Metal2 v_b.P3.pSD 0.0223737f
Cred_11242 v_a.$1224.Metal2 v_b.$2361.Metal2 0.0288072f
Cred_11243 v_a.$1224.Metal2 v_b.$2421.Metal2 0.00977222f
Cred_11244 v_a.$1224.Metal2 v_b.P1.pSD 0.0227986f
Cred_11245 v_a.$1224.Metal2 v_b.P3.nSD 0.000108135f
Cred_11246 v_a.$1224.Metal2 v_b.P3.pSD 0.0239701f
Cred_11247 v_a.$1226.Metal2 v_b.$2361.Metal2 0.0276657f
Cred_11248 v_a.$1226.Metal2 v_b.$2421.Metal2 0.00912497f
Cred_11249 v_a.$1226.Metal2 v_b.P1.pSD 0.0247327f
Cred_11250 v_a.$1226.Metal2 v_b.P3.nSD 0.000100973f
Cred_11251 v_a.$1226.Metal2 v_b.P3.pSD 0.0249042f
Cred_11252 v_a.$1228.Metal2 v_b.$2361.Metal2 0.0262402f
Cred_11253 v_a.$1228.Metal2 v_b.$2421.Metal2 0.00865624f
Cred_11254 v_a.$1228.Metal2 v_b.P1.pSD 0.0256529f
Cred_11255 v_a.$1228.Metal2 v_b.P3.nSD 9.57859e-05f
Cred_11256 v_a.$1228.Metal2 v_b.P3.pSD 0.0258272f
Cred_11257 v_a.$1230.Metal2 v_b.$2361.Metal2 0.0251222f
Cred_11258 v_a.$1230.Metal2 v_b.$2421.Metal2 0.0081739f
Cred_11259 v_a.$1230.Metal2 v_b.P1.pSD 0.0266862f
Cred_11260 v_a.$1230.Metal2 v_b.P3.nSD 9.04485e-05f
Cred_11261 v_a.$1230.Metal2 v_b.P3.pSD 0.0263089f
Cred_11262 v_a.$1232.Metal2 v_b.$2361.Metal2 0.0237364f
Cred_11263 v_a.$1232.Metal2 v_b.$2421.Metal2 0.00783033f
Cred_11264 v_a.$1232.Metal2 v_b.P1.pSD 0.0269644f
Cred_11265 v_a.$1232.Metal2 v_b.P3.nSD 8.66468e-05f
Cred_11266 v_a.$1232.Metal2 v_b.P3.pSD 0.0271198f
Cred_11267 v_a.$1234.Metal2 v_b.$2361.Metal2 0.0227751f
Cred_11268 v_a.$1234.Metal2 v_b.$2421.Metal2 0.0075146f
Cred_11269 v_a.$1234.Metal2 v_b.P1.pSD 0.0275952f
Cred_11270 v_a.$1234.Metal2 v_b.P3.nSD 8.3153e-05f
Cred_11271 v_a.$1234.Metal2 v_b.P3.pSD 0.0277553f
Cred_11272 v_a.$1236.Metal2 v_b.$2361.Metal2 0.0219387f
Cred_11273 v_a.$1236.Metal2 v_b.$2421.Metal2 0.00723665f
Cred_11274 v_a.$1236.Metal2 v_b.P1.pSD 0.0280752f
Cred_11275 v_a.$1236.Metal2 v_b.P3.nSD 8.00774e-05f
Cred_11276 v_a.$1236.Metal2 v_b.P3.pSD 0.028216f
Cred_11277 v_a.$1238.Metal2 v_b.$2361.Metal2 0.0222739f
Cred_11278 v_a.$1238.Metal2 v_b.$2421.Metal2 0.00735066f
Cred_11279 v_a.$1238.Metal2 v_b.P1.pSD 0.030822f
Cred_11280 v_a.$1238.Metal2 v_b.P3.nSD 8.13389e-05f
Cred_11281 v_a.$1238.Metal2 v_b.P3.pSD 0.0310031f
Cred_11282 v_a.$1240.Metal2 v_b.$2361.Metal2 0.0960495f
Cred_11283 v_a.$1240.Metal2 v_b.$2421.Metal2 0.0316377f
Cred_11284 v_a.$1240.Metal2 v_b.P1.pSD 0.150664f
Cred_11285 v_a.$1240.Metal2 v_b.P3.nSD 0.000350088f
Cred_11286 v_a.$1240.Metal2 v_b.P3.pSD 0.151206f
Cred_11287 v_a.$1268.Metal2 v_b.$2361.Metal2 0.0501141f
Cred_11288 v_a.$1268.Metal2 v_b.$2421.Metal2 0.150734f
Cred_11289 v_a.$1268.Metal2 v_b.P3.nSD 0.000554539f
Cred_11290 v_a.$1268.Metal2 v_b.P3.pSD 0.0282287f
Cred_11291 v_a.$1268.Metal2 v_b.P5.pSD 0.0269993f
Cred_11292 v_a.$1268.Metal2 VDD.$340.Metal1 3.02914e-08f
Cred_11293 v_a.$1268.Metal2 VDD.$388.Metal2 1.6456e-07f
Cred_11294 v_a.$1268.Metal2 VDD.$42.Metal1 7.72683e-06f
Cred_11295 v_a.$1268.Metal2 VDD.$666.Metal3 7.24483e-09f
Cred_11296 v_a.$1268.Metal2 VDD.P0.nSD 0.000358461f
Cred_11297 v_a.$1270.Metal2 v_b.$2361.Metal2 0.0142978f
Cred_11298 v_a.$1270.Metal2 v_b.$2421.Metal2 0.0433453f
Cred_11299 v_a.$1270.Metal2 v_b.P3.nSD 0.000158213f
Cred_11300 v_a.$1270.Metal2 v_b.P3.pSD 0.014089f
Cred_11301 v_a.$1270.Metal2 v_b.P5.pSD 0.0138025f
Cred_11302 v_a.$1272.Metal2 v_b.$2361.Metal2 0.0133143f
Cred_11303 v_a.$1272.Metal2 v_b.$2421.Metal2 0.0403664f
Cred_11304 v_a.$1272.Metal2 v_b.P3.nSD 0.00014733f
Cred_11305 v_a.$1272.Metal2 v_b.P3.pSD 0.0162272f
Cred_11306 v_a.$1272.Metal2 v_b.P5.pSD 0.0159616f
Cred_11307 v_a.$1274.Metal2 v_b.$2361.Metal2 0.0123438f
Cred_11308 v_a.$1274.Metal2 v_b.$2421.Metal2 0.0374241f
Cred_11309 v_a.$1274.Metal2 v_b.P3.nSD 0.00013659f
Cred_11310 v_a.$1274.Metal2 v_b.P3.pSD 0.0178411f
Cred_11311 v_a.$1274.Metal2 v_b.P5.pSD 0.0175978f
Cred_11312 v_a.$1276.Metal2 v_b.$2361.Metal2 0.0115617f
Cred_11313 v_a.$1276.Metal2 v_b.$2421.Metal2 0.0350434f
Cred_11314 v_a.$1276.Metal2 v_b.P3.nSD 0.000127936f
Cred_11315 v_a.$1276.Metal2 v_b.P3.pSD 0.0196467f
Cred_11316 v_a.$1276.Metal2 v_b.P5.pSD 0.01941f
Cred_11317 v_a.$1278.Metal2 v_b.$2361.Metal2 0.0108216f
Cred_11318 v_a.$1278.Metal2 v_b.$2421.Metal2 0.0328023f
Cred_11319 v_a.$1278.Metal2 v_b.P3.nSD 0.000119747f
Cred_11320 v_a.$1278.Metal2 v_b.P3.pSD 0.0210632f
Cred_11321 v_a.$1278.Metal2 v_b.P5.pSD 0.0208434f
Cred_11322 v_a.$1280.Metal2 v_b.$2361.Metal2 0.0101668f
Cred_11323 v_a.$1280.Metal2 v_b.$2421.Metal2 0.0308152f
Cred_11324 v_a.$1280.Metal2 v_b.P3.nSD 0.000112501f
Cred_11325 v_a.$1280.Metal2 v_b.P3.pSD 0.0223803f
Cred_11326 v_a.$1280.Metal2 v_b.P5.pSD 0.0221711f
Cred_11327 v_a.$1282.Metal2 v_b.$2361.Metal2 0.00940646f
Cred_11328 v_a.$1282.Metal2 v_b.$2421.Metal2 0.0293236f
Cred_11329 v_a.$1282.Metal2 v_b.P3.nSD 0.000104088f
Cred_11330 v_a.$1282.Metal2 v_b.P3.pSD 0.023157f
Cred_11331 v_a.$1282.Metal2 v_b.P5.pSD 0.0239354f
Cred_11332 v_a.$1284.Metal2 v_b.$2361.Metal2 0.00905594f
Cred_11333 v_a.$1284.Metal2 v_b.$2421.Metal2 0.027446f
Cred_11334 v_a.$1284.Metal2 v_b.P3.nSD 0.000100209f
Cred_11335 v_a.$1284.Metal2 v_b.P3.pSD 0.0245405f
Cred_11336 v_a.$1284.Metal2 v_b.P5.pSD 0.0243519f
Cred_11337 v_a.$1286.Metal2 v_b.$2361.Metal2 0.0126283f
Cred_11338 v_a.$1286.Metal2 v_b.$2421.Metal2 0.0382727f
Cred_11339 v_a.$1286.Metal2 v_b.P3.nSD 0.000139739f
Cred_11340 v_a.$1286.Metal2 v_b.P3.pSD 0.038529f
Cred_11341 v_a.$1286.Metal2 v_b.P5.pSD 0.0382637f
Cred_11342 v_a.$1290.Metal2 v_b.$2361.Metal2 0.0118416f
Cred_11343 v_a.$1290.Metal2 v_b.$2421.Metal2 0.0358903f
Cred_11344 v_a.$1290.Metal2 v_b.P3.nSD 0.000131034f
Cred_11345 v_a.$1290.Metal2 v_b.P3.pSD 0.0400172f
Cred_11346 v_a.$1290.Metal2 v_b.P5.pSD 0.0397699f
Cred_11347 v_a.$1292.Metal2 v_b.$2361.Metal2 0.00752285f
Cred_11348 v_a.$1292.Metal2 v_b.$2421.Metal2 0.0228015f
Cred_11349 v_a.$1292.Metal2 v_b.P3.nSD 8.32444e-05f
Cred_11350 v_a.$1292.Metal2 v_b.P3.pSD 0.0277612f
Cred_11351 v_a.$1292.Metal2 v_b.P5.pSD 0.0276052f
Cred_11352 v_a.$1294.Metal2 v_b.$2361.Metal2 0.0395535f
Cred_11353 v_a.$1294.Metal2 v_b.$2421.Metal2 0.119708f
Cred_11354 v_a.$1294.Metal2 v_b.P3.nSD 0.00043768f
Cred_11355 v_a.$1294.Metal2 v_b.P3.pSD 0.18197f
Cred_11356 v_a.$1294.Metal2 v_b.P5.pSD 0.180585f
Cred_11357 v_a.$1324.Metal2 v_b.$2421.Metal2 0.111833f
Cred_11358 v_a.$1324.Metal2 v_b.$2481.Metal2 0.0364921f
Cred_11359 v_a.$1324.Metal2 v_b.P5.pSD 0.0167181f
Cred_11360 v_a.$1324.Metal2 v_b.P7.nSD 0.000403804f
Cred_11361 v_a.$1324.Metal2 v_b.P7.pSD 0.017266f
Cred_11362 v_a.$1324.Metal2 VDD.$340.Metal1 4.19848e-08f
Cred_11363 v_a.$1324.Metal2 VDD.$388.Metal2 1.36601e-07f
Cred_11364 v_a.$1324.Metal2 VDD.$42.Metal1 6.41403e-06f
Cred_11365 v_a.$1324.Metal2 VDD.$666.Metal3 6.01392e-09f
Cred_11366 v_a.$1324.Metal2 VDD.P0.nSD 0.000386557f
Cred_11367 v_a.$1326.Metal2 v_b.$2421.Metal2 0.046845f
Cred_11368 v_a.$1326.Metal2 v_b.$2481.Metal2 0.015455f
Cred_11369 v_a.$1326.Metal2 v_b.P5.pSD 0.0115297f
Cred_11370 v_a.$1326.Metal2 v_b.P7.nSD 0.000171018f
Cred_11371 v_a.$1326.Metal2 v_b.P7.pSD 0.0118433f
Cred_11372 v_a.$1328.Metal2 v_b.$2421.Metal2 0.0630363f
Cred_11373 v_a.$1328.Metal2 v_b.$2481.Metal2 0.0207975f
Cred_11374 v_a.$1328.Metal2 v_b.P5.pSD 0.0215219f
Cred_11375 v_a.$1328.Metal2 v_b.P7.nSD 0.000230135f
Cred_11376 v_a.$1328.Metal2 v_b.P7.pSD 0.0219439f
Cred_11377 v_a.$1332.Metal2 v_b.$2421.Metal2 0.0572642f
Cred_11378 v_a.$1332.Metal2 v_b.$2481.Metal2 0.0188949f
Cred_11379 v_a.$1332.Metal2 v_b.P5.pSD 0.0255221f
Cred_11380 v_a.$1332.Metal2 v_b.P7.nSD 0.000209082f
Cred_11381 v_a.$1332.Metal2 v_b.P7.pSD 0.025912f
Cred_11382 v_a.$1334.Metal2 v_b.$2421.Metal2 0.0350247f
Cred_11383 v_a.$1334.Metal2 v_b.$2481.Metal2 0.0115582f
Cred_11384 v_a.$1334.Metal2 v_b.P5.pSD 0.0193303f
Cred_11385 v_a.$1334.Metal2 v_b.P7.nSD 0.000127898f
Cred_11386 v_a.$1334.Metal2 v_b.P7.pSD 0.019572f
Cred_11387 v_a.$1336.Metal2 v_b.$2421.Metal2 0.0328708f
Cred_11388 v_a.$1336.Metal2 v_b.$2481.Metal2 0.0108471f
Cred_11389 v_a.$1336.Metal2 v_b.P5.pSD 0.0209015f
Cred_11390 v_a.$1336.Metal2 v_b.P7.nSD 0.000120029f
Cred_11391 v_a.$1336.Metal2 v_b.P7.pSD 0.0211291f
Cred_11392 v_a.$1338.Metal2 v_b.$2421.Metal2 0.0308256f
Cred_11393 v_a.$1338.Metal2 v_b.$2481.Metal2 0.01017f
Cred_11394 v_a.$1338.Metal2 v_b.P5.pSD 0.0221923f
Cred_11395 v_a.$1338.Metal2 v_b.P7.nSD 0.000112537f
Cred_11396 v_a.$1338.Metal2 v_b.P7.pSD 0.0224003f
Cred_11397 v_a.$1340.Metal2 v_b.$2421.Metal2 0.0288449f
Cred_11398 v_a.$1340.Metal2 v_b.$2481.Metal2 0.00978458f
Cred_11399 v_a.$1340.Metal2 v_b.P5.pSD 0.0228561f
Cred_11400 v_a.$1340.Metal2 v_b.P7.nSD 0.000108272f
Cred_11401 v_a.$1340.Metal2 v_b.P7.pSD 0.0240272f
Cred_11402 v_a.$1342.Metal2 v_b.$2421.Metal2 0.0276715f
Cred_11403 v_a.$1342.Metal2 v_b.$2481.Metal2 0.00912576f
Cred_11404 v_a.$1342.Metal2 v_b.P5.pSD 0.0247455f
Cred_11405 v_a.$1342.Metal2 v_b.P7.nSD 0.000100981f
Cred_11406 v_a.$1342.Metal2 v_b.P7.pSD 0.0249082f
Cred_11407 v_a.$1344.Metal2 v_b.$2421.Metal2 0.0262459f
Cred_11408 v_a.$1344.Metal2 v_b.$2481.Metal2 0.00865701f
Cred_11409 v_a.$1344.Metal2 v_b.P5.pSD 0.0256656f
Cred_11410 v_a.$1344.Metal2 v_b.P7.nSD 9.57944e-05f
Cred_11411 v_a.$1344.Metal2 v_b.P7.pSD 0.0258312f
Cred_11412 v_a.$1346.Metal2 v_b.$2421.Metal2 0.0247765f
Cred_11413 v_a.$1346.Metal2 v_b.$2481.Metal2 0.00817415f
Cred_11414 v_a.$1346.Metal2 v_b.P5.pSD 0.0261438f
Cred_11415 v_a.$1346.Metal2 v_b.P7.nSD 9.04513e-05f
Cred_11416 v_a.$1346.Metal2 v_b.P7.pSD 0.0263103f
Cred_11417 v_a.$1348.Metal2 v_b.$2421.Metal2 0.0237612f
Cred_11418 v_a.$1348.Metal2 v_b.$2481.Metal2 0.00783881f
Cred_11419 v_a.$1348.Metal2 v_b.P5.pSD 0.0269933f
Cred_11420 v_a.$1348.Metal2 v_b.P7.nSD 8.67406e-05f
Cred_11421 v_a.$1348.Metal2 v_b.P7.pSD 0.0271518f
Cred_11422 v_a.$1350.Metal2 v_b.$2421.Metal2 0.0235896f
Cred_11423 v_a.$1350.Metal2 v_b.$2481.Metal2 0.00778554f
Cred_11424 v_a.$1350.Metal2 v_b.P5.pSD 0.0292801f
Cred_11425 v_a.$1350.Metal2 v_b.P7.nSD 8.61511e-05f
Cred_11426 v_a.$1350.Metal2 v_b.P7.pSD 0.0294695f
Cred_11427 v_a.$1352.Metal2 v_b.$2421.Metal2 0.123892f
Cred_11428 v_a.$1352.Metal2 v_b.$2481.Metal2 0.0409345f
Cred_11429 v_a.$1352.Metal2 v_b.P5.pSD 0.189387f
Cred_11430 v_a.$1352.Metal2 v_b.P7.nSD 0.000452962f
Cred_11431 v_a.$1352.Metal2 v_b.P7.pSD 0.190921f
Cred_11432 v_a.$138.Metal1 v_b.$2361.Metal2 0.0108883f
Cred_11433 v_a.$138.Metal1 v_b.$2421.Metal2 0.0326155f
Cred_11434 v_a.$138.Metal1 v_b.P3.nSD 0.000120485f
Cred_11435 v_a.$138.Metal1 v_b.P3.pSD 0.0409611f
Cred_11436 v_a.$138.Metal1 v_b.P5.pSD 0.0400272f
Cred_11437 v_a.$1384.Metal2 v_b.$2421.Metal2 0.0500973f
Cred_11438 v_a.$1384.Metal2 v_b.$2481.Metal2 0.150718f
Cred_11439 v_a.$1384.Metal2 v_b.P10.pSD 0.0269993f
Cred_11440 v_a.$1384.Metal2 v_b.P7.nSD 0.000554354f
Cred_11441 v_a.$1384.Metal2 v_b.P7.pSD 0.0281769f
Cred_11442 v_a.$1384.Metal2 VDD.$340.Metal1 5.05567e-08f
Cred_11443 v_a.$1384.Metal2 VDD.$388.Metal2 9.84857e-08f
Cred_11444 v_a.$1384.Metal2 VDD.$42.Metal1 4.62434e-06f
Cred_11445 v_a.$1384.Metal2 VDD.$666.Metal3 4.33587e-09f
Cred_11446 v_a.$1384.Metal2 VDD.P0.nSD 0.000361612f
Cred_11447 v_a.$1386.Metal2 v_b.$2421.Metal2 0.0142961f
Cred_11448 v_a.$1386.Metal2 v_b.$2481.Metal2 0.0433435f
Cred_11449 v_a.$1386.Metal2 v_b.P10.pSD 0.0138025f
Cred_11450 v_a.$1386.Metal2 v_b.P7.nSD 0.000158193f
Cred_11451 v_a.$1386.Metal2 v_b.P7.pSD 0.0140832f
Cred_11452 v_a.$1388.Metal2 v_b.$2421.Metal2 0.0133549f
Cred_11453 v_a.$1388.Metal2 v_b.$2481.Metal2 0.0404959f
Cred_11454 v_a.$1388.Metal2 v_b.P10.pSD 0.0161225f
Cred_11455 v_a.$1388.Metal2 v_b.P7.nSD 0.000147779f
Cred_11456 v_a.$1388.Metal2 v_b.P7.pSD 0.0163775f
Cred_11457 v_a.$1390.Metal2 v_b.$2421.Metal2 0.0124479f
Cred_11458 v_a.$1390.Metal2 v_b.$2481.Metal2 0.037744f
Cred_11459 v_a.$1390.Metal2 v_b.P10.pSD 0.0179884f
Cred_11460 v_a.$1390.Metal2 v_b.P7.nSD 0.000137743f
Cred_11461 v_a.$1390.Metal2 v_b.P7.pSD 0.0182259f
Cred_11462 v_a.$1392.Metal2 v_b.$2421.Metal2 0.0115304f
Cred_11463 v_a.$1392.Metal2 v_b.$2481.Metal2 0.0349514f
Cred_11464 v_a.$1392.Metal2 v_b.P10.pSD 0.019294f
Cred_11465 v_a.$1392.Metal2 v_b.P7.nSD 0.00012759f
Cred_11466 v_a.$1392.Metal2 v_b.P7.pSD 0.0195243f
Cred_11467 v_a.$1394.Metal2 v_b.$2421.Metal2 0.0108315f
Cred_11468 v_a.$1394.Metal2 v_b.$2481.Metal2 0.0328362f
Cred_11469 v_a.$1394.Metal2 v_b.P10.pSD 0.0208883f
Cred_11470 v_a.$1394.Metal2 v_b.P7.nSD 0.000119856f
Cred_11471 v_a.$1394.Metal2 v_b.P7.pSD 0.0211004f
Cred_11472 v_a.$1396.Metal2 v_b.$2421.Metal2 0.0101693f
Cred_11473 v_a.$1396.Metal2 v_b.$2481.Metal2 0.0308263f
Cred_11474 v_a.$1396.Metal2 v_b.P10.pSD 0.0221958f
Cred_11475 v_a.$1396.Metal2 v_b.P7.nSD 0.000112528f
Cred_11476 v_a.$1396.Metal2 v_b.P7.pSD 0.0223968f
Cred_11477 v_a.$1398.Metal2 v_b.$2421.Metal2 0.0093839f
Cred_11478 v_a.$1398.Metal2 v_b.$2481.Metal2 0.0292581f
Cred_11479 v_a.$1398.Metal2 v_b.P10.pSD 0.0238305f
Cred_11480 v_a.$1398.Metal2 v_b.P7.nSD 0.000103838f
Cred_11481 v_a.$1398.Metal2 v_b.P7.pSD 0.0230448f
Cred_11482 v_a.$1400.Metal2 v_b.$2421.Metal2 0.00913058f
Cred_11483 v_a.$1400.Metal2 v_b.$2481.Metal2 0.0276666f
Cred_11484 v_a.$1400.Metal2 v_b.P10.pSD 0.0247247f
Cred_11485 v_a.$1400.Metal2 v_b.P7.nSD 0.000101035f
Cred_11486 v_a.$1400.Metal2 v_b.P7.pSD 0.0249291f
Cred_11487 v_a.$1402.Metal2 v_b.$2421.Metal2 0.00865946f
Cred_11488 v_a.$1402.Metal2 v_b.$2481.Metal2 0.0262434f
Cred_11489 v_a.$1402.Metal2 v_b.P10.pSD 0.0256572f
Cred_11490 v_a.$1402.Metal2 v_b.P7.nSD 9.58215e-05f
Cred_11491 v_a.$1402.Metal2 v_b.P7.pSD 0.0258398f
Cred_11492 v_a.$1404.Metal2 v_b.$2421.Metal2 0.00817377f
Cred_11493 v_a.$1404.Metal2 v_b.$2481.Metal2 0.0247769f
Cred_11494 v_a.$1404.Metal2 v_b.P10.pSD 0.0261459f
Cred_11495 v_a.$1404.Metal2 v_b.P7.nSD 9.04471e-05f
Cred_11496 v_a.$1404.Metal2 v_b.P7.pSD 0.0263081f
Cred_11497 v_a.$1406.Metal2 v_b.$2421.Metal2 0.00783898f
Cred_11498 v_a.$1406.Metal2 v_b.$2481.Metal2 0.023761f
Cred_11499 v_a.$1406.Metal2 v_b.P10.pSD 0.0269942f
Cred_11500 v_a.$1406.Metal2 v_b.P7.nSD 8.67425e-05f
Cred_11501 v_a.$1406.Metal2 v_b.P7.pSD 0.0271509f
Cred_11502 v_a.$1408.Metal2 v_b.$2421.Metal2 0.00778074f
Cred_11503 v_a.$1408.Metal2 v_b.$2481.Metal2 0.0235945f
Cred_11504 v_a.$1408.Metal2 v_b.P10.pSD 0.029313f
Cred_11505 v_a.$1408.Metal2 v_b.P7.nSD 8.6098e-05f
Cred_11506 v_a.$1408.Metal2 v_b.P7.pSD 0.0294365f
Cred_11507 v_a.$1410.Metal2 v_b.$2421.Metal2 0.0408419f
Cred_11508 v_a.$1410.Metal2 v_b.$2481.Metal2 0.123987f
Cred_11509 v_a.$1410.Metal2 v_b.P10.pSD 0.190098f
Cred_11510 v_a.$1410.Metal2 v_b.P7.nSD 0.000451938f
Cred_11511 v_a.$1410.Metal2 v_b.P7.pSD 0.190208f
Cred_11512 v_a.$1442.Metal2 v_b.$2481.Metal2 0.151294f
Cred_11513 v_a.$1442.Metal2 v_b.$2541.Metal2 0.049538f
Cred_11514 v_a.$1442.Metal2 v_b.P10.pSD 0.0271695f
Cred_11515 v_a.$1442.Metal2 v_b.P11.nSD 0.000548164f
Cred_11516 v_a.$1442.Metal2 v_b.P11.pSD 0.0279954f
Cred_11517 v_a.$1442.Metal2 VDD.$340.Metal1 6.534e-08f
Cred_11518 v_a.$1442.Metal2 VDD.$388.Metal2 7.62018e-08f
Cred_11519 v_a.$1442.Metal2 VDD.$42.Metal1 3.57802e-06f
Cred_11520 v_a.$1442.Metal2 VDD.$666.Metal3 3.35482e-09f
Cred_11521 v_a.$1442.Metal2 VDD.P0.nSD 0.000362667f
Cred_11522 v_a.$1444.Metal2 v_b.$2481.Metal2 0.0433386f
Cred_11523 v_a.$1444.Metal2 v_b.$2541.Metal2 0.0143008f
Cred_11524 v_a.$1444.Metal2 v_b.P10.pSD 0.0137958f
Cred_11525 v_a.$1444.Metal2 v_b.P11.nSD 0.000158246f
Cred_11526 v_a.$1444.Metal2 v_b.P11.pSD 0.01409f
Cred_11527 v_a.$1446.Metal2 v_b.$2481.Metal2 0.0404883f
Cred_11528 v_a.$1446.Metal2 v_b.$2541.Metal2 0.0133622f
Cred_11529 v_a.$1446.Metal2 v_b.P10.pSD 0.016109f
Cred_11530 v_a.$1446.Metal2 v_b.P11.nSD 0.00014786f
Cred_11531 v_a.$1446.Metal2 v_b.P11.pSD 0.0163912f
Cred_11532 v_a.$1448.Metal2 v_b.$2481.Metal2 0.0377378f
Cred_11533 v_a.$1448.Metal2 v_b.$2541.Metal2 0.012454f
Cred_11534 v_a.$1448.Metal2 v_b.P10.pSD 0.0179756f
Cred_11535 v_a.$1448.Metal2 v_b.P11.nSD 0.00013781f
Cred_11536 v_a.$1448.Metal2 v_b.P11.pSD 0.0182388f
Cred_11537 v_a.$1450.Metal2 v_b.$2481.Metal2 0.0349511f
Cred_11538 v_a.$1450.Metal2 v_b.$2541.Metal2 0.0115308f
Cred_11539 v_a.$1450.Metal2 v_b.P10.pSD 0.0192925f
Cred_11540 v_a.$1450.Metal2 v_b.P11.nSD 0.000127594f
Cred_11541 v_a.$1450.Metal2 v_b.P11.pSD 0.0195258f
Cred_11542 v_a.$1452.Metal2 v_b.$2481.Metal2 0.0328341f
Cred_11543 v_a.$1452.Metal2 v_b.$2541.Metal2 0.0108335f
Cred_11544 v_a.$1452.Metal2 v_b.P10.pSD 0.0208826f
Cred_11545 v_a.$1452.Metal2 v_b.P11.nSD 0.000119878f
Cred_11546 v_a.$1452.Metal2 v_b.P11.pSD 0.0211062f
Cred_11547 v_a.$1454.Metal2 v_b.$2481.Metal2 0.0308256f
Cred_11548 v_a.$1454.Metal2 v_b.$2541.Metal2 0.01017f
Cred_11549 v_a.$1454.Metal2 v_b.P10.pSD 0.0221923f
Cred_11550 v_a.$1454.Metal2 v_b.P11.nSD 0.000112537f
Cred_11551 v_a.$1454.Metal2 v_b.P11.pSD 0.0224003f
Cred_11552 v_a.$1456.Metal2 v_b.$2481.Metal2 0.0288449f
Cred_11553 v_a.$1456.Metal2 v_b.$2541.Metal2 0.00978458f
Cred_11554 v_a.$1456.Metal2 v_b.P10.pSD 0.0228561f
Cred_11555 v_a.$1456.Metal2 v_b.P11.nSD 0.000108272f
Cred_11556 v_a.$1456.Metal2 v_b.P11.pSD 0.0240272f
Cred_11557 v_a.$1458.Metal2 v_b.$2481.Metal2 0.0276715f
Cred_11558 v_a.$1458.Metal2 v_b.$2541.Metal2 0.00912576f
Cred_11559 v_a.$1458.Metal2 v_b.P10.pSD 0.0247455f
Cred_11560 v_a.$1458.Metal2 v_b.P11.nSD 0.000100981f
Cred_11561 v_a.$1458.Metal2 v_b.P11.pSD 0.0249082f
Cred_11562 v_a.$1460.Metal2 v_b.$2481.Metal2 0.0262459f
Cred_11563 v_a.$1460.Metal2 v_b.$2541.Metal2 0.00865701f
Cred_11564 v_a.$1460.Metal2 v_b.P10.pSD 0.0256656f
Cred_11565 v_a.$1460.Metal2 v_b.P11.nSD 9.57944e-05f
Cred_11566 v_a.$1460.Metal2 v_b.P11.pSD 0.0258312f
Cred_11567 v_a.$1462.Metal2 v_b.$2481.Metal2 0.0247765f
Cred_11568 v_a.$1462.Metal2 v_b.$2541.Metal2 0.00817415f
Cred_11569 v_a.$1462.Metal2 v_b.P10.pSD 0.0261438f
Cred_11570 v_a.$1462.Metal2 v_b.P11.nSD 9.04513e-05f
Cred_11571 v_a.$1462.Metal2 v_b.P11.pSD 0.0263103f
Cred_11572 v_a.$1464.Metal2 v_b.$2481.Metal2 0.0237612f
Cred_11573 v_a.$1464.Metal2 v_b.$2541.Metal2 0.00783881f
Cred_11574 v_a.$1464.Metal2 v_b.P10.pSD 0.0269933f
Cred_11575 v_a.$1464.Metal2 v_b.P11.nSD 8.67406e-05f
Cred_11576 v_a.$1464.Metal2 v_b.P11.pSD 0.0271518f
Cred_11577 v_a.$1466.Metal2 v_b.$2481.Metal2 0.0235896f
Cred_11578 v_a.$1466.Metal2 v_b.$2541.Metal2 0.00778554f
Cred_11579 v_a.$1466.Metal2 v_b.P10.pSD 0.0292801f
Cred_11580 v_a.$1466.Metal2 v_b.P11.nSD 8.61511e-05f
Cred_11581 v_a.$1466.Metal2 v_b.P11.pSD 0.0294695f
Cred_11582 v_a.$1468.Metal2 v_b.$2481.Metal2 0.123892f
Cred_11583 v_a.$1468.Metal2 v_b.$2541.Metal2 0.0409345f
Cred_11584 v_a.$1468.Metal2 v_b.P10.pSD 0.189387f
Cred_11585 v_a.$1468.Metal2 v_b.P11.nSD 0.000452962f
Cred_11586 v_a.$1468.Metal2 v_b.P11.pSD 0.190921f
Cred_11587 v_a.$1500.Metal2 v_b.$2481.Metal2 0.049957f
Cred_11588 v_a.$1500.Metal2 v_b.$2541.Metal2 0.150295f
Cred_11589 v_a.$1500.Metal2 v_b.P11.nSD 0.0005528f
Cred_11590 v_a.$1500.Metal2 v_b.P11.pSD 0.0280714f
Cred_11591 v_a.$1500.Metal2 v_b.P13.pSD 0.0268965f
Cred_11592 v_a.$1500.Metal2 VDD.$340.Metal1 8.44198e-08f
Cred_11593 v_a.$1500.Metal2 VDD.$388.Metal2 5.89461e-08f
Cred_11594 v_a.$1500.Metal2 VDD.$42.Metal1 2.76778e-06f
Cred_11595 v_a.$1500.Metal2 VDD.$666.Metal3 2.59513e-09f
Cred_11596 v_a.$1500.Metal2 VDD.P0.nSD 0.000363316f
Cred_11597 v_a.$1502.Metal2 v_b.$2481.Metal2 0.0142961f
Cred_11598 v_a.$1502.Metal2 v_b.$2541.Metal2 0.0433435f
Cred_11599 v_a.$1502.Metal2 v_b.P11.nSD 0.000158193f
Cred_11600 v_a.$1502.Metal2 v_b.P11.pSD 0.0140832f
Cred_11601 v_a.$1502.Metal2 v_b.P13.pSD 0.0138025f
Cred_11602 v_a.$1504.Metal2 v_b.$2481.Metal2 0.0133549f
Cred_11603 v_a.$1504.Metal2 v_b.$2541.Metal2 0.0404959f
Cred_11604 v_a.$1504.Metal2 v_b.P11.nSD 0.000147779f
Cred_11605 v_a.$1504.Metal2 v_b.P11.pSD 0.0163775f
Cred_11606 v_a.$1504.Metal2 v_b.P13.pSD 0.0161225f
Cred_11607 v_a.$1506.Metal2 v_b.$2481.Metal2 0.0124479f
Cred_11608 v_a.$1506.Metal2 v_b.$2541.Metal2 0.037744f
Cred_11609 v_a.$1506.Metal2 v_b.P11.nSD 0.000137743f
Cred_11610 v_a.$1506.Metal2 v_b.P11.pSD 0.0182259f
Cred_11611 v_a.$1506.Metal2 v_b.P13.pSD 0.0179884f
Cred_11612 v_a.$1508.Metal2 v_b.$2481.Metal2 0.0115304f
Cred_11613 v_a.$1508.Metal2 v_b.$2541.Metal2 0.0349514f
Cred_11614 v_a.$1508.Metal2 v_b.P11.nSD 0.00012759f
Cred_11615 v_a.$1508.Metal2 v_b.P11.pSD 0.0195243f
Cred_11616 v_a.$1508.Metal2 v_b.P13.pSD 0.019294f
Cred_11617 v_a.$1510.Metal2 v_b.$2481.Metal2 0.0108315f
Cred_11618 v_a.$1510.Metal2 v_b.$2541.Metal2 0.0328362f
Cred_11619 v_a.$1510.Metal2 v_b.P11.nSD 0.000119856f
Cred_11620 v_a.$1510.Metal2 v_b.P11.pSD 0.0211004f
Cred_11621 v_a.$1510.Metal2 v_b.P13.pSD 0.0208883f
Cred_11622 v_a.$1512.Metal2 v_b.$2481.Metal2 0.0101693f
Cred_11623 v_a.$1512.Metal2 v_b.$2541.Metal2 0.0308263f
Cred_11624 v_a.$1512.Metal2 v_b.P11.nSD 0.000112528f
Cred_11625 v_a.$1512.Metal2 v_b.P11.pSD 0.0223968f
Cred_11626 v_a.$1512.Metal2 v_b.P13.pSD 0.0221958f
Cred_11627 v_a.$1514.Metal2 v_b.$2481.Metal2 0.0093839f
Cred_11628 v_a.$1514.Metal2 v_b.$2541.Metal2 0.0292581f
Cred_11629 v_a.$1514.Metal2 v_b.P11.nSD 0.000103838f
Cred_11630 v_a.$1514.Metal2 v_b.P11.pSD 0.0230448f
Cred_11631 v_a.$1514.Metal2 v_b.P13.pSD 0.0238305f
Cred_11632 v_a.$1516.Metal2 v_b.$2481.Metal2 0.00913058f
Cred_11633 v_a.$1516.Metal2 v_b.$2541.Metal2 0.0276666f
Cred_11634 v_a.$1516.Metal2 v_b.P11.nSD 0.000101035f
Cred_11635 v_a.$1516.Metal2 v_b.P11.pSD 0.0249291f
Cred_11636 v_a.$1516.Metal2 v_b.P13.pSD 0.0247247f
Cred_11637 v_a.$1518.Metal2 v_b.$2481.Metal2 0.00865946f
Cred_11638 v_a.$1518.Metal2 v_b.$2541.Metal2 0.0262434f
Cred_11639 v_a.$1518.Metal2 v_b.P11.nSD 9.58215e-05f
Cred_11640 v_a.$1518.Metal2 v_b.P11.pSD 0.0258398f
Cred_11641 v_a.$1518.Metal2 v_b.P13.pSD 0.0256572f
Cred_11642 v_a.$1520.Metal2 v_b.$2481.Metal2 0.00817377f
Cred_11643 v_a.$1520.Metal2 v_b.$2541.Metal2 0.0247769f
Cred_11644 v_a.$1520.Metal2 v_b.P11.nSD 9.04471e-05f
Cred_11645 v_a.$1520.Metal2 v_b.P11.pSD 0.0263081f
Cred_11646 v_a.$1520.Metal2 v_b.P13.pSD 0.0261459f
Cred_11647 v_a.$1522.Metal2 v_b.$2481.Metal2 0.00783898f
Cred_11648 v_a.$1522.Metal2 v_b.$2541.Metal2 0.023761f
Cred_11649 v_a.$1522.Metal2 v_b.P11.nSD 8.67425e-05f
Cred_11650 v_a.$1522.Metal2 v_b.P11.pSD 0.0271509f
Cred_11651 v_a.$1522.Metal2 v_b.P13.pSD 0.0269942f
Cred_11652 v_a.$1524.Metal2 v_b.$2481.Metal2 0.00778074f
Cred_11653 v_a.$1524.Metal2 v_b.$2541.Metal2 0.0235945f
Cred_11654 v_a.$1524.Metal2 v_b.P11.nSD 8.6098e-05f
Cred_11655 v_a.$1524.Metal2 v_b.P11.pSD 0.0294365f
Cred_11656 v_a.$1524.Metal2 v_b.P13.pSD 0.029313f
Cred_11657 v_a.$1526.Metal2 v_b.$2481.Metal2 0.0408419f
Cred_11658 v_a.$1526.Metal2 v_b.$2541.Metal2 0.123987f
Cred_11659 v_a.$1526.Metal2 v_b.P11.nSD 0.000451938f
Cred_11660 v_a.$1526.Metal2 v_b.P11.pSD 0.190208f
Cred_11661 v_a.$1526.Metal2 v_b.P13.pSD 0.190098f
Cred_11662 v_a.$1558.Metal2 v_b.$2541.Metal2 0.151294f
Cred_11663 v_a.$1558.Metal2 v_b.$2601.Metal2 0.049538f
Cred_11664 v_a.$1558.Metal2 v_b.P13.pSD 0.0271695f
Cred_11665 v_a.$1558.Metal2 v_b.P15.nSD 0.000548164f
Cred_11666 v_a.$1558.Metal2 v_b.P15.pSD 0.0279954f
Cred_11667 v_a.$1558.Metal2 VDD.$340.Metal1 1.09175e-07f
Cred_11668 v_a.$1558.Metal2 VDD.$388.Metal2 4.56532e-08f
Cred_11669 v_a.$1558.Metal2 VDD.$42.Metal1 2.14362e-06f
Cred_11670 v_a.$1558.Metal2 VDD.$666.Metal3 2.0099e-09f
Cred_11671 v_a.$1558.Metal2 VDD.P0.nSD 0.000364089f
Cred_11672 v_a.$1560.Metal2 v_b.$2541.Metal2 0.0433386f
Cred_11673 v_a.$1560.Metal2 v_b.$2601.Metal2 0.0143008f
Cred_11674 v_a.$1560.Metal2 v_b.P13.pSD 0.0137958f
Cred_11675 v_a.$1560.Metal2 v_b.P15.nSD 0.000158246f
Cred_11676 v_a.$1560.Metal2 v_b.P15.pSD 0.01409f
Cred_11677 v_a.$1562.Metal2 v_b.$2541.Metal2 0.0404883f
Cred_11678 v_a.$1562.Metal2 v_b.$2601.Metal2 0.0133622f
Cred_11679 v_a.$1562.Metal2 v_b.P13.pSD 0.016109f
Cred_11680 v_a.$1562.Metal2 v_b.P15.nSD 0.00014786f
Cred_11681 v_a.$1562.Metal2 v_b.P15.pSD 0.0163912f
Cred_11682 v_a.$1564.Metal2 v_b.$2541.Metal2 0.0377378f
Cred_11683 v_a.$1564.Metal2 v_b.$2601.Metal2 0.012454f
Cred_11684 v_a.$1564.Metal2 v_b.P13.pSD 0.0179756f
Cred_11685 v_a.$1564.Metal2 v_b.P15.nSD 0.00013781f
Cred_11686 v_a.$1564.Metal2 v_b.P15.pSD 0.0182388f
Cred_11687 v_a.$1566.Metal2 v_b.$2541.Metal2 0.0349511f
Cred_11688 v_a.$1566.Metal2 v_b.$2601.Metal2 0.0115308f
Cred_11689 v_a.$1566.Metal2 v_b.P13.pSD 0.0192925f
Cred_11690 v_a.$1566.Metal2 v_b.P15.nSD 0.000127594f
Cred_11691 v_a.$1566.Metal2 v_b.P15.pSD 0.0195258f
Cred_11692 v_a.$1568.Metal2 v_b.$2541.Metal2 0.0328341f
Cred_11693 v_a.$1568.Metal2 v_b.$2601.Metal2 0.0108335f
Cred_11694 v_a.$1568.Metal2 v_b.P13.pSD 0.0208826f
Cred_11695 v_a.$1568.Metal2 v_b.P15.nSD 0.000119878f
Cred_11696 v_a.$1568.Metal2 v_b.P15.pSD 0.0211062f
Cred_11697 v_a.$1570.Metal2 v_b.$2541.Metal2 0.0308256f
Cred_11698 v_a.$1570.Metal2 v_b.$2601.Metal2 0.01017f
Cred_11699 v_a.$1570.Metal2 v_b.P13.pSD 0.0221923f
Cred_11700 v_a.$1570.Metal2 v_b.P15.nSD 0.000112537f
Cred_11701 v_a.$1570.Metal2 v_b.P15.pSD 0.0224003f
Cred_11702 v_a.$1572.Metal2 v_b.$2541.Metal2 0.0288449f
Cred_11703 v_a.$1572.Metal2 v_b.$2601.Metal2 0.00978458f
Cred_11704 v_a.$1572.Metal2 v_b.P13.pSD 0.0228561f
Cred_11705 v_a.$1572.Metal2 v_b.P15.nSD 0.000108272f
Cred_11706 v_a.$1572.Metal2 v_b.P15.pSD 0.0240272f
Cred_11707 v_a.$1574.Metal2 v_b.$2541.Metal2 0.0290675f
Cred_11708 v_a.$1574.Metal2 v_b.$2601.Metal2 0.00958968f
Cred_11709 v_a.$1574.Metal2 v_b.P13.pSD 0.027359f
Cred_11710 v_a.$1574.Metal2 v_b.P15.nSD 0.000106115f
Cred_11711 v_a.$1574.Metal2 v_b.P15.pSD 0.027565f
Cred_11712 v_a.$1576.Metal2 v_b.$2541.Metal2 0.174422f
Cred_11713 v_a.$1576.Metal2 v_b.$2601.Metal2 0.0576048f
Cred_11714 v_a.$1576.Metal2 v_b.P13.pSD 0.241214f
Cred_11715 v_a.$1576.Metal2 v_b.P15.nSD 0.000637427f
Cred_11716 v_a.$1576.Metal2 v_b.P15.pSD 0.243213f
Cred_11717 v_a.$165.Metal1 v_b.$2361.Metal2 0.0217255f
Cred_11718 v_a.$165.Metal1 v_b.$2421.Metal2 0.0650265f
Cred_11719 v_a.$165.Metal1 v_b.P3.nSD 0.000240405f
Cred_11720 v_a.$165.Metal1 v_b.P3.pSD 0.0638846f
Cred_11721 v_a.$165.Metal1 v_b.P5.pSD 0.0622754f
Cred_11722 v_a.$165.Metal1 VDD.$340.Metal1 6.39522e-07f
Cred_11723 v_a.$165.Metal1 VDD.$388.Metal2 3.47425e-06f
Cred_11724 v_a.$165.Metal1 VDD.$42.Metal1 0.000163132f
Cred_11725 v_a.$165.Metal1 VDD.$666.Metal3 1.52955e-07f
Cred_11726 v_a.$165.Metal1 VDD.P0.nSD 0.00756796f
Cred_11727 v_a.$167.Metal1 v_b.$2361.Metal2 0.0115932f
Cred_11728 v_a.$167.Metal1 v_b.$2421.Metal2 0.0348071f
Cred_11729 v_a.$167.Metal1 v_b.P3.nSD 0.000128284f
Cred_11730 v_a.$167.Metal1 v_b.P3.pSD 0.0396457f
Cred_11731 v_a.$167.Metal1 v_b.P5.pSD 0.0388605f
Cred_11732 v_a.$1674.Metal2 v_b.$2601.Metal2 0.100896f
Cred_11733 v_a.$1674.Metal2 v_b.$2631.Metal2 0.102013f
Cred_11734 v_a.$1674.Metal2 v_b.P17.pSD 0.0270836f
Cred_11735 v_a.$1674.Metal2 v_b.P19.pSD 0.0272696f
Cred_11736 v_a.$1674.Metal2 VDD.$340.Metal1 1.82524e-07f
Cred_11737 v_a.$1674.Metal2 VDD.$388.Metal2 2.74274e-08f
Cred_11738 v_a.$1674.Metal2 VDD.$42.Metal1 1.28784e-06f
Cred_11739 v_a.$1674.Metal2 VDD.$666.Metal3 1.2075e-09f
Cred_11740 v_a.$1674.Metal2 VDD.P0.nSD 0.000365033f
Cred_11741 v_a.$1676.Metal2 v_b.$2601.Metal2 0.0289969f
Cred_11742 v_a.$1676.Metal2 v_b.$2631.Metal2 0.0289983f
Cred_11743 v_a.$1676.Metal2 v_b.P17.pSD 0.0137736f
Cred_11744 v_a.$1676.Metal2 v_b.P19.pSD 0.0137757f
Cred_11745 v_a.$1678.Metal2 v_b.$2601.Metal2 0.0271188f
Cred_11746 v_a.$1678.Metal2 v_b.$2631.Metal2 0.027115f
Cred_11747 v_a.$1678.Metal2 v_b.P17.pSD 0.0161083f
Cred_11748 v_a.$1678.Metal2 v_b.P19.pSD 0.0161103f
Cred_11749 v_a.$1680.Metal2 v_b.$2601.Metal2 0.0253045f
Cred_11750 v_a.$1680.Metal2 v_b.$2631.Metal2 0.0252987f
Cred_11751 v_a.$1680.Metal2 v_b.P17.pSD 0.0179931f
Cred_11752 v_a.$1680.Metal2 v_b.P19.pSD 0.0179938f
Cred_11753 v_a.$1682.Metal2 v_b.$2601.Metal2 0.1519f
Cred_11754 v_a.$1682.Metal2 v_b.$2631.Metal2 0.152303f
Cred_11755 v_a.$1682.Metal2 v_b.P17.pSD 0.238932f
Cred_11756 v_a.$1682.Metal2 v_b.P19.pSD 0.239977f
Cred_11757 v_a.$1682.Metal2 VDD.$340.Metal1 7.07227e-08f
Cred_11758 v_a.$1682.Metal2 VDD.$388.Metal2 1.05416e-08f
Cred_11759 v_a.$1682.Metal2 VDD.$42.Metal1 4.94973e-07f
Cred_11760 v_a.$1682.Metal2 VDD.$666.Metal3 4.64097e-10f
Cred_11761 v_a.$1682.Metal2 VDD.P0.nSD 0.000140865f
Cred_11762 v_a.$171.Metal1 v_b.$2361.Metal2 0.0100597f
Cred_11763 v_a.$171.Metal1 v_b.$2421.Metal2 0.0302146f
Cred_11764 v_a.$171.Metal1 v_b.P3.nSD 0.000111316f
Cred_11765 v_a.$171.Metal1 v_b.P3.pSD 0.0420262f
Cred_11766 v_a.$171.Metal1 v_b.P5.pSD 0.0412529f
Cred_11767 v_a.$173.Metal1 v_b.$2361.Metal2 0.00946164f
Cred_11768 v_a.$173.Metal1 v_b.$2421.Metal2 0.0284126f
Cred_11769 v_a.$173.Metal1 v_b.P3.nSD 0.000104698f
Cred_11770 v_a.$173.Metal1 v_b.P3.pSD 0.0436773f
Cred_11771 v_a.$173.Metal1 v_b.P5.pSD 0.0428888f
Cred_11772 v_a.$1732.Metal2 v_b.$2631.Metal2 0.150377f
Cred_11773 v_a.$1732.Metal2 v_b.$2691.Metal2 0.0499863f
Cred_11774 v_a.$1732.Metal2 v_b.$3779.Metal3 1.52613e-05f
Cred_11775 v_a.$1732.Metal2 v_b.P19.pSD 0.026904f
Cred_11776 v_a.$1732.Metal2 v_b.P21.nSD 0.000553125f
Cred_11777 v_a.$1732.Metal2 v_b.P21.pSD 0.0281005f
Cred_11778 v_a.$1732.Metal2 v_b.P37.nSD 1.82461e-08f
Cred_11779 v_a.$1732.Metal2 v_b.P37.pSD 3.47412e-06f
Cred_11780 v_a.$1732.Metal2 VDD.$340.Metal1 2.35788e-07f
Cred_11781 v_a.$1732.Metal2 VDD.$388.Metal2 2.12819e-08f
Cred_11782 v_a.$1732.Metal2 VDD.$42.Metal1 9.99278e-07f
Cred_11783 v_a.$1732.Metal2 VDD.$666.Metal3 9.36942e-10f
Cred_11784 v_a.$1732.Metal2 VDD.P0.nSD 0.000364999f
Cred_11785 v_a.$1734.Metal2 v_b.$2631.Metal2 0.0432735f
Cred_11786 v_a.$1734.Metal2 v_b.$2691.Metal2 0.0142766f
Cred_11787 v_a.$1734.Metal2 v_b.P19.pSD 0.0137736f
Cred_11788 v_a.$1734.Metal2 v_b.P21.nSD 0.000157978f
Cred_11789 v_a.$1734.Metal2 v_b.P21.pSD 0.0140628f
Cred_11790 v_a.$1736.Metal2 v_b.$2631.Metal2 0.0404264f
Cred_11791 v_a.$1736.Metal2 v_b.$2691.Metal2 0.0133373f
Cred_11792 v_a.$1736.Metal2 v_b.$3779.Metal3 3.66103e-06f
Cred_11793 v_a.$1736.Metal2 v_b.P19.pSD 0.0160875f
Cred_11794 v_a.$1736.Metal2 v_b.P21.nSD 0.000147584f
Cred_11795 v_a.$1736.Metal2 v_b.P21.pSD 0.0163613f
Cred_11796 v_a.$1736.Metal2 v_b.P37.nSD 4.37704e-09f
Cred_11797 v_a.$1736.Metal2 v_b.P37.pSD 1.20847e-06f
Cred_11798 v_a.$1738.Metal2 v_b.$2631.Metal2 0.0376758f
Cred_11799 v_a.$1738.Metal2 v_b.$2691.Metal2 0.0124309f
Cred_11800 v_a.$1738.Metal2 v_b.P19.pSD 0.0179515f
Cred_11801 v_a.$1738.Metal2 v_b.P21.nSD 0.000137554f
Cred_11802 v_a.$1738.Metal2 v_b.P21.pSD 0.0182092f
Cred_11803 v_a.$1740.Metal2 v_b.$2631.Metal2 0.0349888f
Cred_11804 v_a.$1740.Metal2 v_b.$2691.Metal2 0.0115427f
Cred_11805 v_a.$1740.Metal2 v_b.$3779.Metal3 6.83197e-06f
Cred_11806 v_a.$1740.Metal2 v_b.P19.pSD 0.0193146f
Cred_11807 v_a.$1740.Metal2 v_b.P21.nSD 0.000127726f
Cred_11808 v_a.$1740.Metal2 v_b.P21.pSD 0.019547f
Cred_11809 v_a.$1740.Metal2 v_b.P37.nSD 8.16814e-09f
Cred_11810 v_a.$1740.Metal2 v_b.P37.pSD 2.86884e-06f
Cred_11811 v_a.$1742.Metal2 v_b.$2631.Metal2 0.032853f
Cred_11812 v_a.$1742.Metal2 v_b.$2691.Metal2 0.0108394f
Cred_11813 v_a.$1742.Metal2 v_b.$3779.Metal3 6.77277e-06f
Cred_11814 v_a.$1742.Metal2 v_b.P19.pSD 0.0208937f
Cred_11815 v_a.$1742.Metal2 v_b.P21.nSD 0.000119944f
Cred_11816 v_a.$1742.Metal2 v_b.P21.pSD 0.0211167f
Cred_11817 v_a.$1742.Metal2 v_b.P37.nSD 8.09736e-09f
Cred_11818 v_a.$1742.Metal2 v_b.P37.pSD 2.92811e-06f
Cred_11819 v_a.$1744.Metal2 v_b.$2631.Metal2 0.0308258f
Cred_11820 v_a.$1744.Metal2 v_b.$2691.Metal2 0.0101697f
Cred_11821 v_a.$1744.Metal2 v_b.P19.pSD 0.0221936f
Cred_11822 v_a.$1744.Metal2 v_b.P21.nSD 0.000112534f
Cred_11823 v_a.$1744.Metal2 v_b.P21.pSD 0.022399f
Cred_11824 v_a.$1746.Metal2 v_b.$2631.Metal2 0.0290536f
Cred_11825 v_a.$1746.Metal2 v_b.$2691.Metal2 0.00958221f
Cred_11826 v_a.$1746.Metal2 v_b.$3779.Metal3 9.42759e-06f
Cred_11827 v_a.$1746.Metal2 v_b.P19.pSD 0.02335f
Cred_11828 v_a.$1746.Metal2 v_b.P21.nSD 0.000106032f
Cred_11829 v_a.$1746.Metal2 v_b.P21.pSD 0.0235293f
Cred_11830 v_a.$1746.Metal2 v_b.P37.nSD 1.12714e-08f
Cred_11831 v_a.$1746.Metal2 v_b.P37.pSD 5.04783e-06f
Cred_11832 v_a.$1748.Metal2 v_b.$2631.Metal2 0.027475f
Cred_11833 v_a.$1748.Metal2 v_b.$2691.Metal2 0.0093163f
Cred_11834 v_a.$1748.Metal2 v_b.$3779.Metal3 1.24744e-05f
Cred_11835 v_a.$1748.Metal2 v_b.P19.pSD 0.0242273f
Cred_11836 v_a.$1748.Metal2 v_b.P21.nSD 0.00010309f
Cred_11837 v_a.$1748.Metal2 v_b.P21.pSD 0.0254301f
Cred_11838 v_a.$1748.Metal2 v_b.P37.nSD 1.49141e-08f
Cred_11839 v_a.$1748.Metal2 v_b.P37.pSD 6.81342e-06f
Cred_11840 v_a.$175.Metal1 v_b.$2361.Metal2 0.0090173f
Cred_11841 v_a.$175.Metal1 v_b.$2421.Metal2 0.0262407f
Cred_11842 v_a.$175.Metal1 v_b.P3.nSD 9.97812e-05f
Cred_11843 v_a.$175.Metal1 v_b.P3.pSD 0.0460188f
Cred_11844 v_a.$175.Metal1 v_b.P5.pSD 0.043101f
Cred_11845 v_a.$1750.Metal2 v_b.$2631.Metal2 0.0262452f
Cred_11846 v_a.$1750.Metal2 v_b.$2691.Metal2 0.00865768f
Cred_11847 v_a.$1750.Metal2 v_b.$3779.Metal3 9.29973e-06f
Cred_11848 v_a.$1750.Metal2 v_b.P19.pSD 0.0256609f
Cred_11849 v_a.$1750.Metal2 v_b.P21.nSD 9.58019e-05f
Cred_11850 v_a.$1750.Metal2 v_b.P21.pSD 0.025836f
Cred_11851 v_a.$1750.Metal2 v_b.P37.nSD 1.11185e-08f
Cred_11852 v_a.$1750.Metal2 v_b.P37.pSD 5.17585e-06f
Cred_11853 v_a.$1752.Metal2 v_b.$2631.Metal2 0.0247765f
Cred_11854 v_a.$1752.Metal2 v_b.$2691.Metal2 0.00817415f
Cred_11855 v_a.$1752.Metal2 v_b.P19.pSD 0.0261438f
Cred_11856 v_a.$1752.Metal2 v_b.P21.nSD 9.04513e-05f
Cred_11857 v_a.$1752.Metal2 v_b.P21.pSD 0.0263103f
Cred_11858 v_a.$1754.Metal2 v_b.$2631.Metal2 0.0237612f
Cred_11859 v_a.$1754.Metal2 v_b.$2691.Metal2 0.00783881f
Cred_11860 v_a.$1754.Metal2 v_b.$3779.Metal3 8.78992e-06f
Cred_11861 v_a.$1754.Metal2 v_b.P19.pSD 0.0269933f
Cred_11862 v_a.$1754.Metal2 v_b.P21.nSD 8.67406e-05f
Cred_11863 v_a.$1754.Metal2 v_b.P21.pSD 0.0271518f
Cred_11864 v_a.$1754.Metal2 v_b.P37.nSD 1.0509e-08f
Cred_11865 v_a.$1754.Metal2 v_b.P37.pSD 5.68626e-06f
Cred_11866 v_a.$1756.Metal2 v_b.$2631.Metal2 0.0235896f
Cred_11867 v_a.$1756.Metal2 v_b.$2691.Metal2 0.00778555f
Cred_11868 v_a.$1756.Metal2 v_b.$3779.Metal3 1.20277e-05f
Cred_11869 v_a.$1756.Metal2 v_b.P19.pSD 0.02928f
Cred_11870 v_a.$1756.Metal2 v_b.P21.nSD 8.61512e-05f
Cred_11871 v_a.$1756.Metal2 v_b.P21.pSD 0.0294696f
Cred_11872 v_a.$1756.Metal2 v_b.P37.nSD 1.43801e-08f
Cred_11873 v_a.$1756.Metal2 v_b.P37.pSD 7.90319e-06f
Cred_11874 v_a.$1758.Metal2 v_b.$2631.Metal2 0.123888f
Cred_11875 v_a.$1758.Metal2 v_b.$2691.Metal2 0.0409384f
Cred_11876 v_a.$1758.Metal2 v_b.$3779.Metal3 0.000188663f
Cred_11877 v_a.$1758.Metal2 v_b.P19.pSD 0.189371f
Cred_11878 v_a.$1758.Metal2 v_b.P21.nSD 0.000453005f
Cred_11879 v_a.$1758.Metal2 v_b.P21.pSD 0.190937f
Cred_11880 v_a.$1758.Metal2 v_b.P37.nSD 2.25562e-07f
Cred_11881 v_a.$1758.Metal2 v_b.P37.pSD 0.000137624f
Cred_11882 v_a.$177.Metal1 v_b.$2361.Metal2 0.00630128f
Cred_11883 v_a.$177.Metal1 v_b.$2421.Metal2 0.0189088f
Cred_11884 v_a.$177.Metal1 v_b.P3.nSD 6.9727e-05f
Cred_11885 v_a.$177.Metal1 v_b.P3.pSD 0.0347776f
Cred_11886 v_a.$177.Metal1 v_b.P5.pSD 0.0341297f
Cred_11887 v_a.$178.Metal1 v_b.$2361.Metal2 0.00594437f
Cred_11888 v_a.$178.Metal1 v_b.$2421.Metal2 0.0178529f
Cred_11889 v_a.$178.Metal1 v_b.P3.nSD 6.57776e-05f
Cred_11890 v_a.$178.Metal1 v_b.P3.pSD 0.035239f
Cred_11891 v_a.$178.Metal1 v_b.P5.pSD 0.0346392f
Cred_11892 v_a.$1790.Metal2 v_b.$2631.Metal2 0.0496689f
Cred_11893 v_a.$1790.Metal2 v_b.$2691.Metal2 0.151692f
Cred_11894 v_a.$1790.Metal2 v_b.$3779.Metal3 8.14819e-05f
Cred_11895 v_a.$1790.Metal2 v_b.P21.nSD 0.000549612f
Cred_11896 v_a.$1790.Metal2 v_b.P21.pSD 0.0280808f
Cred_11897 v_a.$1790.Metal2 v_b.P23.pSD 0.0272712f
Cred_11898 v_a.$1790.Metal2 v_b.P37.nSD 9.74179e-08f
Cred_11899 v_a.$1790.Metal2 v_b.P37.pSD 1.55592e-05f
Cred_11900 v_a.$1790.Metal2 VDD.$340.Metal1 3.05056e-07f
Cred_11901 v_a.$1790.Metal2 VDD.$388.Metal2 1.65808e-08f
Cred_11902 v_a.$1790.Metal2 VDD.$42.Metal1 7.78545e-07f
Cred_11903 v_a.$1790.Metal2 VDD.$666.Metal3 7.29978e-10f
Cred_11904 v_a.$1790.Metal2 VDD.P0.nSD 0.000365431f
Cred_11905 v_a.$1792.Metal2 v_b.$2631.Metal2 0.014276f
Cred_11906 v_a.$1792.Metal2 v_b.$2691.Metal2 0.0432742f
Cred_11907 v_a.$1792.Metal2 v_b.P21.nSD 0.000157971f
Cred_11908 v_a.$1792.Metal2 v_b.P21.pSD 0.0140606f
Cred_11909 v_a.$1792.Metal2 v_b.P23.pSD 0.0137757f
Cred_11910 v_a.$1794.Metal2 v_b.$2631.Metal2 0.0133367f
Cred_11911 v_a.$1794.Metal2 v_b.$2691.Metal2 0.0404271f
Cred_11912 v_a.$1794.Metal2 v_b.$3779.Metal3 4.21205e-06f
Cred_11913 v_a.$1794.Metal2 v_b.P21.nSD 0.000147577f
Cred_11914 v_a.$1794.Metal2 v_b.P21.pSD 0.0163557f
Cred_11915 v_a.$1794.Metal2 v_b.P23.pSD 0.0160931f
Cred_11916 v_a.$1794.Metal2 v_b.P37.nSD 5.03583e-09f
Cred_11917 v_a.$1794.Metal2 v_b.P37.pSD 1.39036e-06f
Cred_11918 v_a.$1796.Metal2 v_b.$2631.Metal2 0.0124287f
Cred_11919 v_a.$1796.Metal2 v_b.$2691.Metal2 0.037678f
Cred_11920 v_a.$1796.Metal2 v_b.P21.nSD 0.000137531f
Cred_11921 v_a.$1796.Metal2 v_b.P21.pSD 0.0182014f
Cred_11922 v_a.$1796.Metal2 v_b.P23.pSD 0.0179593f
Cred_11923 v_a.$1798.Metal2 v_b.$2631.Metal2 0.0115432f
Cred_11924 v_a.$1798.Metal2 v_b.$2691.Metal2 0.0349884f
Cred_11925 v_a.$1798.Metal2 v_b.$3779.Metal3 7.86026e-06f
Cred_11926 v_a.$1798.Metal2 v_b.P21.nSD 0.000127731f
Cred_11927 v_a.$1798.Metal2 v_b.P21.pSD 0.0195467f
Cred_11928 v_a.$1798.Metal2 v_b.P23.pSD 0.0193149f
Cred_11929 v_a.$1798.Metal2 v_b.P37.nSD 9.39754e-09f
Cred_11930 v_a.$1798.Metal2 v_b.P37.pSD 3.30063e-06f
Cred_11931 v_a.$180.Metal1 v_b.$2361.Metal2 0.0273314f
Cred_11932 v_a.$180.Metal1 v_b.$2421.Metal2 0.0821292f
Cred_11933 v_a.$180.Metal1 v_b.P3.nSD 0.000302436f
Cred_11934 v_a.$180.Metal1 v_b.P3.pSD 0.176519f
Cred_11935 v_a.$180.Metal1 v_b.P5.pSD 0.17359f
Cred_11936 v_a.$1800.Metal2 v_b.$2631.Metal2 0.0108379f
Cred_11937 v_a.$1800.Metal2 v_b.$2691.Metal2 0.0328546f
Cred_11938 v_a.$1800.Metal2 v_b.$3779.Metal3 7.79214e-06f
Cred_11939 v_a.$1800.Metal2 v_b.P21.nSD 0.000119927f
Cred_11940 v_a.$1800.Metal2 v_b.P21.pSD 0.0211116f
Cred_11941 v_a.$1800.Metal2 v_b.P23.pSD 0.0208987f
Cred_11942 v_a.$1800.Metal2 v_b.P37.nSD 9.31611e-09f
Cred_11943 v_a.$1800.Metal2 v_b.P37.pSD 3.36883e-06f
Cred_11944 v_a.$1802.Metal2 v_b.$2631.Metal2 0.0101695f
Cred_11945 v_a.$1802.Metal2 v_b.$2691.Metal2 0.0308261f
Cred_11946 v_a.$1802.Metal2 v_b.P21.nSD 0.000112531f
Cred_11947 v_a.$1802.Metal2 v_b.P21.pSD 0.0223981f
Cred_11948 v_a.$1802.Metal2 v_b.P23.pSD 0.0221945f
Cred_11949 v_a.$1804.Metal2 v_b.$2631.Metal2 0.00958629f
Cred_11950 v_a.$1804.Metal2 v_b.$2691.Metal2 0.0290494f
Cred_11951 v_a.$1804.Metal2 v_b.$3779.Metal3 1.08465e-05f
Cred_11952 v_a.$1804.Metal2 v_b.P21.nSD 0.000106077f
Cred_11953 v_a.$1804.Metal2 v_b.P21.pSD 0.0235428f
Cred_11954 v_a.$1804.Metal2 v_b.P23.pSD 0.0233366f
Cred_11955 v_a.$1804.Metal2 v_b.P37.nSD 1.29679e-08f
Cred_11956 v_a.$1804.Metal2 v_b.P37.pSD 5.80759e-06f
Cred_11957 v_a.$1806.Metal2 v_b.$2631.Metal2 0.00894001f
Cred_11958 v_a.$1806.Metal2 v_b.$2691.Metal2 0.027863f
Cred_11959 v_a.$1806.Metal2 v_b.$3779.Metal3 1.43519e-05f
Cred_11960 v_a.$1806.Metal2 v_b.P21.nSD 9.8926e-05f
Cred_11961 v_a.$1806.Metal2 v_b.P21.pSD 0.0244071f
Cred_11962 v_a.$1806.Metal2 v_b.P23.pSD 0.0252428f
Cred_11963 v_a.$1806.Metal2 v_b.P37.nSD 1.71588e-08f
Cred_11964 v_a.$1806.Metal2 v_b.P37.pSD 7.83892e-06f
Cred_11965 v_a.$1808.Metal2 v_b.$2631.Metal2 0.00865878f
Cred_11966 v_a.$1808.Metal2 v_b.$2691.Metal2 0.026244f
Cred_11967 v_a.$1808.Metal2 v_b.$3779.Metal3 1.06994e-05f
Cred_11968 v_a.$1808.Metal2 v_b.P21.nSD 9.5814e-05f
Cred_11969 v_a.$1808.Metal2 v_b.P21.pSD 0.0258351f
Cred_11970 v_a.$1808.Metal2 v_b.P23.pSD 0.0256619f
Cred_11971 v_a.$1808.Metal2 v_b.P37.nSD 1.2792e-08f
Cred_11972 v_a.$1808.Metal2 v_b.P37.pSD 5.95487e-06f
Cred_11973 v_a.$1810.Metal2 v_b.$2631.Metal2 0.00817377f
Cred_11974 v_a.$1810.Metal2 v_b.$2691.Metal2 0.0247769f
Cred_11975 v_a.$1810.Metal2 v_b.P21.nSD 9.04471e-05f
Cred_11976 v_a.$1810.Metal2 v_b.P21.pSD 0.0263081f
Cred_11977 v_a.$1810.Metal2 v_b.P23.pSD 0.0261459f
Cred_11978 v_a.$1812.Metal2 v_b.$2631.Metal2 0.00783898f
Cred_11979 v_a.$1812.Metal2 v_b.$2691.Metal2 0.023761f
Cred_11980 v_a.$1812.Metal2 v_b.$3779.Metal3 1.01129e-05f
Cred_11981 v_a.$1812.Metal2 v_b.P21.nSD 8.67425e-05f
Cred_11982 v_a.$1812.Metal2 v_b.P21.pSD 0.0271509f
Cred_11983 v_a.$1812.Metal2 v_b.P23.pSD 0.0269942f
Cred_11984 v_a.$1812.Metal2 v_b.P37.nSD 1.20908e-08f
Cred_11985 v_a.$1812.Metal2 v_b.P37.pSD 6.54211e-06f
Cred_11986 v_a.$1814.Metal2 v_b.$2631.Metal2 0.00778073f
Cred_11987 v_a.$1814.Metal2 v_b.$2691.Metal2 0.0235945f
Cred_11988 v_a.$1814.Metal2 v_b.$3779.Metal3 1.3838e-05f
Cred_11989 v_a.$1814.Metal2 v_b.P21.nSD 8.60979e-05f
Cred_11990 v_a.$1814.Metal2 v_b.P21.pSD 0.0294365f
Cred_11991 v_a.$1814.Metal2 v_b.P23.pSD 0.029313f
Cred_11992 v_a.$1814.Metal2 v_b.P37.nSD 1.65444e-08f
Cred_11993 v_a.$1814.Metal2 v_b.P37.pSD 9.09271e-06f
Cred_11994 v_a.$1816.Metal2 v_b.$2631.Metal2 0.040838f
Cred_11995 v_a.$1816.Metal2 v_b.$2691.Metal2 0.123991f
Cred_11996 v_a.$1816.Metal2 v_b.$3779.Metal3 0.000217059f
Cred_11997 v_a.$1816.Metal2 v_b.P21.nSD 0.000451895f
Cred_11998 v_a.$1816.Metal2 v_b.P21.pSD 0.190192f
Cred_11999 v_a.$1816.Metal2 v_b.P23.pSD 0.190114f
Cred_12000 v_a.$1816.Metal2 v_b.P37.nSD 2.59511e-07f
Cred_12001 v_a.$1816.Metal2 v_b.P37.pSD 0.000158337f
Cred_12002 v_a.$1848.Metal2 v_b.$2691.Metal2 0.150377f
Cred_12003 v_a.$1848.Metal2 v_b.$2751.Metal2 0.0499863f
Cred_12004 v_a.$1848.Metal2 v_b.$3779.Metal3 2.06692e-05f
Cred_12005 v_a.$1848.Metal2 v_b.P23.pSD 0.026904f
Cred_12006 v_a.$1848.Metal2 v_b.P25.nSD 0.000553125f
Cred_12007 v_a.$1848.Metal2 v_b.P25.pSD 0.0281005f
Cred_12008 v_a.$1848.Metal2 v_b.P37.nSD 2.47117e-08f
Cred_12009 v_a.$1848.Metal2 v_b.P37.pSD 4.70519e-06f
Cred_12010 v_a.$1848.Metal2 VDD.$340.Metal1 3.94083e-07f
Cred_12011 v_a.$1848.Metal2 VDD.$388.Metal2 1.29538e-08f
Cred_12012 v_a.$1848.Metal2 VDD.$42.Metal1 6.08238e-07f
Cred_12013 v_a.$1848.Metal2 VDD.$666.Metal3 5.70296e-10f
Cred_12014 v_a.$1848.Metal2 VDD.P0.nSD 0.000365241f
Cred_12015 v_a.$1850.Metal2 v_b.$2691.Metal2 0.0432735f
Cred_12016 v_a.$1850.Metal2 v_b.$2751.Metal2 0.0142766f
Cred_12017 v_a.$1850.Metal2 v_b.P23.pSD 0.0137736f
Cred_12018 v_a.$1850.Metal2 v_b.P25.nSD 0.000157978f
Cred_12019 v_a.$1850.Metal2 v_b.P25.pSD 0.0140628f
Cred_12020 v_a.$1852.Metal2 v_b.$2691.Metal2 0.0404264f
Cred_12021 v_a.$1852.Metal2 v_b.$2751.Metal2 0.0133373f
Cred_12022 v_a.$1852.Metal2 v_b.$3779.Metal3 4.95833e-06f
Cred_12023 v_a.$1852.Metal2 v_b.P23.pSD 0.0160875f
Cred_12024 v_a.$1852.Metal2 v_b.P25.nSD 0.000147584f
Cred_12025 v_a.$1852.Metal2 v_b.P25.pSD 0.0163613f
Cred_12026 v_a.$1852.Metal2 v_b.P37.nSD 5.92806e-09f
Cred_12027 v_a.$1852.Metal2 v_b.P37.pSD 1.6367e-06f
Cred_12028 v_a.$1854.Metal2 v_b.$2691.Metal2 0.0376758f
Cred_12029 v_a.$1854.Metal2 v_b.$2751.Metal2 0.0124309f
Cred_12030 v_a.$1854.Metal2 v_b.P23.pSD 0.0179515f
Cred_12031 v_a.$1854.Metal2 v_b.P25.nSD 0.000137554f
Cred_12032 v_a.$1854.Metal2 v_b.P25.pSD 0.0182092f
Cred_12033 v_a.$1856.Metal2 v_b.$2691.Metal2 0.0349888f
Cred_12034 v_a.$1856.Metal2 v_b.$2751.Metal2 0.0115427f
Cred_12035 v_a.$1856.Metal2 v_b.$3779.Metal3 9.25291e-06f
Cred_12036 v_a.$1856.Metal2 v_b.P23.pSD 0.0193146f
Cred_12037 v_a.$1856.Metal2 v_b.P25.nSD 0.000127726f
Cred_12038 v_a.$1856.Metal2 v_b.P25.pSD 0.019547f
Cred_12039 v_a.$1856.Metal2 v_b.P37.nSD 1.10626e-08f
Cred_12040 v_a.$1856.Metal2 v_b.P37.pSD 3.88543e-06f
Cred_12041 v_a.$1858.Metal2 v_b.$2691.Metal2 0.032853f
Cred_12042 v_a.$1858.Metal2 v_b.$2751.Metal2 0.0108394f
Cred_12043 v_a.$1858.Metal2 v_b.$3779.Metal3 9.17273e-06f
Cred_12044 v_a.$1858.Metal2 v_b.P23.pSD 0.0208937f
Cred_12045 v_a.$1858.Metal2 v_b.P25.nSD 0.000119944f
Cred_12046 v_a.$1858.Metal2 v_b.P25.pSD 0.0211167f
Cred_12047 v_a.$1858.Metal2 v_b.P37.nSD 1.09667e-08f
Cred_12048 v_a.$1858.Metal2 v_b.P37.pSD 3.9657e-06f
Cred_12049 v_a.$1860.Metal2 v_b.$2691.Metal2 0.0308258f
Cred_12050 v_a.$1860.Metal2 v_b.$2751.Metal2 0.0101697f
Cred_12051 v_a.$1860.Metal2 v_b.P23.pSD 0.0221936f
Cred_12052 v_a.$1860.Metal2 v_b.P25.nSD 0.000112534f
Cred_12053 v_a.$1860.Metal2 v_b.P25.pSD 0.022399f
Cred_12054 v_a.$1862.Metal2 v_b.$2691.Metal2 0.0290536f
Cred_12055 v_a.$1862.Metal2 v_b.$2751.Metal2 0.00958221f
Cred_12056 v_a.$1862.Metal2 v_b.$3779.Metal3 1.27683e-05f
Cred_12057 v_a.$1862.Metal2 v_b.P23.pSD 0.02335f
Cred_12058 v_a.$1862.Metal2 v_b.P25.nSD 0.000106032f
Cred_12059 v_a.$1862.Metal2 v_b.P25.pSD 0.0235293f
Cred_12060 v_a.$1862.Metal2 v_b.P37.nSD 1.52655e-08f
Cred_12061 v_a.$1862.Metal2 v_b.P37.pSD 6.83656e-06f
Cred_12062 v_a.$1864.Metal2 v_b.$2691.Metal2 0.027475f
Cred_12063 v_a.$1864.Metal2 v_b.$2751.Metal2 0.0093163f
Cred_12064 v_a.$1864.Metal2 v_b.$3779.Metal3 1.68948e-05f
Cred_12065 v_a.$1864.Metal2 v_b.P23.pSD 0.0242273f
Cred_12066 v_a.$1864.Metal2 v_b.P25.nSD 0.00010309f
Cred_12067 v_a.$1864.Metal2 v_b.P25.pSD 0.0254301f
Cred_12068 v_a.$1864.Metal2 v_b.P37.nSD 2.0199e-08f
Cred_12069 v_a.$1864.Metal2 v_b.P37.pSD 9.22779e-06f
Cred_12070 v_a.$1866.Metal2 v_b.$2691.Metal2 0.0262452f
Cred_12071 v_a.$1866.Metal2 v_b.$2751.Metal2 0.00865768f
Cred_12072 v_a.$1866.Metal2 v_b.$3779.Metal3 1.25951e-05f
Cred_12073 v_a.$1866.Metal2 v_b.P23.pSD 0.0256609f
Cred_12074 v_a.$1866.Metal2 v_b.P25.nSD 9.58019e-05f
Cred_12075 v_a.$1866.Metal2 v_b.P25.pSD 0.025836f
Cred_12076 v_a.$1866.Metal2 v_b.P37.nSD 1.50585e-08f
Cred_12077 v_a.$1866.Metal2 v_b.P37.pSD 7.00993e-06f
Cred_12078 v_a.$1868.Metal2 v_b.$2691.Metal2 0.0247765f
Cred_12079 v_a.$1868.Metal2 v_b.$2751.Metal2 0.00817415f
Cred_12080 v_a.$1868.Metal2 v_b.P23.pSD 0.0261438f
Cred_12081 v_a.$1868.Metal2 v_b.P25.nSD 9.04513e-05f
Cred_12082 v_a.$1868.Metal2 v_b.P25.pSD 0.0263103f
Cred_12083 v_a.$1870.Metal2 v_b.$2691.Metal2 0.0237612f
Cred_12084 v_a.$1870.Metal2 v_b.$2751.Metal2 0.00783881f
Cred_12085 v_a.$1870.Metal2 v_b.$3779.Metal3 1.19047e-05f
Cred_12086 v_a.$1870.Metal2 v_b.P23.pSD 0.0269933f
Cred_12087 v_a.$1870.Metal2 v_b.P25.nSD 8.67406e-05f
Cred_12088 v_a.$1870.Metal2 v_b.P25.pSD 0.0271518f
Cred_12089 v_a.$1870.Metal2 v_b.P37.nSD 1.4233e-08f
Cred_12090 v_a.$1870.Metal2 v_b.P37.pSD 7.70122e-06f
Cred_12091 v_a.$1872.Metal2 v_b.$2691.Metal2 0.0235896f
Cred_12092 v_a.$1872.Metal2 v_b.$2751.Metal2 0.00778555f
Cred_12093 v_a.$1872.Metal2 v_b.$3779.Metal3 1.62898e-05f
Cred_12094 v_a.$1872.Metal2 v_b.P23.pSD 0.02928f
Cred_12095 v_a.$1872.Metal2 v_b.P25.nSD 8.61512e-05f
Cred_12096 v_a.$1872.Metal2 v_b.P25.pSD 0.0294696f
Cred_12097 v_a.$1872.Metal2 v_b.P37.nSD 1.94757e-08f
Cred_12098 v_a.$1872.Metal2 v_b.P37.pSD 1.07037e-05f
Cred_12099 v_a.$1874.Metal2 v_b.$2691.Metal2 0.123888f
Cred_12100 v_a.$1874.Metal2 v_b.$2751.Metal2 0.0409384f
Cred_12101 v_a.$1874.Metal2 v_b.$3779.Metal3 0.000255517f
Cred_12102 v_a.$1874.Metal2 v_b.P23.pSD 0.189371f
Cred_12103 v_a.$1874.Metal2 v_b.P25.nSD 0.000453005f
Cred_12104 v_a.$1874.Metal2 v_b.P25.pSD 0.190937f
Cred_12105 v_a.$1874.Metal2 v_b.P37.nSD 3.0549e-07f
Cred_12106 v_a.$1874.Metal2 v_b.P37.pSD 0.000186391f
Cred_12107 v_a.$1906.Metal2 v_b.$2691.Metal2 0.0496738f
Cred_12108 v_a.$1906.Metal2 v_b.$2751.Metal2 0.151687f
Cred_12109 v_a.$1906.Metal2 v_b.$3779.Metal3 0.000116572f
Cred_12110 v_a.$1906.Metal2 v_b.P25.nSD 0.000549667f
Cred_12111 v_a.$1906.Metal2 v_b.P25.pSD 0.0280825f
Cred_12112 v_a.$1906.Metal2 v_b.P27.pSD 0.0272696f
Cred_12113 v_a.$1906.Metal2 v_b.P37.nSD 1.39371e-07f
Cred_12114 v_a.$1906.Metal2 v_b.P37.pSD 2.22598e-05f
Cred_12115 v_a.$1906.Metal2 VDD.$340.Metal1 1.72998e-06f
Cred_12116 v_a.$1906.Metal2 VDD.$388.Metal2 3.19369e-08f
Cred_12117 v_a.$1906.Metal2 VDD.$42.Metal1 1.49958e-06f
Cred_12118 v_a.$1906.Metal2 VDD.$666.Metal3 1.40603e-09f
Cred_12119 v_a.$1906.Metal2 VDD.P0.nSD 0.00119793f
Cred_12120 v_a.$1908.Metal2 v_b.$2691.Metal2 0.014276f
Cred_12121 v_a.$1908.Metal2 v_b.$2751.Metal2 0.0432742f
Cred_12122 v_a.$1908.Metal2 v_b.P25.nSD 0.000157971f
Cred_12123 v_a.$1908.Metal2 v_b.P25.pSD 0.0140606f
Cred_12124 v_a.$1908.Metal2 v_b.P27.pSD 0.0137757f
Cred_12125 v_a.$1910.Metal2 v_b.$2691.Metal2 0.0133367f
Cred_12126 v_a.$1910.Metal2 v_b.$2751.Metal2 0.0404271f
Cred_12127 v_a.$1910.Metal2 v_b.$3779.Metal3 6.02598e-06f
Cred_12128 v_a.$1910.Metal2 v_b.P25.nSD 0.000147577f
Cred_12129 v_a.$1910.Metal2 v_b.P25.pSD 0.0163557f
Cred_12130 v_a.$1910.Metal2 v_b.P27.pSD 0.0160931f
Cred_12131 v_a.$1910.Metal2 v_b.P37.nSD 7.20452e-09f
Cred_12132 v_a.$1910.Metal2 v_b.P37.pSD 1.98912e-06f
Cred_12133 v_a.$1912.Metal2 v_b.$2691.Metal2 0.0124287f
Cred_12134 v_a.$1912.Metal2 v_b.$2751.Metal2 0.037678f
Cred_12135 v_a.$1912.Metal2 v_b.P25.nSD 0.000137531f
Cred_12136 v_a.$1912.Metal2 v_b.P25.pSD 0.0182014f
Cred_12137 v_a.$1912.Metal2 v_b.P27.pSD 0.0179593f
Cred_12138 v_a.$1914.Metal2 v_b.$2691.Metal2 0.0115432f
Cred_12139 v_a.$1914.Metal2 v_b.$2751.Metal2 0.0349884f
Cred_12140 v_a.$1914.Metal2 v_b.$3779.Metal3 1.12453e-05f
Cred_12141 v_a.$1914.Metal2 v_b.P25.nSD 0.000127731f
Cred_12142 v_a.$1914.Metal2 v_b.P25.pSD 0.0195467f
Cred_12143 v_a.$1914.Metal2 v_b.P27.pSD 0.0193149f
Cred_12144 v_a.$1914.Metal2 v_b.P37.nSD 1.34446e-08f
Cred_12145 v_a.$1914.Metal2 v_b.P37.pSD 4.72205e-06f
Cred_12146 v_a.$1916.Metal2 v_b.$2691.Metal2 0.0108379f
Cred_12147 v_a.$1916.Metal2 v_b.$2751.Metal2 0.0328546f
Cred_12148 v_a.$1916.Metal2 v_b.$3779.Metal3 1.11478e-05f
Cred_12149 v_a.$1916.Metal2 v_b.P25.nSD 0.000119927f
Cred_12150 v_a.$1916.Metal2 v_b.P25.pSD 0.0211116f
Cred_12151 v_a.$1916.Metal2 v_b.P27.pSD 0.0208987f
Cred_12152 v_a.$1916.Metal2 v_b.P37.nSD 1.33281e-08f
Cred_12153 v_a.$1916.Metal2 v_b.P37.pSD 4.81962e-06f
Cred_12154 v_a.$1918.Metal2 v_b.$2691.Metal2 0.0101695f
Cred_12155 v_a.$1918.Metal2 v_b.$2751.Metal2 0.0308261f
Cred_12156 v_a.$1918.Metal2 v_b.P25.nSD 0.000112531f
Cred_12157 v_a.$1918.Metal2 v_b.P25.pSD 0.0223981f
Cred_12158 v_a.$1918.Metal2 v_b.P27.pSD 0.0221945f
Cred_12159 v_a.$1920.Metal2 v_b.$2691.Metal2 0.00958629f
Cred_12160 v_a.$1920.Metal2 v_b.$2751.Metal2 0.0290494f
Cred_12161 v_a.$1920.Metal2 v_b.$3779.Metal3 1.55176e-05f
Cred_12162 v_a.$1920.Metal2 v_b.P25.nSD 0.000106077f
Cred_12163 v_a.$1920.Metal2 v_b.P25.pSD 0.0235428f
Cred_12164 v_a.$1920.Metal2 v_b.P27.pSD 0.0233366f
Cred_12165 v_a.$1920.Metal2 v_b.P37.nSD 1.85525e-08f
Cred_12166 v_a.$1920.Metal2 v_b.P37.pSD 8.30864e-06f
Cred_12167 v_a.$1922.Metal2 v_b.$2691.Metal2 0.00894001f
Cred_12168 v_a.$1922.Metal2 v_b.$2751.Metal2 0.027863f
Cred_12169 v_a.$1922.Metal2 v_b.$3779.Metal3 2.05326e-05f
Cred_12170 v_a.$1922.Metal2 v_b.P25.nSD 9.8926e-05f
Cred_12171 v_a.$1922.Metal2 v_b.P25.pSD 0.0244071f
Cred_12172 v_a.$1922.Metal2 v_b.P27.pSD 0.0252428f
Cred_12173 v_a.$1922.Metal2 v_b.P37.nSD 2.45483e-08f
Cred_12174 v_a.$1922.Metal2 v_b.P37.pSD 1.12148e-05f
Cred_12175 v_a.$1924.Metal2 v_b.$2691.Metal2 0.00865878f
Cred_12176 v_a.$1924.Metal2 v_b.$2751.Metal2 0.026244f
Cred_12177 v_a.$1924.Metal2 v_b.$3779.Metal3 1.53072e-05f
Cred_12178 v_a.$1924.Metal2 v_b.P25.nSD 9.5814e-05f
Cred_12179 v_a.$1924.Metal2 v_b.P25.pSD 0.0258351f
Cred_12180 v_a.$1924.Metal2 v_b.P27.pSD 0.0256619f
Cred_12181 v_a.$1924.Metal2 v_b.P37.nSD 1.83009e-08f
Cred_12182 v_a.$1924.Metal2 v_b.P37.pSD 8.51934e-06f
Cred_12183 v_a.$1926.Metal2 v_b.$2691.Metal2 0.00817377f
Cred_12184 v_a.$1926.Metal2 v_b.$2751.Metal2 0.0247769f
Cred_12185 v_a.$1926.Metal2 v_b.P25.nSD 9.04471e-05f
Cred_12186 v_a.$1926.Metal2 v_b.P25.pSD 0.0263081f
Cred_12187 v_a.$1926.Metal2 v_b.P27.pSD 0.0261459f
Cred_12188 v_a.$1928.Metal2 v_b.$2691.Metal2 0.00783898f
Cred_12189 v_a.$1928.Metal2 v_b.$2751.Metal2 0.023761f
Cred_12190 v_a.$1928.Metal2 v_b.$3779.Metal3 1.4468e-05f
Cred_12191 v_a.$1928.Metal2 v_b.P25.nSD 8.67425e-05f
Cred_12192 v_a.$1928.Metal2 v_b.P25.pSD 0.0271509f
Cred_12193 v_a.$1928.Metal2 v_b.P27.pSD 0.0269942f
Cred_12194 v_a.$1928.Metal2 v_b.P37.nSD 1.72977e-08f
Cred_12195 v_a.$1928.Metal2 v_b.P37.pSD 9.35948e-06f
Cred_12196 v_a.$1930.Metal2 v_b.$2691.Metal2 0.00778073f
Cred_12197 v_a.$1930.Metal2 v_b.$2751.Metal2 0.0235945f
Cred_12198 v_a.$1930.Metal2 v_b.$3779.Metal3 1.97974e-05f
Cred_12199 v_a.$1930.Metal2 v_b.P25.nSD 8.60979e-05f
Cred_12200 v_a.$1930.Metal2 v_b.P25.pSD 0.0294365f
Cred_12201 v_a.$1930.Metal2 v_b.P27.pSD 0.029313f
Cred_12202 v_a.$1930.Metal2 v_b.P37.nSD 2.36693e-08f
Cred_12203 v_a.$1930.Metal2 v_b.P37.pSD 1.30085e-05f
Cred_12204 v_a.$1932.Metal2 v_b.$2691.Metal2 0.040838f
Cred_12205 v_a.$1932.Metal2 v_b.$2751.Metal2 0.123991f
Cred_12206 v_a.$1932.Metal2 v_b.$3779.Metal3 0.000310536f
Cred_12207 v_a.$1932.Metal2 v_b.P25.nSD 0.000451895f
Cred_12208 v_a.$1932.Metal2 v_b.P25.pSD 0.190192f
Cred_12209 v_a.$1932.Metal2 v_b.P27.pSD 0.190114f
Cred_12210 v_a.$1932.Metal2 v_b.P37.nSD 3.7127e-07f
Cred_12211 v_a.$1932.Metal2 v_b.P37.pSD 0.000226526f
Cred_12212 v_a.$1964.Metal2 v_b.$2751.Metal2 0.15112f
Cred_12213 v_a.$1964.Metal2 v_b.$2811.Metal2 0.0502238f
Cred_12214 v_a.$1964.Metal2 v_b.$3779.Metal3 0.000148561f
Cred_12215 v_a.$1964.Metal2 v_b.P27.pSD 0.0270836f
Cred_12216 v_a.$1964.Metal2 v_b.P29.nSD 0.000555753f
Cred_12217 v_a.$1964.Metal2 v_b.P29.pSD 0.0282795f
Cred_12218 v_a.$1964.Metal2 v_b.P37.nSD 1.77616e-07f
Cred_12219 v_a.$1964.Metal2 v_b.P37.pSD 2.83682e-05f
Cred_12220 v_a.$1964.Metal2 VDD.$340.Metal1 6.4916e-07f
Cred_12221 v_a.$1964.Metal2 VDD.$388.Metal2 7.84276e-09f
Cred_12222 v_a.$1964.Metal2 VDD.$42.Metal1 3.68252e-07f
Cred_12223 v_a.$1964.Metal2 VDD.$666.Metal3 3.45281e-10f
Cred_12224 v_a.$1964.Metal2 VDD.P0.nSD 0.000365506f
Cred_12225 v_a.$1966.Metal2 v_b.$2751.Metal2 0.0432735f
Cred_12226 v_a.$1966.Metal2 v_b.$2811.Metal2 0.0142766f
Cred_12227 v_a.$1966.Metal2 v_b.P27.pSD 0.0137736f
Cred_12228 v_a.$1966.Metal2 v_b.P29.nSD 0.000157978f
Cred_12229 v_a.$1966.Metal2 v_b.P29.pSD 0.0140628f
Cred_12230 v_a.$1968.Metal2 v_b.$2751.Metal2 0.0404264f
Cred_12231 v_a.$1968.Metal2 v_b.$2811.Metal2 0.0133373f
Cred_12232 v_a.$1968.Metal2 v_b.$3779.Metal3 7.67959e-06f
Cred_12233 v_a.$1968.Metal2 v_b.P27.pSD 0.0160875f
Cred_12234 v_a.$1968.Metal2 v_b.P29.nSD 0.000147584f
Cred_12235 v_a.$1968.Metal2 v_b.P29.pSD 0.0163613f
Cred_12236 v_a.$1968.Metal2 v_b.P37.nSD 9.18154e-09f
Cred_12237 v_a.$1968.Metal2 v_b.P37.pSD 2.53496e-06f
Cred_12238 v_a.$1970.Metal2 v_b.$2751.Metal2 0.0376758f
Cred_12239 v_a.$1970.Metal2 v_b.$2811.Metal2 0.0124309f
Cred_12240 v_a.$1970.Metal2 v_b.P27.pSD 0.0179515f
Cred_12241 v_a.$1970.Metal2 v_b.P29.nSD 0.000137554f
Cred_12242 v_a.$1970.Metal2 v_b.P29.pSD 0.0182092f
Cred_12243 v_a.$1972.Metal2 v_b.$2751.Metal2 0.0349888f
Cred_12244 v_a.$1972.Metal2 v_b.$2811.Metal2 0.0115427f
Cred_12245 v_a.$1972.Metal2 v_b.$3779.Metal3 1.43312e-05f
Cred_12246 v_a.$1972.Metal2 v_b.P27.pSD 0.0193146f
Cred_12247 v_a.$1972.Metal2 v_b.P29.nSD 0.000127726f
Cred_12248 v_a.$1972.Metal2 v_b.P29.pSD 0.019547f
Cred_12249 v_a.$1972.Metal2 v_b.P37.nSD 1.7134e-08f
Cred_12250 v_a.$1972.Metal2 v_b.P37.pSD 6.01786e-06f
Cred_12251 v_a.$1974.Metal2 v_b.$2751.Metal2 0.032853f
Cred_12252 v_a.$1974.Metal2 v_b.$2811.Metal2 0.0108394f
Cred_12253 v_a.$1974.Metal2 v_b.$3779.Metal3 1.4207e-05f
Cred_12254 v_a.$1974.Metal2 v_b.P27.pSD 0.0208937f
Cred_12255 v_a.$1974.Metal2 v_b.P29.nSD 0.000119944f
Cred_12256 v_a.$1974.Metal2 v_b.P29.pSD 0.0211167f
Cred_12257 v_a.$1974.Metal2 v_b.P37.nSD 1.69855e-08f
Cred_12258 v_a.$1974.Metal2 v_b.P37.pSD 6.14219e-06f
Cred_12259 v_a.$1976.Metal2 v_b.$2751.Metal2 0.0308258f
Cred_12260 v_a.$1976.Metal2 v_b.$2811.Metal2 0.0101697f
Cred_12261 v_a.$1976.Metal2 v_b.P27.pSD 0.0221936f
Cred_12262 v_a.$1976.Metal2 v_b.P29.nSD 0.000112534f
Cred_12263 v_a.$1976.Metal2 v_b.P29.pSD 0.022399f
Cred_12264 v_a.$1978.Metal2 v_b.$2751.Metal2 0.0290536f
Cred_12265 v_a.$1978.Metal2 v_b.$2811.Metal2 0.00958221f
Cred_12266 v_a.$1978.Metal2 v_b.$3779.Metal3 1.97759e-05f
Cred_12267 v_a.$1978.Metal2 v_b.P27.pSD 0.02335f
Cred_12268 v_a.$1978.Metal2 v_b.P29.nSD 0.000106032f
Cred_12269 v_a.$1978.Metal2 v_b.P29.pSD 0.0235293f
Cred_12270 v_a.$1978.Metal2 v_b.P37.nSD 2.36436e-08f
Cred_12271 v_a.$1978.Metal2 v_b.P37.pSD 1.05886e-05f
Cred_12272 v_a.$1980.Metal2 v_b.$2751.Metal2 0.0273605f
Cred_12273 v_a.$1980.Metal2 v_b.$2811.Metal2 0.009278f
Cred_12274 v_a.$1980.Metal2 v_b.$3779.Metal3 2.61671e-05f
Cred_12275 v_a.$1980.Metal2 v_b.P27.pSD 0.0240299f
Cred_12276 v_a.$1980.Metal2 v_b.P29.nSD 0.000102666f
Cred_12277 v_a.$1980.Metal2 v_b.P29.pSD 0.0252279f
Cred_12278 v_a.$1980.Metal2 v_b.P37.nSD 3.12847e-08f
Cred_12279 v_a.$1980.Metal2 v_b.P37.pSD 1.42922e-05f
Cred_12280 v_a.$1982.Metal2 v_b.$2751.Metal2 0.0260306f
Cred_12281 v_a.$1982.Metal2 v_b.$2811.Metal2 0.00858592f
Cred_12282 v_a.$1982.Metal2 v_b.$3779.Metal3 1.95077e-05f
Cred_12283 v_a.$1982.Metal2 v_b.P27.pSD 0.0252924f
Cred_12284 v_a.$1982.Metal2 v_b.P29.nSD 9.50077e-05f
Cred_12285 v_a.$1982.Metal2 v_b.P29.pSD 0.0254585f
Cred_12286 v_a.$1982.Metal2 v_b.P37.nSD 2.33229e-08f
Cred_12287 v_a.$1982.Metal2 v_b.P37.pSD 1.08572e-05f
Cred_12288 v_a.$1984.Metal2 v_b.$2751.Metal2 0.0248341f
Cred_12289 v_a.$1984.Metal2 v_b.$2811.Metal2 0.00819341f
Cred_12290 v_a.$1984.Metal2 v_b.P27.pSD 0.026247f
Cred_12291 v_a.$1984.Metal2 v_b.P29.nSD 9.06645e-05f
Cred_12292 v_a.$1984.Metal2 v_b.P29.pSD 0.0264161f
Cred_12293 v_a.$1986.Metal2 v_b.$2751.Metal2 0.0237477f
Cred_12294 v_a.$1986.Metal2 v_b.$2811.Metal2 0.00783433f
Cred_12295 v_a.$1986.Metal2 v_b.$3779.Metal3 1.84383e-05f
Cred_12296 v_a.$1986.Metal2 v_b.P27.pSD 0.0269715f
Cred_12297 v_a.$1986.Metal2 v_b.P29.nSD 8.6691e-05f
Cred_12298 v_a.$1986.Metal2 v_b.P29.pSD 0.0271295f
Cred_12299 v_a.$1986.Metal2 v_b.P37.nSD 2.20444e-08f
Cred_12300 v_a.$1986.Metal2 v_b.P37.pSD 1.19279e-05f
Cred_12301 v_a.$1988.Metal2 v_b.$2751.Metal2 0.0227998f
Cred_12302 v_a.$1988.Metal2 v_b.$2811.Metal2 0.00752209f
Cred_12303 v_a.$1988.Metal2 v_b.$3779.Metal3 2.44529e-05f
Cred_12304 v_a.$1988.Metal2 v_b.P27.pSD 0.0276023f
Cred_12305 v_a.$1988.Metal2 v_b.P29.nSD 8.32359e-05f
Cred_12306 v_a.$1988.Metal2 v_b.P29.pSD 0.0277565f
Cred_12307 v_a.$1988.Metal2 v_b.P37.nSD 2.92353e-08f
Cred_12308 v_a.$1988.Metal2 v_b.P37.pSD 1.60085e-05f
Cred_12309 v_a.$1990.Metal2 v_b.$2751.Metal2 0.1191f
Cred_12310 v_a.$1990.Metal2 v_b.$2811.Metal2 0.0394153f
Cred_12311 v_a.$1990.Metal2 v_b.$3779.Metal3 0.000391631f
Cred_12312 v_a.$1990.Metal2 v_b.P27.pSD 0.178888f
Cred_12313 v_a.$1990.Metal2 v_b.P29.nSD 0.000436151f
Cred_12314 v_a.$1990.Metal2 v_b.P29.pSD 0.181032f
Cred_12315 v_a.$1990.Metal2 v_b.P37.nSD 4.68225e-07f
Cred_12316 v_a.$1990.Metal2 v_b.P37.pSD 0.000285667f
Cred_12317 v_a.$2022.Metal2 v_b.$2751.Metal2 0.0493943f
Cred_12318 v_a.$2022.Metal2 v_b.$2811.Metal2 0.150917f
Cred_12319 v_a.$2022.Metal2 v_b.$3779.Metal3 4.41204e-05f
Cred_12320 v_a.$2022.Metal2 v_b.P29.nSD 0.000546574f
Cred_12321 v_a.$2022.Metal2 v_b.P29.pSD 0.0278028f
Cred_12322 v_a.$2022.Metal2 v_b.P31.pSD 0.0270833f
Cred_12323 v_a.$2022.Metal2 v_b.P37.nSD 5.27493e-08f
Cred_12324 v_a.$2022.Metal2 v_b.P37.pSD 1.00437e-05f
Cred_12325 v_a.$2022.Metal2 VDD.$340.Metal1 8.31051e-07f
Cred_12326 v_a.$2022.Metal2 VDD.$388.Metal2 6.06189e-09f
Cred_12327 v_a.$2022.Metal2 VDD.$42.Metal1 2.84633e-07f
Cred_12328 v_a.$2022.Metal2 VDD.$666.Metal3 2.66877e-10f
Cred_12329 v_a.$2022.Metal2 VDD.P0.nSD 0.000365135f
Cred_12330 v_a.$2024.Metal2 v_b.$2751.Metal2 0.0142739f
Cred_12331 v_a.$2024.Metal2 v_b.$2811.Metal2 0.0432709f
Cred_12332 v_a.$2024.Metal2 v_b.P29.nSD 0.000157949f
Cred_12333 v_a.$2024.Metal2 v_b.P29.pSD 0.0140539f
Cred_12334 v_a.$2024.Metal2 v_b.P31.pSD 0.0137736f
Cred_12335 v_a.$2026.Metal2 v_b.$2751.Metal2 0.0133304f
Cred_12336 v_a.$2026.Metal2 v_b.$2811.Metal2 0.0404168f
Cred_12337 v_a.$2026.Metal2 v_b.$3779.Metal3 1.0584e-05f
Cred_12338 v_a.$2026.Metal2 v_b.P29.nSD 0.000147508f
Cred_12339 v_a.$2026.Metal2 v_b.P29.pSD 0.016333f
Cred_12340 v_a.$2026.Metal2 v_b.P31.pSD 0.0160859f
Cred_12341 v_a.$2026.Metal2 v_b.P37.nSD 1.2654e-08f
Cred_12342 v_a.$2026.Metal2 v_b.P37.pSD 3.49367e-06f
Cred_12343 v_a.$2028.Metal2 v_b.$2751.Metal2 0.0124221f
Cred_12344 v_a.$2028.Metal2 v_b.$2811.Metal2 0.037667f
Cred_12345 v_a.$2028.Metal2 v_b.P29.nSD 0.000137457f
Cred_12346 v_a.$2028.Metal2 v_b.P29.pSD 0.0181767f
Cred_12347 v_a.$2028.Metal2 v_b.P31.pSD 0.0179515f
Cred_12348 v_a.$2030.Metal2 v_b.$2751.Metal2 0.011542f
Cred_12349 v_a.$2030.Metal2 v_b.$2811.Metal2 0.0349865f
Cred_12350 v_a.$2030.Metal2 v_b.$3779.Metal3 1.97512e-05f
Cred_12351 v_a.$2030.Metal2 v_b.P29.nSD 0.000127718f
Cred_12352 v_a.$2030.Metal2 v_b.P29.pSD 0.019542f
Cred_12353 v_a.$2030.Metal2 v_b.P31.pSD 0.0193134f
Cred_12354 v_a.$2030.Metal2 v_b.P37.nSD 2.3614e-08f
Cred_12355 v_a.$2030.Metal2 v_b.P37.pSD 8.29379e-06f
Cred_12356 v_a.$2032.Metal2 v_b.$2751.Metal2 0.0108352f
Cred_12357 v_a.$2032.Metal2 v_b.$2811.Metal2 0.0328501f
Cred_12358 v_a.$2032.Metal2 v_b.$3779.Metal3 1.958e-05f
Cred_12359 v_a.$2032.Metal2 v_b.P29.nSD 0.000119897f
Cred_12360 v_a.$2032.Metal2 v_b.P29.pSD 0.0211003f
Cred_12361 v_a.$2032.Metal2 v_b.P31.pSD 0.0208952f
Cred_12362 v_a.$2032.Metal2 v_b.P37.nSD 2.34094e-08f
Cred_12363 v_a.$2032.Metal2 v_b.P37.pSD 8.46515e-06f
Cred_12364 v_a.$2034.Metal2 v_b.$2751.Metal2 0.0101673f
Cred_12365 v_a.$2034.Metal2 v_b.$2811.Metal2 0.0308225f
Cred_12366 v_a.$2034.Metal2 v_b.P29.nSD 0.000112507f
Cred_12367 v_a.$2034.Metal2 v_b.P29.pSD 0.0223881f
Cred_12368 v_a.$2034.Metal2 v_b.P31.pSD 0.0221913f
Cred_12369 v_a.$2036.Metal2 v_b.$2751.Metal2 0.00958562f
Cred_12370 v_a.$2036.Metal2 v_b.$2811.Metal2 0.0290483f
Cred_12371 v_a.$2036.Metal2 v_b.$3779.Metal3 2.72551e-05f
Cred_12372 v_a.$2036.Metal2 v_b.P29.nSD 0.00010607f
Cred_12373 v_a.$2036.Metal2 v_b.P29.pSD 0.0235397f
Cred_12374 v_a.$2036.Metal2 v_b.P31.pSD 0.0233356f
Cred_12375 v_a.$2036.Metal2 v_b.P37.nSD 3.25856e-08f
Cred_12376 v_a.$2036.Metal2 v_b.P37.pSD 1.45932e-05f
Cred_12377 v_a.$2038.Metal2 v_b.$2751.Metal2 0.00893488f
Cred_12378 v_a.$2038.Metal2 v_b.$2811.Metal2 0.0278546f
Cred_12379 v_a.$2038.Metal2 v_b.$3779.Metal3 3.60634e-05f
Cred_12380 v_a.$2038.Metal2 v_b.P29.nSD 9.88692e-05f
Cred_12381 v_a.$2038.Metal2 v_b.P29.pSD 0.0243805f
Cred_12382 v_a.$2038.Metal2 v_b.P31.pSD 0.0252344f
Cred_12383 v_a.$2038.Metal2 v_b.P37.nSD 4.31165e-08f
Cred_12384 v_a.$2038.Metal2 v_b.P37.pSD 1.96975e-05f
Cred_12385 v_a.$2040.Metal2 v_b.$2751.Metal2 0.00865377f
Cred_12386 v_a.$2040.Metal2 v_b.$2811.Metal2 0.0262358f
Cred_12387 v_a.$2040.Metal2 v_b.$3779.Metal3 2.68854e-05f
Cred_12388 v_a.$2040.Metal2 v_b.P29.nSD 9.57585e-05f
Cred_12389 v_a.$2040.Metal2 v_b.P29.pSD 0.0258085f
Cred_12390 v_a.$2040.Metal2 v_b.P31.pSD 0.0256535f
Cred_12391 v_a.$2040.Metal2 v_b.P37.nSD 3.21436e-08f
Cred_12392 v_a.$2040.Metal2 v_b.P37.pSD 1.49633e-05f
Cred_12393 v_a.$2042.Metal2 v_b.$2751.Metal2 0.00817259f
Cred_12394 v_a.$2042.Metal2 v_b.$2811.Metal2 0.0247749f
Cred_12395 v_a.$2042.Metal2 v_b.P29.nSD 9.0434e-05f
Cred_12396 v_a.$2042.Metal2 v_b.P29.pSD 0.0263013f
Cred_12397 v_a.$2042.Metal2 v_b.P31.pSD 0.0261438f
Cred_12398 v_a.$2044.Metal2 v_b.$2751.Metal2 0.00783702f
Cred_12399 v_a.$2044.Metal2 v_b.$2811.Metal2 0.0237577f
Cred_12400 v_a.$2044.Metal2 v_b.$3779.Metal3 2.54116e-05f
Cred_12401 v_a.$2044.Metal2 v_b.P29.nSD 8.67208e-05f
Cred_12402 v_a.$2044.Metal2 v_b.P29.pSD 0.0271393f
Cred_12403 v_a.$2044.Metal2 v_b.P31.pSD 0.0269905f
Cred_12404 v_a.$2044.Metal2 v_b.P37.nSD 3.03815e-08f
Cred_12405 v_a.$2044.Metal2 v_b.P37.pSD 1.64389e-05f
Cred_12406 v_a.$2046.Metal2 v_b.$2751.Metal2 0.00778146f
Cred_12407 v_a.$2046.Metal2 v_b.$2811.Metal2 0.0235899f
Cred_12408 v_a.$2046.Metal2 v_b.$3779.Metal3 3.4772e-05f
Cred_12409 v_a.$2046.Metal2 v_b.P29.nSD 8.6106e-05f
Cred_12410 v_a.$2046.Metal2 v_b.P29.pSD 0.0294439f
Cred_12411 v_a.$2046.Metal2 v_b.P31.pSD 0.0292952f
Cred_12412 v_a.$2046.Metal2 v_b.P37.nSD 4.15726e-08f
Cred_12413 v_a.$2046.Metal2 v_b.P37.pSD 2.28481e-05f
Cred_12414 v_a.$2048.Metal2 v_b.$2751.Metal2 0.0409343f
Cred_12415 v_a.$2048.Metal2 v_b.$2811.Metal2 0.123983f
Cred_12416 v_a.$2048.Metal2 v_b.$3779.Metal3 0.000545424f
Cred_12417 v_a.$2048.Metal2 v_b.P29.nSD 0.00045296f
Cred_12418 v_a.$2048.Metal2 v_b.P29.pSD 0.190892f
Cred_12419 v_a.$2048.Metal2 v_b.P31.pSD 0.189752f
Cred_12420 v_a.$2048.Metal2 v_b.P37.nSD 6.52097e-07f
Cred_12421 v_a.$2048.Metal2 v_b.P37.pSD 0.000397869f
Cred_12422 v_a.$2080.Metal2 v_b.$2811.Metal2 0.15116f
Cred_12423 v_a.$2080.Metal2 v_b.$2871.Metal2 0.0502203f
Cred_12424 v_a.$2080.Metal2 v_b.$3779.Metal3 0.000357425f
Cred_12425 v_a.$2080.Metal2 v_b.P31.pSD 0.0271822f
Cred_12426 v_a.$2080.Metal2 v_b.P33.nSD 0.000555714f
Cred_12427 v_a.$2080.Metal2 v_b.P33.pSD 0.0282728f
Cred_12428 v_a.$2080.Metal2 v_b.P37.nSD 4.27329e-07f
Cred_12429 v_a.$2080.Metal2 v_b.P37.pSD 6.91794e-05f
Cred_12430 v_a.$2080.Metal2 VDD.$340.Metal1 1.06935e-06f
Cred_12431 v_a.$2080.Metal2 VDD.$388.Metal2 4.69248e-09f
Cred_12432 v_a.$2080.Metal2 VDD.$42.Metal1 2.20333e-07f
Cred_12433 v_a.$2080.Metal2 VDD.$666.Metal3 2.06588e-10f
Cred_12434 v_a.$2080.Metal2 VDD.P0.nSD 0.000365237f
Cred_12435 v_a.$2082.Metal2 v_b.$2811.Metal2 0.0432786f
Cred_12436 v_a.$2082.Metal2 v_b.$2871.Metal2 0.0142763f
Cred_12437 v_a.$2082.Metal2 v_b.P31.pSD 0.0137824f
Cred_12438 v_a.$2082.Metal2 v_b.P33.nSD 0.000157975f
Cred_12439 v_a.$2082.Metal2 v_b.P33.pSD 0.0140617f
Cred_12440 v_a.$2084.Metal2 v_b.$2811.Metal2 0.0404394f
Cred_12441 v_a.$2084.Metal2 v_b.$2871.Metal2 0.0133363f
Cred_12442 v_a.$2084.Metal2 v_b.$3779.Metal3 2.02924e-05f
Cred_12443 v_a.$2084.Metal2 v_b.P31.pSD 0.0161156f
Cred_12444 v_a.$2084.Metal2 v_b.P33.nSD 0.000147573f
Cred_12445 v_a.$2084.Metal2 v_b.P33.pSD 0.0163577f
Cred_12446 v_a.$2084.Metal2 v_b.P37.nSD 2.42611e-08f
Cred_12447 v_a.$2084.Metal2 v_b.P37.pSD 6.69833e-06f
Cred_12448 v_a.$2086.Metal2 v_b.$2811.Metal2 0.0376926f
Cred_12449 v_a.$2086.Metal2 v_b.$2871.Metal2 0.0124298f
Cred_12450 v_a.$2086.Metal2 v_b.P31.pSD 0.0179839f
Cred_12451 v_a.$2086.Metal2 v_b.P33.nSD 0.000137542f
Cred_12452 v_a.$2086.Metal2 v_b.P33.pSD 0.0182053f
Cred_12453 v_a.$2088.Metal2 v_b.$2811.Metal2 0.0349879f
Cred_12454 v_a.$2088.Metal2 v_b.$2871.Metal2 0.0115418f
Cred_12455 v_a.$2088.Metal2 v_b.$3779.Metal3 3.78684e-05f
Cred_12456 v_a.$2088.Metal2 v_b.P31.pSD 0.0193183f
Cred_12457 v_a.$2088.Metal2 v_b.P33.nSD 0.000127716f
Cred_12458 v_a.$2088.Metal2 v_b.P33.pSD 0.0195449f
Cred_12459 v_a.$2088.Metal2 v_b.P37.nSD 4.52746e-08f
Cred_12460 v_a.$2088.Metal2 v_b.P37.pSD 1.59015e-05f
Cred_12461 v_a.$2090.Metal2 v_b.$2811.Metal2 0.0328567f
Cred_12462 v_a.$2090.Metal2 v_b.$2871.Metal2 0.0108375f
Cred_12463 v_a.$2090.Metal2 v_b.$3779.Metal3 3.75402e-05f
Cred_12464 v_a.$2090.Metal2 v_b.P31.pSD 0.0209072f
Cred_12465 v_a.$2090.Metal2 v_b.P33.nSD 0.000119923f
Cred_12466 v_a.$2090.Metal2 v_b.P33.pSD 0.0211121f
Cred_12467 v_a.$2090.Metal2 v_b.P37.nSD 4.48822e-08f
Cred_12468 v_a.$2090.Metal2 v_b.P37.pSD 1.623e-05f
Cred_12469 v_a.$2092.Metal2 v_b.$2811.Metal2 0.0308313f
Cred_12470 v_a.$2092.Metal2 v_b.$2871.Metal2 0.0101694f
Cred_12471 v_a.$2092.Metal2 v_b.P31.pSD 0.0222067f
Cred_12472 v_a.$2092.Metal2 v_b.P33.nSD 0.00011253f
Cred_12473 v_a.$2092.Metal2 v_b.P33.pSD 0.0223974f
Cred_12474 v_a.$2094.Metal2 v_b.$2811.Metal2 0.0290496f
Cred_12475 v_a.$2094.Metal2 v_b.$2871.Metal2 0.0095821f
Cred_12476 v_a.$2094.Metal2 v_b.$3779.Metal3 5.22555e-05f
Cred_12477 v_a.$2094.Metal2 v_b.P31.pSD 0.0233468f
Cred_12478 v_a.$2094.Metal2 v_b.P33.nSD 0.000106031f
Cred_12479 v_a.$2094.Metal2 v_b.P33.pSD 0.0235288f
Cred_12480 v_a.$2094.Metal2 v_b.P37.nSD 6.24754e-08f
Cred_12481 v_a.$2094.Metal2 v_b.P37.pSD 2.79792e-05f
Cred_12482 v_a.$2096.Metal2 v_b.$2811.Metal2 0.0273599f
Cred_12483 v_a.$2096.Metal2 v_b.$2871.Metal2 0.00927757f
Cred_12484 v_a.$2096.Metal2 v_b.$3779.Metal3 6.91433e-05f
Cred_12485 v_a.$2096.Metal2 v_b.P31.pSD 0.0240383f
Cred_12486 v_a.$2096.Metal2 v_b.P33.nSD 0.000102661f
Cred_12487 v_a.$2096.Metal2 v_b.P33.pSD 0.0252257f
Cred_12488 v_a.$2096.Metal2 v_b.P37.nSD 8.26662e-08f
Cred_12489 v_a.$2096.Metal2 v_b.P37.pSD 3.77656e-05f
Cred_12490 v_a.$2098.Metal2 v_b.$2811.Metal2 0.0260264f
Cred_12491 v_a.$2098.Metal2 v_b.$2871.Metal2 0.00858584f
Cred_12492 v_a.$2098.Metal2 v_b.$3779.Metal3 5.15468e-05f
Cred_12493 v_a.$2098.Metal2 v_b.P31.pSD 0.0252886f
Cred_12494 v_a.$2098.Metal2 v_b.P33.nSD 9.50069e-05f
Cred_12495 v_a.$2098.Metal2 v_b.P33.pSD 0.025458f
Cred_12496 v_a.$2098.Metal2 v_b.P37.nSD 6.16281e-08f
Cred_12497 v_a.$2098.Metal2 v_b.P37.pSD 2.86888e-05f
Cred_12498 v_a.$2100.Metal2 v_b.$2811.Metal2 0.0248401f
Cred_12499 v_a.$2100.Metal2 v_b.$2871.Metal2 0.00819303f
Cred_12500 v_a.$2100.Metal2 v_b.P31.pSD 0.0262648f
Cred_12501 v_a.$2100.Metal2 v_b.P33.nSD 9.06602e-05f
Cred_12502 v_a.$2100.Metal2 v_b.P33.pSD 0.0264139f
Cred_12503 v_a.$2102.Metal2 v_b.$2811.Metal2 0.0237481f
Cred_12504 v_a.$2102.Metal2 v_b.$2871.Metal2 0.00783331f
Cred_12505 v_a.$2102.Metal2 v_b.$3779.Metal3 4.8721e-05f
Cred_12506 v_a.$2102.Metal2 v_b.P31.pSD 0.0269793f
Cred_12507 v_a.$2102.Metal2 v_b.P33.nSD 8.66797e-05f
Cred_12508 v_a.$2102.Metal2 v_b.P33.pSD 0.0271251f
Cred_12509 v_a.$2102.Metal2 v_b.P37.nSD 5.82497e-08f
Cred_12510 v_a.$2102.Metal2 v_b.P37.pSD 3.15179e-05f
Cred_12511 v_a.$2104.Metal2 v_b.$2811.Metal2 0.0227989f
Cred_12512 v_a.$2104.Metal2 v_b.$2871.Metal2 0.00752034f
Cred_12513 v_a.$2104.Metal2 v_b.$3779.Metal3 6.46139e-05f
Cred_12514 v_a.$2104.Metal2 v_b.P31.pSD 0.0276086f
Cred_12515 v_a.$2104.Metal2 v_b.P33.nSD 8.32166e-05f
Cred_12516 v_a.$2104.Metal2 v_b.P33.pSD 0.0277495f
Cred_12517 v_a.$2104.Metal2 v_b.P37.nSD 7.72509e-08f
Cred_12518 v_a.$2104.Metal2 v_b.P37.pSD 4.23004e-05f
Cred_12519 v_a.$2106.Metal2 v_b.$2811.Metal2 0.119679f
Cred_12520 v_a.$2106.Metal2 v_b.$2871.Metal2 0.0394059f
Cred_12521 v_a.$2106.Metal2 v_b.$3779.Metal3 0.00103484f
Cred_12522 v_a.$2106.Metal2 v_b.P31.pSD 0.18103f
Cred_12523 v_a.$2106.Metal2 v_b.P33.nSD 0.000436047f
Cred_12524 v_a.$2106.Metal2 v_b.P33.pSD 0.181007f
Cred_12525 v_a.$2106.Metal2 v_b.P37.nSD 1.23723e-06f
Cred_12526 v_a.$2106.Metal2 v_b.P37.pSD 0.00075484f
Cred_12527 v_a.$2187.Metal3 v_b.$2361.Metal2 0.0555113f
Cred_12528 v_a.$2187.Metal3 v_b.P0.nSD 0.000210778f
Cred_12529 v_a.$2187.Metal3 v_b.P0.pSD 0.0127956f
Cred_12530 v_a.$2187.Metal3 v_b.P1.pSD 0.0122737f
Cred_12531 v_a.$2187.Metal3 VDD.$340.Metal1 1.16916e-07f
Cred_12532 v_a.$2187.Metal3 VDD.$388.Metal2 5.42057e-06f
Cred_12533 v_a.$2187.Metal3 VDD.$42.Metal1 0.00025452f
Cred_12534 v_a.$2187.Metal3 VDD.$666.Metal3 2.38643e-07f
Cred_12535 v_a.$2187.Metal3 VDD.P0.nSD 0.00385203f
Cred_12536 v_a.$2191.Metal3 v_b.$2361.Metal2 0.018147f
Cred_12537 v_a.$2191.Metal3 v_b.P0.nSD 7.32359e-05f
Cred_12538 v_a.$2191.Metal3 v_b.P0.pSD 0.00904757f
Cred_12539 v_a.$2191.Metal3 v_b.P1.pSD 0.00723693f
Cred_12540 v_a.$2193.Metal3 v_b.$2361.Metal2 0.0235083f
Cred_12541 v_a.$2193.Metal3 v_b.P0.nSD 9.96904e-05f
Cred_12542 v_a.$2193.Metal3 v_b.P0.pSD 0.01227f
Cred_12543 v_a.$2193.Metal3 v_b.P1.pSD 0.00958525f
Cred_12544 v_a.$2193.Metal3 VDD.$340.Metal1 3.0517e-07f
Cred_12545 v_a.$2193.Metal3 VDD.$388.Metal2 8.43343e-06f
Cred_12546 v_a.$2193.Metal3 VDD.$42.Metal1 0.000395987f
Cred_12547 v_a.$2193.Metal3 VDD.$666.Metal3 3.71285e-07f
Cred_12548 v_a.$2193.Metal3 VDD.P0.nSD 0.0065319f
Cred_12549 v_a.$2197.Metal3 v_b.$2361.Metal2 0.126036f
Cred_12550 v_a.$2197.Metal3 v_b.P0.nSD 0.000521281f
Cred_12551 v_a.$2197.Metal3 v_b.P0.pSD 0.165394f
Cred_12552 v_a.$2197.Metal3 v_b.P1.pSD 0.149302f
Cred_12553 v_a.$2197.Metal3 VDD.$340.Metal1 1.29603e-08f
Cred_12554 v_a.$2197.Metal3 VDD.$388.Metal2 0.00274594f
Cred_12555 v_a.$2197.Metal3 VDD.$392.Metal2 8.62016e-07f
Cred_12556 v_a.$2197.Metal3 VDD.$42.Metal1 0.00176665f
Cred_12557 v_a.$2197.Metal3 VDD.$55.Metal1 0.000147883f
Cred_12558 v_a.$2197.Metal3 VDD.$666.Metal3 0.005183f
Cred_12559 v_a.$2197.Metal3 VDD.P0.nSD 0.00123132f
Cred_12560 v_a.$2215.Metal3 v_b.$2361.Metal2 0.115577f
Cred_12561 v_a.$2215.Metal3 v_b.$2421.Metal2 0.037727f
Cred_12562 v_a.$2215.Metal3 v_b.P1.nSD 0.0122929f
Cred_12563 v_a.$2215.Metal3 v_b.P1.pSD 0.0111286f
Cred_12564 v_a.$2215.Metal3 v_b.P3.nSD 0.0130898f
Cred_12565 v_a.$2215.Metal3 v_b.P3.pSD 0.0118942f
Cred_12566 v_a.$2215.Metal3 VDD.$340.Metal1 3.48792e-10f
Cred_12567 v_a.$2215.Metal3 VDD.$388.Metal2 3.16212e-09f
Cred_12568 v_a.$2215.Metal3 VDD.$42.Metal1 1.48475e-07f
Cred_12569 v_a.$2215.Metal3 VDD.$666.Metal3 1.39213e-10f
Cred_12570 v_a.$2215.Metal3 VDD.P0.nSD 5.29398e-06f
Cred_12571 v_a.$2215.Metal3 VSS.$17.Metal1 9.88666e-05f
Cred_12572 v_a.$2215.Metal3 VSS.$301.Metal1 1.7167e-07f
Cred_12573 v_a.$2215.Metal3 VSS.$606.Metal2 1.81389e-08f
Cred_12574 v_a.$2215.Metal3 VSS.$760.Metal3 1.07325e-09f
Cred_12575 v_a.$2215.Metal3 VSS.P0.pSD 0.000712643f
Cred_12576 v_a.$2219.Metal3 v_b.$2361.Metal2 0.0219377f
Cred_12577 v_a.$2219.Metal3 v_b.$2421.Metal2 0.00788396f
Cred_12578 v_a.$2219.Metal3 v_b.P1.pSD 0.00792551f
Cred_12579 v_a.$2219.Metal3 v_b.P3.nSD 8.72402e-05f
Cred_12580 v_a.$2219.Metal3 v_b.P3.pSD 0.00936165f
Cred_12581 v_a.$2223.Metal3 v_b.$2361.Metal2 0.0242303f
Cred_12582 v_a.$2223.Metal3 v_b.$2421.Metal2 0.00797951f
Cred_12583 v_a.$2223.Metal3 v_b.P1.pSD 0.0121578f
Cred_12584 v_a.$2223.Metal3 v_b.P3.nSD 8.82976e-05f
Cred_12585 v_a.$2223.Metal3 v_b.P3.pSD 0.0128915f
Cred_12586 v_a.$2223.Metal3 VDD.$340.Metal1 3.09374e-07f
Cred_12587 v_a.$2223.Metal3 VDD.$388.Metal2 2.78207e-06f
Cred_12588 v_a.$2223.Metal3 VDD.$42.Metal1 0.000130631f
Cred_12589 v_a.$2223.Metal3 VDD.$666.Metal3 1.22482e-07f
Cred_12590 v_a.$2223.Metal3 VDD.P0.nSD 0.00467724f
Cred_12591 v_a.$2227.Metal3 v_b.$2361.Metal2 0.0107648f
Cred_12592 v_a.$2227.Metal3 v_b.$2421.Metal2 0.00319963f
Cred_12593 v_a.$2227.Metal3 v_b.P1.pSD 0.0112336f
Cred_12594 v_a.$2227.Metal3 v_b.P3.nSD 3.54056e-05f
Cred_12595 v_a.$2227.Metal3 v_b.P3.pSD 0.00965066f
Cred_12596 v_a.$2229.Metal3 v_b.$2361.Metal2 0.00918708f
Cred_12597 v_a.$2229.Metal3 v_b.$2421.Metal2 0.00291311f
Cred_12598 v_a.$2229.Metal3 v_b.P1.pSD 0.0117015f
Cred_12599 v_a.$2229.Metal3 v_b.P3.nSD 3.22351e-05f
Cred_12600 v_a.$2229.Metal3 v_b.P3.pSD 0.0110502f
Cred_12601 v_a.$2233.Metal3 v_b.$2361.Metal2 0.0250022f
Cred_12602 v_a.$2233.Metal3 v_b.$2421.Metal2 0.00785047f
Cred_12603 v_a.$2233.Metal3 v_b.P1.pSD 0.0386277f
Cred_12604 v_a.$2233.Metal3 v_b.P3.nSD 8.68696e-05f
Cred_12605 v_a.$2233.Metal3 v_b.P3.pSD 0.0362702f
Cred_12606 v_a.$2237.Metal3 v_b.$2361.Metal2 0.392039f
Cred_12607 v_a.$2237.Metal3 v_b.$2421.Metal2 0.860504f
Cred_12608 v_a.$2237.Metal3 v_b.$2481.Metal2 0.0756185f
Cred_12609 v_a.$2237.Metal3 v_b.P1.nSD 0.0354325f
Cred_12610 v_a.$2237.Metal3 v_b.P3.nSD 0.14211f
Cred_12611 v_a.$2237.Metal3 v_b.P3.pSD 0.0103639f
Cred_12612 v_a.$2237.Metal3 v_b.P5.nSD 0.140607f
Cred_12613 v_a.$2237.Metal3 v_b.P5.pSD 0.00524743f
Cred_12614 v_a.$2237.Metal3 v_b.P7.nSD 0.0427876f
Cred_12615 v_a.$2237.Metal3 v_b.P7.pSD 0.00152059f
Cred_12616 v_a.$2237.Metal3 VDD.$340.Metal1 6.76964e-10f
Cred_12617 v_a.$2237.Metal3 VDD.$388.Metal2 3.67766e-09f
Cred_12618 v_a.$2237.Metal3 VDD.$42.Metal1 1.72682e-07f
Cred_12619 v_a.$2237.Metal3 VDD.$666.Metal3 1.6191e-10f
Cred_12620 v_a.$2237.Metal3 VDD.P0.nSD 8.01103e-06f
Cred_12621 v_a.$2237.Metal3 VSS.$17.Metal1 0.00106991f
Cred_12622 v_a.$2237.Metal3 VSS.$301.Metal1 3.16054e-06f
Cred_12623 v_a.$2237.Metal3 VSS.$606.Metal2 3.33947e-07f
Cred_12624 v_a.$2237.Metal3 VSS.$760.Metal3 1.97592e-08f
Cred_12625 v_a.$2237.Metal3 VSS.P0.pSD 0.0101998f
Cred_12626 v_a.$2247.Metal3 v_b.$2361.Metal2 0.0125838f
Cred_12627 v_a.$2247.Metal3 v_b.$2421.Metal2 0.038697f
Cred_12628 v_a.$2247.Metal3 v_b.P3.nSD 0.000139247f
Cred_12629 v_a.$2247.Metal3 v_b.P3.pSD 0.0101072f
Cred_12630 v_a.$2247.Metal3 v_b.P5.pSD 0.0102427f
Cred_12631 v_a.$2247.Metal3 VDD.$340.Metal1 8.92344e-10f
Cred_12632 v_a.$2247.Metal3 VDD.$388.Metal2 4.84773e-09f
Cred_12633 v_a.$2247.Metal3 VDD.$42.Metal1 2.27622e-07f
Cred_12634 v_a.$2247.Metal3 VDD.$666.Metal3 2.13423e-10f
Cred_12635 v_a.$2247.Metal3 VDD.P0.nSD 1.05598e-05f
Cred_12636 v_a.$2251.Metal3 v_b.$2361.Metal2 0.00449346f
Cred_12637 v_a.$2251.Metal3 v_b.$2421.Metal2 0.0154946f
Cred_12638 v_a.$2251.Metal3 v_b.P3.nSD 4.97226e-05f
Cred_12639 v_a.$2251.Metal3 v_b.P3.pSD 0.00678141f
Cred_12640 v_a.$2251.Metal3 v_b.P5.pSD 0.00806496f
Cred_12641 v_a.$2253.Metal3 v_b.$2361.Metal2 0.00658839f
Cred_12642 v_a.$2253.Metal3 v_b.$2421.Metal2 0.0193385f
Cred_12643 v_a.$2253.Metal3 v_b.P3.nSD 7.2904e-05f
Cred_12644 v_a.$2253.Metal3 v_b.P3.pSD 0.00994214f
Cred_12645 v_a.$2253.Metal3 v_b.P5.pSD 0.00990067f
Cred_12646 v_a.$2253.Metal3 VDD.$340.Metal1 3.99377e-07f
Cred_12647 v_a.$2253.Metal3 VDD.$388.Metal2 2.15208e-06f
Cred_12648 v_a.$2253.Metal3 VDD.$42.Metal1 0.00010105f
Cred_12649 v_a.$2253.Metal3 VDD.$666.Metal3 9.47463e-08f
Cred_12650 v_a.$2253.Metal3 VDD.P0.nSD 0.00470738f
Cred_12651 v_a.$2257.Metal3 v_b.$2361.Metal2 0.00481277f
Cred_12652 v_a.$2257.Metal3 v_b.$2421.Metal2 0.0135224f
Cred_12653 v_a.$2257.Metal3 v_b.P3.nSD 5.32559e-05f
Cred_12654 v_a.$2257.Metal3 v_b.P3.pSD 0.015271f
Cred_12655 v_a.$2257.Metal3 v_b.P5.pSD 0.0135288f
Cred_12656 v_a.$2261.Metal3 v_b.$2361.Metal2 0.0151058f
Cred_12657 v_a.$2261.Metal3 v_b.$2421.Metal2 0.0442026f
Cred_12658 v_a.$2261.Metal3 v_b.P3.nSD 0.000167154f
Cred_12659 v_a.$2261.Metal3 v_b.P3.pSD 0.0690763f
Cred_12660 v_a.$2261.Metal3 v_b.P5.pSD 0.0654218f
Cred_12661 v_a.$2275.Metal3 v_b.$2421.Metal2 0.124559f
Cred_12662 v_a.$2275.Metal3 v_b.$2481.Metal2 0.0409692f
Cred_12663 v_a.$2275.Metal3 v_b.P5.nSD 0.0144925f
Cred_12664 v_a.$2275.Metal3 v_b.P5.pSD 0.0111284f
Cred_12665 v_a.$2275.Metal3 v_b.P7.nSD 0.0150077f
Cred_12666 v_a.$2275.Metal3 v_b.P7.pSD 0.0119594f
Cred_12667 v_a.$2275.Metal3 VDD.$340.Metal1 5.81586e-10f
Cred_12668 v_a.$2275.Metal3 VDD.$388.Metal2 1.89224e-09f
Cred_12669 v_a.$2275.Metal3 VDD.$42.Metal1 8.88491e-08f
Cred_12670 v_a.$2275.Metal3 VDD.$666.Metal3 8.33066e-11f
Cred_12671 v_a.$2275.Metal3 VDD.P0.nSD 5.3547e-06f
Cred_12672 v_a.$2275.Metal3 VSS.$17.Metal1 6.7316e-05f
Cred_12673 v_a.$2275.Metal3 VSS.$301.Metal1 3.28075e-07f
Cred_12674 v_a.$2275.Metal3 VSS.$606.Metal2 3.46649e-08f
Cred_12675 v_a.$2275.Metal3 VSS.$760.Metal3 2.05108e-09f
Cred_12676 v_a.$2275.Metal3 VSS.P0.pSD 0.00085588f
Cred_12677 v_a.$2279.Metal3 v_b.$2421.Metal2 0.0219325f
Cred_12678 v_a.$2279.Metal3 v_b.$2481.Metal2 0.00788396f
Cred_12679 v_a.$2279.Metal3 v_b.P5.pSD 0.00792244f
Cred_12680 v_a.$2279.Metal3 v_b.P7.nSD 8.72402e-05f
Cred_12681 v_a.$2279.Metal3 v_b.P7.pSD 0.00936165f
Cred_12682 v_a.$228.Metal1 v_b.$2421.Metal2 0.0604409f
Cred_12683 v_a.$228.Metal1 v_b.$2481.Metal2 0.0201118f
Cred_12684 v_a.$228.Metal1 v_b.P5.pSD 0.0608871f
Cred_12685 v_a.$228.Metal1 v_b.P7.nSD 0.000222547f
Cred_12686 v_a.$228.Metal1 v_b.P7.pSD 0.0621316f
Cred_12687 v_a.$228.Metal1 VDD.$340.Metal1 8.24672e-07f
Cred_12688 v_a.$228.Metal1 VDD.$388.Metal2 2.68314e-06f
Cred_12689 v_a.$228.Metal1 VDD.$42.Metal1 0.000125985f
Cred_12690 v_a.$228.Metal1 VDD.$666.Metal3 1.18126e-07f
Cred_12691 v_a.$228.Metal1 VDD.P0.nSD 0.0075928f
Cred_12692 v_a.$2283.Metal3 v_b.$2421.Metal2 0.0242303f
Cred_12693 v_a.$2283.Metal3 v_b.$2481.Metal2 0.00797951f
Cred_12694 v_a.$2283.Metal3 v_b.P5.pSD 0.0121578f
Cred_12695 v_a.$2283.Metal3 v_b.P7.nSD 8.82976e-05f
Cred_12696 v_a.$2283.Metal3 v_b.P7.pSD 0.0128915f
Cred_12697 v_a.$2283.Metal3 VDD.$340.Metal1 5.15869e-07f
Cred_12698 v_a.$2283.Metal3 VDD.$388.Metal2 1.66482e-06f
Cred_12699 v_a.$2283.Metal3 VDD.$42.Metal1 7.81708e-05f
Cred_12700 v_a.$2283.Metal3 VDD.$666.Metal3 7.32944e-08f
Cred_12701 v_a.$2283.Metal3 VDD.P0.nSD 0.00473066f
Cred_12702 v_a.$2287.Metal3 v_b.$2421.Metal2 0.0138318f
Cred_12703 v_a.$2287.Metal3 v_b.$2481.Metal2 0.00421151f
Cred_12704 v_a.$2287.Metal3 v_b.P5.pSD 0.0149299f
Cred_12705 v_a.$2287.Metal3 v_b.P7.nSD 4.66026e-05f
Cred_12706 v_a.$2287.Metal3 v_b.P7.pSD 0.0133692f
Cred_12707 v_a.$2291.Metal3 v_b.$2421.Metal2 0.0456712f
Cred_12708 v_a.$2291.Metal3 v_b.$2481.Metal2 0.0145749f
Cred_12709 v_a.$2291.Metal3 v_b.P5.pSD 0.0700584f
Cred_12710 v_a.$2291.Metal3 v_b.P7.nSD 0.000161279f
Cred_12711 v_a.$2291.Metal3 v_b.P7.pSD 0.0673288f
Cred_12712 v_a.$2297.Metal3 v_b.$2421.Metal2 0.415566f
Cred_12713 v_a.$2297.Metal3 v_b.$2481.Metal2 0.637795f
Cred_12714 v_a.$2297.Metal3 v_b.P10.nSD 0.0988344f
Cred_12715 v_a.$2297.Metal3 v_b.P10.pSD 0.00524743f
Cred_12716 v_a.$2297.Metal3 v_b.P5.nSD 0.0417725f
Cred_12717 v_a.$2297.Metal3 v_b.P7.nSD 0.143259f
Cred_12718 v_a.$2297.Metal3 v_b.P7.pSD 0.0105033f
Cred_12719 v_a.$2297.Metal3 VDD.$340.Metal1 1.12986e-09f
Cred_12720 v_a.$2297.Metal3 VDD.$388.Metal2 2.201e-09f
Cred_12721 v_a.$2297.Metal3 VDD.$42.Metal1 1.03347e-07f
Cred_12722 v_a.$2297.Metal3 VDD.$666.Metal3 9.68998e-11f
Cred_12723 v_a.$2297.Metal3 VDD.P0.nSD 8.08145e-06f
Cred_12724 v_a.$2297.Metal3 VSS.$17.Metal1 0.000547678f
Cred_12725 v_a.$2297.Metal3 VSS.$301.Metal1 3.82901e-06f
Cred_12726 v_a.$2297.Metal3 VSS.$606.Metal2 4.04579e-07f
Cred_12727 v_a.$2297.Metal3 VSS.$760.Metal3 2.39384e-08f
Cred_12728 v_a.$2297.Metal3 VSS.P0.pSD 0.00838172f
Cred_12729 v_a.$230.Metal1 v_b.$2421.Metal2 0.0258696f
Cred_12730 v_a.$230.Metal1 v_b.$2481.Metal2 0.00865026f
Cred_12731 v_a.$230.Metal1 v_b.P5.pSD 0.0283681f
Cred_12732 v_a.$230.Metal1 v_b.P7.nSD 9.57197e-05f
Cred_12733 v_a.$230.Metal1 v_b.P7.pSD 0.0291209f
Cred_12734 v_a.$2307.Metal3 v_b.$2421.Metal2 0.0125834f
Cred_12735 v_a.$2307.Metal3 v_b.$2481.Metal2 0.0386966f
Cred_12736 v_a.$2307.Metal3 v_b.P10.pSD 0.0102427f
Cred_12737 v_a.$2307.Metal3 v_b.P7.nSD 0.000139242f
Cred_12738 v_a.$2307.Metal3 v_b.P7.pSD 0.0101059f
Cred_12739 v_a.$2307.Metal3 VDD.$340.Metal1 1.48933e-09f
Cred_12740 v_a.$2307.Metal3 VDD.$388.Metal2 2.90126e-09f
Cred_12741 v_a.$2307.Metal3 VDD.$42.Metal1 1.36227e-07f
Cred_12742 v_a.$2307.Metal3 VDD.$666.Metal3 1.27729e-10f
Cred_12743 v_a.$2307.Metal3 VDD.P0.nSD 1.06526e-05f
Cred_12744 v_a.$231.Metal1 v_b.$2421.Metal2 0.0249491f
Cred_12745 v_a.$231.Metal1 v_b.$2481.Metal2 0.00834131f
Cred_12746 v_a.$231.Metal1 v_b.P5.pSD 0.0292707f
Cred_12747 v_a.$231.Metal1 v_b.P7.nSD 9.2301e-05f
Cred_12748 v_a.$231.Metal1 v_b.P7.pSD 0.0300337f
Cred_12749 v_a.$2311.Metal3 v_b.$2421.Metal2 0.00449346f
Cred_12750 v_a.$2311.Metal3 v_b.$2481.Metal2 0.0154946f
Cred_12751 v_a.$2311.Metal3 v_b.P10.pSD 0.00806496f
Cred_12752 v_a.$2311.Metal3 v_b.P7.nSD 4.97226e-05f
Cred_12753 v_a.$2311.Metal3 v_b.P7.pSD 0.00678141f
Cred_12754 v_a.$2313.Metal3 v_b.$2421.Metal2 0.00658839f
Cred_12755 v_a.$2313.Metal3 v_b.$2481.Metal2 0.0193385f
Cred_12756 v_a.$2313.Metal3 v_b.P10.pSD 0.00990067f
Cred_12757 v_a.$2313.Metal3 v_b.P7.nSD 7.2904e-05f
Cred_12758 v_a.$2313.Metal3 v_b.P7.pSD 0.00994214f
Cred_12759 v_a.$2313.Metal3 VDD.$340.Metal1 6.66574e-07f
Cred_12760 v_a.$2313.Metal3 VDD.$388.Metal2 1.28798e-06f
Cred_12761 v_a.$2313.Metal3 VDD.$42.Metal1 6.04763e-05f
Cred_12762 v_a.$2313.Metal3 VDD.$666.Metal3 5.67037e-08f
Cred_12763 v_a.$2313.Metal3 VDD.P0.nSD 0.00474859f
Cred_12764 v_a.$2317.Metal3 v_b.$2421.Metal2 0.00473631f
Cred_12765 v_a.$2317.Metal3 v_b.$2481.Metal2 0.0132906f
Cred_12766 v_a.$2317.Metal3 v_b.P10.pSD 0.0132845f
Cred_12767 v_a.$2317.Metal3 v_b.P7.nSD 5.24097e-05f
Cred_12768 v_a.$2317.Metal3 v_b.P7.pSD 0.0150251f
Cred_12769 v_a.$2321.Metal3 v_b.$2421.Metal2 0.0153095f
Cred_12770 v_a.$2321.Metal3 v_b.$2481.Metal2 0.0449137f
Cred_12771 v_a.$2321.Metal3 v_b.P10.pSD 0.0670358f
Cred_12772 v_a.$2321.Metal3 v_b.P7.nSD 0.000169408f
Cred_12773 v_a.$2321.Metal3 v_b.P7.pSD 0.0703662f
Cred_12774 v_a.$2327.Metal3 v_b.$2481.Metal2 0.638663f
Cred_12775 v_a.$2327.Metal3 v_b.$2541.Metal2 0.414235f
Cred_12776 v_a.$2327.Metal3 v_b.P10.nSD 0.0984141f
Cred_12777 v_a.$2327.Metal3 v_b.P10.pSD 0.00524499f
Cred_12778 v_a.$2327.Metal3 v_b.P11.nSD 0.143496f
Cred_12779 v_a.$2327.Metal3 v_b.P11.pSD 0.0104981f
Cred_12780 v_a.$2327.Metal3 v_b.P13.nSD 0.0419508f
Cred_12781 v_a.$2327.Metal3 VDD.$340.Metal1 1.46024e-09f
Cred_12782 v_a.$2327.Metal3 VDD.$388.Metal2 1.70299e-09f
Cred_12783 v_a.$2327.Metal3 VDD.$42.Metal1 7.99629e-08f
Cred_12784 v_a.$2327.Metal3 VDD.$666.Metal3 7.49748e-11f
Cred_12785 v_a.$2327.Metal3 VDD.P0.nSD 8.10503e-06f
Cred_12786 v_a.$2327.Metal3 VSS.$17.Metal1 0.000363515f
Cred_12787 v_a.$2327.Metal3 VSS.$301.Metal1 5.77784e-06f
Cred_12788 v_a.$2327.Metal3 VSS.$606.Metal2 6.10496e-07f
Cred_12789 v_a.$2327.Metal3 VSS.$760.Metal3 3.61222e-08f
Cred_12790 v_a.$2327.Metal3 VSS.P0.pSD 0.00856372f
Cred_12791 v_a.$233.Metal1 v_b.$2421.Metal2 0.030853f
Cred_12792 v_a.$233.Metal1 v_b.$2481.Metal2 0.0103169f
Cred_12793 v_a.$233.Metal1 v_b.P5.pSD 0.039898f
Cred_12794 v_a.$233.Metal1 v_b.P7.nSD 0.000114162f
Cred_12795 v_a.$233.Metal1 v_b.P7.pSD 0.0409202f
Cred_12796 v_a.$2337.Metal3 v_b.$2481.Metal2 0.0384153f
Cred_12797 v_a.$2337.Metal3 v_b.$2541.Metal2 0.0128562f
Cred_12798 v_a.$2337.Metal3 v_b.P10.pSD 0.00985286f
Cred_12799 v_a.$2337.Metal3 v_b.P11.nSD 0.000142261f
Cred_12800 v_a.$2337.Metal3 v_b.P11.pSD 0.0105013f
Cred_12801 v_a.$2337.Metal3 VDD.$340.Metal1 1.92483e-09f
Cred_12802 v_a.$2337.Metal3 VDD.$388.Metal2 2.24481e-09f
Cred_12803 v_a.$2337.Metal3 VDD.$42.Metal1 1.05404e-07f
Cred_12804 v_a.$2337.Metal3 VDD.$666.Metal3 9.88285e-11f
Cred_12805 v_a.$2337.Metal3 VDD.P0.nSD 1.06837e-05f
Cred_12806 v_a.$2341.Metal3 v_b.$2481.Metal2 0.0145431f
Cred_12807 v_a.$2341.Metal3 v_b.$2541.Metal2 0.00541613f
Cred_12808 v_a.$2341.Metal3 v_b.P10.pSD 0.00669105f
Cred_12809 v_a.$2341.Metal3 v_b.P11.nSD 5.99323e-05f
Cred_12810 v_a.$2341.Metal3 v_b.P11.pSD 0.00817387f
Cred_12811 v_a.$2343.Metal3 v_b.$2481.Metal2 0.0196594f
Cred_12812 v_a.$2343.Metal3 v_b.$2541.Metal2 0.00627722f
Cred_12813 v_a.$2343.Metal3 v_b.P10.pSD 0.00980966f
Cred_12814 v_a.$2343.Metal3 v_b.P11.nSD 6.94608e-05f
Cred_12815 v_a.$2343.Metal3 v_b.P11.pSD 0.0100269f
Cred_12816 v_a.$2343.Metal3 VDD.$340.Metal1 8.61488e-07f
Cred_12817 v_a.$2343.Metal3 VDD.$388.Metal2 9.96555e-07f
Cred_12818 v_a.$2343.Metal3 VDD.$42.Metal1 4.67927e-05f
Cred_12819 v_a.$2343.Metal3 VDD.$666.Metal3 4.38738e-08f
Cred_12820 v_a.$2343.Metal3 VDD.P0.nSD 0.00476239f
Cred_12821 v_a.$2347.Metal3 v_b.$2481.Metal2 0.0138318f
Cred_12822 v_a.$2347.Metal3 v_b.$2541.Metal2 0.00421151f
Cred_12823 v_a.$2347.Metal3 v_b.P10.pSD 0.0149299f
Cred_12824 v_a.$2347.Metal3 v_b.P11.nSD 4.66026e-05f
Cred_12825 v_a.$2347.Metal3 v_b.P11.pSD 0.0133692f
Cred_12826 v_a.$235.Metal1 v_b.$2421.Metal2 0.0287807f
Cred_12827 v_a.$235.Metal1 v_b.$2481.Metal2 0.00962396f
Cred_12828 v_a.$235.Metal1 v_b.P5.pSD 0.0412278f
Cred_12829 v_a.$235.Metal1 v_b.P7.nSD 0.000106494f
Cred_12830 v_a.$235.Metal1 v_b.P7.pSD 0.0422632f
Cred_12831 v_a.$2351.Metal3 v_b.$2481.Metal2 0.0456712f
Cred_12832 v_a.$2351.Metal3 v_b.$2541.Metal2 0.0145749f
Cred_12833 v_a.$2351.Metal3 v_b.P10.pSD 0.0700584f
Cred_12834 v_a.$2351.Metal3 v_b.P11.nSD 0.000161279f
Cred_12835 v_a.$2351.Metal3 v_b.P11.pSD 0.0673288f
Cred_12836 v_a.$2365.Metal3 v_b.$2481.Metal2 0.0400366f
Cred_12837 v_a.$2365.Metal3 v_b.$2541.Metal2 0.120787f
Cred_12838 v_a.$2365.Metal3 v_b.P11.nSD 0.0149355f
Cred_12839 v_a.$2365.Metal3 v_b.P11.pSD 0.0108413f
Cred_12840 v_a.$2365.Metal3 v_b.P13.nSD 0.0145544f
Cred_12841 v_a.$2365.Metal3 v_b.P13.pSD 0.0100409f
Cred_12842 v_a.$2365.Metal3 VDD.$340.Metal1 3.61165e-09f
Cred_12843 v_a.$2365.Metal3 VDD.$388.Metal2 2.52183e-09f
Cred_12844 v_a.$2365.Metal3 VDD.$42.Metal1 1.18411e-07f
Cred_12845 v_a.$2365.Metal3 VDD.$666.Metal3 1.11025e-10f
Cred_12846 v_a.$2365.Metal3 VDD.P0.nSD 1.55434e-05f
Cred_12847 v_a.$2365.Metal3 VSS.$17.Metal1 3.1184e-05f
Cred_12848 v_a.$2365.Metal3 VSS.$301.Metal1 7.10427e-07f
Cred_12849 v_a.$2365.Metal3 VSS.$606.Metal2 7.50648e-08f
Cred_12850 v_a.$2365.Metal3 VSS.$760.Metal3 4.44148e-09f
Cred_12851 v_a.$2365.Metal3 VSS.P0.pSD 0.000891587f
Cred_12852 v_a.$2367.Metal3 v_b.$2481.Metal2 0.00618072f
Cred_12853 v_a.$2367.Metal3 v_b.$2541.Metal2 0.0194015f
Cred_12854 v_a.$2367.Metal3 v_b.P11.nSD 6.8393e-05f
Cred_12855 v_a.$2367.Metal3 v_b.P11.pSD 0.00529364f
Cred_12856 v_a.$2367.Metal3 v_b.P13.pSD 0.00555706f
Cred_12857 v_a.$2367.Metal3 VDD.$340.Metal1 8.02567e-10f
Cred_12858 v_a.$2367.Metal3 VDD.$388.Metal2 5.60392e-10f
Cred_12859 v_a.$2367.Metal3 VDD.$42.Metal1 2.63129e-08f
Cred_12860 v_a.$2367.Metal3 VDD.$666.Metal3 2.46715e-11f
Cred_12861 v_a.$2367.Metal3 VDD.P0.nSD 3.45399e-06f
Cred_12862 v_a.$237.Metal1 v_b.$2421.Metal2 0.0331473f
Cred_12863 v_a.$237.Metal1 v_b.$2481.Metal2 0.0109137f
Cred_12864 v_a.$237.Metal1 v_b.P5.pSD 0.0537809f
Cred_12865 v_a.$237.Metal1 v_b.P7.nSD 0.000120766f
Cred_12866 v_a.$237.Metal1 v_b.P7.pSD 0.0537941f
Cred_12867 v_a.$2371.Metal3 v_b.$2481.Metal2 0.00449346f
Cred_12868 v_a.$2371.Metal3 v_b.$2541.Metal2 0.0154946f
Cred_12869 v_a.$2371.Metal3 v_b.P11.nSD 4.97226e-05f
Cred_12870 v_a.$2371.Metal3 v_b.P11.pSD 0.00678141f
Cred_12871 v_a.$2371.Metal3 v_b.P13.pSD 0.00806496f
Cred_12872 v_a.$2373.Metal3 v_b.$2481.Metal2 0.00658839f
Cred_12873 v_a.$2373.Metal3 v_b.$2541.Metal2 0.0193385f
Cred_12874 v_a.$2373.Metal3 v_b.P11.nSD 7.2904e-05f
Cred_12875 v_a.$2373.Metal3 v_b.P11.pSD 0.00994214f
Cred_12876 v_a.$2373.Metal3 v_b.P13.pSD 0.00990067f
Cred_12877 v_a.$2373.Metal3 VDD.$340.Metal1 1.11354e-06f
Cred_12878 v_a.$2373.Metal3 VDD.$388.Metal2 7.71228e-07f
Cred_12879 v_a.$2373.Metal3 VDD.$42.Metal1 3.62126e-05f
Cred_12880 v_a.$2373.Metal3 VDD.$666.Metal3 3.39536e-08f
Cred_12881 v_a.$2373.Metal3 VDD.P0.nSD 0.00477295f
Cred_12882 v_a.$2377.Metal3 v_b.$2481.Metal2 0.00473631f
Cred_12883 v_a.$2377.Metal3 v_b.$2541.Metal2 0.0132906f
Cred_12884 v_a.$2377.Metal3 v_b.P11.nSD 5.24097e-05f
Cred_12885 v_a.$2377.Metal3 v_b.P11.pSD 0.0150251f
Cred_12886 v_a.$2377.Metal3 v_b.P13.pSD 0.0132845f
Cred_12887 v_a.$2381.Metal3 v_b.$2481.Metal2 0.0153095f
Cred_12888 v_a.$2381.Metal3 v_b.$2541.Metal2 0.0449137f
Cred_12889 v_a.$2381.Metal3 v_b.P11.nSD 0.000169408f
Cred_12890 v_a.$2381.Metal3 v_b.P11.pSD 0.0703662f
Cred_12891 v_a.$2381.Metal3 v_b.P13.pSD 0.0670358f
Cred_12892 v_a.$2387.Metal3 v_b.$2481.Metal2 0.075853f
Cred_12893 v_a.$2387.Metal3 v_b.$2541.Metal2 0.974017f
Cred_12894 v_a.$2387.Metal3 v_b.$2601.Metal2 0.735224f
Cred_12895 v_a.$2387.Metal3 v_b.P11.nSD 0.0426118f
Cred_12896 v_a.$2387.Metal3 v_b.P11.pSD 0.00152531f
Cred_12897 v_a.$2387.Metal3 v_b.P13.nSD 0.140365f
Cred_12898 v_a.$2387.Metal3 v_b.P13.pSD 0.00524499f
Cred_12899 v_a.$2387.Metal3 v_b.P15.nSD 0.15134f
Cred_12900 v_a.$2387.Metal3 v_b.P15.pSD 0.251027f
Cred_12901 v_a.$2387.Metal3 v_b.P17.nSD 0.0486585f
Cred_12902 v_a.$2387.Metal3 v_b.P17.pSD 0.243043f
Cred_12903 v_a.$2387.Metal3 VDD.$340.Metal1 1.222e-06f
Cred_12904 v_a.$2387.Metal3 VDD.$388.Metal2 3.05225e-07f
Cred_12905 v_a.$2387.Metal3 VDD.$42.Metal1 1.43317e-05f
Cred_12906 v_a.$2387.Metal3 VDD.$666.Metal3 1.34377e-08f
Cred_12907 v_a.$2387.Metal3 VDD.P0.nSD 0.00315122f
Cred_12908 v_a.$2387.Metal3 VSS.$17.Metal1 0.000316336f
Cred_12909 v_a.$2387.Metal3 VSS.$301.Metal1 1.22573e-05f
Cred_12910 v_a.$2387.Metal3 VSS.$606.Metal2 1.29513e-06f
Cred_12911 v_a.$2387.Metal3 VSS.$760.Metal3 7.6631e-08f
Cred_12912 v_a.$2387.Metal3 VSS.P0.pSD 0.0116914f
Cred_12913 v_a.$2397.Metal3 v_b.$2541.Metal2 0.0384153f
Cred_12914 v_a.$2397.Metal3 v_b.$2601.Metal2 0.0128562f
Cred_12915 v_a.$2397.Metal3 v_b.P13.pSD 0.00985286f
Cred_12916 v_a.$2397.Metal3 v_b.P15.nSD 0.000142261f
Cred_12917 v_a.$2397.Metal3 v_b.P15.pSD 0.0105013f
Cred_12918 v_a.$2397.Metal3 VDD.$340.Metal1 3.21615e-09f
Cred_12919 v_a.$2397.Metal3 VDD.$388.Metal2 1.34488e-09f
Cred_12920 v_a.$2397.Metal3 VDD.$42.Metal1 6.31482e-08f
Cred_12921 v_a.$2397.Metal3 VDD.$666.Metal3 5.9209e-11f
Cred_12922 v_a.$2397.Metal3 VDD.P0.nSD 1.07256e-05f
Cred_12923 v_a.$240.Metal1 v_b.$2421.Metal2 0.0304612f
Cred_12924 v_a.$240.Metal1 v_b.$2481.Metal2 0.0101013f
Cred_12925 v_a.$240.Metal1 v_b.P5.pSD 0.055196f
Cred_12926 v_a.$240.Metal1 v_b.P7.nSD 0.000111776f
Cred_12927 v_a.$240.Metal1 v_b.P7.pSD 0.0558782f
Cred_12928 v_a.$2401.Metal3 v_b.$2541.Metal2 0.0145431f
Cred_12929 v_a.$2401.Metal3 v_b.$2601.Metal2 0.00541613f
Cred_12930 v_a.$2401.Metal3 v_b.P13.pSD 0.00669105f
Cred_12931 v_a.$2401.Metal3 v_b.P15.nSD 5.99323e-05f
Cred_12932 v_a.$2401.Metal3 v_b.P15.pSD 0.00817387f
Cred_12933 v_a.$2403.Metal3 v_b.$2541.Metal2 0.0196594f
Cred_12934 v_a.$2403.Metal3 v_b.$2601.Metal2 0.00627722f
Cred_12935 v_a.$2403.Metal3 v_b.P13.pSD 0.00980966f
Cred_12936 v_a.$2403.Metal3 v_b.P15.nSD 6.94608e-05f
Cred_12937 v_a.$2403.Metal3 v_b.P15.pSD 0.0100269f
Cred_12938 v_a.$2403.Metal3 VDD.$340.Metal1 1.43944e-06f
Cred_12939 v_a.$2403.Metal3 VDD.$388.Metal2 5.97051e-07f
Cred_12940 v_a.$2403.Metal3 VDD.$42.Metal1 2.80342e-05f
Cred_12941 v_a.$2403.Metal3 VDD.$666.Metal3 2.62854e-08f
Cred_12942 v_a.$2403.Metal3 VDD.P0.nSD 0.00478098f
Cred_12943 v_a.$2407.Metal3 v_b.$2541.Metal2 0.103969f
Cred_12944 v_a.$2407.Metal3 v_b.$2601.Metal2 0.033564f
Cred_12945 v_a.$2407.Metal3 v_b.P13.pSD 0.153069f
Cred_12946 v_a.$2407.Metal3 v_b.P15.nSD 0.000371403f
Cred_12947 v_a.$2407.Metal3 v_b.P15.pSD 0.149929f
Cred_12948 v_a.$242.Metal1 v_b.$2421.Metal2 0.0822923f
Cred_12949 v_a.$242.Metal1 v_b.$2481.Metal2 0.027468f
Cred_12950 v_a.$242.Metal1 v_b.P5.pSD 0.171611f
Cred_12951 v_a.$242.Metal1 v_b.P7.nSD 0.000303948f
Cred_12952 v_a.$242.Metal1 v_b.P7.pSD 0.175337f
Cred_12953 v_a.$2447.Metal3 v_b.$2541.Metal2 0.181116f
Cred_12954 v_a.$2447.Metal3 v_b.$2601.Metal2 0.931998f
Cred_12955 v_a.$2447.Metal3 v_b.$2631.Metal2 0.609098f
Cred_12956 v_a.$2447.Metal3 v_b.$2691.Metal2 0.0756185f
Cred_12957 v_a.$2447.Metal3 v_b.$3779.Metal3 0.00387987f
Cred_12958 v_a.$2447.Metal3 v_b.P15.nSD 0.0504558f
Cred_12959 v_a.$2447.Metal3 v_b.P15.pSD 0.242054f
Cred_12960 v_a.$2447.Metal3 v_b.P17.nSD 0.147073f
Cred_12961 v_a.$2447.Metal3 v_b.P17.pSD 0.249818f
Cred_12962 v_a.$2447.Metal3 v_b.P19.nSD 0.140607f
Cred_12963 v_a.$2447.Metal3 v_b.P19.pSD 0.00656854f
Cred_12964 v_a.$2447.Metal3 v_b.P21.nSD 0.0427876f
Cred_12965 v_a.$2447.Metal3 v_b.P21.pSD 0.00152059f
Cred_12966 v_a.$2447.Metal3 v_b.P37.nSD 0.000356204f
Cred_12967 v_a.$2447.Metal3 v_b.P37.pSD 1.08593e-05f
Cred_12968 v_a.$2447.Metal3 VDD.$340.Metal1 1.22474e-06f
Cred_12969 v_a.$2447.Metal3 VDD.$388.Metal2 3.04982e-07f
Cred_12970 v_a.$2447.Metal3 VDD.$42.Metal1 1.43203e-05f
Cred_12971 v_a.$2447.Metal3 VDD.$666.Metal3 1.3427e-08f
Cred_12972 v_a.$2447.Metal3 VDD.P0.nSD 0.00315343f
Cred_12973 v_a.$2447.Metal3 VSS.$17.Metal1 0.000193419f
Cred_12974 v_a.$2447.Metal3 VSS.$301.Metal1 2.01236e-05f
Cred_12975 v_a.$2447.Metal3 VSS.$606.Metal2 2.12629e-06f
Cred_12976 v_a.$2447.Metal3 VSS.$760.Metal3 1.2581e-07f
Cred_12977 v_a.$2447.Metal3 VSS.P0.pSD 0.0118055f
Cred_12978 v_a.$2458.Metal3 v_b.$2601.Metal2 0.0265464f
Cred_12979 v_a.$2458.Metal3 v_b.$2631.Metal2 0.023515f
Cred_12980 v_a.$2458.Metal3 v_b.P17.pSD 0.0114869f
Cred_12981 v_a.$2458.Metal3 v_b.P19.pSD 0.0101082f
Cred_12982 v_a.$2458.Metal3 VDD.$340.Metal1 4.20721e-09f
Cred_12983 v_a.$2458.Metal3 VDD.$388.Metal2 6.32205e-10f
Cred_12984 v_a.$2458.Metal3 VDD.$42.Metal1 2.96848e-08f
Cred_12985 v_a.$2458.Metal3 VDD.$666.Metal3 2.78331e-11f
Cred_12986 v_a.$2458.Metal3 VDD.P0.nSD 8.41405e-06f
Cred_12987 v_a.$2462.Metal3 v_b.$2601.Metal2 0.132392f
Cred_12988 v_a.$2462.Metal3 v_b.$2631.Metal2 0.12931f
Cred_12989 v_a.$2462.Metal3 v_b.P17.pSD 0.245266f
Cred_12990 v_a.$2462.Metal3 v_b.P19.pSD 0.242622f
Cred_12991 v_a.$2462.Metal3 VDD.$340.Metal1 2.28693e-06f
Cred_12992 v_a.$2462.Metal3 VDD.$388.Metal2 3.40878e-07f
Cred_12993 v_a.$2462.Metal3 VDD.$42.Metal1 1.60057e-05f
Cred_12994 v_a.$2462.Metal3 VDD.$666.Metal3 1.50073e-08f
Cred_12995 v_a.$2462.Metal3 VDD.P0.nSD 0.00455509f
Cred_12996 v_a.$2485.Metal3 v_b.$2631.Metal2 0.125194f
Cred_12997 v_a.$2485.Metal3 v_b.$2691.Metal2 0.0407331f
Cred_12998 v_a.$2485.Metal3 v_b.$3779.Metal3 0.00473822f
Cred_12999 v_a.$2485.Metal3 v_b.P19.nSD 0.0144925f
Cred_13000 v_a.$2485.Metal3 v_b.P19.pSD 0.0109679f
Cred_13001 v_a.$2485.Metal3 v_b.P21.nSD 0.0150051f
Cred_13002 v_a.$2485.Metal3 v_b.P21.pSD 0.011453f
Cred_13003 v_a.$2485.Metal3 v_b.P37.nSD 0.000127637f
Cred_13004 v_a.$2485.Metal3 v_b.P37.pSD 0.000617322f
Cred_13005 v_a.$2485.Metal3 VDD.$340.Metal1 1.08261e-08f
Cred_13006 v_a.$2485.Metal3 VDD.$388.Metal2 9.7715e-10f
Cred_13007 v_a.$2485.Metal3 VDD.$42.Metal1 4.58816e-08f
Cred_13008 v_a.$2485.Metal3 VDD.$666.Metal3 4.30194e-11f
Cred_13009 v_a.$2485.Metal3 VDD.P0.nSD 1.67588e-05f
Cred_13010 v_a.$2485.Metal3 VSS.$17.Metal1 1.12582e-05f
Cred_13011 v_a.$2485.Metal3 VSS.$301.Metal1 1.98561e-06f
Cred_13012 v_a.$2485.Metal3 VSS.$606.Metal2 2.09802e-07f
Cred_13013 v_a.$2485.Metal3 VSS.$760.Metal3 1.24137e-08f
Cred_13014 v_a.$2485.Metal3 VSS.P0.pSD 0.000910095f
Cred_13015 v_a.$2488.Metal3 v_b.$2631.Metal2 0.0163469f
Cred_13016 v_a.$2488.Metal3 v_b.$2691.Metal2 0.00476904f
Cred_13017 v_a.$2488.Metal3 v_b.$3779.Metal3 0.0023822f
Cred_13018 v_a.$2488.Metal3 v_b.P19.pSD 0.00489442f
Cred_13019 v_a.$2488.Metal3 v_b.P21.nSD 5.2772e-05f
Cred_13020 v_a.$2488.Metal3 v_b.P21.pSD 0.00417423f
Cred_13021 v_a.$2488.Metal3 v_b.P37.nSD 2.84811e-06f
Cred_13022 v_a.$2488.Metal3 v_b.P37.pSD 0.000654459f
Cred_13023 v_a.$2488.Metal3 VDD.$340.Metal1 1.48442e-09f
Cred_13024 v_a.$2488.Metal3 VDD.$388.Metal2 1.33981e-10f
Cred_13025 v_a.$2488.Metal3 VDD.$42.Metal1 6.29101e-09f
Cred_13026 v_a.$2488.Metal3 VDD.$666.Metal3 5.89857e-12f
Cred_13027 v_a.$2488.Metal3 VDD.P0.nSD 2.29787e-06f
Cred_13028 v_a.$2490.Metal3 v_b.$2631.Metal2 0.0128436f
Cred_13029 v_a.$2490.Metal3 v_b.$2691.Metal2 0.00384294f
Cred_13030 v_a.$2490.Metal3 v_b.$3779.Metal3 0.00219925f
Cred_13031 v_a.$2490.Metal3 v_b.P19.pSD 0.00658053f
Cred_13032 v_a.$2490.Metal3 v_b.P21.nSD 4.25242e-05f
Cred_13033 v_a.$2490.Metal3 v_b.P21.pSD 0.0058565f
Cred_13034 v_a.$2490.Metal3 v_b.P37.nSD 2.62937e-06f
Cred_13035 v_a.$2490.Metal3 v_b.P37.pSD 0.000837574f
Cred_13036 v_a.$2493.Metal3 v_b.$2631.Metal2 0.0221936f
Cred_13037 v_a.$2493.Metal3 v_b.$2691.Metal2 0.00683509f
Cred_13038 v_a.$2493.Metal3 v_b.$3779.Metal3 0.00284434f
Cred_13039 v_a.$2493.Metal3 v_b.P19.pSD 0.0116274f
Cred_13040 v_a.$2493.Metal3 v_b.P21.nSD 7.56339e-05f
Cred_13041 v_a.$2493.Metal3 v_b.P21.pSD 0.0108977f
Cred_13042 v_a.$2493.Metal3 v_b.P37.nSD 3.40063e-06f
Cred_13043 v_a.$2493.Metal3 v_b.P37.pSD 0.00139065f
Cred_13044 v_a.$2493.Metal3 VDD.$340.Metal1 3.10994e-06f
Cred_13045 v_a.$2493.Metal3 VDD.$388.Metal2 2.78442e-07f
Cred_13046 v_a.$2493.Metal3 VDD.$42.Metal1 1.30741e-05f
Cred_13047 v_a.$2493.Metal3 VDD.$666.Metal3 1.22585e-08f
Cred_13048 v_a.$2493.Metal3 VDD.P0.nSD 0.00479461f
Cred_13049 v_a.$2497.Metal3 v_b.$2631.Metal2 0.0138935f
Cred_13050 v_a.$2497.Metal3 v_b.$2691.Metal2 0.00415161f
Cred_13051 v_a.$2497.Metal3 v_b.$3779.Metal3 0.0030158f
Cred_13052 v_a.$2497.Metal3 v_b.P19.pSD 0.0150754f
Cred_13053 v_a.$2497.Metal3 v_b.P21.nSD 4.59398e-05f
Cred_13054 v_a.$2497.Metal3 v_b.P21.pSD 0.0132224f
Cred_13055 v_a.$2497.Metal3 v_b.P37.nSD 3.60562e-06f
Cred_13056 v_a.$2497.Metal3 v_b.P37.pSD 0.00181488f
Cred_13057 v_a.$2501.Metal3 v_b.$2631.Metal2 0.0454914f
Cred_13058 v_a.$2501.Metal3 v_b.$2691.Metal2 0.0147493f
Cred_13059 v_a.$2501.Metal3 v_b.$3779.Metal3 0.00509356f
Cred_13060 v_a.$2501.Metal3 v_b.P19.pSD 0.0693241f
Cred_13061 v_a.$2501.Metal3 v_b.P21.nSD 0.000163208f
Cred_13062 v_a.$2501.Metal3 v_b.P21.pSD 0.0680667f
Cred_13063 v_a.$2501.Metal3 v_b.P37.nSD 6.08974e-06f
Cred_13064 v_a.$2501.Metal3 v_b.P37.pSD 0.00361533f
Cred_13065 v_a.$2507.Metal3 v_b.$2631.Metal2 0.418062f
Cred_13066 v_a.$2507.Metal3 v_b.$2691.Metal2 0.873639f
Cred_13067 v_a.$2507.Metal3 v_b.$2751.Metal2 0.0756185f
Cred_13068 v_a.$2507.Metal3 v_b.$3779.Metal3 0.0220619f
Cred_13069 v_a.$2507.Metal3 v_b.P19.nSD 0.0417725f
Cred_13070 v_a.$2507.Metal3 v_b.P21.nSD 0.143281f
Cred_13071 v_a.$2507.Metal3 v_b.P21.pSD 0.0120128f
Cred_13072 v_a.$2507.Metal3 v_b.P23.nSD 0.140607f
Cred_13073 v_a.$2507.Metal3 v_b.P23.pSD 0.00662959f
Cred_13074 v_a.$2507.Metal3 v_b.P25.nSD 0.0427876f
Cred_13075 v_a.$2507.Metal3 v_b.P25.pSD 0.00152059f
Cred_13076 v_a.$2507.Metal3 v_b.P37.nSD 0.00180702f
Cred_13077 v_a.$2507.Metal3 v_b.P37.pSD 0.000491034f
Cred_13078 v_a.$2507.Metal3 VDD.$340.Metal1 8.64531e-09f
Cred_13079 v_a.$2507.Metal3 VDD.$388.Metal2 4.69901e-10f
Cred_13080 v_a.$2507.Metal3 VDD.$42.Metal1 2.2064e-08f
Cred_13081 v_a.$2507.Metal3 VDD.$666.Metal3 2.06876e-11f
Cred_13082 v_a.$2507.Metal3 VDD.P0.nSD 1.03563e-05f
Cred_13083 v_a.$2507.Metal3 VSS.$17.Metal1 0.000111723f
Cred_13084 v_a.$2507.Metal3 VSS.$301.Metal1 3.27218e-05f
Cred_13085 v_a.$2507.Metal3 VSS.$606.Metal2 3.45744e-06f
Cred_13086 v_a.$2507.Metal3 VSS.$760.Metal3 2.04572e-07f
Cred_13087 v_a.$2507.Metal3 VSS.P0.pSD 0.0114476f
Cred_13088 v_a.$2518.Metal3 v_b.$2631.Metal2 0.0111359f
Cred_13089 v_a.$2518.Metal3 v_b.$2691.Metal2 0.0318052f
Cred_13090 v_a.$2518.Metal3 v_b.$3779.Metal3 0.00416634f
Cred_13091 v_a.$2518.Metal3 v_b.P21.nSD 0.000123225f
Cred_13092 v_a.$2518.Metal3 v_b.P21.pSD 0.00908863f
Cred_13093 v_a.$2518.Metal3 v_b.P23.pSD 0.00799883f
Cred_13094 v_a.$2518.Metal3 v_b.P37.nSD 4.98118e-06f
Cred_13095 v_a.$2518.Metal3 v_b.P37.pSD 0.00101082f
Cred_13096 v_a.$2518.Metal3 VDD.$340.Metal1 7.03159e-09f
Cred_13097 v_a.$2518.Metal3 VDD.$388.Metal2 3.8219e-10f
Cred_13098 v_a.$2518.Metal3 VDD.$42.Metal1 1.79455e-08f
Cred_13099 v_a.$2518.Metal3 VDD.$666.Metal3 1.68261e-11f
Cred_13100 v_a.$2518.Metal3 VDD.P0.nSD 8.42323e-06f
Cred_13101 v_a.$2520.Metal3 v_b.$2631.Metal2 0.00443124f
Cred_13102 v_a.$2520.Metal3 v_b.$2691.Metal2 0.0122369f
Cred_13103 v_a.$2520.Metal3 v_b.$3779.Metal3 0.00253026f
Cred_13104 v_a.$2520.Metal3 v_b.P21.nSD 4.9034e-05f
Cred_13105 v_a.$2520.Metal3 v_b.P21.pSD 0.00666964f
Cred_13106 v_a.$2520.Metal3 v_b.P23.pSD 0.00577922f
Cred_13107 v_a.$2520.Metal3 v_b.P37.nSD 3.02512e-06f
Cred_13108 v_a.$2520.Metal3 v_b.P37.pSD 0.000963639f
Cred_13109 v_a.$2523.Metal3 v_b.$2631.Metal2 0.00756137f
Cred_13110 v_a.$2523.Metal3 v_b.$2691.Metal2 0.0214446f
Cred_13111 v_a.$2523.Metal3 v_b.$3779.Metal3 0.00327245f
Cred_13112 v_a.$2523.Metal3 v_b.P21.nSD 8.36706e-05f
Cred_13113 v_a.$2523.Metal3 v_b.P21.pSD 0.0117794f
Cred_13114 v_a.$2523.Metal3 v_b.P23.pSD 0.0107602f
Cred_13115 v_a.$2523.Metal3 v_b.P37.nSD 3.91246e-06f
Cred_13116 v_a.$2523.Metal3 v_b.P37.pSD 0.00159996f
Cred_13117 v_a.$2523.Metal3 VDD.$340.Metal1 4.02054e-06f
Cred_13118 v_a.$2523.Metal3 VDD.$388.Metal2 2.16785e-07f
Cred_13119 v_a.$2523.Metal3 VDD.$42.Metal1 1.0179e-05f
Cred_13120 v_a.$2523.Metal3 VDD.$666.Metal3 9.54403e-09f
Cred_13121 v_a.$2523.Metal3 VDD.P0.nSD 0.00479665f
Cred_13122 v_a.$2527.Metal3 v_b.$2631.Metal2 0.00479621f
Cred_13123 v_a.$2527.Metal3 v_b.$2691.Metal2 0.0132289f
Cred_13124 v_a.$2527.Metal3 v_b.$3779.Metal3 0.00346971f
Cred_13125 v_a.$2527.Metal3 v_b.P21.nSD 5.30726e-05f
Cred_13126 v_a.$2527.Metal3 v_b.P21.pSD 0.0151719f
Cred_13127 v_a.$2527.Metal3 v_b.P23.pSD 0.0131389f
Cred_13128 v_a.$2527.Metal3 v_b.P37.nSD 4.1483e-06f
Cred_13129 v_a.$2527.Metal3 v_b.P37.pSD 0.00208804f
Cred_13130 v_a.$2531.Metal3 v_b.$2631.Metal2 0.0151351f
Cred_13131 v_a.$2531.Metal3 v_b.$2691.Metal2 0.0450935f
Cred_13132 v_a.$2531.Metal3 v_b.$3779.Metal3 0.00586019f
Cred_13133 v_a.$2531.Metal3 v_b.P21.nSD 0.000167478f
Cred_13134 v_a.$2531.Metal3 v_b.P21.pSD 0.0696284f
Cred_13135 v_a.$2531.Metal3 v_b.P23.pSD 0.0677701f
Cred_13136 v_a.$2531.Metal3 v_b.P37.nSD 7.00631e-06f
Cred_13137 v_a.$2531.Metal3 v_b.P37.pSD 0.00415948f
Cred_13138 v_a.$2545.Metal3 v_b.$2691.Metal2 0.12503f
Cred_13139 v_a.$2545.Metal3 v_b.$2751.Metal2 0.0407331f
Cred_13140 v_a.$2545.Metal3 v_b.$3779.Metal3 0.00641722f
Cred_13141 v_a.$2545.Metal3 v_b.P23.nSD 0.0144925f
Cred_13142 v_a.$2545.Metal3 v_b.P23.pSD 0.0109679f
Cred_13143 v_a.$2545.Metal3 v_b.P25.nSD 0.0150051f
Cred_13144 v_a.$2545.Metal3 v_b.P25.pSD 0.011453f
Cred_13145 v_a.$2545.Metal3 v_b.P37.nSD 0.000172865f
Cred_13146 v_a.$2545.Metal3 v_b.P37.pSD 0.000836073f
Cred_13147 v_a.$2545.Metal3 VDD.$340.Metal1 1.80942e-08f
Cred_13148 v_a.$2545.Metal3 VDD.$388.Metal2 5.94769e-10f
Cred_13149 v_a.$2545.Metal3 VDD.$42.Metal1 2.79271e-08f
Cred_13150 v_a.$2545.Metal3 VDD.$666.Metal3 2.6185e-11f
Cred_13151 v_a.$2545.Metal3 VDD.P0.nSD 1.67699e-05f
Cred_13152 v_a.$2545.Metal3 VSS.$17.Metal1 6.85306e-06f
Cred_13153 v_a.$2545.Metal3 VSS.$301.Metal1 3.31887e-06f
Cred_13154 v_a.$2545.Metal3 VSS.$606.Metal2 3.50677e-07f
Cred_13155 v_a.$2545.Metal3 VSS.$760.Metal3 2.07491e-08f
Cred_13156 v_a.$2545.Metal3 VSS.P0.pSD 0.000913018f
Cred_13157 v_a.$2548.Metal3 v_b.$2691.Metal2 0.0163469f
Cred_13158 v_a.$2548.Metal3 v_b.$2751.Metal2 0.00476904f
Cred_13159 v_a.$2548.Metal3 v_b.$3779.Metal3 0.00322635f
Cred_13160 v_a.$2548.Metal3 v_b.P23.pSD 0.00489442f
Cred_13161 v_a.$2548.Metal3 v_b.P25.nSD 5.2772e-05f
Cred_13162 v_a.$2548.Metal3 v_b.P25.pSD 0.00417423f
Cred_13163 v_a.$2548.Metal3 v_b.P37.nSD 3.85735e-06f
Cred_13164 v_a.$2548.Metal3 v_b.P37.pSD 0.00088637f
Cred_13165 v_a.$2548.Metal3 VDD.$340.Metal1 2.48097e-09f
Cred_13166 v_a.$2548.Metal3 VDD.$388.Metal2 8.15513e-11f
Cred_13167 v_a.$2548.Metal3 VDD.$42.Metal1 3.8292e-09f
Cred_13168 v_a.$2548.Metal3 VDD.$666.Metal3 3.59033e-12f
Cred_13169 v_a.$2548.Metal3 VDD.P0.nSD 2.29939e-06f
Cred_13170 v_a.$2550.Metal3 v_b.$2691.Metal2 0.0128436f
Cred_13171 v_a.$2550.Metal3 v_b.$2751.Metal2 0.00384294f
Cred_13172 v_a.$2550.Metal3 v_b.$3779.Metal3 0.00297857f
Cred_13173 v_a.$2550.Metal3 v_b.P23.pSD 0.00658053f
Cred_13174 v_a.$2550.Metal3 v_b.P25.nSD 4.25242e-05f
Cred_13175 v_a.$2550.Metal3 v_b.P25.pSD 0.0058565f
Cred_13176 v_a.$2550.Metal3 v_b.P37.nSD 3.5611e-06f
Cred_13177 v_a.$2550.Metal3 v_b.P37.pSD 0.00113437f
Cred_13178 v_a.$2553.Metal3 v_b.$2691.Metal2 0.0221936f
Cred_13179 v_a.$2553.Metal3 v_b.$2751.Metal2 0.00683509f
Cred_13180 v_a.$2553.Metal3 v_b.$3779.Metal3 0.00385225f
Cred_13181 v_a.$2553.Metal3 v_b.P23.pSD 0.0116274f
Cred_13182 v_a.$2553.Metal3 v_b.P25.nSD 7.56339e-05f
Cred_13183 v_a.$2553.Metal3 v_b.P25.pSD 0.0108977f
Cred_13184 v_a.$2553.Metal3 v_b.P37.nSD 4.60566e-06f
Cred_13185 v_a.$2553.Metal3 v_b.P37.pSD 0.00188343f
Cred_13186 v_a.$2553.Metal3 VDD.$340.Metal1 5.19779e-06f
Cred_13187 v_a.$2553.Metal3 VDD.$388.Metal2 1.69505e-07f
Cred_13188 v_a.$2553.Metal3 VDD.$42.Metal1 7.95901e-06f
Cred_13189 v_a.$2553.Metal3 VDD.$666.Metal3 7.46253e-09f
Cred_13190 v_a.$2553.Metal3 VDD.P0.nSD 0.00479775f
Cred_13191 v_a.$2557.Metal3 v_b.$2691.Metal2 0.0138935f
Cred_13192 v_a.$2557.Metal3 v_b.$2751.Metal2 0.00415161f
Cred_13193 v_a.$2557.Metal3 v_b.$3779.Metal3 0.00408446f
Cred_13194 v_a.$2557.Metal3 v_b.P23.pSD 0.0150754f
Cred_13195 v_a.$2557.Metal3 v_b.P25.nSD 4.59398e-05f
Cred_13196 v_a.$2557.Metal3 v_b.P25.pSD 0.0132224f
Cred_13197 v_a.$2557.Metal3 v_b.P37.nSD 4.88328e-06f
Cred_13198 v_a.$2557.Metal3 v_b.P37.pSD 0.00245799f
Cred_13199 v_a.$2561.Metal3 v_b.$2691.Metal2 0.0454914f
Cred_13200 v_a.$2561.Metal3 v_b.$2751.Metal2 0.0147493f
Cred_13201 v_a.$2561.Metal3 v_b.$3779.Metal3 0.00689848f
Cred_13202 v_a.$2561.Metal3 v_b.P23.pSD 0.0693241f
Cred_13203 v_a.$2561.Metal3 v_b.P25.nSD 0.000163208f
Cred_13204 v_a.$2561.Metal3 v_b.P25.pSD 0.0680667f
Cred_13205 v_a.$2561.Metal3 v_b.P37.nSD 8.24766e-06f
Cred_13206 v_a.$2561.Metal3 v_b.P37.pSD 0.00489644f
Cred_13207 v_a.$2567.Metal3 v_b.$2691.Metal2 0.417775f
Cred_13208 v_a.$2567.Metal3 v_b.$2751.Metal2 0.643756f
Cred_13209 v_a.$2567.Metal3 v_b.$3779.Metal3 0.0237491f
Cred_13210 v_a.$2567.Metal3 v_b.P23.nSD 0.0417725f
Cred_13211 v_a.$2567.Metal3 v_b.P25.nSD 0.143283f
Cred_13212 v_a.$2567.Metal3 v_b.P25.pSD 0.0120776f
Cred_13213 v_a.$2567.Metal3 v_b.P27.nSD 0.0988344f
Cred_13214 v_a.$2567.Metal3 v_b.P27.pSD 0.00656854f
Cred_13215 v_a.$2567.Metal3 v_b.P37.nSD 0.00186786f
Cred_13216 v_a.$2567.Metal3 v_b.P37.pSD 0.000680629f
Cred_13217 v_a.$2567.Metal3 VDD.$340.Metal1 4.90278e-08f
Cred_13218 v_a.$2567.Metal3 VDD.$388.Metal2 9.05091e-10f
Cred_13219 v_a.$2567.Metal3 VDD.$42.Metal1 4.24981e-08f
Cred_13220 v_a.$2567.Metal3 VDD.$666.Metal3 3.9847e-11f
Cred_13221 v_a.$2567.Metal3 VDD.P0.nSD 3.39494e-05f
Cred_13222 v_a.$2567.Metal3 VSS.$17.Metal1 6.02231e-05f
Cred_13223 v_a.$2567.Metal3 VSS.$301.Metal1 4.43172e-05f
Cred_13224 v_a.$2567.Metal3 VSS.$606.Metal2 4.68262e-06f
Cred_13225 v_a.$2567.Metal3 VSS.$760.Metal3 2.77064e-07f
Cred_13226 v_a.$2567.Metal3 VSS.P0.pSD 0.00979286f
Cred_13227 v_a.$2578.Metal3 v_b.$2691.Metal2 0.0112469f
Cred_13228 v_a.$2578.Metal3 v_b.$2751.Metal2 0.0316907f
Cred_13229 v_a.$2578.Metal3 v_b.$3779.Metal3 0.00596059f
Cred_13230 v_a.$2578.Metal3 v_b.P25.nSD 0.000124453f
Cred_13231 v_a.$2578.Metal3 v_b.P25.pSD 0.00912696f
Cred_13232 v_a.$2578.Metal3 v_b.P27.pSD 0.00796274f
Cred_13233 v_a.$2578.Metal3 v_b.P37.nSD 7.12634e-06f
Cred_13234 v_a.$2578.Metal3 v_b.P37.pSD 0.00144613f
Cred_13235 v_a.$2578.Metal3 VDD.$340.Metal1 3.98764e-08f
Cred_13236 v_a.$2578.Metal3 VDD.$388.Metal2 7.36149e-10f
Cred_13237 v_a.$2578.Metal3 VDD.$42.Metal1 3.45655e-08f
Cred_13238 v_a.$2578.Metal3 VDD.$666.Metal3 3.24092e-11f
Cred_13239 v_a.$2578.Metal3 VDD.P0.nSD 2.76125e-05f
Cred_13240 v_a.$2580.Metal3 v_b.$2691.Metal2 0.00443124f
Cred_13241 v_a.$2580.Metal3 v_b.$2751.Metal2 0.0122369f
Cred_13242 v_a.$2580.Metal3 v_b.$3779.Metal3 0.00361992f
Cred_13243 v_a.$2580.Metal3 v_b.P25.nSD 4.9034e-05f
Cred_13244 v_a.$2580.Metal3 v_b.P25.pSD 0.00666964f
Cred_13245 v_a.$2580.Metal3 v_b.P27.pSD 0.00577922f
Cred_13246 v_a.$2580.Metal3 v_b.P37.nSD 4.3279e-06f
Cred_13247 v_a.$2580.Metal3 v_b.P37.pSD 0.00137863f
Cred_13248 v_a.$2583.Metal3 v_b.$2691.Metal2 0.00756137f
Cred_13249 v_a.$2583.Metal3 v_b.$2751.Metal2 0.0214446f
Cred_13250 v_a.$2583.Metal3 v_b.$3779.Metal3 0.00468173f
Cred_13251 v_a.$2583.Metal3 v_b.P25.nSD 8.36706e-05f
Cred_13252 v_a.$2583.Metal3 v_b.P25.pSD 0.0117794f
Cred_13253 v_a.$2583.Metal3 v_b.P27.pSD 0.0107602f
Cred_13254 v_a.$2583.Metal3 v_b.P37.nSD 5.59737e-06f
Cred_13255 v_a.$2583.Metal3 v_b.P37.pSD 0.00228898f
Cred_13256 v_a.$2583.Metal3 VDD.$340.Metal1 6.64641e-06f
Cred_13257 v_a.$2583.Metal3 VDD.$388.Metal2 1.34037e-07f
Cred_13258 v_a.$2583.Metal3 VDD.$42.Metal1 6.29364e-06f
Cred_13259 v_a.$2583.Metal3 VDD.$666.Metal3 5.90104e-09f
Cred_13260 v_a.$2583.Metal3 VDD.P0.nSD 0.004798f
Cred_13261 v_a.$2587.Metal3 v_b.$2691.Metal2 0.00479621f
Cred_13262 v_a.$2587.Metal3 v_b.$2751.Metal2 0.0132289f
Cred_13263 v_a.$2587.Metal3 v_b.$3779.Metal3 0.00496394f
Cred_13264 v_a.$2587.Metal3 v_b.P25.nSD 5.30726e-05f
Cred_13265 v_a.$2587.Metal3 v_b.P25.pSD 0.0151719f
Cred_13266 v_a.$2587.Metal3 v_b.P27.pSD 0.0131389f
Cred_13267 v_a.$2587.Metal3 v_b.P37.nSD 5.93478e-06f
Cred_13268 v_a.$2587.Metal3 v_b.P37.pSD 0.00298726f
Cred_13269 v_a.$2591.Metal3 v_b.$2691.Metal2 0.0151351f
Cred_13270 v_a.$2591.Metal3 v_b.$2751.Metal2 0.0450935f
Cred_13271 v_a.$2591.Metal3 v_b.$3779.Metal3 0.00838389f
Cred_13272 v_a.$2591.Metal3 v_b.P25.nSD 0.000167478f
Cred_13273 v_a.$2591.Metal3 v_b.P25.pSD 0.0696284f
Cred_13274 v_a.$2591.Metal3 v_b.P27.pSD 0.0677701f
Cred_13275 v_a.$2591.Metal3 v_b.P37.nSD 1.00236e-05f
Cred_13276 v_a.$2591.Metal3 v_b.P37.pSD 0.00595077f
Cred_13277 v_a.$2597.Metal3 v_b.$2751.Metal2 0.644206f
Cred_13278 v_a.$2597.Metal3 v_b.$2811.Metal2 0.415335f
Cred_13279 v_a.$2597.Metal3 v_b.$3779.Metal3 0.0347863f
Cred_13280 v_a.$2597.Metal3 v_b.P27.nSD 0.0984141f
Cred_13281 v_a.$2597.Metal3 v_b.P27.pSD 0.00677481f
Cred_13282 v_a.$2597.Metal3 v_b.P29.nSD 0.142051f
Cred_13283 v_a.$2597.Metal3 v_b.P29.pSD 0.0118404f
Cred_13284 v_a.$2597.Metal3 v_b.P31.nSD 0.04156f
Cred_13285 v_a.$2597.Metal3 v_b.P37.nSD 0.0027954f
Cred_13286 v_a.$2597.Metal3 v_b.P37.pSD 0.000880053f
Cred_13287 v_a.$2597.Metal3 VDD.$340.Metal1 1.83972e-08f
Cred_13288 v_a.$2597.Metal3 VDD.$388.Metal2 2.22264e-10f
Cred_13289 v_a.$2597.Metal3 VDD.$42.Metal1 1.04363e-08f
Cred_13290 v_a.$2597.Metal3 VDD.$666.Metal3 9.78526e-12f
Cred_13291 v_a.$2597.Metal3 VDD.P0.nSD 1.03585e-05f
Cred_13292 v_a.$2597.Metal3 VSS.$17.Metal1 3.75561e-05f
Cred_13293 v_a.$2597.Metal3 VSS.$301.Metal1 5.70279e-05f
Cred_13294 v_a.$2597.Metal3 VSS.$606.Metal2 6.02565e-06f
Cred_13295 v_a.$2597.Metal3 VSS.$760.Metal3 3.5653e-07f
Cred_13296 v_a.$2597.Metal3 VSS.P0.pSD 0.00883269f
Cred_13297 v_a.$2608.Metal3 v_b.$2751.Metal2 0.0329095f
Cred_13298 v_a.$2608.Metal3 v_b.$2811.Metal2 0.010065f
Cred_13299 v_a.$2608.Metal3 v_b.$3779.Metal3 0.00759625f
Cred_13300 v_a.$2608.Metal3 v_b.P27.pSD 0.0089008f
Cred_13301 v_a.$2608.Metal3 v_b.P29.nSD 0.000111374f
Cred_13302 v_a.$2608.Metal3 v_b.P29.pSD 0.00816513f
Cred_13303 v_a.$2608.Metal3 v_b.P37.nSD 9.08191e-06f
Cred_13304 v_a.$2608.Metal3 v_b.P37.pSD 0.00184297f
Cred_13305 v_a.$2608.Metal3 VDD.$340.Metal1 1.49632e-08f
Cred_13306 v_a.$2608.Metal3 VDD.$388.Metal2 1.80776e-10f
Cred_13307 v_a.$2608.Metal3 VDD.$42.Metal1 8.48826e-09f
Cred_13308 v_a.$2608.Metal3 VDD.$666.Metal3 7.95876e-12f
Cred_13309 v_a.$2608.Metal3 VDD.P0.nSD 8.42497e-06f
Cred_13310 v_a.$2610.Metal3 v_b.$2751.Metal2 0.0128436f
Cred_13311 v_a.$2610.Metal3 v_b.$2811.Metal2 0.00384294f
Cred_13312 v_a.$2610.Metal3 v_b.$3779.Metal3 0.00461328f
Cred_13313 v_a.$2610.Metal3 v_b.P27.pSD 0.00658053f
Cred_13314 v_a.$2610.Metal3 v_b.P29.nSD 4.25242e-05f
Cred_13315 v_a.$2610.Metal3 v_b.P29.pSD 0.0058565f
Cred_13316 v_a.$2610.Metal3 v_b.P37.nSD 5.51554e-06f
Cred_13317 v_a.$2610.Metal3 v_b.P37.pSD 0.00175695f
Cred_13318 v_a.$2613.Metal3 v_b.$2751.Metal2 0.0221936f
Cred_13319 v_a.$2613.Metal3 v_b.$2811.Metal2 0.00683509f
Cred_13320 v_a.$2613.Metal3 v_b.$3779.Metal3 0.00596647f
Cred_13321 v_a.$2613.Metal3 v_b.P27.pSD 0.0116274f
Cred_13322 v_a.$2613.Metal3 v_b.P29.nSD 7.56339e-05f
Cred_13323 v_a.$2613.Metal3 v_b.P29.pSD 0.0108977f
Cred_13324 v_a.$2613.Metal3 v_b.P37.nSD 7.13337e-06f
Cred_13325 v_a.$2613.Metal3 v_b.P37.pSD 0.00291711f
Cred_13326 v_a.$2613.Metal3 VDD.$340.Metal1 8.48783e-06f
Cred_13327 v_a.$2613.Metal3 VDD.$388.Metal2 1.03365e-07f
Cred_13328 v_a.$2613.Metal3 VDD.$42.Metal1 4.85344e-06f
Cred_13329 v_a.$2613.Metal3 VDD.$666.Metal3 4.55067e-09f
Cred_13330 v_a.$2613.Metal3 VDD.P0.nSD 0.00479763f
Cred_13331 v_a.$2617.Metal3 v_b.$2751.Metal2 0.0138935f
Cred_13332 v_a.$2617.Metal3 v_b.$2811.Metal2 0.00415161f
Cred_13333 v_a.$2617.Metal3 v_b.$3779.Metal3 0.00632612f
Cred_13334 v_a.$2617.Metal3 v_b.P27.pSD 0.0150754f
Cred_13335 v_a.$2617.Metal3 v_b.P29.nSD 4.59398e-05f
Cred_13336 v_a.$2617.Metal3 v_b.P29.pSD 0.0132224f
Cred_13337 v_a.$2617.Metal3 v_b.P37.nSD 7.56336e-06f
Cred_13338 v_a.$2617.Metal3 v_b.P37.pSD 0.00380701f
Cred_13339 v_a.$2621.Metal3 v_b.$2751.Metal2 0.0446437f
Cred_13340 v_a.$2621.Metal3 v_b.$2811.Metal2 0.0144861f
Cred_13341 v_a.$2621.Metal3 v_b.$3779.Metal3 0.0106839f
Cred_13342 v_a.$2621.Metal3 v_b.P27.pSD 0.067437f
Cred_13343 v_a.$2621.Metal3 v_b.P29.nSD 0.000160296f
Cred_13344 v_a.$2621.Metal3 v_b.P29.pSD 0.0663515f
Cred_13345 v_a.$2621.Metal3 v_b.P37.nSD 1.27734e-05f
Cred_13346 v_a.$2621.Metal3 v_b.P37.pSD 0.00758323f
Cred_13347 v_a.$2635.Metal3 v_b.$2751.Metal2 0.0412254f
Cred_13348 v_a.$2635.Metal3 v_b.$2811.Metal2 0.123812f
Cred_13349 v_a.$2635.Metal3 v_b.$3779.Metal3 0.0136981f
Cred_13350 v_a.$2635.Metal3 v_b.P29.nSD 0.0144432f
Cred_13351 v_a.$2635.Metal3 v_b.P29.pSD 0.0117931f
Cred_13352 v_a.$2635.Metal3 v_b.P31.nSD 0.0144188f
Cred_13353 v_a.$2635.Metal3 v_b.P31.pSD 0.0106336f
Cred_13354 v_a.$2635.Metal3 v_b.P37.nSD 0.000368996f
Cred_13355 v_a.$2635.Metal3 v_b.P37.pSD 0.00178467f
Cred_13356 v_a.$2635.Metal3 VDD.$340.Metal1 3.81575e-08f
Cred_13357 v_a.$2635.Metal3 VDD.$388.Metal2 2.7833e-10f
Cred_13358 v_a.$2635.Metal3 VDD.$42.Metal1 1.30688e-08f
Cred_13359 v_a.$2635.Metal3 VDD.$666.Metal3 1.22536e-11f
Cred_13360 v_a.$2635.Metal3 VDD.P0.nSD 1.6765e-05f
Cred_13361 v_a.$2635.Metal3 VSS.$17.Metal1 3.22049e-06f
Cred_13362 v_a.$2635.Metal3 VSS.$301.Metal1 6.96909e-06f
Cred_13363 v_a.$2635.Metal3 VSS.$606.Metal2 7.36365e-07f
Cred_13364 v_a.$2635.Metal3 VSS.$760.Metal3 4.35697e-08f
Cred_13365 v_a.$2635.Metal3 VSS.P0.pSD 0.000912591f
Cred_13366 v_a.$2638.Metal3 v_b.$2751.Metal2 0.00569991f
Cred_13367 v_a.$2638.Metal3 v_b.$2811.Metal2 0.0153866f
Cred_13368 v_a.$2638.Metal3 v_b.$3779.Metal3 0.00688693f
Cred_13369 v_a.$2638.Metal3 v_b.P29.nSD 6.30725e-05f
Cred_13370 v_a.$2638.Metal3 v_b.P29.pSD 0.00500849f
Cred_13371 v_a.$2638.Metal3 v_b.P31.pSD 0.00407827f
Cred_13372 v_a.$2638.Metal3 v_b.P37.nSD 8.23386e-06f
Cred_13373 v_a.$2638.Metal3 v_b.P37.pSD 0.00189204f
Cred_13374 v_a.$2638.Metal3 VDD.$340.Metal1 5.23193e-09f
Cred_13375 v_a.$2638.Metal3 VDD.$388.Metal2 3.8163e-11f
Cred_13376 v_a.$2638.Metal3 VDD.$42.Metal1 1.79192e-09f
Cred_13377 v_a.$2638.Metal3 VDD.$666.Metal3 1.68014e-12f
Cred_13378 v_a.$2638.Metal3 VDD.P0.nSD 2.29873e-06f
Cred_13379 v_a.$2640.Metal3 v_b.$2751.Metal2 0.00443124f
Cred_13380 v_a.$2640.Metal3 v_b.$2811.Metal2 0.0122369f
Cred_13381 v_a.$2640.Metal3 v_b.$3779.Metal3 0.00635801f
Cred_13382 v_a.$2640.Metal3 v_b.P29.nSD 4.9034e-05f
Cred_13383 v_a.$2640.Metal3 v_b.P29.pSD 0.00666964f
Cred_13384 v_a.$2640.Metal3 v_b.P31.pSD 0.00577922f
Cred_13385 v_a.$2640.Metal3 v_b.P37.nSD 7.60149e-06f
Cred_13386 v_a.$2640.Metal3 v_b.P37.pSD 0.00242142f
Cred_13387 v_a.$2643.Metal3 v_b.$2751.Metal2 0.00756137f
Cred_13388 v_a.$2643.Metal3 v_b.$2811.Metal2 0.0214446f
Cred_13389 v_a.$2643.Metal3 v_b.$3779.Metal3 0.00822297f
Cred_13390 v_a.$2643.Metal3 v_b.P29.nSD 8.36706e-05f
Cred_13391 v_a.$2643.Metal3 v_b.P29.pSD 0.0117794f
Cred_13392 v_a.$2643.Metal3 v_b.P31.pSD 0.0107602f
Cred_13393 v_a.$2643.Metal3 v_b.P37.nSD 9.83119e-06f
Cred_13394 v_a.$2643.Metal3 v_b.P37.pSD 0.00402036f
Cred_13395 v_a.$2643.Metal3 VDD.$340.Metal1 1.08735e-05f
Cred_13396 v_a.$2643.Metal3 VDD.$388.Metal2 7.99536e-08f
Cred_13397 v_a.$2643.Metal3 VDD.$42.Metal1 3.75418e-06f
Cred_13398 v_a.$2643.Metal3 VDD.$666.Metal3 3.51999e-09f
Cred_13399 v_a.$2643.Metal3 VDD.P0.nSD 0.00479637f
Cred_13400 v_a.$2647.Metal3 v_b.$2751.Metal2 0.00479621f
Cred_13401 v_a.$2647.Metal3 v_b.$2811.Metal2 0.0132289f
Cred_13402 v_a.$2647.Metal3 v_b.$3779.Metal3 0.00871864f
Cred_13403 v_a.$2647.Metal3 v_b.P29.nSD 5.30726e-05f
Cred_13404 v_a.$2647.Metal3 v_b.P29.pSD 0.0151719f
Cred_13405 v_a.$2647.Metal3 v_b.P31.pSD 0.0131389f
Cred_13406 v_a.$2647.Metal3 v_b.P37.nSD 1.04238e-05f
Cred_13407 v_a.$2647.Metal3 v_b.P37.pSD 0.00524681f
Cred_13408 v_a.$2651.Metal3 v_b.$2751.Metal2 0.01516f
Cred_13409 v_a.$2651.Metal3 v_b.$2811.Metal2 0.0450933f
Cred_13410 v_a.$2651.Metal3 v_b.$3779.Metal3 0.0147254f
Cred_13411 v_a.$2651.Metal3 v_b.P29.nSD 0.000167754f
Cred_13412 v_a.$2651.Metal3 v_b.P29.pSD 0.0698092f
Cred_13413 v_a.$2651.Metal3 v_b.P31.pSD 0.0676828f
Cred_13414 v_a.$2651.Metal3 v_b.P37.nSD 1.76054e-05f
Cred_13415 v_a.$2651.Metal3 v_b.P37.pSD 0.0104519f
Cred_13416 v_a.$2657.Metal3 v_b.$1992.Metal1 3.86337e-07f
Cred_13417 v_a.$2657.Metal3 v_b.$2003.Metal1 0.000204073f
Cred_13418 v_a.$2657.Metal3 v_b.$2751.Metal2 0.0750611f
Cred_13419 v_a.$2657.Metal3 v_b.$2811.Metal2 1.13341f
Cred_13420 v_a.$2657.Metal3 v_b.$2871.Metal2 1.1983f
Cred_13421 v_a.$2657.Metal3 v_b.$2962.Metal2 3.42099e-06f
Cred_13422 v_a.$2657.Metal3 v_b.$3053.Metal2 3.51933e-06f
Cred_13423 v_a.$2657.Metal3 v_b.$3056.Metal2 2.84973e-06f
Cred_13424 v_a.$2657.Metal3 v_b.$3089.Metal2 7.08372e-07f
Cred_13425 v_a.$2657.Metal3 v_b.$3487.Metal2 3.78204e-05f
Cred_13426 v_a.$2657.Metal3 v_b.$3491.Metal2 4.26724e-06f
Cred_13427 v_a.$2657.Metal3 v_b.$3495.Metal2 4.01903e-06f
Cred_13428 v_a.$2657.Metal3 v_b.$3499.Metal2 3.8095e-06f
Cred_13429 v_a.$2657.Metal3 v_b.$3503.Metal2 1.06558e-05f
Cred_13430 v_a.$2657.Metal3 v_b.$3505.Metal2 1.40995e-05f
Cred_13431 v_a.$2657.Metal3 v_b.$3507.Metal2 0.0006384f
Cred_13432 v_a.$2657.Metal3 v_b.$3779.Metal3 0.752892f
Cred_13433 v_a.$2657.Metal3 v_b.$3785.Metal3 0.107553f
Cred_13434 v_a.$2657.Metal3 v_b.$3821.Metal3 0.0662159f
Cred_13435 v_a.$2657.Metal3 v_b.$3857.Metal3 0.0231133f
Cred_13436 v_a.$2657.Metal3 v_b.$3890.Metal3 0.0242689f
Cred_13437 v_a.$2657.Metal3 v_b.$3903.Metal3 0.0373685f
Cred_13438 v_a.$2657.Metal3 v_b.$3934.Metal3 0.0306903f
Cred_13439 v_a.$2657.Metal3 v_b.$3970.Metal3 0.0115347f
Cred_13440 v_a.$2657.Metal3 v_b.$3980.Metal3 0.0036178f
Cred_13441 v_a.$2657.Metal3 v_b.$3982.Metal3 0.00206982f
Cred_13442 v_a.$2657.Metal3 v_b.$3984.Metal3 0.00195558f
Cred_13443 v_a.$2657.Metal3 v_b.$3986.Metal3 0.00273526f
Cred_13444 v_a.$2657.Metal3 v_b.$3990.Metal3 0.00847727f
Cred_13445 v_a.$2657.Metal3 v_b.$4009.Metal3 0.0226625f
Cred_13446 v_a.$2657.Metal3 v_b.P29.nSD 0.0411461f
Cred_13447 v_a.$2657.Metal3 v_b.P29.pSD 0.00150938f
Cred_13448 v_a.$2657.Metal3 v_b.P31.nSD 0.143604f
Cred_13449 v_a.$2657.Metal3 v_b.P31.pSD 0.0066261f
Cred_13450 v_a.$2657.Metal3 v_b.P33.nSD 0.195993f
Cred_13451 v_a.$2657.Metal3 v_b.P33.pSD 0.451703f
Cred_13452 v_a.$2657.Metal3 v_b.P35.nSD 0.0876823f
Cred_13453 v_a.$2657.Metal3 v_b.P35.pSD 0.422828f
Cred_13454 v_a.$2657.Metal3 v_b.P37.nSD 0.0260437f
Cred_13455 v_a.$2657.Metal3 v_b.P37.pSD 0.150322f
Cred_13456 v_a.$2657.Metal3 v_b.P41.nSD 0.00216519f
Cred_13457 v_a.$2657.Metal3 v_b.P41.pSD 0.0215563f
Cred_13458 v_a.$2657.Metal3 v_b.P45.nSD 0.00134858f
Cred_13459 v_a.$2657.Metal3 v_b.P45.pSD 0.0134086f
Cred_13460 v_a.$2657.Metal3 v_b.P49.nSD 0.00101983f
Cred_13461 v_a.$2657.Metal3 v_b.P49.pSD 0.00983113f
Cred_13462 v_a.$2657.Metal3 v_b.P53.nSD 0.000767662f
Cred_13463 v_a.$2657.Metal3 v_b.P53.pSD 0.00763386f
Cred_13464 v_a.$2657.Metal3 v_b.P57.nSD 0.000630776f
Cred_13465 v_a.$2657.Metal3 v_b.P57.pSD 0.00627944f
Cred_13466 v_a.$2657.Metal3 v_b.P61.nSD 0.000536482f
Cred_13467 v_a.$2657.Metal3 v_b.P61.pSD 0.000141077f
Cred_13468 v_a.$2657.Metal3 v_b.P65.nSD 0.000465771f
Cred_13469 v_a.$2657.Metal3 v_b.P65.pSD 0.00463655f
Cred_13470 v_a.$2657.Metal3 VDD.$230.Metal1 0.000974687f
Cred_13471 v_a.$2657.Metal3 VDD.$238.Metal1 0.000199253f
Cred_13472 v_a.$2657.Metal3 VDD.$340.Metal1 2.16978e-05f
Cred_13473 v_a.$2657.Metal3 VDD.$388.Metal2 5.74645e-08f
Cred_13474 v_a.$2657.Metal3 VDD.$42.Metal1 2.69821e-06f
Cred_13475 v_a.$2657.Metal3 VDD.$552.Metal2 0.000392889f
Cred_13476 v_a.$2657.Metal3 VDD.$560.Metal2 0.000398939f
Cred_13477 v_a.$2657.Metal3 VDD.$568.Metal2 2.23676e-06f
Cred_13478 v_a.$2657.Metal3 VDD.$666.Metal3 2.5299e-09f
Cred_13479 v_a.$2657.Metal3 VDD.$750.Metal3 0.0028236f
Cred_13480 v_a.$2657.Metal3 VDD.$758.Metal3 0.000139765f
Cred_13481 v_a.$2657.Metal3 VDD.P0.nSD 0.00576326f
Cred_13482 v_a.$2657.Metal3 VSS.$17.Metal1 4.09783e-05f
Cred_13483 v_a.$2657.Metal3 VSS.$213.Metal1 0.00087393f
Cred_13484 v_a.$2657.Metal3 VSS.$221.Metal1 0.000179226f
Cred_13485 v_a.$2657.Metal3 VSS.$301.Metal1 0.000168275f
Cred_13486 v_a.$2657.Metal3 VSS.$526.Metal2 1.38213e-06f
Cred_13487 v_a.$2657.Metal3 VSS.$606.Metal2 1.77802e-05f
Cred_13488 v_a.$2657.Metal3 VSS.$716.Metal3 0.00402368f
Cred_13489 v_a.$2657.Metal3 VSS.$760.Metal3 1.05203e-06f
Cred_13490 v_a.$2657.Metal3 VSS.P0.pSD 0.0157415f
Cred_13491 v_a.$2668.Metal3 v_b.$2811.Metal2 0.0306706f
Cred_13492 v_a.$2668.Metal3 v_b.$2871.Metal2 0.0100288f
Cred_13493 v_a.$2668.Metal3 v_b.$3779.Metal3 0.0192887f
Cred_13494 v_a.$2668.Metal3 v_b.P31.pSD 0.00799616f
Cred_13495 v_a.$2668.Metal3 v_b.P33.nSD 0.000110974f
Cred_13496 v_a.$2668.Metal3 v_b.P33.pSD 0.00815255f
Cred_13497 v_a.$2668.Metal3 v_b.P37.nSD 2.30612e-05f
Cred_13498 v_a.$2668.Metal3 v_b.P37.pSD 0.00474091f
Cred_13499 v_a.$2668.Metal3 VDD.$340.Metal1 2.46487e-08f
Cred_13500 v_a.$2668.Metal3 VDD.$388.Metal2 1.08162e-10f
Cred_13501 v_a.$2668.Metal3 VDD.$42.Metal1 5.0787e-09f
Cred_13502 v_a.$2668.Metal3 VDD.$666.Metal3 4.76188e-12f
Cred_13503 v_a.$2668.Metal3 VDD.P0.nSD 8.41877e-06f
Cred_13504 v_a.$2670.Metal3 v_b.$2811.Metal2 0.0113726f
Cred_13505 v_a.$2670.Metal3 v_b.$2871.Metal2 0.00375189f
Cred_13506 v_a.$2670.Metal3 v_b.$3779.Metal3 0.0121901f
Cred_13507 v_a.$2670.Metal3 v_b.P31.pSD 0.00560448f
Cred_13508 v_a.$2670.Metal3 v_b.P33.nSD 4.15167e-05f
Cred_13509 v_a.$2670.Metal3 v_b.P33.pSD 0.00567993f
Cred_13510 v_a.$2670.Metal3 v_b.P37.nSD 1.45741e-05f
Cred_13511 v_a.$2670.Metal3 v_b.P37.pSD 0.00464253f
Cred_13512 v_a.$2673.Metal3 v_b.$2811.Metal2 0.0201642f
Cred_13513 v_a.$2673.Metal3 v_b.$2871.Metal2 0.00665227f
Cred_13514 v_a.$2673.Metal3 v_b.$3779.Metal3 0.0157657f
Cred_13515 v_a.$2673.Metal3 v_b.P31.pSD 0.0104094f
Cred_13516 v_a.$2673.Metal3 v_b.P33.nSD 7.36109e-05f
Cred_13517 v_a.$2673.Metal3 v_b.P33.pSD 0.0105431f
Cred_13518 v_a.$2673.Metal3 v_b.P37.nSD 1.88491e-05f
Cred_13519 v_a.$2673.Metal3 v_b.P37.pSD 0.00770813f
Cred_13520 v_a.$2673.Metal3 VDD.$340.Metal1 1.39802e-05f
Cred_13521 v_a.$2673.Metal3 VDD.$388.Metal2 6.18452e-08f
Cred_13522 v_a.$2673.Metal3 VDD.$42.Metal1 2.90391e-06f
Cred_13523 v_a.$2673.Metal3 VDD.$666.Metal3 2.72276e-09f
Cred_13524 v_a.$2673.Metal3 VDD.P0.nSD 0.00479413f
Cred_13525 v_a.$2677.Metal3 v_b.$2811.Metal2 0.0122985f
Cred_13526 v_a.$2677.Metal3 v_b.$2871.Metal2 0.00405735f
Cred_13527 v_a.$2677.Metal3 v_b.$3779.Metal3 0.016716f
Cred_13528 v_a.$2677.Metal3 v_b.P31.pSD 0.0127937f
Cred_13529 v_a.$2677.Metal3 v_b.P33.nSD 4.48968e-05f
Cred_13530 v_a.$2677.Metal3 v_b.P33.pSD 0.0128753f
Cred_13531 v_a.$2677.Metal3 v_b.P37.nSD 1.99853e-05f
Cred_13532 v_a.$2677.Metal3 v_b.P37.pSD 0.0100596f
Cred_13533 v_a.$2681.Metal3 v_b.$2811.Metal2 0.0427167f
Cred_13534 v_a.$2681.Metal3 v_b.$2871.Metal2 0.0140723f
Cred_13535 v_a.$2681.Metal3 v_b.$3779.Metal3 0.0282308f
Cred_13536 v_a.$2681.Metal3 v_b.P31.pSD 0.0645338f
Cred_13537 v_a.$2681.Metal3 v_b.P33.nSD 0.000155717f
Cred_13538 v_a.$2681.Metal3 v_b.P33.pSD 0.0646014f
Cred_13539 v_a.$2681.Metal3 v_b.P37.nSD 3.37521e-05f
Cred_13540 v_a.$2681.Metal3 v_b.P37.pSD 0.0200378f
Cred_13541 v_a.$291.Metal1 v_b.$2421.Metal2 0.0210813f
Cred_13542 v_a.$291.Metal1 v_b.$2481.Metal2 0.0643823f
Cred_13543 v_a.$291.Metal1 v_b.P10.pSD 0.0622754f
Cred_13544 v_a.$291.Metal1 v_b.P7.nSD 0.000233276f
Cred_13545 v_a.$291.Metal1 v_b.P7.pSD 0.0618654f
Cred_13546 v_a.$291.Metal1 VDD.$340.Metal1 1.06737e-06f
Cred_13547 v_a.$291.Metal1 VDD.$388.Metal2 2.07927e-06f
Cred_13548 v_a.$291.Metal1 VDD.$42.Metal1 9.76308e-05f
Cred_13549 v_a.$291.Metal1 VDD.$666.Metal3 9.15405e-08f
Cred_13550 v_a.$291.Metal1 VDD.P0.nSD 0.00763449f
Cred_13551 v_a.$293.Metal1 v_b.$2421.Metal2 0.0136983f
Cred_13552 v_a.$293.Metal1 v_b.$2481.Metal2 0.04209f
Cred_13553 v_a.$293.Metal1 v_b.P10.pSD 0.048231f
Cred_13554 v_a.$293.Metal1 v_b.P7.nSD 0.000151578f
Cred_13555 v_a.$293.Metal1 v_b.P7.pSD 0.0475412f
Cred_13556 v_a.$296.Metal1 v_b.$2421.Metal2 0.0127162f
Cred_13557 v_a.$296.Metal1 v_b.$2481.Metal2 0.0390725f
Cred_13558 v_a.$296.Metal1 v_b.P10.pSD 0.0503136f
Cred_13559 v_a.$296.Metal1 v_b.P7.nSD 0.000140712f
Cred_13560 v_a.$296.Metal1 v_b.P7.pSD 0.0495624f
Cred_13561 v_a.$298.Metal1 v_b.$2421.Metal2 0.00943136f
Cred_13562 v_a.$298.Metal1 v_b.$2481.Metal2 0.0289793f
Cred_13563 v_a.$298.Metal1 v_b.P10.pSD 0.0420697f
Cred_13564 v_a.$298.Metal1 v_b.P7.nSD 0.000104363f
Cred_13565 v_a.$298.Metal1 v_b.P7.pSD 0.0414174f
Cred_13566 v_a.$300.Metal1 v_b.$2421.Metal2 0.0109462f
Cred_13567 v_a.$300.Metal1 v_b.$2481.Metal2 0.0331138f
Cred_13568 v_a.$300.Metal1 v_b.P10.pSD 0.0535747f
Cred_13569 v_a.$300.Metal1 v_b.P7.nSD 0.000121125f
Cred_13570 v_a.$300.Metal1 v_b.P7.pSD 0.054001f
Cred_13571 v_a.$303.Metal1 v_b.$2421.Metal2 0.0100237f
Cred_13572 v_a.$303.Metal1 v_b.$2481.Metal2 0.0305412f
Cred_13573 v_a.$303.Metal1 v_b.P10.pSD 0.0556751f
Cred_13574 v_a.$303.Metal1 v_b.P7.nSD 0.000110918f
Cred_13575 v_a.$303.Metal1 v_b.P7.pSD 0.0553975f
Cred_13576 v_a.$305.Metal1 v_b.$2421.Metal2 0.0269914f
Cred_13577 v_a.$305.Metal1 v_b.$2481.Metal2 0.0827837f
Cred_13578 v_a.$305.Metal1 v_b.P10.pSD 0.174785f
Cred_13579 v_a.$305.Metal1 v_b.P7.nSD 0.000298674f
Cred_13580 v_a.$305.Metal1 v_b.P7.pSD 0.172154f
Cred_13581 v_a.$354.Metal1 v_b.$2481.Metal2 0.064138f
Cred_13582 v_a.$354.Metal1 v_b.$2541.Metal2 0.0213182f
Cred_13583 v_a.$354.Metal1 v_b.P10.pSD 0.0614415f
Cred_13584 v_a.$354.Metal1 v_b.P11.nSD 0.000235897f
Cred_13585 v_a.$354.Metal1 v_b.P11.pSD 0.0627041f
Cred_13586 v_a.$354.Metal1 VDD.$340.Metal1 1.37948e-06f
Cred_13587 v_a.$354.Metal1 VDD.$388.Metal2 1.6088e-06f
Cred_13588 v_a.$354.Metal1 VDD.$42.Metal1 7.55404e-05f
Cred_13589 v_a.$354.Metal1 VDD.$666.Metal3 7.08281e-08f
Cred_13590 v_a.$354.Metal1 VDD.P0.nSD 0.00765676f
Cred_13591 v_a.$356.Metal1 v_b.$2481.Metal2 0.0418015f
Cred_13592 v_a.$356.Metal1 v_b.$2541.Metal2 0.013978f
Cred_13593 v_a.$356.Metal1 v_b.P10.pSD 0.0472658f
Cred_13594 v_a.$356.Metal1 v_b.P11.nSD 0.000154674f
Cred_13595 v_a.$356.Metal1 v_b.P11.pSD 0.0485121f
Cred_13596 v_a.$359.Metal1 v_b.$2481.Metal2 0.0388047f
Cred_13597 v_a.$359.Metal1 v_b.$2541.Metal2 0.0129759f
Cred_13598 v_a.$359.Metal1 v_b.P10.pSD 0.0493067f
Cred_13599 v_a.$359.Metal1 v_b.P11.nSD 0.000143585f
Cred_13600 v_a.$359.Metal1 v_b.P11.pSD 0.0505745f
Cred_13601 v_a.$361.Metal1 v_b.$2481.Metal2 0.0287807f
Cred_13602 v_a.$361.Metal1 v_b.$2541.Metal2 0.00962396f
Cred_13603 v_a.$361.Metal1 v_b.P10.pSD 0.0412278f
Cred_13604 v_a.$361.Metal1 v_b.P11.nSD 0.000106494f
Cred_13605 v_a.$361.Metal1 v_b.P11.pSD 0.0422632f
Cred_13606 v_a.$363.Metal1 v_b.$2481.Metal2 0.0331473f
Cred_13607 v_a.$363.Metal1 v_b.$2541.Metal2 0.0109137f
Cred_13608 v_a.$363.Metal1 v_b.P10.pSD 0.0537809f
Cred_13609 v_a.$363.Metal1 v_b.P11.nSD 0.000120766f
Cred_13610 v_a.$363.Metal1 v_b.P11.pSD 0.0537941f
Cred_13611 v_a.$366.Metal1 v_b.$2481.Metal2 0.0304612f
Cred_13612 v_a.$366.Metal1 v_b.$2541.Metal2 0.0101013f
Cred_13613 v_a.$366.Metal1 v_b.P10.pSD 0.055196f
Cred_13614 v_a.$366.Metal1 v_b.P11.nSD 0.000111776f
Cred_13615 v_a.$366.Metal1 v_b.P11.pSD 0.0558782f
Cred_13616 v_a.$368.Metal1 v_b.$2481.Metal2 0.0822923f
Cred_13617 v_a.$368.Metal1 v_b.$2541.Metal2 0.027468f
Cred_13618 v_a.$368.Metal1 v_b.P10.pSD 0.171611f
Cred_13619 v_a.$368.Metal1 v_b.P11.nSD 0.000303948f
Cred_13620 v_a.$368.Metal1 v_b.P11.pSD 0.175337f
Cred_13621 v_a.$39.Metal1 v_b.$2361.Metal2 0.078375f
Cred_13622 v_a.$39.Metal1 v_b.P0.nSD 0.000312414f
Cred_13623 v_a.$39.Metal1 v_b.P0.pSD 0.0677515f
Cred_13624 v_a.$39.Metal1 v_b.P1.pSD 0.0628027f
Cred_13625 v_a.$39.Metal1 VDD.$340.Metal1 3.84268e-07f
Cred_13626 v_a.$39.Metal1 VDD.$388.Metal2 5.81189e-06f
Cred_13627 v_a.$39.Metal1 VDD.$42.Metal1 0.000272894f
Cred_13628 v_a.$39.Metal1 VDD.$666.Metal3 2.55871e-07f
Cred_13629 v_a.$39.Metal1 VDD.P0.nSD 0.00746031f
Cred_13630 v_a.$41.Metal1 v_b.$2361.Metal2 0.0510845f
Cred_13631 v_a.$41.Metal1 v_b.P0.nSD 0.000206226f
Cred_13632 v_a.$41.Metal1 v_b.P0.pSD 0.0521335f
Cred_13633 v_a.$41.Metal1 v_b.P1.pSD 0.04783f
Cred_13634 v_a.$417.Metal1 v_b.$2481.Metal2 0.0210746f
Cred_13635 v_a.$417.Metal1 v_b.$2541.Metal2 0.0643621f
Cred_13636 v_a.$417.Metal1 v_b.P11.nSD 0.000233202f
Cred_13637 v_a.$417.Metal1 v_b.P11.pSD 0.0618604f
Cred_13638 v_a.$417.Metal1 v_b.P13.pSD 0.0622705f
Cred_13639 v_a.$417.Metal1 VDD.$340.Metal1 1.78308e-06f
Cred_13640 v_a.$417.Metal1 VDD.$388.Metal2 1.24504e-06f
Cred_13641 v_a.$417.Metal1 VDD.$42.Metal1 5.84599e-05f
Cred_13642 v_a.$417.Metal1 VDD.$666.Metal3 5.48132e-08f
Cred_13643 v_a.$417.Metal1 VDD.P0.nSD 0.0076738f
Cred_13644 v_a.$419.Metal1 v_b.$2481.Metal2 0.0136983f
Cred_13645 v_a.$419.Metal1 v_b.$2541.Metal2 0.04209f
Cred_13646 v_a.$419.Metal1 v_b.P11.nSD 0.000151578f
Cred_13647 v_a.$419.Metal1 v_b.P11.pSD 0.0475412f
Cred_13648 v_a.$419.Metal1 v_b.P13.pSD 0.048231f
Cred_13649 v_a.$422.Metal1 v_b.$2481.Metal2 0.0127162f
Cred_13650 v_a.$422.Metal1 v_b.$2541.Metal2 0.0390725f
Cred_13651 v_a.$422.Metal1 v_b.P11.nSD 0.000140712f
Cred_13652 v_a.$422.Metal1 v_b.P11.pSD 0.0495624f
Cred_13653 v_a.$422.Metal1 v_b.P13.pSD 0.0503136f
Cred_13654 v_a.$424.Metal1 v_b.$2481.Metal2 0.00943136f
Cred_13655 v_a.$424.Metal1 v_b.$2541.Metal2 0.0289793f
Cred_13656 v_a.$424.Metal1 v_b.P11.nSD 0.000104363f
Cred_13657 v_a.$424.Metal1 v_b.P11.pSD 0.0414174f
Cred_13658 v_a.$424.Metal1 v_b.P13.pSD 0.0420697f
Cred_13659 v_a.$426.Metal1 v_b.$2481.Metal2 0.0109462f
Cred_13660 v_a.$426.Metal1 v_b.$2541.Metal2 0.0331138f
Cred_13661 v_a.$426.Metal1 v_b.P11.nSD 0.000121125f
Cred_13662 v_a.$426.Metal1 v_b.P11.pSD 0.054001f
Cred_13663 v_a.$426.Metal1 v_b.P13.pSD 0.0535747f
Cred_13664 v_a.$429.Metal1 v_b.$2481.Metal2 0.0100237f
Cred_13665 v_a.$429.Metal1 v_b.$2541.Metal2 0.0305412f
Cred_13666 v_a.$429.Metal1 v_b.P11.nSD 0.000110918f
Cred_13667 v_a.$429.Metal1 v_b.P11.pSD 0.0553975f
Cred_13668 v_a.$429.Metal1 v_b.P13.pSD 0.0556751f
Cred_13669 v_a.$431.Metal1 v_b.$2481.Metal2 0.0269914f
Cred_13670 v_a.$431.Metal1 v_b.$2541.Metal2 0.0827837f
Cred_13671 v_a.$431.Metal1 v_b.P11.nSD 0.000298674f
Cred_13672 v_a.$431.Metal1 v_b.P11.pSD 0.172154f
Cred_13673 v_a.$431.Metal1 v_b.P13.pSD 0.174785f
Cred_13674 v_a.$44.Metal1 v_b.$2361.Metal2 0.0475438f
Cred_13675 v_a.$44.Metal1 v_b.P0.nSD 0.000192149f
Cred_13676 v_a.$44.Metal1 v_b.P0.pSD 0.0540259f
Cred_13677 v_a.$44.Metal1 v_b.P1.pSD 0.0499869f
Cred_13678 v_a.$46.Metal1 v_b.$2361.Metal2 0.0352881f
Cred_13679 v_a.$46.Metal1 v_b.P0.nSD 0.000142323f
Cred_13680 v_a.$46.Metal1 v_b.P0.pSD 0.0446948f
Cred_13681 v_a.$46.Metal1 v_b.P1.pSD 0.0418924f
Cred_13682 v_a.$48.Metal1 v_b.$2361.Metal2 0.132616f
Cred_13683 v_a.$48.Metal1 v_b.P0.nSD 0.000535405f
Cred_13684 v_a.$48.Metal1 v_b.P0.pSD 0.206774f
Cred_13685 v_a.$48.Metal1 v_b.P1.pSD 0.196913f
Cred_13686 v_a.$48.Metal1 VDD.$340.Metal1 4.50756e-14f
Cred_13687 v_a.$48.Metal1 VDD.$388.Metal2 1.95953e-05f
Cred_13688 v_a.$48.Metal1 VDD.$392.Metal2 5.0766e-09f
Cred_13689 v_a.$48.Metal1 VDD.$42.Metal1 8.6558e-06f
Cred_13690 v_a.$48.Metal1 VDD.$55.Metal1 8.70913e-07f
Cred_13691 v_a.$48.Metal1 VDD.$666.Metal3 0.000187101f
Cred_13692 v_a.$48.Metal1 VDD.P0.nSD 2.14223e-08f
Cred_13693 v_a.$480.Metal1 v_b.$2541.Metal2 0.064138f
Cred_13694 v_a.$480.Metal1 v_b.$2601.Metal2 0.0213182f
Cred_13695 v_a.$480.Metal1 v_b.P13.pSD 0.0614415f
Cred_13696 v_a.$480.Metal1 v_b.P15.nSD 0.000235897f
Cred_13697 v_a.$480.Metal1 v_b.P15.pSD 0.0627041f
Cred_13698 v_a.$480.Metal1 VDD.$340.Metal1 2.30494e-06f
Cred_13699 v_a.$480.Metal1 VDD.$388.Metal2 9.63846e-07f
Cred_13700 v_a.$480.Metal1 VDD.$42.Metal1 4.52569e-05f
Cred_13701 v_a.$480.Metal1 VDD.$666.Metal3 4.24337e-08f
Cred_13702 v_a.$480.Metal1 VDD.P0.nSD 0.00768679f
Cred_13703 v_a.$482.Metal1 v_b.$2541.Metal2 0.0418015f
Cred_13704 v_a.$482.Metal1 v_b.$2601.Metal2 0.013978f
Cred_13705 v_a.$482.Metal1 v_b.P13.pSD 0.0472658f
Cred_13706 v_a.$482.Metal1 v_b.P15.nSD 0.000154674f
Cred_13707 v_a.$482.Metal1 v_b.P15.pSD 0.0485121f
Cred_13708 v_a.$485.Metal1 v_b.$2541.Metal2 0.0388047f
Cred_13709 v_a.$485.Metal1 v_b.$2601.Metal2 0.0129759f
Cred_13710 v_a.$485.Metal1 v_b.P13.pSD 0.0493067f
Cred_13711 v_a.$485.Metal1 v_b.P15.nSD 0.000143585f
Cred_13712 v_a.$485.Metal1 v_b.P15.pSD 0.0505745f
Cred_13713 v_a.$487.Metal1 v_b.$2541.Metal2 0.0287807f
Cred_13714 v_a.$487.Metal1 v_b.$2601.Metal2 0.00962396f
Cred_13715 v_a.$487.Metal1 v_b.P13.pSD 0.0412278f
Cred_13716 v_a.$487.Metal1 v_b.P15.nSD 0.000106494f
Cred_13717 v_a.$487.Metal1 v_b.P15.pSD 0.0422632f
Cred_13718 v_a.$489.Metal1 v_b.$2541.Metal2 0.108103f
Cred_13719 v_a.$489.Metal1 v_b.$2601.Metal2 0.0358232f
Cred_13720 v_a.$489.Metal1 v_b.P13.pSD 0.194109f
Cred_13721 v_a.$489.Metal1 v_b.P15.nSD 0.000396403f
Cred_13722 v_a.$489.Metal1 v_b.P15.pSD 0.196447f
Cred_13723 v_a.$606.Metal1 v_b.$2601.Metal2 0.0427642f
Cred_13724 v_a.$606.Metal1 v_b.$2631.Metal2 0.0433684f
Cred_13725 v_a.$606.Metal1 v_b.P17.pSD 0.0614338f
Cred_13726 v_a.$606.Metal1 v_b.P19.pSD 0.0622873f
Cred_13727 v_a.$606.Metal1 VDD.$340.Metal1 3.85203e-06f
Cred_13728 v_a.$606.Metal1 VDD.$388.Metal2 5.78833e-07f
Cred_13729 v_a.$606.Metal1 VDD.$42.Metal1 2.71788e-05f
Cred_13730 v_a.$606.Metal1 VDD.$666.Metal3 2.54834e-08f
Cred_13731 v_a.$606.Metal1 VDD.P0.nSD 0.00770372f
Cred_13732 v_a.$608.Metal1 v_b.$2601.Metal2 0.0278235f
Cred_13733 v_a.$608.Metal1 v_b.$2631.Metal2 0.0283917f
Cred_13734 v_a.$608.Metal1 v_b.P17.pSD 0.0472658f
Cred_13735 v_a.$608.Metal1 v_b.P19.pSD 0.048231f
Cred_13736 v_a.$611.Metal1 v_b.$2601.Metal2 0.103196f
Cred_13737 v_a.$611.Metal1 v_b.$2631.Metal2 0.104265f
Cred_13738 v_a.$611.Metal1 v_b.P17.pSD 0.229281f
Cred_13739 v_a.$611.Metal1 v_b.P19.pSD 0.231865f
Cred_13740 v_a.$611.Metal1 VDD.$340.Metal1 2.06166e-08f
Cred_13741 v_a.$611.Metal1 VDD.$388.Metal2 3.073e-09f
Cred_13742 v_a.$611.Metal1 VDD.$42.Metal1 1.44291e-07f
Cred_13743 v_a.$611.Metal1 VDD.$666.Metal3 1.3529e-10f
Cred_13744 v_a.$611.Metal1 VDD.P0.nSD 4.10639e-05f
Cred_13745 v_a.$669.Metal1 v_b.$2631.Metal2 0.0640873f
Cred_13746 v_a.$669.Metal1 v_b.$2691.Metal2 0.0213423f
Cred_13747 v_a.$669.Metal1 v_b.$3779.Metal3 2.61424e-07f
Cred_13748 v_a.$669.Metal1 v_b.P19.pSD 0.0614269f
Cred_13749 v_a.$669.Metal1 v_b.P21.nSD 0.000236164f
Cred_13750 v_a.$669.Metal1 v_b.P21.pSD 0.0627098f
Cred_13751 v_a.$669.Metal1 v_b.P37.nSD 3.12552e-10f
Cred_13752 v_a.$669.Metal1 v_b.P37.pSD 5.7627e-08f
Cred_13753 v_a.$669.Metal1 VDD.$340.Metal1 4.97985e-06f
Cred_13754 v_a.$669.Metal1 VDD.$388.Metal2 4.49473e-07f
Cred_13755 v_a.$669.Metal1 VDD.$42.Metal1 2.11048e-05f
Cred_13756 v_a.$669.Metal1 VDD.$666.Metal3 1.97882e-08f
Cred_13757 v_a.$669.Metal1 VDD.P0.nSD 0.00770879f
Cred_13758 v_a.$671.Metal1 v_b.$2631.Metal2 0.0418015f
Cred_13759 v_a.$671.Metal1 v_b.$2691.Metal2 0.013978f
Cred_13760 v_a.$671.Metal1 v_b.P19.pSD 0.0472658f
Cred_13761 v_a.$671.Metal1 v_b.P21.nSD 0.000154674f
Cred_13762 v_a.$671.Metal1 v_b.P21.pSD 0.0485121f
Cred_13763 v_a.$674.Metal1 v_b.$2631.Metal2 0.0388047f
Cred_13764 v_a.$674.Metal1 v_b.$2691.Metal2 0.0129759f
Cred_13765 v_a.$674.Metal1 v_b.P19.pSD 0.0493067f
Cred_13766 v_a.$674.Metal1 v_b.P21.nSD 0.000143585f
Cred_13767 v_a.$674.Metal1 v_b.P21.pSD 0.0505745f
Cred_13768 v_a.$676.Metal1 v_b.$2631.Metal2 0.0288054f
Cred_13769 v_a.$676.Metal1 v_b.$2691.Metal2 0.00960003f
Cred_13770 v_a.$676.Metal1 v_b.P19.pSD 0.041342f
Cred_13771 v_a.$676.Metal1 v_b.P21.nSD 0.000106229f
Cred_13772 v_a.$676.Metal1 v_b.P21.pSD 0.0421485f
Cred_13773 v_a.$678.Metal1 v_b.$2631.Metal2 0.0331845f
Cred_13774 v_a.$678.Metal1 v_b.$2691.Metal2 0.0108776f
Cred_13775 v_a.$678.Metal1 v_b.P19.pSD 0.0539123f
Cred_13776 v_a.$678.Metal1 v_b.P21.nSD 0.000120367f
Cred_13777 v_a.$678.Metal1 v_b.P21.pSD 0.0536619f
Cred_13778 v_a.$681.Metal1 v_b.$2631.Metal2 0.0303963f
Cred_13779 v_a.$681.Metal1 v_b.$2691.Metal2 0.0101642f
Cred_13780 v_a.$681.Metal1 v_b.P19.pSD 0.0548752f
Cred_13781 v_a.$681.Metal1 v_b.P21.nSD 0.000112472f
Cred_13782 v_a.$681.Metal1 v_b.P21.pSD 0.0562002f
Cred_13783 v_a.$683.Metal1 v_b.$2631.Metal2 0.0822917f
Cred_13784 v_a.$683.Metal1 v_b.$2691.Metal2 0.0274685f
Cred_13785 v_a.$683.Metal1 v_b.$3779.Metal3 2.89359e-05f
Cred_13786 v_a.$683.Metal1 v_b.P19.pSD 0.171609f
Cred_13787 v_a.$683.Metal1 v_b.P21.nSD 0.000303954f
Cred_13788 v_a.$683.Metal1 v_b.P21.pSD 0.17534f
Cred_13789 v_a.$683.Metal1 v_b.P37.nSD 3.4595e-08f
Cred_13790 v_a.$683.Metal1 v_b.P37.pSD 2.12135e-05f
Cred_13791 v_a.$732.Metal1 v_b.$2631.Metal2 0.0210538f
Cred_13792 v_a.$732.Metal1 v_b.$2691.Metal2 0.0644226f
Cred_13793 v_a.$732.Metal1 v_b.$3779.Metal3 2.74283e-06f
Cred_13794 v_a.$732.Metal1 v_b.P21.nSD 0.000232971f
Cred_13795 v_a.$732.Metal1 v_b.P21.pSD 0.0618571f
Cred_13796 v_a.$732.Metal1 v_b.P23.pSD 0.0622873f
Cred_13797 v_a.$732.Metal1 v_b.P37.nSD 3.27926e-09f
Cred_13798 v_a.$732.Metal1 v_b.P37.pSD 5.08009e-07f
Cred_13799 v_a.$732.Metal1 VDD.$340.Metal1 6.43797e-06f
Cred_13800 v_a.$732.Metal1 VDD.$388.Metal2 3.49925e-07f
Cred_13801 v_a.$732.Metal1 VDD.$42.Metal1 1.64305e-05f
Cred_13802 v_a.$732.Metal1 VDD.$666.Metal3 1.54056e-08f
Cred_13803 v_a.$732.Metal1 VDD.P0.nSD 0.00771212f
Cred_13804 v_a.$734.Metal1 v_b.$2631.Metal2 0.0136983f
Cred_13805 v_a.$734.Metal1 v_b.$2691.Metal2 0.04209f
Cred_13806 v_a.$734.Metal1 v_b.P21.nSD 0.000151578f
Cred_13807 v_a.$734.Metal1 v_b.P21.pSD 0.0475412f
Cred_13808 v_a.$734.Metal1 v_b.P23.pSD 0.048231f
Cred_13809 v_a.$737.Metal1 v_b.$2631.Metal2 0.0127162f
Cred_13810 v_a.$737.Metal1 v_b.$2691.Metal2 0.0390725f
Cred_13811 v_a.$737.Metal1 v_b.P21.nSD 0.000140712f
Cred_13812 v_a.$737.Metal1 v_b.P21.pSD 0.0495624f
Cred_13813 v_a.$737.Metal1 v_b.P23.pSD 0.0503136f
Cred_13814 v_a.$739.Metal1 v_b.$2631.Metal2 0.00945528f
Cred_13815 v_a.$739.Metal1 v_b.$2691.Metal2 0.0289546f
Cred_13816 v_a.$739.Metal1 v_b.P21.nSD 0.000104628f
Cred_13817 v_a.$739.Metal1 v_b.P21.pSD 0.0415321f
Cred_13818 v_a.$739.Metal1 v_b.P23.pSD 0.0419555f
Cred_13819 v_a.$741.Metal1 v_b.$2631.Metal2 0.0109823f
Cred_13820 v_a.$741.Metal1 v_b.$2691.Metal2 0.0330767f
Cred_13821 v_a.$741.Metal1 v_b.P21.nSD 0.000121524f
Cred_13822 v_a.$741.Metal1 v_b.P21.pSD 0.0541332f
Cred_13823 v_a.$741.Metal1 v_b.P23.pSD 0.0534432f
Cred_13824 v_a.$744.Metal1 v_b.$2631.Metal2 0.0099608f
Cred_13825 v_a.$744.Metal1 v_b.$2691.Metal2 0.0306061f
Cred_13826 v_a.$744.Metal1 v_b.P21.nSD 0.000110222f
Cred_13827 v_a.$744.Metal1 v_b.P21.pSD 0.0550755f
Cred_13828 v_a.$744.Metal1 v_b.P23.pSD 0.0559958f
Cred_13829 v_a.$746.Metal1 v_b.$2631.Metal2 0.0269909f
Cred_13830 v_a.$746.Metal1 v_b.$2691.Metal2 0.0827843f
Cred_13831 v_a.$746.Metal1 v_b.$3779.Metal3 3.3291e-05f
Cred_13832 v_a.$746.Metal1 v_b.P21.nSD 0.000298668f
Cred_13833 v_a.$746.Metal1 v_b.P21.pSD 0.172152f
Cred_13834 v_a.$746.Metal1 v_b.P23.pSD 0.174787f
Cred_13835 v_a.$746.Metal1 v_b.P37.nSD 3.98019e-08f
Cred_13836 v_a.$746.Metal1 v_b.P37.pSD 2.44064e-05f
Cred_13837 v_a.$795.Metal1 v_b.$2691.Metal2 0.0640873f
Cred_13838 v_a.$795.Metal1 v_b.$2751.Metal2 0.0213423f
Cred_13839 v_a.$795.Metal1 v_b.$3779.Metal3 3.5406e-07f
Cred_13840 v_a.$795.Metal1 v_b.P23.pSD 0.0614269f
Cred_13841 v_a.$795.Metal1 v_b.P25.nSD 0.000236164f
Cred_13842 v_a.$795.Metal1 v_b.P25.pSD 0.0627098f
Cred_13843 v_a.$795.Metal1 v_b.P37.nSD 4.23306e-10f
Cred_13844 v_a.$795.Metal1 v_b.P37.pSD 7.80474e-08f
Cred_13845 v_a.$795.Metal1 VDD.$340.Metal1 8.32305e-06f
Cred_13846 v_a.$795.Metal1 VDD.$388.Metal2 2.73584e-07f
Cred_13847 v_a.$795.Metal1 VDD.$42.Metal1 1.2846e-05f
Cred_13848 v_a.$795.Metal1 VDD.$666.Metal3 1.20447e-08f
Cred_13849 v_a.$795.Metal1 VDD.P0.nSD 0.00771389f
Cred_13850 v_a.$797.Metal1 v_b.$2691.Metal2 0.0418015f
Cred_13851 v_a.$797.Metal1 v_b.$2751.Metal2 0.013978f
Cred_13852 v_a.$797.Metal1 v_b.P23.pSD 0.0472658f
Cred_13853 v_a.$797.Metal1 v_b.P25.nSD 0.000154674f
Cred_13854 v_a.$797.Metal1 v_b.P25.pSD 0.0485121f
Cred_13855 v_a.$800.Metal1 v_b.$2691.Metal2 0.0388047f
Cred_13856 v_a.$800.Metal1 v_b.$2751.Metal2 0.0129759f
Cred_13857 v_a.$800.Metal1 v_b.P23.pSD 0.0493067f
Cred_13858 v_a.$800.Metal1 v_b.P25.nSD 0.000143585f
Cred_13859 v_a.$800.Metal1 v_b.P25.pSD 0.0505745f
Cred_13860 v_a.$802.Metal1 v_b.$2691.Metal2 0.0288054f
Cred_13861 v_a.$802.Metal1 v_b.$2751.Metal2 0.00960003f
Cred_13862 v_a.$802.Metal1 v_b.P23.pSD 0.041342f
Cred_13863 v_a.$802.Metal1 v_b.P25.nSD 0.000106229f
Cred_13864 v_a.$802.Metal1 v_b.P25.pSD 0.0421485f
Cred_13865 v_a.$804.Metal1 v_b.$2691.Metal2 0.0331845f
Cred_13866 v_a.$804.Metal1 v_b.$2751.Metal2 0.0108776f
Cred_13867 v_a.$804.Metal1 v_b.P23.pSD 0.0539123f
Cred_13868 v_a.$804.Metal1 v_b.P25.nSD 0.000120367f
Cred_13869 v_a.$804.Metal1 v_b.P25.pSD 0.0536619f
Cred_13870 v_a.$807.Metal1 v_b.$2691.Metal2 0.0303963f
Cred_13871 v_a.$807.Metal1 v_b.$2751.Metal2 0.0101642f
Cred_13872 v_a.$807.Metal1 v_b.P23.pSD 0.0548752f
Cred_13873 v_a.$807.Metal1 v_b.P25.nSD 0.000112472f
Cred_13874 v_a.$807.Metal1 v_b.P25.pSD 0.0562002f
Cred_13875 v_a.$809.Metal1 v_b.$2691.Metal2 0.0822917f
Cred_13876 v_a.$809.Metal1 v_b.$2751.Metal2 0.0274685f
Cred_13877 v_a.$809.Metal1 v_b.$3779.Metal3 3.91894e-05f
Cred_13878 v_a.$809.Metal1 v_b.P23.pSD 0.171609f
Cred_13879 v_a.$809.Metal1 v_b.P25.nSD 0.000303954f
Cred_13880 v_a.$809.Metal1 v_b.P25.pSD 0.17534f
Cred_13881 v_a.$809.Metal1 v_b.P37.nSD 4.68539e-08f
Cred_13882 v_a.$809.Metal1 v_b.P37.pSD 2.87306e-05f
Cred_13883 v_a.$858.Metal1 v_b.$2691.Metal2 0.0210539f
Cred_13884 v_a.$858.Metal1 v_b.$2751.Metal2 0.0644224f
Cred_13885 v_a.$858.Metal1 v_b.$3779.Metal3 3.92403e-06f
Cred_13886 v_a.$858.Metal1 v_b.P25.nSD 0.000232973f
Cred_13887 v_a.$858.Metal1 v_b.P25.pSD 0.0618571f
Cred_13888 v_a.$858.Metal1 v_b.P27.pSD 0.0622873f
Cred_13889 v_a.$858.Metal1 v_b.P37.nSD 4.69149e-09f
Cred_13890 v_a.$858.Metal1 v_b.P37.pSD 7.26784e-07f
Cred_13891 v_a.$858.Metal1 VDD.$340.Metal1 3.65099e-05f
Cred_13892 v_a.$858.Metal1 VDD.$388.Metal2 6.74002e-07f
Cred_13893 v_a.$858.Metal1 VDD.$42.Metal1 3.16474e-05f
Cred_13894 v_a.$858.Metal1 VDD.$666.Metal3 2.96732e-08f
Cred_13895 v_a.$858.Metal1 VDD.P0.nSD 0.0252814f
Cred_13896 v_a.$860.Metal1 v_b.$2691.Metal2 0.0136983f
Cred_13897 v_a.$860.Metal1 v_b.$2751.Metal2 0.04209f
Cred_13898 v_a.$860.Metal1 v_b.P25.nSD 0.000151578f
Cred_13899 v_a.$860.Metal1 v_b.P25.pSD 0.0475412f
Cred_13900 v_a.$860.Metal1 v_b.P27.pSD 0.048231f
Cred_13901 v_a.$863.Metal1 v_b.$2691.Metal2 0.0127162f
Cred_13902 v_a.$863.Metal1 v_b.$2751.Metal2 0.0390725f
Cred_13903 v_a.$863.Metal1 v_b.P25.nSD 0.000140712f
Cred_13904 v_a.$863.Metal1 v_b.P25.pSD 0.0495624f
Cred_13905 v_a.$863.Metal1 v_b.P27.pSD 0.0503136f
Cred_13906 v_a.$865.Metal1 v_b.$2691.Metal2 0.00945528f
Cred_13907 v_a.$865.Metal1 v_b.$2751.Metal2 0.0289546f
Cred_13908 v_a.$865.Metal1 v_b.P25.nSD 0.000104628f
Cred_13909 v_a.$865.Metal1 v_b.P25.pSD 0.0415321f
Cred_13910 v_a.$865.Metal1 v_b.P27.pSD 0.0419555f
Cred_13911 v_a.$867.Metal1 v_b.$2691.Metal2 0.0109823f
Cred_13912 v_a.$867.Metal1 v_b.$2751.Metal2 0.0330767f
Cred_13913 v_a.$867.Metal1 v_b.P25.nSD 0.000121524f
Cred_13914 v_a.$867.Metal1 v_b.P25.pSD 0.0541332f
Cred_13915 v_a.$867.Metal1 v_b.P27.pSD 0.0534432f
Cred_13916 v_a.$870.Metal1 v_b.$2691.Metal2 0.0099608f
Cred_13917 v_a.$870.Metal1 v_b.$2751.Metal2 0.0306061f
Cred_13918 v_a.$870.Metal1 v_b.P25.nSD 0.000110222f
Cred_13919 v_a.$870.Metal1 v_b.P25.pSD 0.0550755f
Cred_13920 v_a.$870.Metal1 v_b.P27.pSD 0.0559958f
Cred_13921 v_a.$872.Metal1 v_b.$2691.Metal2 0.0269909f
Cred_13922 v_a.$872.Metal1 v_b.$2751.Metal2 0.0827843f
Cred_13923 v_a.$872.Metal1 v_b.$3779.Metal3 4.76278e-05f
Cred_13924 v_a.$872.Metal1 v_b.P25.nSD 0.000298668f
Cred_13925 v_a.$872.Metal1 v_b.P25.pSD 0.172152f
Cred_13926 v_a.$872.Metal1 v_b.P27.pSD 0.174787f
Cred_13927 v_a.$872.Metal1 v_b.P37.nSD 5.69427e-08f
Cred_13928 v_a.$872.Metal1 v_b.P37.pSD 3.4917e-05f
Cred_13929 v_a.$921.Metal1 v_b.$2751.Metal2 0.0641156f
Cred_13930 v_a.$921.Metal1 v_b.$2811.Metal2 0.0213514f
Cred_13931 v_a.$921.Metal1 v_b.$3779.Metal3 5.00084e-06f
Cred_13932 v_a.$921.Metal1 v_b.P27.pSD 0.0614338f
Cred_13933 v_a.$921.Metal1 v_b.P29.nSD 0.000236265f
Cred_13934 v_a.$921.Metal1 v_b.P29.pSD 0.0627166f
Cred_13935 v_a.$921.Metal1 v_b.P37.nSD 5.97889e-09f
Cred_13936 v_a.$921.Metal1 v_b.P37.pSD 9.26224e-07f
Cred_13937 v_a.$921.Metal1 VDD.$340.Metal1 1.37e-05f
Cred_13938 v_a.$921.Metal1 VDD.$388.Metal2 1.65515e-07f
Cred_13939 v_a.$921.Metal1 VDD.$42.Metal1 7.77167e-06f
Cred_13940 v_a.$921.Metal1 VDD.$666.Metal3 7.28686e-09f
Cred_13941 v_a.$921.Metal1 VDD.P0.nSD 0.00771371f
Cred_13942 v_a.$923.Metal1 v_b.$2751.Metal2 0.0418015f
Cred_13943 v_a.$923.Metal1 v_b.$2811.Metal2 0.013978f
Cred_13944 v_a.$923.Metal1 v_b.P27.pSD 0.0472658f
Cred_13945 v_a.$923.Metal1 v_b.P29.nSD 0.000154674f
Cred_13946 v_a.$923.Metal1 v_b.P29.pSD 0.0485121f
Cred_13947 v_a.$926.Metal1 v_b.$2751.Metal2 0.0388047f
Cred_13948 v_a.$926.Metal1 v_b.$2811.Metal2 0.0129759f
Cred_13949 v_a.$926.Metal1 v_b.P27.pSD 0.0493067f
Cred_13950 v_a.$926.Metal1 v_b.P29.nSD 0.000143585f
Cred_13951 v_a.$926.Metal1 v_b.P29.pSD 0.0505745f
Cred_13952 v_a.$928.Metal1 v_b.$2751.Metal2 0.0288054f
Cred_13953 v_a.$928.Metal1 v_b.$2811.Metal2 0.00960003f
Cred_13954 v_a.$928.Metal1 v_b.P27.pSD 0.041342f
Cred_13955 v_a.$928.Metal1 v_b.P29.nSD 0.000106229f
Cred_13956 v_a.$928.Metal1 v_b.P29.pSD 0.0421485f
Cred_13957 v_a.$930.Metal1 v_b.$2751.Metal2 0.0270344f
Cred_13958 v_a.$930.Metal1 v_b.$2811.Metal2 0.00882111f
Cred_13959 v_a.$930.Metal1 v_b.P27.pSD 0.0433119f
Cred_13960 v_a.$930.Metal1 v_b.P29.nSD 9.76102e-05f
Cred_13961 v_a.$930.Metal1 v_b.P29.pSD 0.0428037f
Cred_13962 v_a.$932.Metal1 v_b.$2751.Metal2 0.0251152f
Cred_13963 v_a.$932.Metal1 v_b.$2811.Metal2 0.00839825f
Cred_13964 v_a.$932.Metal1 v_b.P27.pSD 0.0439705f
Cred_13965 v_a.$932.Metal1 v_b.P29.nSD 9.29311e-05f
Cred_13966 v_a.$932.Metal1 v_b.P29.pSD 0.0450373f
Cred_13967 v_a.$934.Metal1 v_b.$2751.Metal2 0.0235035f
Cred_13968 v_a.$934.Metal1 v_b.$2811.Metal2 0.00785933f
Cred_13969 v_a.$934.Metal1 v_b.P27.pSD 0.0449587f
Cred_13970 v_a.$934.Metal1 v_b.P29.nSD 8.69677e-05f
Cred_13971 v_a.$934.Metal1 v_b.P29.pSD 0.0460348f
Cred_13972 v_a.$936.Metal1 v_b.$2751.Metal2 0.0793897f
Cred_13973 v_a.$936.Metal1 v_b.$2811.Metal2 0.0267812f
Cred_13974 v_a.$936.Metal1 v_b.$3779.Metal3 7.02725e-05f
Cred_13975 v_a.$936.Metal1 v_b.P27.pSD 0.166147f
Cred_13976 v_a.$936.Metal1 v_b.P29.nSD 0.000296348f
Cred_13977 v_a.$936.Metal1 v_b.P29.pSD 0.17275f
Cred_13978 v_a.$936.Metal1 v_b.P37.nSD 8.40162e-08f
Cred_13979 v_a.$936.Metal1 v_b.P37.pSD 5.15184e-05f
Cred_13980 v_a.$984.Metal1 v_b.$2751.Metal2 0.0197911f
Cred_13981 v_a.$984.Metal1 v_b.$2811.Metal2 0.0625979f
Cred_13982 v_a.$984.Metal1 v_b.$3779.Metal3 7.55773e-07f
Cred_13983 v_a.$984.Metal1 v_b.P29.nSD 0.000218999f
Cred_13984 v_a.$984.Metal1 v_b.P29.pSD 0.0579195f
Cred_13985 v_a.$984.Metal1 v_b.P31.pSD 0.0614368f
Cred_13986 v_a.$984.Metal1 v_b.P37.nSD 9.03585e-10f
Cred_13987 v_a.$984.Metal1 v_b.P37.pSD 1.66599e-07f
Cred_13988 v_a.$984.Metal1 VDD.$340.Metal1 1.75518e-05f
Cred_13989 v_a.$984.Metal1 VDD.$388.Metal2 1.28027e-07f
Cred_13990 v_a.$984.Metal1 VDD.$42.Metal1 6.01145e-06f
Cred_13991 v_a.$984.Metal1 VDD.$666.Metal3 5.63645e-09f
Cred_13992 v_a.$984.Metal1 VDD.P0.nSD 0.00771165f
Cred_13993 v_a.$986.Metal1 v_b.$2751.Metal2 0.0128187f
Cred_13994 v_a.$986.Metal1 v_b.$2811.Metal2 0.0406422f
Cred_13995 v_a.$986.Metal1 v_b.P29.nSD 0.000141846f
Cred_13996 v_a.$986.Metal1 v_b.P29.pSD 0.0444886f
Cred_13997 v_a.$986.Metal1 v_b.P31.pSD 0.0472658f
Cred_13998 v_a.$989.Metal1 v_b.$2751.Metal2 0.0118997f
Cred_13999 v_a.$989.Metal1 v_b.$2811.Metal2 0.0377285f
Cred_14000 v_a.$989.Metal1 v_b.P29.nSD 0.000131676f
Cred_14001 v_a.$989.Metal1 v_b.P29.pSD 0.04638f
Cred_14002 v_a.$989.Metal1 v_b.P31.pSD 0.0493067f
Cred_14003 v_a.$991.Metal1 v_b.$2751.Metal2 0.00886784f
Cred_14004 v_a.$991.Metal1 v_b.$2811.Metal2 0.0279877f
Cred_14005 v_a.$991.Metal1 v_b.P29.nSD 9.81274e-05f
Cred_14006 v_a.$991.Metal1 v_b.P29.pSD 0.0389597f
Cred_14007 v_a.$991.Metal1 v_b.P31.pSD 0.0411411f
Cred_14008 v_a.$993.Metal1 v_b.$2751.Metal2 0.010411f
Cred_14009 v_a.$993.Metal1 v_b.$2811.Metal2 0.0321364f
Cred_14010 v_a.$993.Metal1 v_b.P29.nSD 0.000115203f
Cred_14011 v_a.$993.Metal1 v_b.P29.pSD 0.0512994f
Cred_14012 v_a.$993.Metal1 v_b.P31.pSD 0.0525456f
Cred_14013 v_a.$996.Metal1 v_b.$2751.Metal2 0.00932121f
Cred_14014 v_a.$996.Metal1 v_b.$2811.Metal2 0.0295533f
Cred_14015 v_a.$996.Metal1 v_b.P29.nSD 0.000103144f
Cred_14016 v_a.$996.Metal1 v_b.P29.pSD 0.0515391f
Cred_14017 v_a.$996.Metal1 v_b.P31.pSD 0.0548752f
Cred_14018 v_a.$998.Metal1 v_b.$2751.Metal2 0.0267276f
Cred_14019 v_a.$998.Metal1 v_b.$2811.Metal2 0.0818935f
Cred_14020 v_a.$998.Metal1 v_b.$3779.Metal3 8.36533e-05f
Cred_14021 v_a.$998.Metal1 v_b.P29.nSD 0.000295755f
Cred_14022 v_a.$998.Metal1 v_b.P29.pSD 0.170816f
Cred_14023 v_a.$998.Metal1 v_b.P31.pSD 0.172792f
Cred_14024 v_a.$998.Metal1 v_b.P37.nSD 1.00014e-07f
Cred_14025 v_a.$998.Metal1 v_b.P37.pSD 6.13281e-05f
Cred_14026 v_a.P0.nSD v_b.$2361.Metal2 0.340594f
Cred_14027 v_a.P0.nSD v_b.P0.nSD 0.112596f
Cred_14028 v_a.P0.nSD v_b.P0.pSD 0.00244831f
Cred_14029 v_a.P0.nSD v_b.P1.nSD 0.0923299f
Cred_14030 v_a.P0.nSD VSS.$17.Metal1 0.00205853f
Cred_14031 v_a.P0.nSD VSS.$301.Metal1 1.23487e-06f
Cred_14032 v_a.P0.nSD VSS.$366.Metal2 0.000928993f
Cred_14033 v_a.P0.nSD VSS.$39.Metal1 0.000543369f
Cred_14034 v_a.P0.nSD VSS.$606.Metal2 1.30478e-07f
Cred_14035 v_a.P0.nSD VSS.$636.Metal3 0.00068264f
Cred_14036 v_a.P0.nSD VSS.$760.Metal3 7.72022e-09f
Cred_14037 v_a.P0.nSD VSS.P0.pSD 0.0065805f
Cred_14038 v_a.P0.pSD v_b.$2361.Metal2 0.08218f
Cred_14039 v_a.P0.pSD v_b.P0.nSD 0.000331483f
Cred_14040 v_a.P0.pSD v_b.P0.pSD 0.128107f
Cred_14041 v_a.P0.pSD v_b.P1.pSD 0.122463f
Cred_14042 v_a.P0.pSD VDD.$340.Metal1 2.16007e-07f
Cred_14043 v_a.P0.pSD VDD.$388.Metal2 0.00144254f
Cred_14044 v_a.P0.pSD VDD.$392.Metal2 8.12767e-07f
Cred_14045 v_a.P0.pSD VDD.$42.Metal1 0.00149101f
Cred_14046 v_a.P0.pSD VDD.$55.Metal1 0.000139434f
Cred_14047 v_a.P0.pSD VDD.$666.Metal3 0.000242965f
Cred_14048 v_a.P0.pSD VDD.P0.nSD 0.00417958f
Cred_14049 v_a.P10.nSD v_b.$2481.Metal2 0.251407f
Cred_14050 v_a.P10.nSD v_b.$2541.Metal2 0.0832451f
Cred_14051 v_a.P10.nSD v_b.P10.nSD 0.0877729f
Cred_14052 v_a.P10.nSD v_b.P11.nSD 0.0898723f
Cred_14053 v_a.P10.nSD v_b.P11.pSD 0.00167395f
Cred_14054 v_a.P10.nSD VSS.$17.Metal1 0.000306074f
Cred_14055 v_a.P10.nSD VSS.$301.Metal1 4.16917e-06f
Cred_14056 v_a.P10.nSD VSS.$606.Metal2 4.40521e-07f
Cred_14057 v_a.P10.nSD VSS.$760.Metal3 2.6065e-08f
Cred_14058 v_a.P10.nSD VSS.P0.pSD 0.00670179f
Cred_14059 v_a.P10.pSD v_b.$2481.Metal2 0.0269639f
Cred_14060 v_a.P10.pSD v_b.$2541.Metal2 0.00897054f
Cred_14061 v_a.P10.pSD v_b.P10.pSD 0.0477334f
Cred_14062 v_a.P10.pSD v_b.P11.nSD 9.92638e-05f
Cred_14063 v_a.P10.pSD v_b.P11.pSD 0.0486984f
Cred_14064 v_a.P10.pSD VDD.$340.Metal1 7.75701e-07f
Cred_14065 v_a.P10.pSD VDD.$388.Metal2 8.97742e-07f
Cred_14066 v_a.P10.pSD VDD.$42.Metal1 4.2153e-05f
Cred_14067 v_a.P10.pSD VDD.$666.Metal3 3.95235e-08f
Cred_14068 v_a.P10.pSD VDD.P0.nSD 0.00428915f
Cred_14069 v_a.P12.nSD v_b.$2481.Metal2 0.0834744f
Cred_14070 v_a.P12.nSD v_b.$2541.Metal2 0.253941f
Cred_14071 v_a.P12.nSD v_b.P11.nSD 0.0890733f
Cred_14072 v_a.P12.nSD v_b.P11.pSD 0.00167856f
Cred_14073 v_a.P12.nSD v_b.P13.nSD 0.0893295f
Cred_14074 v_a.P12.nSD VSS.$17.Metal1 0.000237679f
Cred_14075 v_a.P12.nSD VSS.$301.Metal1 5.41057e-06f
Cred_14076 v_a.P12.nSD VSS.$606.Metal2 5.71689e-07f
Cred_14077 v_a.P12.nSD VSS.$760.Metal3 3.38261e-08f
Cred_14078 v_a.P12.nSD VSS.P0.pSD 0.00679282f
Cred_14079 v_a.P12.pSD v_b.$2481.Metal2 0.00885843f
Cred_14080 v_a.P12.pSD v_b.$2541.Metal2 0.0270788f
Cred_14081 v_a.P12.pSD v_b.P11.nSD 9.80232e-05f
Cred_14082 v_a.P12.pSD v_b.P11.pSD 0.0479115f
Cred_14083 v_a.P12.pSD v_b.P13.pSD 0.0485179f
Cred_14084 v_a.P12.pSD VDD.$340.Metal1 1.00265e-06f
Cred_14085 v_a.P12.pSD VDD.$388.Metal2 6.94757e-07f
Cred_14086 v_a.P12.pSD VDD.$42.Metal1 3.2622e-05f
Cred_14087 v_a.P12.pSD VDD.$666.Metal3 3.0587e-08f
Cred_14088 v_a.P12.pSD VDD.P0.nSD 0.00429866f
Cred_14089 v_a.P14.nSD v_b.$2541.Metal2 0.251407f
Cred_14090 v_a.P14.nSD v_b.$2601.Metal2 0.0832451f
Cred_14091 v_a.P14.nSD v_b.P13.nSD 0.0877729f
Cred_14092 v_a.P14.nSD v_b.P15.nSD 0.0898723f
Cred_14093 v_a.P14.nSD v_b.P15.pSD 0.00167395f
Cred_14094 v_a.P14.nSD VSS.$17.Metal1 0.000183372f
Cred_14095 v_a.P14.nSD VSS.$301.Metal1 6.97265e-06f
Cred_14096 v_a.P14.nSD VSS.$606.Metal2 7.36741e-07f
Cred_14097 v_a.P14.nSD VSS.$760.Metal3 4.3592e-08f
Cred_14098 v_a.P14.nSD VSS.P0.pSD 0.00682138f
Cred_14099 v_a.P14.pSD v_b.$2541.Metal2 0.0667425f
Cred_14100 v_a.P14.pSD v_b.$2601.Metal2 0.0221741f
Cred_14101 v_a.P14.pSD v_b.P13.pSD 0.119773f
Cred_14102 v_a.P14.pSD v_b.P15.nSD 0.000245368f
Cred_14103 v_a.P14.pSD v_b.P15.pSD 0.121844f
Cred_14104 v_a.P14.pSD VDD.$340.Metal1 1.2961e-06f
Cred_14105 v_a.P14.pSD VDD.$388.Metal2 5.37851e-07f
Cred_14106 v_a.P14.pSD VDD.$42.Metal1 2.52545e-05f
Cred_14107 v_a.P14.pSD VDD.$666.Metal3 2.36791e-08f
Cred_14108 v_a.P14.pSD VDD.P0.nSD 0.0043059f
Cred_14109 v_a.P16.nSD v_b.$2541.Metal2 0.0844237f
Cred_14110 v_a.P16.nSD v_b.$2601.Metal2 0.256835f
Cred_14111 v_a.P16.nSD v_b.P15.nSD 0.089144f
Cred_14112 v_a.P16.nSD v_b.P15.pSD 0.00384782f
Cred_14113 v_a.P16.nSD v_b.P17.nSD 0.08939f
Cred_14114 v_a.P16.nSD v_b.P17.pSD 0.00219194f
Cred_14115 v_a.P16.nSD VDD.$340.Metal1 1.09989e-08f
Cred_14116 v_a.P16.nSD VDD.$388.Metal2 2.74354e-09f
Cred_14117 v_a.P16.nSD VDD.$42.Metal1 1.28821e-07f
Cred_14118 v_a.P16.nSD VDD.$666.Metal3 1.20785e-10f
Cred_14119 v_a.P16.nSD VDD.P0.nSD 2.83466e-05f
Cred_14120 v_a.P16.nSD VSS.$17.Metal1 0.000142602f
Cred_14121 v_a.P16.nSD VSS.$301.Metal1 9.05147e-06f
Cred_14122 v_a.P16.nSD VSS.$606.Metal2 9.56392e-07f
Cred_14123 v_a.P16.nSD VSS.$760.Metal3 5.65884e-08f
Cred_14124 v_a.P16.nSD VSS.P0.pSD 0.00688768f
Cred_14125 v_a.P16.pSD v_b.$2541.Metal2 0.191661f
Cred_14126 v_a.P16.pSD v_b.$2601.Metal2 0.590227f
Cred_14127 v_a.P16.pSD v_b.P15.nSD 0.00319472f
Cred_14128 v_a.P16.pSD v_b.P15.pSD 0.638655f
Cred_14129 v_a.P16.pSD v_b.P17.nSD 0.00107848f
Cred_14130 v_a.P16.pSD v_b.P17.pSD 0.658038f
Cred_14131 v_a.P16.pSD VDD.$340.Metal1 4.21432e-06f
Cred_14132 v_a.P16.pSD VDD.$388.Metal2 1.05171e-06f
Cred_14133 v_a.P16.pSD VDD.$42.Metal1 4.93825e-05f
Cred_14134 v_a.P16.pSD VDD.$666.Metal3 4.6302e-08f
Cred_14135 v_a.P16.pSD VDD.P0.nSD 0.0108638f
Cred_14136 v_a.P16.pSD VSS.$17.Metal1 1.38563e-06f
Cred_14137 v_a.P16.pSD VSS.$301.Metal1 8.80189e-08f
Cred_14138 v_a.P16.pSD VSS.$606.Metal2 9.30021e-09f
Cred_14139 v_a.P16.pSD VSS.$760.Metal3 5.50281e-10f
Cred_14140 v_a.P16.pSD VSS.P0.pSD 6.69522e-05f
Cred_14141 v_a.P18.nSD v_b.$2601.Metal2 0.168162f
Cred_14142 v_a.P18.nSD v_b.$2631.Metal2 0.169085f
Cred_14143 v_a.P18.nSD v_b.P17.nSD 0.0877729f
Cred_14144 v_a.P18.nSD v_b.P19.nSD 0.0889511f
Cred_14145 v_a.P18.nSD VSS.$17.Metal1 0.000110125f
Cred_14146 v_a.P18.nSD VSS.$301.Metal1 1.16566e-05f
Cred_14147 v_a.P18.nSD VSS.$606.Metal2 1.23165e-06f
Cred_14148 v_a.P18.nSD VSS.$760.Metal3 7.28753e-08f
Cred_14149 v_a.P18.nSD VSS.P0.pSD 0.00688942f
Cred_14150 v_a.P18.pSD v_b.$2601.Metal2 0.0865585f
Cred_14151 v_a.P18.pSD v_b.$2631.Metal2 0.0872534f
Cred_14152 v_a.P18.pSD v_b.P17.pSD 0.212675f
Cred_14153 v_a.P18.pSD v_b.P19.pSD 0.215027f
Cred_14154 v_a.P18.pSD VDD.$340.Metal1 2.19339e-06f
Cred_14155 v_a.P18.pSD VDD.$388.Metal2 3.27087e-07f
Cred_14156 v_a.P18.pSD VDD.$42.Metal1 1.53582e-05f
Cred_14157 v_a.P18.pSD VDD.$666.Metal3 1.44002e-08f
Cred_14158 v_a.P18.pSD VDD.P0.nSD 0.00436979f
Cred_14159 v_a.P2.nSD v_b.$2361.Metal2 0.247506f
Cred_14160 v_a.P2.nSD v_b.$2421.Metal2 0.0831756f
Cred_14161 v_a.P2.nSD v_b.P1.nSD 0.0834986f
Cred_14162 v_a.P2.nSD v_b.P3.nSD 0.0889693f
Cred_14163 v_a.P2.nSD v_b.P3.pSD 0.00167255f
Cred_14164 v_a.P2.nSD VSS.$17.Metal1 0.000857037f
Cred_14165 v_a.P2.nSD VSS.$301.Metal1 1.48698e-06f
Cred_14166 v_a.P2.nSD VSS.$606.Metal2 1.57117e-07f
Cred_14167 v_a.P2.nSD VSS.$760.Metal3 9.29638e-09f
Cred_14168 v_a.P2.nSD VSS.P0.pSD 0.00617491f
Cred_14169 v_a.P2.pSD v_b.$2361.Metal2 0.0165063f
Cred_14170 v_a.P2.pSD v_b.$2421.Metal2 0.00548539f
Cred_14171 v_a.P2.pSD v_b.P1.pSD 0.0269491f
Cred_14172 v_a.P2.pSD v_b.P3.nSD 6.06987e-05f
Cred_14173 v_a.P2.pSD v_b.P3.pSD 0.0274997f
Cred_14174 v_a.P2.pSD VDD.$340.Metal1 2.78548e-07f
Cred_14175 v_a.P2.pSD VDD.$388.Metal2 2.50605e-06f
Cred_14176 v_a.P2.pSD VDD.$42.Metal1 0.00011767f
Cred_14177 v_a.P2.pSD VDD.$666.Metal3 1.1033e-07f
Cred_14178 v_a.P2.pSD VDD.P0.nSD 0.00421216f
Cred_14179 v_a.P20.nSD v_b.$2631.Metal2 0.253482f
Cred_14180 v_a.P20.nSD v_b.$2691.Metal2 0.083927f
Cred_14181 v_a.P20.nSD v_b.$3779.Metal3 0.000519545f
Cred_14182 v_a.P20.nSD v_b.P19.nSD 0.0881496f
Cred_14183 v_a.P20.nSD v_b.P21.nSD 0.0902582f
Cred_14184 v_a.P20.nSD v_b.P21.pSD 0.00168766f
Cred_14185 v_a.P20.nSD v_b.P37.nSD 5.08892e-05f
Cred_14186 v_a.P20.nSD v_b.P37.pSD 1.45414e-06f
Cred_14187 v_a.P20.nSD VSS.$17.Metal1 8.58074e-05f
Cred_14188 v_a.P20.nSD VSS.$301.Metal1 1.51223e-05f
Cred_14189 v_a.P20.nSD VSS.$606.Metal2 1.59784e-06f
Cred_14190 v_a.P20.nSD VSS.$760.Metal3 9.45422e-08f
Cred_14191 v_a.P20.nSD VSS.P0.pSD 0.00693389f
Cred_14192 v_a.P20.pSD v_b.$2631.Metal2 0.0269605f
Cred_14193 v_a.P20.pSD v_b.$2691.Metal2 0.00897319f
Cred_14194 v_a.P20.pSD v_b.$3779.Metal3 1.33016e-05f
Cred_14195 v_a.P20.pSD v_b.P19.pSD 0.0477229f
Cred_14196 v_a.P20.pSD v_b.P21.nSD 9.92931e-05f
Cred_14197 v_a.P20.pSD v_b.P21.pSD 0.0487088f
Cred_14198 v_a.P20.pSD v_b.P37.nSD 1.59031e-08f
Cred_14199 v_a.P20.pSD v_b.P37.pSD 9.7496e-06f
Cred_14200 v_a.P20.pSD VDD.$340.Metal1 2.80025e-06f
Cred_14201 v_a.P20.pSD VDD.$388.Metal2 2.50832e-07f
Cred_14202 v_a.P20.pSD VDD.$42.Metal1 1.17777e-05f
Cred_14203 v_a.P20.pSD VDD.$666.Metal3 1.1043e-08f
Cred_14204 v_a.P20.pSD VDD.P0.nSD 0.00431817f
Cred_14205 v_a.P22.nSD v_b.$2631.Metal2 0.0827903f
Cred_14206 v_a.P22.nSD v_b.$2691.Metal2 0.251876f
Cred_14207 v_a.P22.nSD v_b.$3779.Metal3 0.000557483f
Cred_14208 v_a.P22.nSD v_b.P21.nSD 0.088689f
Cred_14209 v_a.P22.nSD v_b.P21.pSD 0.00166481f
Cred_14210 v_a.P22.nSD v_b.P23.nSD 0.0889511f
Cred_14211 v_a.P22.nSD v_b.P37.nSD 5.48525e-05f
Cred_14212 v_a.P22.nSD v_b.P37.pSD 1.56032e-06f
Cred_14213 v_a.P22.nSD VSS.$17.Metal1 6.65764e-05f
Cred_14214 v_a.P22.nSD VSS.$301.Metal1 1.94842e-05f
Cred_14215 v_a.P22.nSD VSS.$606.Metal2 2.05873e-06f
Cred_14216 v_a.P22.nSD VSS.$760.Metal3 1.21813e-07f
Cred_14217 v_a.P22.nSD VSS.P0.pSD 0.00692426f
Cred_14218 v_a.P22.pSD v_b.$2631.Metal2 0.00885585f
Cred_14219 v_a.P22.pSD v_b.$2691.Metal2 0.0270824f
Cred_14220 v_a.P22.pSD v_b.$3779.Metal3 1.53635e-05f
Cred_14221 v_a.P22.pSD v_b.P21.nSD 9.79947e-05f
Cred_14222 v_a.P22.pSD v_b.P21.pSD 0.0479011f
Cred_14223 v_a.P22.pSD v_b.P23.pSD 0.0485285f
Cred_14224 v_a.P22.pSD v_b.P37.nSD 1.83683e-08f
Cred_14225 v_a.P22.pSD v_b.P37.pSD 1.12278e-05f
Cred_14226 v_a.P22.pSD VDD.$340.Metal1 3.62017e-06f
Cred_14227 v_a.P22.pSD VDD.$388.Metal2 1.95288e-07f
Cred_14228 v_a.P22.pSD VDD.$42.Metal1 9.16965e-06f
Cred_14229 v_a.P22.pSD VDD.$666.Metal3 8.59764e-09f
Cred_14230 v_a.P22.pSD VDD.P0.nSD 0.00432002f
Cred_14231 v_a.P24.nSD v_b.$2691.Metal2 0.253478f
Cred_14232 v_a.P24.nSD v_b.$2751.Metal2 0.083927f
Cred_14233 v_a.P24.nSD v_b.$3779.Metal3 0.000703647f
Cred_14234 v_a.P24.nSD v_b.P23.nSD 0.0881496f
Cred_14235 v_a.P24.nSD v_b.P25.nSD 0.0902582f
Cred_14236 v_a.P24.nSD v_b.P25.pSD 0.00168766f
Cred_14237 v_a.P24.nSD v_b.P37.nSD 6.89219e-05f
Cred_14238 v_a.P24.nSD v_b.P37.pSD 1.96942e-06f
Cred_14239 v_a.P24.nSD VSS.$17.Metal1 5.22318e-05f
Cred_14240 v_a.P24.nSD VSS.$301.Metal1 2.52763e-05f
Cred_14241 v_a.P24.nSD VSS.$606.Metal2 2.67074e-06f
Cred_14242 v_a.P24.nSD VSS.$760.Metal3 1.58024e-07f
Cred_14243 v_a.P24.nSD VSS.P0.pSD 0.00695618f
Cred_14244 v_a.P24.pSD v_b.$2691.Metal2 0.0269605f
Cred_14245 v_a.P24.pSD v_b.$2751.Metal2 0.00897319f
Cred_14246 v_a.P24.pSD v_b.$3779.Metal3 1.80151e-05f
Cred_14247 v_a.P24.pSD v_b.P23.pSD 0.0477229f
Cred_14248 v_a.P24.pSD v_b.P25.nSD 9.92931e-05f
Cred_14249 v_a.P24.pSD v_b.P25.pSD 0.0487088f
Cred_14250 v_a.P24.pSD v_b.P37.nSD 2.15384e-08f
Cred_14251 v_a.P24.pSD v_b.P37.pSD 1.32044e-05f
Cred_14252 v_a.P24.pSD VDD.$340.Metal1 4.68018e-06f
Cred_14253 v_a.P24.pSD VDD.$388.Metal2 1.52696e-07f
Cred_14254 v_a.P24.pSD VDD.$42.Metal1 7.16975e-06f
Cred_14255 v_a.P24.pSD VDD.$666.Metal3 6.7225e-09f
Cred_14256 v_a.P24.pSD VDD.P0.nSD 0.004321f
Cred_14257 v_a.P26.nSD v_b.$2691.Metal2 0.0827903f
Cred_14258 v_a.P26.nSD v_b.$2751.Metal2 0.251876f
Cred_14259 v_a.P26.nSD v_b.$3779.Metal3 0.000797564f
Cred_14260 v_a.P26.nSD v_b.P25.nSD 0.088689f
Cred_14261 v_a.P26.nSD v_b.P25.pSD 0.00166481f
Cred_14262 v_a.P26.nSD v_b.P27.nSD 0.0889511f
Cred_14263 v_a.P26.nSD v_b.P37.nSD 7.84748e-05f
Cred_14264 v_a.P26.nSD v_b.P37.pSD 2.23228e-06f
Cred_14265 v_a.P26.nSD VSS.$17.Metal1 4.64904e-05f
Cred_14266 v_a.P26.nSD VSS.$301.Metal1 3.99204e-05f
Cred_14267 v_a.P26.nSD VSS.$606.Metal2 4.21806e-06f
Cred_14268 v_a.P26.nSD VSS.$760.Metal3 2.49577e-07f
Cred_14269 v_a.P26.nSD VSS.P0.pSD 0.0082265f
Cred_14270 v_a.P26.pSD v_b.$2691.Metal2 0.00885586f
Cred_14271 v_a.P26.pSD v_b.$2751.Metal2 0.0270824f
Cred_14272 v_a.P26.pSD v_b.$3779.Metal3 2.19799e-05f
Cred_14273 v_a.P26.pSD v_b.P25.nSD 9.79948e-05f
Cred_14274 v_a.P26.pSD v_b.P25.pSD 0.0479011f
Cred_14275 v_a.P26.pSD v_b.P27.pSD 0.0485285f
Cred_14276 v_a.P26.pSD v_b.P37.nSD 2.62786e-08f
Cred_14277 v_a.P26.pSD v_b.P37.pSD 1.60631e-05f
Cred_14278 v_a.P26.pSD VDD.$340.Metal1 7.06735e-06f
Cred_14279 v_a.P26.pSD VDD.$388.Metal2 1.30469e-07f
Cred_14280 v_a.P26.pSD VDD.$42.Metal1 6.12609e-06f
Cred_14281 v_a.P26.pSD VDD.$666.Metal3 5.74394e-09f
Cred_14282 v_a.P26.pSD VDD.P0.nSD 0.00489381f
Cred_14283 v_a.P28.nSD v_b.$2751.Metal2 0.251407f
Cred_14284 v_a.P28.nSD v_b.$2811.Metal2 0.0832451f
Cred_14285 v_a.P28.nSD v_b.$3779.Metal3 0.00101643f
Cred_14286 v_a.P28.nSD v_b.P27.nSD 0.0877729f
Cred_14287 v_a.P28.nSD v_b.P29.nSD 0.0898723f
Cred_14288 v_a.P28.nSD v_b.P29.pSD 0.00167395f
Cred_14289 v_a.P28.nSD v_b.P37.nSD 0.000100009f
Cred_14290 v_a.P28.nSD v_b.P37.pSD 2.84485e-06f
Cred_14291 v_a.P28.nSD VSS.$17.Metal1 3.16012e-05f
Cred_14292 v_a.P28.nSD VSS.$301.Metal1 4.13196e-05f
Cred_14293 v_a.P28.nSD VSS.$606.Metal2 4.36589e-06f
Cred_14294 v_a.P28.nSD VSS.$760.Metal3 2.58324e-07f
Cred_14295 v_a.P28.nSD VSS.P0.pSD 0.00693496f
Cred_14296 v_a.P28.pSD v_b.$2751.Metal2 0.022201f
Cred_14297 v_a.P28.pSD v_b.$2811.Metal2 0.00745751f
Cred_14298 v_a.P28.pSD v_b.$3779.Metal3 2.40343e-05f
Cred_14299 v_a.P28.pSD v_b.P27.pSD 0.0373716f
Cred_14300 v_a.P28.pSD v_b.P29.nSD 8.25213e-05f
Cred_14301 v_a.P28.pSD v_b.P29.pSD 0.0389168f
Cred_14302 v_a.P28.pSD v_b.P37.nSD 2.87349e-08f
Cred_14303 v_a.P28.pSD v_b.P37.pSD 1.75554e-05f
Cred_14304 v_a.P28.pSD VDD.$340.Metal1 7.64614e-06f
Cred_14305 v_a.P28.pSD VDD.$388.Metal2 9.30716e-08f
Cred_14306 v_a.P28.pSD VDD.$42.Metal1 4.37012e-06f
Cred_14307 v_a.P28.pSD VDD.$666.Metal3 4.09751e-09f
Cred_14308 v_a.P28.pSD VDD.P0.nSD 0.0043209f
Cred_14309 v_a.P30.nSD v_b.$2751.Metal2 0.0809704f
Cred_14310 v_a.P30.nSD v_b.$2811.Metal2 0.250082f
Cred_14311 v_a.P30.nSD v_b.$3779.Metal3 0.001502f
Cred_14312 v_a.P30.nSD v_b.P29.nSD 0.0844386f
Cred_14313 v_a.P30.nSD v_b.P29.pSD 0.00162821f
Cred_14314 v_a.P30.nSD v_b.P31.nSD 0.0880943f
Cred_14315 v_a.P30.nSD v_b.P37.nSD 0.00014712f
Cred_14316 v_a.P30.nSD v_b.P37.pSD 4.2039e-06f
Cred_14317 v_a.P30.nSD VSS.$17.Metal1 2.45271e-05f
Cred_14318 v_a.P30.nSD VSS.$301.Metal1 5.31167e-05f
Cred_14319 v_a.P30.nSD VSS.$606.Metal2 5.61239e-06f
Cred_14320 v_a.P30.nSD VSS.$760.Metal3 3.32078e-07f
Cred_14321 v_a.P30.nSD VSS.P0.pSD 0.00695292f
Cred_14322 v_a.P30.pSD v_b.$2751.Metal2 0.00891326f
Cred_14323 v_a.P30.pSD v_b.$2811.Metal2 0.0270224f
Cred_14324 v_a.P30.pSD v_b.$3779.Metal3 3.84548e-05f
Cred_14325 v_a.P30.pSD v_b.P29.nSD 9.863e-05f
Cred_14326 v_a.P30.pSD v_b.P29.pSD 0.0484548f
Cred_14327 v_a.P30.pSD v_b.P31.pSD 0.0481478f
Cred_14328 v_a.P30.pSD v_b.P37.nSD 4.59757e-08f
Cred_14329 v_a.P30.pSD v_b.P37.pSD 2.8186e-05f
Cred_14330 v_a.P30.pSD VDD.$340.Metal1 9.79524e-06f
Cred_14331 v_a.P30.pSD VDD.$388.Metal2 7.19917e-08f
Cred_14332 v_a.P30.pSD VDD.$42.Metal1 3.38033e-06f
Cred_14333 v_a.P30.pSD VDD.$666.Metal3 3.16946e-09f
Cred_14334 v_a.P30.pSD VDD.P0.nSD 0.00431976f
Cred_14335 v_a.P32.nSD v_b.$2811.Metal2 0.257222f
Cred_14336 v_a.P32.nSD v_b.$2871.Metal2 0.0828556f
Cred_14337 v_a.P32.nSD v_b.$3779.Metal3 0.00261352f
Cred_14338 v_a.P32.nSD v_b.P31.nSD 0.0935511f
Cred_14339 v_a.P32.nSD v_b.P33.nSD 0.0892288f
Cred_14340 v_a.P32.nSD v_b.P33.pSD 0.00166612f
Cred_14341 v_a.P32.nSD v_b.P37.nSD 0.000259395f
Cred_14342 v_a.P32.nSD v_b.P37.pSD 7.31489e-06f
Cred_14343 v_a.P32.nSD VSS.$17.Metal1 1.89067e-05f
Cred_14344 v_a.P32.nSD VSS.$301.Metal1 6.80623e-05f
Cred_14345 v_a.P32.nSD VSS.$606.Metal2 7.19157e-06f
Cred_14346 v_a.P32.nSD VSS.$760.Metal3 4.25516e-07f
Cred_14347 v_a.P32.nSD VSS.P0.pSD 0.00691792f
Cred_14348 v_a.P32.pSD v_b.$2811.Metal2 0.0229108f
Cred_14349 v_a.P32.pSD v_b.$2871.Metal2 0.00745928f
Cred_14350 v_a.P32.pSD v_b.$3779.Metal3 6.3475e-05f
Cred_14351 v_a.P32.pSD v_b.P31.pSD 0.0397167f
Cred_14352 v_a.P32.pSD v_b.P33.nSD 8.25409e-05f
Cred_14353 v_a.P32.pSD v_b.P33.pSD 0.0389439f
Cred_14354 v_a.P32.pSD v_b.P37.nSD 7.58892e-08f
Cred_14355 v_a.P32.pSD v_b.P37.pSD 4.63826e-05f
Cred_14356 v_a.P32.pSD VDD.$340.Metal1 1.2594e-05f
Cred_14357 v_a.P32.pSD VDD.$388.Metal2 5.56866e-08f
Cred_14358 v_a.P32.pSD VDD.$42.Metal1 2.61473e-06f
Cred_14359 v_a.P32.pSD VDD.$666.Metal3 2.45162e-09f
Cred_14360 v_a.P32.pSD VDD.P0.nSD 0.00431775f
Cred_14361 v_a.P34.nSD v_b.$1992.Metal1 2.54043e-09f
Cred_14362 v_a.P34.nSD v_b.$2003.Metal1 1.34192e-06f
Cred_14363 v_a.P34.nSD v_b.$2811.Metal2 0.089926f
Cred_14364 v_a.P34.nSD v_b.$2871.Metal2 0.268643f
Cred_14365 v_a.P34.nSD v_b.$2962.Metal2 1.60805e-07f
Cred_14366 v_a.P34.nSD v_b.$3053.Metal2 1.9503e-07f
Cred_14367 v_a.P34.nSD v_b.$3056.Metal2 2.10671e-07f
Cred_14368 v_a.P34.nSD v_b.$3089.Metal2 5.23676e-08f
Cred_14369 v_a.P34.nSD v_b.$3487.Metal2 2.48695e-07f
Cred_14370 v_a.P34.nSD v_b.$3491.Metal2 2.80599e-08f
Cred_14371 v_a.P34.nSD v_b.$3495.Metal2 2.64278e-08f
Cred_14372 v_a.P34.nSD v_b.$3499.Metal2 2.50501e-08f
Cred_14373 v_a.P34.nSD v_b.$3503.Metal2 7.00689e-08f
Cred_14374 v_a.P34.nSD v_b.$3505.Metal2 9.27137e-08f
Cred_14375 v_a.P34.nSD v_b.$3507.Metal2 4.19791e-06f
Cred_14376 v_a.P34.nSD v_b.$3779.Metal3 0.025257f
Cred_14377 v_a.P34.nSD v_b.$3785.Metal3 0.00454839f
Cred_14378 v_a.P34.nSD v_b.$3821.Metal3 0.00280491f
Cred_14379 v_a.P34.nSD v_b.$3857.Metal3 0.00097284f
Cred_14380 v_a.P34.nSD v_b.$3890.Metal3 0.00102148f
Cred_14381 v_a.P34.nSD v_b.$3903.Metal3 0.00157279f
Cred_14382 v_a.P34.nSD v_b.$3934.Metal3 0.00129176f
Cred_14383 v_a.P34.nSD v_b.$3970.Metal3 0.00100322f
Cred_14384 v_a.P34.nSD v_b.$3980.Metal3 2.37895e-05f
Cred_14385 v_a.P34.nSD v_b.$3982.Metal3 1.36105e-05f
Cred_14386 v_a.P34.nSD v_b.$3984.Metal3 1.28592e-05f
Cred_14387 v_a.P34.nSD v_b.$3986.Metal3 1.79862e-05f
Cred_14388 v_a.P34.nSD v_b.$3990.Metal3 5.57438e-05f
Cred_14389 v_a.P34.nSD v_b.$4009.Metal3 0.000953865f
Cred_14390 v_a.P34.nSD v_b.P33.nSD 0.0926561f
Cred_14391 v_a.P34.nSD v_b.P33.pSD 0.00466641f
Cred_14392 v_a.P34.nSD v_b.P35.nSD 0.0889176f
Cred_14393 v_a.P34.nSD v_b.P35.pSD 0.00278038f
Cred_14394 v_a.P34.nSD v_b.P37.nSD 0.00206386f
Cred_14395 v_a.P34.nSD v_b.P37.pSD 0.00103138f
Cred_14396 v_a.P34.nSD v_b.P41.nSD 0.000229974f
Cred_14397 v_a.P34.nSD v_b.P41.pSD 0.000141747f
Cred_14398 v_a.P34.nSD v_b.P45.nSD 0.000143166f
Cred_14399 v_a.P34.nSD v_b.P45.pSD 8.81709e-05f
Cred_14400 v_a.P34.nSD v_b.P49.nSD 0.000105567f
Cred_14401 v_a.P34.nSD v_b.P49.pSD 6.8392e-05f
Cred_14402 v_a.P34.nSD v_b.P53.nSD 8.15e-05f
Cred_14403 v_a.P34.nSD v_b.P53.pSD 5.01977e-05f
Cred_14404 v_a.P34.nSD v_b.P57.nSD 6.69955e-05f
Cred_14405 v_a.P34.nSD v_b.P57.pSD 4.12915e-05f
Cred_14406 v_a.P34.nSD v_b.P61.nSD 5.69597e-05f
Cred_14407 v_a.P34.nSD v_b.P61.pSD 9.27675e-07f
Cred_14408 v_a.P34.nSD v_b.P65.nSD 4.94691e-05f
Cred_14409 v_a.P34.nSD v_b.P65.pSD 3.04884e-05f
Cred_14410 v_a.P34.nSD VDD.$230.Metal1 6.40922e-06f
Cred_14411 v_a.P34.nSD VDD.$238.Metal1 1.31022e-06f
Cred_14412 v_a.P34.nSD VDD.$340.Metal1 1.42478e-07f
Cred_14413 v_a.P34.nSD VDD.$388.Metal2 3.76993e-10f
Cred_14414 v_a.P34.nSD VDD.$42.Metal1 1.77015e-08f
Cred_14415 v_a.P34.nSD VDD.$552.Metal2 2.58351e-06f
Cred_14416 v_a.P34.nSD VDD.$560.Metal2 2.62329e-06f
Cred_14417 v_a.P34.nSD VDD.$568.Metal2 1.47082e-08f
Cred_14418 v_a.P34.nSD VDD.$666.Metal3 1.65973e-11f
Cred_14419 v_a.P34.nSD VDD.$750.Metal3 1.85671e-05f
Cred_14420 v_a.P34.nSD VDD.$758.Metal3 9.1905e-07f
Cred_14421 v_a.P34.nSD VDD.P0.nSD 3.78292e-05f
Cred_14422 v_a.P34.nSD VSS.$17.Metal1 1.53924e-05f
Cred_14423 v_a.P34.nSD VSS.$213.Metal1 0.000939791f
Cred_14424 v_a.P34.nSD VSS.$221.Metal1 0.000191913f
Cred_14425 v_a.P34.nSD VSS.$301.Metal1 9.21863e-05f
Cred_14426 v_a.P34.nSD VSS.$518.Metal2 0.000498726f
Cred_14427 v_a.P34.nSD VSS.$526.Metal2 0.000500206f
Cred_14428 v_a.P34.nSD VSS.$606.Metal2 9.74054e-06f
Cred_14429 v_a.P34.nSD VSS.$716.Metal3 0.000499831f
Cred_14430 v_a.P34.nSD VSS.$760.Metal3 5.76335e-07f
Cred_14431 v_a.P34.nSD VSS.P0.pSD 0.00725904f
Cred_14432 v_a.P34.pSD v_b.$1992.Metal1 7.26761e-08f
Cred_14433 v_a.P34.pSD v_b.$2003.Metal1 0.000150913f
Cred_14434 v_a.P34.pSD v_b.$2811.Metal2 0.208549f
Cred_14435 v_a.P34.pSD v_b.$2871.Metal2 0.625056f
Cred_14436 v_a.P34.pSD v_b.$2962.Metal2 2.77786e-07f
Cred_14437 v_a.P34.pSD v_b.$3053.Metal2 2.1341e-07f
Cred_14438 v_a.P34.pSD v_b.$3056.Metal2 4.38681e-08f
Cred_14439 v_a.P34.pSD v_b.$3089.Metal2 1.09045e-08f
Cred_14440 v_a.P34.pSD v_b.$3487.Metal2 7.27419e-06f
Cred_14441 v_a.P34.pSD v_b.$3491.Metal2 1.31215e-06f
Cred_14442 v_a.P34.pSD v_b.$3495.Metal2 1.56198e-06f
Cred_14443 v_a.P34.pSD v_b.$3499.Metal2 1.77289e-06f
Cred_14444 v_a.P34.pSD v_b.$3503.Metal2 5.94126e-06f
Cred_14445 v_a.P34.pSD v_b.$3505.Metal2 8.01579e-06f
Cred_14446 v_a.P34.pSD v_b.$3507.Metal2 0.000469144f
Cred_14447 v_a.P34.pSD v_b.$3779.Metal3 0.161037f
Cred_14448 v_a.P34.pSD v_b.$3785.Metal3 0.0315132f
Cred_14449 v_a.P34.pSD v_b.$3821.Metal3 0.0195224f
Cred_14450 v_a.P34.pSD v_b.$3857.Metal3 0.00688034f
Cred_14451 v_a.P34.pSD v_b.$3890.Metal3 0.00722435f
Cred_14452 v_a.P34.pSD v_b.$3903.Metal3 0.0111091f
Cred_14453 v_a.P34.pSD v_b.$3934.Metal3 0.00913542f
Cred_14454 v_a.P34.pSD v_b.$3970.Metal3 0.000450928f
Cred_14455 v_a.P34.pSD v_b.$3980.Metal3 0.000849575f
Cred_14456 v_a.P34.pSD v_b.$3982.Metal3 0.000719679f
Cred_14457 v_a.P34.pSD v_b.$3984.Metal3 0.000834678f
Cred_14458 v_a.P34.pSD v_b.$3986.Metal3 0.00142926f
Cred_14459 v_a.P34.pSD v_b.$3990.Metal3 0.00585728f
Cred_14460 v_a.P34.pSD v_b.$4009.Metal3 0.00674541f
Cred_14461 v_a.P34.pSD v_b.P33.nSD 0.00372713f
Cred_14462 v_a.P34.pSD v_b.P33.pSD 0.685206f
Cred_14463 v_a.P34.pSD v_b.P35.nSD 0.00134976f
Cred_14464 v_a.P34.pSD v_b.P35.pSD 0.664849f
Cred_14465 v_a.P34.pSD v_b.P37.nSD 0.000494188f
Cred_14466 v_a.P34.pSD v_b.P37.pSD 0.0825933f
Cred_14467 v_a.P34.pSD v_b.P41.nSD 3.33305e-05f
Cred_14468 v_a.P34.pSD v_b.P41.pSD 0.0126371f
Cred_14469 v_a.P34.pSD v_b.P45.nSD 2.07598e-05f
Cred_14470 v_a.P34.pSD v_b.P45.pSD 0.00785863f
Cred_14471 v_a.P34.pSD v_b.P49.nSD 2.78137e-05f
Cred_14472 v_a.P34.pSD v_b.P49.pSD 0.00573288f
Cred_14473 v_a.P34.pSD v_b.P53.nSD 1.18172e-05f
Cred_14474 v_a.P34.pSD v_b.P53.pSD 0.00447424f
Cred_14475 v_a.P34.pSD v_b.P57.nSD 9.71004e-06f
Cred_14476 v_a.P34.pSD v_b.P57.pSD 0.00368118f
Cred_14477 v_a.P34.pSD v_b.P61.nSD 8.25849e-06f
Cred_14478 v_a.P34.pSD v_b.P61.pSD 0.000104415f
Cred_14479 v_a.P34.pSD v_b.P65.nSD 7.16998e-06f
Cred_14480 v_a.P34.pSD v_b.P65.pSD 0.00271804f
Cred_14481 v_a.P34.pSD VDD.$230.Metal1 0.00183758f
Cred_14482 v_a.P34.pSD VDD.$238.Metal1 0.000375227f
Cred_14483 v_a.P34.pSD VDD.$340.Metal1 4.29616e-05f
Cred_14484 v_a.P34.pSD VDD.$388.Metal2 1.13624e-07f
Cred_14485 v_a.P34.pSD VDD.$42.Metal1 5.33513e-06f
Cred_14486 v_a.P34.pSD VDD.$552.Metal2 0.0009924f
Cred_14487 v_a.P34.pSD VDD.$560.Metal2 0.000998759f
Cred_14488 v_a.P34.pSD VDD.$568.Metal2 1.71726e-06f
Cred_14489 v_a.P34.pSD VDD.$666.Metal3 5.00232e-09f
Cred_14490 v_a.P34.pSD VDD.$750.Metal3 0.00217334f
Cred_14491 v_a.P34.pSD VDD.$758.Metal3 0.000107304f
Cred_14492 v_a.P34.pSD VDD.P0.nSD 0.011404f
Cred_14493 v_a.P34.pSD VSS.$17.Metal1 2.27521e-07f
Cred_14494 v_a.P34.pSD VSS.$213.Metal1 1.34531e-05f
Cred_14495 v_a.P34.pSD VSS.$221.Metal1 2.75897e-06f
Cred_14496 v_a.P34.pSD VSS.$301.Metal1 1.34449e-06f
Cred_14497 v_a.P34.pSD VSS.$526.Metal2 2.12762e-08f
Cred_14498 v_a.P34.pSD VSS.$606.Metal2 1.42061e-07f
Cred_14499 v_a.P34.pSD VSS.$716.Metal3 6.19396e-05f
Cred_14500 v_a.P34.pSD VSS.$760.Metal3 8.40554e-09f
Cred_14501 v_a.P34.pSD VSS.P0.pSD 0.000106587f
Cred_14502 v_a.P4.nSD v_b.$2361.Metal2 0.0859544f
Cred_14503 v_a.P4.nSD v_b.$2421.Metal2 0.25504f
Cred_14504 v_a.P4.nSD v_b.P3.nSD 0.0945495f
Cred_14505 v_a.P4.nSD v_b.P3.pSD 0.00172843f
Cred_14506 v_a.P4.nSD v_b.P5.nSD 0.0889511f
Cred_14507 v_a.P4.nSD VSS.$17.Metal1 0.000660975f
Cred_14508 v_a.P4.nSD VSS.$301.Metal1 1.92254e-06f
Cred_14509 v_a.P4.nSD VSS.$606.Metal2 2.03138e-07f
Cred_14510 v_a.P4.nSD VSS.$760.Metal3 1.20194e-08f
Cred_14511 v_a.P4.nSD VSS.P0.pSD 0.00634939f
Cred_14512 v_a.P4.pSD v_b.$2361.Metal2 0.00750417f
Cred_14513 v_a.P4.pSD v_b.$2421.Metal2 0.0225872f
Cred_14514 v_a.P4.pSD v_b.P3.nSD 8.30376e-05f
Cred_14515 v_a.P4.pSD v_b.P3.pSD 0.0394682f
Cred_14516 v_a.P4.pSD v_b.P5.pSD 0.0388048f
Cred_14517 v_a.P4.pSD VDD.$340.Metal1 3.59607e-07f
Cred_14518 v_a.P4.pSD VDD.$388.Metal2 1.93869e-06f
Cred_14519 v_a.P4.pSD VDD.$42.Metal1 9.10303e-05f
Cred_14520 v_a.P4.pSD VDD.$666.Metal3 8.53518e-08f
Cred_14521 v_a.P4.pSD VDD.P0.nSD 0.0042396f
Cred_14522 v_a.P6.nSD v_b.$2421.Metal2 0.253478f
Cred_14523 v_a.P6.nSD v_b.$2481.Metal2 0.083927f
Cred_14524 v_a.P6.nSD v_b.P5.nSD 0.0881496f
Cred_14525 v_a.P6.nSD v_b.P7.nSD 0.0902582f
Cred_14526 v_a.P6.nSD v_b.P7.pSD 0.00168766f
Cred_14527 v_a.P6.nSD VSS.$17.Metal1 0.000513071f
Cred_14528 v_a.P6.nSD VSS.$301.Metal1 2.4986e-06f
Cred_14529 v_a.P6.nSD VSS.$606.Metal2 2.64006e-07f
Cred_14530 v_a.P6.nSD VSS.$760.Metal3 1.56209e-08f
Cred_14531 v_a.P6.nSD VSS.P0.pSD 0.00652066f
Cred_14532 v_a.P6.pSD v_b.$2421.Metal2 0.0266222f
Cred_14533 v_a.P6.pSD v_b.$2481.Metal2 0.00885694f
Cred_14534 v_a.P6.pSD v_b.P5.pSD 0.0474149f
Cred_14535 v_a.P6.pSD v_b.P7.nSD 9.80068e-05f
Cred_14536 v_a.P6.pSD v_b.P7.pSD 0.0483714f
Cred_14537 v_a.P6.pSD VDD.$340.Metal1 4.64467e-07f
Cred_14538 v_a.P6.pSD VDD.$388.Metal2 1.49965e-06f
Cred_14539 v_a.P6.pSD VDD.$42.Metal1 7.04151e-05f
Cred_14540 v_a.P6.pSD VDD.$666.Metal3 6.60225e-08f
Cred_14541 v_a.P6.pSD VDD.P0.nSD 0.00426028f
Cred_14542 v_a.P8.nSD v_b.$2421.Metal2 0.0827903f
Cred_14543 v_a.P8.nSD v_b.$2481.Metal2 0.251876f
Cred_14544 v_a.P8.nSD v_b.P10.nSD 0.0889511f
Cred_14545 v_a.P8.nSD v_b.P7.nSD 0.088689f
Cred_14546 v_a.P8.nSD v_b.P7.pSD 0.00166481f
Cred_14547 v_a.P8.nSD VSS.$17.Metal1 0.00039558f
Cred_14548 v_a.P8.nSD VSS.$301.Metal1 3.22275e-06f
Cred_14549 v_a.P8.nSD VSS.$606.Metal2 3.4052e-07f
Cred_14550 v_a.P8.nSD VSS.$760.Metal3 2.01481e-08f
Cred_14551 v_a.P8.nSD VSS.P0.pSD 0.00661334f
Cred_14552 v_a.P8.pSD v_b.$2421.Metal2 0.00885859f
Cred_14553 v_a.P8.pSD v_b.$2481.Metal2 0.0270793f
Cred_14554 v_a.P8.pSD v_b.P10.pSD 0.048518f
Cred_14555 v_a.P8.pSD v_b.P7.nSD 9.8025e-05f
Cred_14556 v_a.P8.pSD v_b.P7.pSD 0.0479116f
Cred_14557 v_a.P8.pSD VDD.$340.Metal1 6.00196e-07f
Cred_14558 v_a.P8.pSD VDD.$388.Metal2 1.16027e-06f
Cred_14559 v_a.P8.pSD VDD.$42.Metal1 5.44798e-05f
Cred_14560 v_a.P8.pSD VDD.$666.Metal3 5.10813e-08f
Cred_14561 v_a.P8.pSD VDD.P0.nSD 0.00427672f
Cred_14562 v_b VDD.$332.Metal1 0.00125787f
Cred_14563 v_b VDD.$340.Metal1 0.0259819f
Cred_14564 v_b VDD.$388.Metal2 5.90914e-08f
Cred_14565 v_b VDD.$42.Metal1 2.7746e-06f
Cred_14566 v_b VDD.$644.Metal2 0.00186087f
Cred_14567 v_b VDD.$666.Metal3 2.60152e-09f
Cred_14568 v_b VDD.$794.Metal3 0.00121617f
Cred_14569 v_b VDD.P0.nSD 0.119278f
Cred_14570 v_b VSS.$17.Metal1 1.25844e-05f
Cred_14571 v_b VSS.$301.Metal1 0.0341372f
Cred_14572 v_b VSS.$606.Metal2 0.00947956f
Cred_14573 v_b VSS.$760.Metal3 0.00376834f
Cred_14574 v_b VSS.P0.pSD 0.0793097f
Cred_14575 v_b.$1992.Metal1 VDD.$340.Metal1 0.000160305f
Cred_14576 v_b.$1992.Metal1 VDD.$388.Metal2 1.16692e-08f
Cred_14577 v_b.$1992.Metal1 VDD.$42.Metal1 5.47921e-07f
Cred_14578 v_b.$1992.Metal1 VDD.$666.Metal3 5.13742e-10f
Cred_14579 v_b.$1992.Metal1 VDD.P0.nSD 0.00693706f
Cred_14580 v_b.$2244.Metal1 VDD.$340.Metal1 0.000267908f
Cred_14581 v_b.$2244.Metal1 VDD.$388.Metal2 7.00885e-09f
Cred_14582 v_b.$2244.Metal1 VDD.$42.Metal1 3.29097e-07f
Cred_14583 v_b.$2244.Metal1 VDD.$666.Metal3 3.08568e-10f
Cred_14584 v_b.$2244.Metal1 VDD.P0.nSD 0.00682968f
Cred_14585 v_b.$2255.Metal1 VDD.$321.Metal1 1.19014e-06f
Cred_14586 v_b.$2255.Metal1 VDD.$332.Metal1 1.1363e-05f
Cred_14587 v_b.$2255.Metal1 VDD.$340.Metal1 2.44977e-07f
Cred_14588 v_b.$2255.Metal1 VDD.$640.Metal2 6.9374e-09f
Cred_14589 v_b.$2255.Metal1 VDD.$644.Metal2 1.69007e-05f
Cred_14590 v_b.$2255.Metal1 VDD.$794.Metal3 0.000209084f
Cred_14591 v_b.$2255.Metal1 VDD.P0.nSD 1.23502e-08f
Cred_14592 v_b.$2361.Metal2 VDD.$340.Metal1 7.6171e-06f
Cred_14593 v_b.$2361.Metal2 VDD.$388.Metal2 0.00234243f
Cred_14594 v_b.$2361.Metal2 VDD.$42.Metal1 0.0259027f
Cred_14595 v_b.$2361.Metal2 VDD.$666.Metal3 0.00121059f
Cred_14596 v_b.$2361.Metal2 VDD.P0.nSD 0.188569f
Cred_14597 v_b.$2361.Metal2 VSS.$17.Metal1 0.0502142f
Cred_14598 v_b.$2361.Metal2 VSS.$301.Metal1 2.65158e-05f
Cred_14599 v_b.$2361.Metal2 VSS.$366.Metal2 0.00562259f
Cred_14600 v_b.$2361.Metal2 VSS.$39.Metal1 0.001218f
Cred_14601 v_b.$2361.Metal2 VSS.$606.Metal2 2.8017e-06f
Cred_14602 v_b.$2361.Metal2 VSS.$636.Metal3 0.00371027f
Cred_14603 v_b.$2361.Metal2 VSS.$760.Metal3 1.65773e-07f
Cred_14604 v_b.$2361.Metal2 VSS.P0.pSD 0.144408f
Cred_14605 v_b.$2421.Metal2 VDD.$340.Metal1 9.63186e-06f
Cred_14606 v_b.$2421.Metal2 VDD.$388.Metal2 4.22466e-05f
Cred_14607 v_b.$2421.Metal2 VDD.$42.Metal1 0.00198367f
Cred_14608 v_b.$2421.Metal2 VDD.$666.Metal3 1.85992e-06f
Cred_14609 v_b.$2421.Metal2 VDD.P0.nSD 0.0997111f
Cred_14610 v_b.$2421.Metal2 VSS.$17.Metal1 0.0104644f
Cred_14611 v_b.$2421.Metal2 VSS.$301.Metal1 3.52121e-05f
Cred_14612 v_b.$2421.Metal2 VSS.$606.Metal2 3.72056e-06f
Cred_14613 v_b.$2421.Metal2 VSS.$760.Metal3 2.20141e-07f
Cred_14614 v_b.$2421.Metal2 VSS.P0.pSD 0.103699f
Cred_14615 v_b.$2481.Metal2 VDD.$340.Metal1 1.5908e-05f
Cred_14616 v_b.$2481.Metal2 VDD.$388.Metal2 2.38851e-05f
Cred_14617 v_b.$2481.Metal2 VDD.$42.Metal1 0.00112151f
Cred_14618 v_b.$2481.Metal2 VDD.$666.Metal3 1.05155e-06f
Cred_14619 v_b.$2481.Metal2 VDD.P0.nSD 0.0982858f
Cred_14620 v_b.$2481.Metal2 VSS.$17.Metal1 0.00550775f
Cred_14621 v_b.$2481.Metal2 VSS.$301.Metal1 5.80524e-05f
Cred_14622 v_b.$2481.Metal2 VSS.$606.Metal2 6.13391e-06f
Cred_14623 v_b.$2481.Metal2 VSS.$760.Metal3 3.62935e-07f
Cred_14624 v_b.$2481.Metal2 VSS.P0.pSD 0.103514f
Cred_14625 v_b.$2541.Metal2 VDD.$340.Metal1 2.6578e-05f
Cred_14626 v_b.$2541.Metal2 VDD.$388.Metal2 1.43055e-05f
Cred_14627 v_b.$2541.Metal2 VDD.$42.Metal1 0.000671706f
Cred_14628 v_b.$2541.Metal2 VDD.$666.Metal3 6.29804e-07f
Cred_14629 v_b.$2541.Metal2 VDD.P0.nSD 0.0987349f
Cred_14630 v_b.$2541.Metal2 VSS.$17.Metal1 0.00329875f
Cred_14631 v_b.$2541.Metal2 VSS.$301.Metal1 9.71066e-05f
Cred_14632 v_b.$2541.Metal2 VSS.$606.Metal2 1.02604e-05f
Cred_14633 v_b.$2541.Metal2 VSS.$760.Metal3 6.07096e-07f
Cred_14634 v_b.$2541.Metal2 VSS.P0.pSD 0.105679f
Cred_14635 v_b.$2601.Metal2 VDD.$340.Metal1 3.04025e-05f
Cred_14636 v_b.$2601.Metal2 VDD.$388.Metal2 6.95859e-06f
Cred_14637 v_b.$2601.Metal2 VDD.$42.Metal1 0.000326737f
Cred_14638 v_b.$2601.Metal2 VDD.$666.Metal3 3.06355e-07f
Cred_14639 v_b.$2601.Metal2 VDD.P0.nSD 0.074414f
Cred_14640 v_b.$2601.Metal2 VSS.$17.Metal1 0.00160461f
Cred_14641 v_b.$2601.Metal2 VSS.$301.Metal1 0.000111123f
Cred_14642 v_b.$2601.Metal2 VSS.$606.Metal2 1.17414e-05f
Cred_14643 v_b.$2601.Metal2 VSS.$760.Metal3 6.94722e-07f
Cred_14644 v_b.$2601.Metal2 VSS.P0.pSD 0.0802973f
Cred_14645 v_b.$2631.Metal2 VDD.$340.Metal1 4.65802e-05f
Cred_14646 v_b.$2631.Metal2 VDD.$388.Metal2 4.56489e-06f
Cred_14647 v_b.$2631.Metal2 VDD.$42.Metal1 0.000214342f
Cred_14648 v_b.$2631.Metal2 VDD.$666.Metal3 2.00971e-07f
Cred_14649 v_b.$2631.Metal2 VDD.P0.nSD 0.0745127f
Cred_14650 v_b.$2631.Metal2 VSS.$17.Metal1 0.00105263f
Cred_14651 v_b.$2631.Metal2 VSS.$301.Metal1 0.000170281f
Cred_14652 v_b.$2631.Metal2 VSS.$606.Metal2 1.79921e-05f
Cred_14653 v_b.$2631.Metal2 VSS.$760.Metal3 1.06457e-06f
Cred_14654 v_b.$2631.Metal2 VSS.P0.pSD 0.0807835f
Cred_14655 v_b.$2691.Metal2 VDD.$340.Metal1 9.52937e-05f
Cred_14656 v_b.$2691.Metal2 VDD.$388.Metal2 4.02447e-06f
Cred_14657 v_b.$2691.Metal2 VDD.$42.Metal1 0.000188967f
Cred_14658 v_b.$2691.Metal2 VDD.$666.Metal3 1.77179e-07f
Cred_14659 v_b.$2691.Metal2 VDD.P0.nSD 0.0986679f
Cred_14660 v_b.$2691.Metal2 VSS.$17.Metal1 0.000930576f
Cred_14661 v_b.$2691.Metal2 VSS.$301.Metal1 0.000350555f
Cred_14662 v_b.$2691.Metal2 VSS.$606.Metal2 3.70401e-05f
Cred_14663 v_b.$2691.Metal2 VSS.$760.Metal3 2.19162e-06f
Cred_14664 v_b.$2691.Metal2 VSS.P0.pSD 0.107682f
Cred_14665 v_b.$2751.Metal2 VDD.$340.Metal1 0.00015856f
Cred_14666 v_b.$2751.Metal2 VDD.$388.Metal2 2.46956e-06f
Cred_14667 v_b.$2751.Metal2 VDD.$42.Metal1 0.000115957f
Cred_14668 v_b.$2751.Metal2 VDD.$666.Metal3 1.08723e-07f
Cred_14669 v_b.$2751.Metal2 VDD.P0.nSD 0.0994547f
Cred_14670 v_b.$2751.Metal2 VSS.$17.Metal1 0.000567091f
Cred_14671 v_b.$2751.Metal2 VSS.$301.Metal1 0.000578004f
Cred_14672 v_b.$2751.Metal2 VSS.$606.Metal2 6.10728e-05f
Cred_14673 v_b.$2751.Metal2 VSS.$760.Metal3 3.61359e-06f
Cred_14674 v_b.$2751.Metal2 VSS.P0.pSD 0.107792f
Cred_14675 v_b.$2811.Metal2 VDD.$340.Metal1 0.000259661f
Cred_14676 v_b.$2811.Metal2 VDD.$388.Metal2 1.47714e-06f
Cred_14677 v_b.$2811.Metal2 VDD.$42.Metal1 6.93585e-05f
Cred_14678 v_b.$2811.Metal2 VDD.$666.Metal3 6.50318e-08f
Cred_14679 v_b.$2811.Metal2 VDD.P0.nSD 0.0991174f
Cred_14680 v_b.$2811.Metal2 VSS.$17.Metal1 0.000340449f
Cred_14681 v_b.$2811.Metal2 VSS.$301.Metal1 0.000949798f
Cred_14682 v_b.$2811.Metal2 VSS.$606.Metal2 0.000100357f
Cred_14683 v_b.$2811.Metal2 VSS.$760.Metal3 5.938e-06f
Cred_14684 v_b.$2811.Metal2 VSS.P0.pSD 0.10769f
Cred_14685 v_b.$2871.Metal2 VDD.$230.Metal1 0.000839839f
Cred_14686 v_b.$2871.Metal2 VDD.$238.Metal1 0.0011876f
Cred_14687 v_b.$2871.Metal2 VDD.$340.Metal1 0.000273683f
Cred_14688 v_b.$2871.Metal2 VDD.$388.Metal2 6.73976e-07f
Cred_14689 v_b.$2871.Metal2 VDD.$42.Metal1 3.16462e-05f
Cred_14690 v_b.$2871.Metal2 VDD.$560.Metal2 0.00232585f
Cred_14691 v_b.$2871.Metal2 VDD.$568.Metal2 5.56335e-06f
Cred_14692 v_b.$2871.Metal2 VDD.$666.Metal3 2.96721e-08f
Cred_14693 v_b.$2871.Metal2 VDD.$750.Metal3 0.00105404f
Cred_14694 v_b.$2871.Metal2 VDD.$758.Metal3 0.00034763f
Cred_14695 v_b.$2871.Metal2 VDD.P0.nSD 0.0694447f
Cred_14696 v_b.$2871.Metal2 VSS.$17.Metal1 0.000160727f
Cred_14697 v_b.$2871.Metal2 VSS.$213.Metal1 0.00132092f
Cred_14698 v_b.$2871.Metal2 VSS.$221.Metal1 0.00187176f
Cred_14699 v_b.$2871.Metal2 VSS.$301.Metal1 0.00104722f
Cred_14700 v_b.$2871.Metal2 VSS.$526.Metal2 0.00794415f
Cred_14701 v_b.$2871.Metal2 VSS.$534.Metal2 0.000493593f
Cred_14702 v_b.$2871.Metal2 VSS.$606.Metal2 0.000110651f
Cred_14703 v_b.$2871.Metal2 VSS.$716.Metal3 0.00223556f
Cred_14704 v_b.$2871.Metal2 VSS.$724.Metal3 0.000738579f
Cred_14705 v_b.$2871.Metal2 VSS.$760.Metal3 6.54708e-06f
Cred_14706 v_b.$2871.Metal2 VSS.P0.pSD 0.078268f
Cred_14707 v_b.$2962.Metal2 VDD.$340.Metal1 0.000259313f
Cred_14708 v_b.$2962.Metal2 VDD.$388.Metal2 3.43105e-07f
Cred_14709 v_b.$2962.Metal2 VDD.$42.Metal1 1.61103e-05f
Cred_14710 v_b.$2962.Metal2 VDD.$666.Metal3 1.51053e-08f
Cred_14711 v_b.$2962.Metal2 VDD.P0.nSD 0.0485441f
Cred_14712 v_b.$2962.Metal2 VSS.$17.Metal1 7.57231e-05f
Cred_14713 v_b.$2962.Metal2 VSS.$301.Metal1 0.000913894f
Cred_14714 v_b.$2962.Metal2 VSS.$606.Metal2 9.65635e-05f
Cred_14715 v_b.$2962.Metal2 VSS.$760.Metal3 5.71353e-06f
Cred_14716 v_b.$2962.Metal2 VSS.P0.pSD 0.050364f
Cred_14717 v_b.$3053.Metal2 VDD.$340.Metal1 0.000159155f
Cred_14718 v_b.$3053.Metal2 VDD.$388.Metal2 1.45357e-07f
Cred_14719 v_b.$3053.Metal2 VDD.$42.Metal1 6.82515e-06f
Cred_14720 v_b.$3053.Metal2 VDD.$666.Metal3 6.39939e-09f
Cred_14721 v_b.$3053.Metal2 VDD.P0.nSD 0.0247853f
Cred_14722 v_b.$3053.Metal2 VSS.$17.Metal1 3.3902e-05f
Cred_14723 v_b.$3053.Metal2 VSS.$301.Metal1 0.000588145f
Cred_14724 v_b.$3053.Metal2 VSS.$606.Metal2 6.21443e-05f
Cred_14725 v_b.$3053.Metal2 VSS.$760.Metal3 3.67699e-06f
Cred_14726 v_b.$3053.Metal2 VSS.P0.pSD 0.0269895f
Cred_14727 v_b.$3056.Metal2 VDD.$340.Metal1 0.000154034f
Cred_14728 v_b.$3056.Metal2 VDD.$388.Metal2 1.09356e-07f
Cred_14729 v_b.$3056.Metal2 VDD.$42.Metal1 5.13473e-06f
Cred_14730 v_b.$3056.Metal2 VDD.$666.Metal3 4.81443e-09f
Cred_14731 v_b.$3056.Metal2 VDD.P0.nSD 0.0211538f
Cred_14732 v_b.$3056.Metal2 VSS.$17.Metal1 2.42663e-05f
Cred_14733 v_b.$3056.Metal2 VSS.$301.Metal1 0.000543084f
Cred_14734 v_b.$3056.Metal2 VSS.$606.Metal2 5.73831e-05f
Cred_14735 v_b.$3056.Metal2 VSS.$760.Metal3 3.39528e-06f
Cred_14736 v_b.$3056.Metal2 VSS.P0.pSD 0.021899f
Cred_14737 v_b.$3089.Metal2 VDD.$340.Metal1 0.000202516f
Cred_14738 v_b.$3089.Metal2 VDD.$388.Metal2 1.1539e-07f
Cred_14739 v_b.$3089.Metal2 VDD.$42.Metal1 5.41809e-06f
Cred_14740 v_b.$3089.Metal2 VDD.$666.Metal3 5.08011e-09f
Cred_14741 v_b.$3089.Metal2 VDD.P0.nSD 0.0248676f
Cred_14742 v_b.$3089.Metal2 VSS.$17.Metal1 2.76046e-05f
Cred_14743 v_b.$3089.Metal2 VSS.$301.Metal1 0.000769336f
Cred_14744 v_b.$3089.Metal2 VSS.$606.Metal2 8.12892e-05f
Cred_14745 v_b.$3089.Metal2 VSS.$760.Metal3 4.80977e-06f
Cred_14746 v_b.$3089.Metal2 VSS.P0.pSD 0.0276761f
Cred_14747 v_b.$3153.Metal2 VDD.$340.Metal1 0.000371989f
Cred_14748 v_b.$3153.Metal2 VDD.$388.Metal2 1.5187e-07f
Cred_14749 v_b.$3153.Metal2 VDD.$42.Metal1 7.13097e-06f
Cred_14750 v_b.$3153.Metal2 VDD.$666.Metal3 6.68613e-09f
Cred_14751 v_b.$3153.Metal2 VDD.P0.nSD 0.0385663f
Cred_14752 v_b.$3153.Metal2 VSS.$17.Metal1 3.4143e-05f
Cred_14753 v_b.$3153.Metal2 VSS.$301.Metal1 0.00132892f
Cred_14754 v_b.$3153.Metal2 VSS.$606.Metal2 0.000140416f
Cred_14755 v_b.$3153.Metal2 VSS.$760.Metal3 8.3082e-06f
Cred_14756 v_b.$3153.Metal2 VSS.P0.pSD 0.0402009f
Cred_14757 v_b.$3247.Metal2 VDD.$340.Metal1 0.000441326f
Cred_14758 v_b.$3247.Metal2 VDD.$388.Metal2 1.25581e-07f
Cred_14759 v_b.$3247.Metal2 VDD.$42.Metal1 5.89658e-06f
Cred_14760 v_b.$3247.Metal2 VDD.$666.Metal3 5.52874e-09f
Cred_14761 v_b.$3247.Metal2 VDD.P0.nSD 0.0381281f
Cred_14762 v_b.$3247.Metal2 VSS.$17.Metal1 2.8376e-05f
Cred_14763 v_b.$3247.Metal2 VSS.$301.Metal1 0.00158011f
Cred_14764 v_b.$3247.Metal2 VSS.$606.Metal2 0.000166957f
Cred_14765 v_b.$3247.Metal2 VSS.$760.Metal3 9.87861e-06f
Cred_14766 v_b.$3247.Metal2 VSS.P0.pSD 0.0396888f
Cred_14767 v_b.$3294.Metal2 VDD.$340.Metal1 0.000338261f
Cred_14768 v_b.$3294.Metal2 VDD.$388.Metal2 6.90456e-08f
Cred_14769 v_b.$3294.Metal2 VDD.$42.Metal1 3.242e-06f
Cred_14770 v_b.$3294.Metal2 VDD.$666.Metal3 3.03976e-09f
Cred_14771 v_b.$3294.Metal2 VDD.P0.nSD 0.0247296f
Cred_14772 v_b.$3294.Metal2 VSS.$17.Metal1 1.65239e-05f
Cred_14773 v_b.$3294.Metal2 VSS.$301.Metal1 0.00128612f
Cred_14774 v_b.$3294.Metal2 VSS.$606.Metal2 0.000135893f
Cred_14775 v_b.$3294.Metal2 VSS.$760.Metal3 8.04063e-06f
Cred_14776 v_b.$3294.Metal2 VSS.P0.pSD 0.027141f
Cred_14777 v_b.$3344.Metal2 VDD.$340.Metal1 0.000487536f
Cred_14778 v_b.$3344.Metal2 VDD.$388.Metal2 7.51316e-08f
Cred_14779 v_b.$3344.Metal2 VDD.$42.Metal1 3.52776e-06f
Cred_14780 v_b.$3344.Metal2 VDD.$666.Metal3 3.3077e-09f
Cred_14781 v_b.$3344.Metal2 VDD.P0.nSD 0.0309141f
Cred_14782 v_b.$3344.Metal2 VSS.$17.Metal1 1.68079e-05f
Cred_14783 v_b.$3344.Metal2 VSS.$301.Metal1 0.00173312f
Cred_14784 v_b.$3344.Metal2 VSS.$606.Metal2 0.000183124f
Cred_14785 v_b.$3344.Metal2 VSS.$760.Metal3 1.08352e-05f
Cred_14786 v_b.$3344.Metal2 VSS.P0.pSD 0.031553f
Cred_14787 v_b.$3435.Metal2 VDD.$340.Metal1 0.000591766f
Cred_14788 v_b.$3435.Metal2 VDD.$388.Metal2 5.45144e-08f
Cred_14789 v_b.$3435.Metal2 VDD.$42.Metal1 2.55969e-06f
Cred_14790 v_b.$3435.Metal2 VDD.$666.Metal3 2.40002e-09f
Cred_14791 v_b.$3435.Metal2 VDD.P0.nSD 0.0271365f
Cred_14792 v_b.$3435.Metal2 VSS.$17.Metal1 1.31075e-05f
Cred_14793 v_b.$3435.Metal2 VSS.$301.Metal1 0.00302328f
Cred_14794 v_b.$3435.Metal2 VSS.$606.Metal2 0.000319444f
Cred_14795 v_b.$3435.Metal2 VSS.$760.Metal3 1.89011e-05f
Cred_14796 v_b.$3435.Metal2 VSS.P0.pSD 0.0313651f
Cred_14797 v_b.$3438.Metal2 VDD.$340.Metal1 0.00042565f
Cred_14798 v_b.$3438.Metal2 VDD.$388.Metal2 3.86503e-08f
Cred_14799 v_b.$3438.Metal2 VDD.$42.Metal1 1.8148e-06f
Cred_14800 v_b.$3438.Metal2 VDD.$666.Metal3 1.70159e-09f
Cred_14801 v_b.$3438.Metal2 VDD.P0.nSD 0.0206306f
Cred_14802 v_b.$3438.Metal2 VSS.$17.Metal1 8.44677e-06f
Cred_14803 v_b.$3438.Metal2 VSS.$301.Metal1 0.00148428f
Cred_14804 v_b.$3438.Metal2 VSS.$606.Metal2 0.000156831f
Cred_14805 v_b.$3438.Metal2 VSS.$760.Metal3 9.27947e-06f
Cred_14806 v_b.$3438.Metal2 VSS.P0.pSD 0.0203465f
Cred_14807 v_b.$3487.Metal2 VDD.$340.Metal1 8.16252e-06f
Cred_14808 v_b.$3487.Metal2 VDD.$388.Metal2 5.9418e-10f
Cred_14809 v_b.$3487.Metal2 VDD.$42.Metal1 2.78994e-08f
Cred_14810 v_b.$3487.Metal2 VDD.$666.Metal3 2.6159e-11f
Cred_14811 v_b.$3487.Metal2 VDD.P0.nSD 0.000353226f
Cred_14812 v_b.$3529.Metal2 VDD.$340.Metal1 0.000565566f
Cred_14813 v_b.$3529.Metal2 VDD.$388.Metal2 4.1373e-08f
Cred_14814 v_b.$3529.Metal2 VDD.$42.Metal1 1.94265e-06f
Cred_14815 v_b.$3529.Metal2 VDD.$666.Metal3 1.82146e-09f
Cred_14816 v_b.$3529.Metal2 VDD.P0.nSD 0.0245129f
Cred_14817 v_b.$3529.Metal2 VSS.$17.Metal1 9.86192e-06f
Cred_14818 v_b.$3529.Metal2 VSS.$301.Metal1 0.00214726f
Cred_14819 v_b.$3529.Metal2 VSS.$606.Metal2 0.000226883f
Cred_14820 v_b.$3529.Metal2 VSS.$760.Metal3 1.34244e-05f
Cred_14821 v_b.$3529.Metal2 VSS.P0.pSD 0.0261688f
Cred_14822 v_b.$3535.Metal2 VDD.$340.Metal1 0.000538886f
Cred_14823 v_b.$3535.Metal2 VDD.$388.Metal2 3.16331e-08f
Cred_14824 v_b.$3535.Metal2 VDD.$42.Metal1 1.48532e-06f
Cred_14825 v_b.$3535.Metal2 VDD.$666.Metal3 1.39266e-09f
Cred_14826 v_b.$3535.Metal2 VDD.P0.nSD 0.0208883f
Cred_14827 v_b.$3535.Metal2 VSS.$17.Metal1 6.96438e-06f
Cred_14828 v_b.$3535.Metal2 VSS.$301.Metal1 0.00188921f
Cred_14829 v_b.$3535.Metal2 VSS.$606.Metal2 0.000199617f
Cred_14830 v_b.$3535.Metal2 VSS.$760.Metal3 1.18111e-05f
Cred_14831 v_b.$3535.Metal2 VSS.P0.pSD 0.0204526f
Cred_14832 v_b.$3565.Metal2 VDD.$340.Metal1 0.000725131f
Cred_14833 v_b.$3565.Metal2 VDD.$388.Metal2 3.28243e-08f
Cred_14834 v_b.$3565.Metal2 VDD.$42.Metal1 1.54125e-06f
Cred_14835 v_b.$3565.Metal2 VDD.$666.Metal3 1.4451e-09f
Cred_14836 v_b.$3565.Metal2 VDD.P0.nSD 0.0245613f
Cred_14837 v_b.$3565.Metal2 VSS.$17.Metal1 7.53201e-06f
Cred_14838 v_b.$3565.Metal2 VSS.$301.Metal1 0.00266276f
Cred_14839 v_b.$3565.Metal2 VSS.$606.Metal2 0.000281351f
Cred_14840 v_b.$3565.Metal2 VSS.$760.Metal3 1.66472e-05f
Cred_14841 v_b.$3565.Metal2 VSS.P0.pSD 0.0248731f
Cred_14842 v_b.$3629.Metal2 VDD.$340.Metal1 0.001659f
Cred_14843 v_b.$3629.Metal2 VDD.$388.Metal2 5.24212e-08f
Cred_14844 v_b.$3629.Metal2 VDD.$42.Metal1 2.46141e-06f
Cred_14845 v_b.$3629.Metal2 VDD.$666.Metal3 2.30786e-09f
Cred_14846 v_b.$3629.Metal2 VDD.P0.nSD 0.0465493f
Cred_14847 v_b.$3629.Metal2 VSS.$17.Metal1 1.15951e-05f
Cred_14848 v_b.$3629.Metal2 VSS.$301.Metal1 0.00587053f
Cred_14849 v_b.$3629.Metal2 VSS.$606.Metal2 0.00062029f
Cred_14850 v_b.$3629.Metal2 VSS.$760.Metal3 3.67017e-05f
Cred_14851 v_b.$3629.Metal2 VSS.P0.pSD 0.0447141f
Cred_14852 v_b.$3678.Metal2 VDD.$340.Metal1 1.36395e-05f
Cred_14853 v_b.$3678.Metal2 VDD.$388.Metal2 3.56827e-10f
Cred_14854 v_b.$3678.Metal2 VDD.$42.Metal1 1.67546e-08f
Cred_14855 v_b.$3678.Metal2 VDD.$666.Metal3 1.57095e-11f
Cred_14856 v_b.$3678.Metal2 VDD.P0.nSD 0.000347705f
Cred_14857 v_b.$3694.Metal2 VDD.$340.Metal1 1.50011e-06f
Cred_14858 v_b.$3694.Metal2 VDD.$388.Metal2 1.21495e-12f
Cred_14859 v_b.$3694.Metal2 VDD.$42.Metal1 5.70475e-11f
Cred_14860 v_b.$3694.Metal2 VDD.$666.Metal3 5.34889e-14f
Cred_14861 v_b.$3694.Metal2 VDD.P0.nSD 5.58618e-06f
Cred_14862 v_b.$3696.Metal2 VDD.$340.Metal1 3.01225e-06f
Cred_14863 v_b.$3696.Metal2 VDD.$388.Metal2 2.43965e-12f
Cred_14864 v_b.$3696.Metal2 VDD.$42.Metal1 1.14552e-10f
Cred_14865 v_b.$3696.Metal2 VDD.$666.Metal3 1.07407e-13f
Cred_14866 v_b.$3696.Metal2 VDD.P0.nSD 1.12171e-05f
Cred_14867 v_b.$3698.Metal2 VDD.$321.Metal1 4.4359e-06f
Cred_14868 v_b.$3698.Metal2 VDD.$332.Metal1 4.2296e-05f
Cred_14869 v_b.$3698.Metal2 VDD.$340.Metal1 3.42861e-06f
Cred_14870 v_b.$3698.Metal2 VDD.$388.Metal2 1.96088e-12f
Cred_14871 v_b.$3698.Metal2 VDD.$42.Metal1 9.20723e-11f
Cred_14872 v_b.$3698.Metal2 VDD.$640.Metal2 2.58571e-08f
Cred_14873 v_b.$3698.Metal2 VDD.$644.Metal2 5.91466e-05f
Cred_14874 v_b.$3698.Metal2 VDD.$666.Metal3 8.63287e-14f
Cred_14875 v_b.$3698.Metal2 VDD.$794.Metal3 0.000605376f
Cred_14876 v_b.$3698.Metal2 VDD.P0.nSD 9.31775e-06f
Cred_14877 v_b.$3779.Metal3 VDD.$238.Metal1 0.000986306f
Cred_14878 v_b.$3779.Metal3 VDD.$340.Metal1 2.77683e-05f
Cred_14879 v_b.$3779.Metal3 VDD.$388.Metal2 4.39789e-08f
Cred_14880 v_b.$3779.Metal3 VDD.$42.Metal1 2.065e-06f
Cred_14881 v_b.$3779.Metal3 VDD.$560.Metal2 0.000528985f
Cred_14882 v_b.$3779.Metal3 VDD.$568.Metal2 0.000528985f
Cred_14883 v_b.$3779.Metal3 VDD.$666.Metal3 1.93619e-09f
Cred_14884 v_b.$3779.Metal3 VDD.$750.Metal3 0.00148821f
Cred_14885 v_b.$3779.Metal3 VDD.$758.Metal3 0.00148821f
Cred_14886 v_b.$3779.Metal3 VDD.P0.nSD 0.00570256f
Cred_14887 v_b.$3779.Metal3 VSS.$17.Metal1 9.41627e-06f
Cred_14888 v_b.$3779.Metal3 VSS.$221.Metal1 0.00108062f
Cred_14889 v_b.$3779.Metal3 VSS.$301.Metal1 9.43175e-05f
Cred_14890 v_b.$3779.Metal3 VSS.$526.Metal2 0.000802256f
Cred_14891 v_b.$3779.Metal3 VSS.$534.Metal2 0.000802256f
Cred_14892 v_b.$3779.Metal3 VSS.$606.Metal2 9.96573e-06f
Cred_14893 v_b.$3779.Metal3 VSS.$716.Metal3 0.0024579f
Cred_14894 v_b.$3779.Metal3 VSS.$724.Metal3 0.0024579f
Cred_14895 v_b.$3779.Metal3 VSS.$760.Metal3 5.89659e-07f
Cred_14896 v_b.$3779.Metal3 VSS.P0.pSD 0.00572655f
Cred_14897 v_b.$3785.Metal3 VDD.$340.Metal1 3.88591e-05f
Cred_14898 v_b.$3785.Metal3 VDD.$388.Metal2 3.69398e-08f
Cred_14899 v_b.$3785.Metal3 VDD.$42.Metal1 1.73449e-06f
Cred_14900 v_b.$3785.Metal3 VDD.$666.Metal3 1.62629e-09f
Cred_14901 v_b.$3785.Metal3 VDD.P0.nSD 0.00617807f
Cred_14902 v_b.$3785.Metal3 VSS.$17.Metal1 7.53201e-06f
Cred_14903 v_b.$3785.Metal3 VSS.$301.Metal1 0.000125664f
Cred_14904 v_b.$3785.Metal3 VSS.$606.Metal2 1.32779e-05f
Cred_14905 v_b.$3785.Metal3 VSS.$760.Metal3 7.85633e-07f
Cred_14906 v_b.$3785.Metal3 VSS.P0.pSD 0.00588666f
Cred_14907 v_b.$3821.Metal3 VDD.$340.Metal1 5.00705e-05f
Cred_14908 v_b.$3821.Metal3 VDD.$388.Metal2 2.84962e-08f
Cred_14909 v_b.$3821.Metal3 VDD.$42.Metal1 1.33803e-06f
Cred_14910 v_b.$3821.Metal3 VDD.$666.Metal3 1.25456e-09f
Cred_14911 v_b.$3821.Metal3 VDD.P0.nSD 0.00615044f
Cred_14912 v_b.$3821.Metal3 VSS.$17.Metal1 5.80917e-06f
Cred_14913 v_b.$3821.Metal3 VSS.$301.Metal1 0.000161924f
Cred_14914 v_b.$3821.Metal3 VSS.$606.Metal2 1.71092e-05f
Cred_14915 v_b.$3821.Metal3 VSS.$760.Metal3 1.01233e-06f
Cred_14916 v_b.$3821.Metal3 VSS.P0.pSD 0.00583196f
Cred_14917 v_b.$3857.Metal3 VDD.$340.Metal1 3.22558e-05f
Cred_14918 v_b.$3857.Metal3 VDD.$388.Metal2 1.10127e-08f
Cred_14919 v_b.$3857.Metal3 VDD.$42.Metal1 5.17097e-07f
Cred_14920 v_b.$3857.Metal3 VDD.$666.Metal3 4.8484e-10f
Cred_14921 v_b.$3857.Metal3 VDD.P0.nSD 0.00306193f
Cred_14922 v_b.$3857.Metal3 VSS.$17.Metal1 2.25237e-06f
Cred_14923 v_b.$3857.Metal3 VSS.$301.Metal1 0.000104647f
Cred_14924 v_b.$3857.Metal3 VSS.$606.Metal2 1.10572e-05f
Cred_14925 v_b.$3857.Metal3 VSS.$760.Metal3 6.5424e-07f
Cred_14926 v_b.$3857.Metal3 VSS.P0.pSD 0.00289459f
Cred_14927 v_b.$3890.Metal3 VDD.$340.Metal1 3.38873e-05f
Cred_14928 v_b.$3890.Metal3 VDD.$388.Metal2 1.15246e-08f
Cred_14929 v_b.$3890.Metal3 VDD.$42.Metal1 5.4113e-07f
Cred_14930 v_b.$3890.Metal3 VDD.$666.Metal3 5.07374e-10f
Cred_14931 v_b.$3890.Metal3 VDD.P0.nSD 0.00321047f
Cred_14932 v_b.$3890.Metal3 VSS.$17.Metal1 2.35541e-06f
Cred_14933 v_b.$3890.Metal3 VSS.$301.Metal1 0.000109963f
Cred_14934 v_b.$3890.Metal3 VSS.$606.Metal2 1.16189e-05f
Cred_14935 v_b.$3890.Metal3 VSS.$760.Metal3 6.87473e-07f
Cred_14936 v_b.$3890.Metal3 VSS.P0.pSD 0.00303406f
Cred_14937 v_b.$3903.Metal3 VDD.$340.Metal1 8.37848e-05f
Cred_14938 v_b.$3903.Metal3 VDD.$388.Metal2 1.70783e-08f
Cred_14939 v_b.$3903.Metal3 VDD.$42.Metal1 8.019e-07f
Cred_14940 v_b.$3903.Metal3 VDD.$666.Metal3 7.51877e-10f
Cred_14941 v_b.$3903.Metal3 VDD.P0.nSD 0.00612651f
Cred_14942 v_b.$3903.Metal3 VSS.$17.Metal1 3.47814e-06f
Cred_14943 v_b.$3903.Metal3 VSS.$301.Metal1 0.000271027f
Cred_14944 v_b.$3903.Metal3 VSS.$606.Metal2 2.86371e-05f
Cred_14945 v_b.$3903.Metal3 VSS.$760.Metal3 1.69442e-06f
Cred_14946 v_b.$3903.Metal3 VSS.P0.pSD 0.00572323f
Cred_14947 v_b.$3934.Metal3 VDD.$340.Metal1 0.000108649f
Cred_14948 v_b.$3934.Metal3 VDD.$388.Metal2 1.32757e-08f
Cred_14949 v_b.$3934.Metal3 VDD.$42.Metal1 6.23352e-07f
Cred_14950 v_b.$3934.Metal3 VDD.$666.Metal3 5.84467e-10f
Cred_14951 v_b.$3934.Metal3 VDD.P0.nSD 0.00612562f
Cred_14952 v_b.$3934.Metal3 VSS.$17.Metal1 2.70148e-06f
Cred_14953 v_b.$3934.Metal3 VSS.$301.Metal1 0.000351523f
Cred_14954 v_b.$3934.Metal3 VSS.$606.Metal2 3.71425e-05f
Cred_14955 v_b.$3934.Metal3 VSS.$760.Metal3 2.19767e-06f
Cred_14956 v_b.$3934.Metal3 VSS.P0.pSD 0.00565928f
Cred_14957 v_b.$3970.Metal3 VDD.$340.Metal1 5.02676e-07f
Cred_14958 v_b.$3970.Metal3 VDD.$388.Metal2 3.71521e-11f
Cred_14959 v_b.$3970.Metal3 VDD.$42.Metal1 1.74446e-09f
Cred_14960 v_b.$3970.Metal3 VDD.$666.Metal3 1.63564e-12f
Cred_14961 v_b.$3970.Metal3 VDD.P0.nSD 2.18399e-05f
Cred_14962 v_b.$3970.Metal3 VSS.$17.Metal1 2.07534e-06f
Cred_14963 v_b.$3970.Metal3 VSS.$301.Metal1 0.000452095f
Cred_14964 v_b.$3970.Metal3 VSS.$606.Metal2 4.77691e-05f
Cred_14965 v_b.$3970.Metal3 VSS.$760.Metal3 2.82643e-06f
Cred_14966 v_b.$3970.Metal3 VSS.P0.pSD 0.0055155f
Cred_14967 v_b.$3980.Metal3 VDD.$340.Metal1 5.27312e-08f
Cred_14968 v_b.$3980.Metal3 VDD.$388.Metal2 3.8385e-12f
Cred_14969 v_b.$3980.Metal3 VDD.$42.Metal1 1.80235e-10f
Cred_14970 v_b.$3980.Metal3 VDD.$666.Metal3 1.68992e-13f
Cred_14971 v_b.$3980.Metal3 VDD.P0.nSD 2.28189e-06f
Cred_14972 v_b.$3986.Metal3 VDD.$340.Metal1 0.000108217f
Cred_14973 v_b.$3986.Metal3 VDD.$388.Metal2 7.94178e-09f
Cred_14974 v_b.$3986.Metal3 VDD.$42.Metal1 3.72902e-07f
Cred_14975 v_b.$3986.Metal3 VDD.$666.Metal3 3.4964e-10f
Cred_14976 v_b.$3986.Metal3 VDD.P0.nSD 0.00470248f
Cred_14977 v_b.$4009.Metal3 VDD.$340.Metal1 0.000181145f
Cred_14978 v_b.$4009.Metal3 VDD.$388.Metal2 7.9367e-09f
Cred_14979 v_b.$4009.Metal3 VDD.$42.Metal1 3.72664e-07f
Cred_14980 v_b.$4009.Metal3 VDD.$666.Metal3 3.49417e-10f
Cred_14981 v_b.$4009.Metal3 VDD.P0.nSD 0.0060366f
Cred_14982 v_b.$4009.Metal3 VSS.$17.Metal1 1.60559e-06f
Cred_14983 v_b.$4009.Metal3 VSS.$301.Metal1 0.000585797f
Cred_14984 v_b.$4009.Metal3 VSS.$606.Metal2 6.18962e-05f
Cred_14985 v_b.$4009.Metal3 VSS.$760.Metal3 3.66232e-06f
Cred_14986 v_b.$4009.Metal3 VSS.P0.pSD 0.00538053f
Cred_14987 v_b.$4042.Metal3 VDD.$340.Metal1 0.000198826f
Cred_14988 v_b.$4042.Metal3 VDD.$388.Metal2 2.93023e-09f
Cred_14989 v_b.$4042.Metal3 VDD.$42.Metal1 1.37587e-07f
Cred_14990 v_b.$4042.Metal3 VDD.$666.Metal3 1.29005e-10f
Cred_14991 v_b.$4042.Metal3 VDD.P0.nSD 0.0037443f
Cred_14992 v_b.$4042.Metal3 VSS.$17.Metal1 2.07767e-06f
Cred_14993 v_b.$4042.Metal3 VSS.$301.Metal1 0.00361881f
Cred_14994 v_b.$4042.Metal3 VSS.$606.Metal2 0.00143626f
Cred_14995 v_b.$4042.Metal3 VSS.$760.Metal3 0.00401236f
Cred_14996 v_b.$4042.Metal3 VSS.P0.pSD 0.0108153f
Cred_14997 v_b.$4053.Metal3 VDD.$340.Metal1 0.000261043f
Cred_14998 v_b.$4053.Metal3 VDD.$388.Metal2 2.17075e-09f
Cred_14999 v_b.$4053.Metal3 VDD.$42.Metal1 1.01926e-07f
Cred_15000 v_b.$4053.Metal3 VDD.$666.Metal3 9.55681e-11f
Cred_15001 v_b.$4053.Metal3 VDD.P0.nSD 0.00362894f
Cred_15002 v_b.$4053.Metal3 VSS.$17.Metal1 3.21264e-08f
Cred_15003 v_b.$4053.Metal3 VSS.$301.Metal1 6.22748e-05f
Cred_15004 v_b.$4053.Metal3 VSS.$606.Metal2 2.784e-05f
Cred_15005 v_b.$4053.Metal3 VSS.$760.Metal3 8.08739e-05f
Cred_15006 v_b.$4053.Metal3 VSS.P0.pSD 0.000166126f
Cred_15007 v_b.$4061.Metal3 VDD.$340.Metal1 0.000367954f
Cred_15008 v_b.$4061.Metal3 VDD.$388.Metal2 4.92144e-09f
Cred_15009 v_b.$4061.Metal3 VDD.$42.Metal1 2.31084e-07f
Cred_15010 v_b.$4061.Metal3 VDD.$666.Metal3 2.16668e-10f
Cred_15011 v_b.$4061.Metal3 VDD.P0.nSD 0.00532672f
Cred_15012 v_b.$4065.Metal3 VDD.$321.Metal1 0.000147846f
Cred_15013 v_b.$4065.Metal3 VDD.$332.Metal1 0.00140455f
Cred_15014 v_b.$4065.Metal3 VDD.$340.Metal1 0.000344146f
Cred_15015 v_b.$4065.Metal3 VDD.$388.Metal2 2.44567e-10f
Cred_15016 v_b.$4065.Metal3 VDD.$42.Metal1 1.14835e-08f
Cred_15017 v_b.$4065.Metal3 VDD.$640.Metal2 8.61806e-07f
Cred_15018 v_b.$4065.Metal3 VDD.$644.Metal2 0.00161851f
Cred_15019 v_b.$4065.Metal3 VDD.$666.Metal3 1.07672e-11f
Cred_15020 v_b.$4065.Metal3 VDD.$794.Metal3 0.00422003f
Cred_15021 v_b.$4065.Metal3 VDD.P0.nSD 0.00115793f
Cred_15022 v_b.P0.nSD VDD.$340.Metal1 2.75519e-08f
Cred_15023 v_b.P0.nSD VDD.$388.Metal2 2.06745e-05f
Cred_15024 v_b.P0.nSD VDD.$42.Metal1 0.00021426f
Cred_15025 v_b.P0.nSD VDD.$666.Metal3 1.08739e-05f
Cred_15026 v_b.P0.nSD VDD.P0.nSD 0.00105747f
Cred_15027 v_b.P0.nSD VSS.$17.Metal1 0.033725f
Cred_15028 v_b.P0.nSD VSS.$301.Metal1 4.03815e-06f
Cred_15029 v_b.P0.nSD VSS.$366.Metal2 0.00321705f
Cred_15030 v_b.P0.nSD VSS.$39.Metal1 0.00185371f
Cred_15031 v_b.P0.nSD VSS.$606.Metal2 4.26678e-07f
Cred_15032 v_b.P0.nSD VSS.$636.Metal3 0.00227636f
Cred_15033 v_b.P0.nSD VSS.$760.Metal3 2.52459e-08f
Cred_15034 v_b.P0.nSD VSS.P0.pSD 0.0391247f
Cred_15035 v_b.P0.pSD VDD.$340.Metal1 3.14651e-06f
Cred_15036 v_b.P0.pSD VDD.$388.Metal2 0.0100384f
Cred_15037 v_b.P0.pSD VDD.$42.Metal1 0.080613f
Cred_15038 v_b.P0.pSD VDD.$666.Metal3 0.00602031f
Cred_15039 v_b.P0.pSD VDD.P0.nSD 0.213008f
Cred_15040 v_b.P0.pSD VSS.$17.Metal1 0.000607901f
Cred_15041 v_b.P0.pSD VSS.$301.Metal1 1.54084e-07f
Cred_15042 v_b.P0.pSD VSS.$366.Metal2 8.53913e-05f
Cred_15043 v_b.P0.pSD VSS.$39.Metal1 1.8498e-05f
Cred_15044 v_b.P0.pSD VSS.$606.Metal2 1.62807e-08f
Cred_15045 v_b.P0.pSD VSS.$636.Metal3 5.63486e-05f
Cred_15046 v_b.P0.pSD VSS.$760.Metal3 9.63307e-10f
Cred_15047 v_b.P0.pSD VSS.P0.pSD 0.00113606f
Cred_15048 v_b.P1.nSD VSS.$17.Metal1 0.00075913f
Cred_15049 v_b.P1.nSD VSS.$301.Metal1 1.02121e-06f
Cred_15050 v_b.P1.nSD VSS.$606.Metal2 1.07903e-07f
Cred_15051 v_b.P1.nSD VSS.$760.Metal3 6.38447e-09f
Cred_15052 v_b.P1.nSD VSS.P0.pSD 0.00473668f
Cred_15053 v_b.P1.pSD VDD.$340.Metal1 4.97896e-07f
Cred_15054 v_b.P1.pSD VDD.$388.Metal2 5.78288e-06f
Cred_15055 v_b.P1.pSD VDD.$42.Metal1 0.000271532f
Cred_15056 v_b.P1.pSD VDD.$666.Metal3 2.54593e-07f
Cred_15057 v_b.P1.pSD VDD.P0.nSD 0.00852322f
Cred_15058 v_b.P10.nSD VSS.$17.Metal1 0.000270687f
Cred_15059 v_b.P10.nSD VSS.$301.Metal1 2.86474e-06f
Cred_15060 v_b.P10.nSD VSS.$606.Metal2 3.02693e-07f
Cred_15061 v_b.P10.nSD VSS.$760.Metal3 1.79099e-08f
Cred_15062 v_b.P10.nSD VSS.P0.pSD 0.00519888f
Cred_15063 v_b.P10.pSD VDD.$340.Metal1 1.37565e-06f
Cred_15064 v_b.P10.pSD VDD.$388.Metal2 2.05694e-06f
Cred_15065 v_b.P10.pSD VDD.$42.Metal1 9.65823e-05f
Cred_15066 v_b.P10.pSD VDD.$666.Metal3 9.05575e-08f
Cred_15067 v_b.P10.pSD VDD.P0.nSD 0.00864076f
Cred_15068 v_b.P11.nSD VDD.$340.Metal1 5.55267e-08f
Cred_15069 v_b.P11.nSD VDD.$388.Metal2 4.99127e-08f
Cred_15070 v_b.P11.nSD VDD.$42.Metal1 2.34362e-06f
Cred_15071 v_b.P11.nSD VDD.$666.Metal3 2.19743e-09f
Cred_15072 v_b.P11.nSD VDD.P0.nSD 0.000270533f
Cred_15073 v_b.P11.nSD VSS.$17.Metal1 0.000220969f
Cred_15074 v_b.P11.nSD VSS.$301.Metal1 3.90825e-06f
Cred_15075 v_b.P11.nSD VSS.$606.Metal2 4.12952e-07f
Cred_15076 v_b.P11.nSD VSS.$760.Metal3 2.44338e-08f
Cred_15077 v_b.P11.nSD VSS.P0.pSD 0.00554688f
Cred_15078 v_b.P11.pSD VDD.$340.Metal1 1.87894e-06f
Cred_15079 v_b.P11.pSD VDD.$388.Metal2 1.68237e-06f
Cred_15080 v_b.P11.pSD VDD.$42.Metal1 7.89949e-05f
Cred_15081 v_b.P11.pSD VDD.$666.Metal3 7.40671e-08f
Cred_15082 v_b.P11.pSD VDD.P0.nSD 0.00915432f
Cred_15083 v_b.P11.pSD VSS.$17.Metal1 2.09156e-05f
Cred_15084 v_b.P11.pSD VSS.$301.Metal1 3.68506e-07f
Cred_15085 v_b.P11.pSD VSS.$606.Metal2 3.89369e-08f
Cred_15086 v_b.P11.pSD VSS.$760.Metal3 2.30384e-09f
Cred_15087 v_b.P11.pSD VSS.P0.pSD 0.000522829f
Cred_15088 v_b.P13.nSD VSS.$17.Metal1 0.000162123f
Cred_15089 v_b.P13.nSD VSS.$301.Metal1 4.79195e-06f
Cred_15090 v_b.P13.nSD VSS.$606.Metal2 5.06325e-07f
Cred_15091 v_b.P13.nSD VSS.$760.Metal3 2.99586e-08f
Cred_15092 v_b.P13.nSD VSS.P0.pSD 0.0053053f
Cred_15093 v_b.P13.pSD VDD.$340.Metal1 2.29834e-06f
Cred_15094 v_b.P13.pSD VDD.$388.Metal2 1.23196e-06f
Cred_15095 v_b.P13.pSD VDD.$42.Metal1 5.78462e-05f
Cred_15096 v_b.P13.pSD VDD.$666.Metal3 5.42378e-08f
Cred_15097 v_b.P13.pSD VDD.P0.nSD 0.00867944f
Cred_15098 v_b.P15.nSD VDD.$340.Metal1 9.27847e-08f
Cred_15099 v_b.P15.nSD VDD.$388.Metal2 2.99151e-08f
Cred_15100 v_b.P15.nSD VDD.$42.Metal1 1.40465e-06f
Cred_15101 v_b.P15.nSD VDD.$666.Metal3 1.31702e-09f
Cred_15102 v_b.P15.nSD VDD.P0.nSD 0.000271455f
Cred_15103 v_b.P15.nSD VSS.$17.Metal1 0.000132438f
Cred_15104 v_b.P15.nSD VSS.$301.Metal1 6.53535e-06f
Cred_15105 v_b.P15.nSD VSS.$606.Metal2 6.90535e-07f
Cred_15106 v_b.P15.nSD VSS.$760.Metal3 4.0858e-08f
Cred_15107 v_b.P15.nSD VSS.P0.pSD 0.00563249f
Cred_15108 v_b.P15.pSD VDD.$340.Metal1 3.1397e-06f
Cred_15109 v_b.P15.pSD VDD.$388.Metal2 1.00833e-06f
Cred_15110 v_b.P15.pSD VDD.$42.Metal1 4.73457e-05f
Cred_15111 v_b.P15.pSD VDD.$666.Metal3 4.43922e-08f
Cred_15112 v_b.P15.pSD VDD.P0.nSD 0.00918541f
Cred_15113 v_b.P15.pSD VSS.$17.Metal1 1.25357e-05f
Cred_15114 v_b.P15.pSD VSS.$301.Metal1 6.16213e-07f
Cred_15115 v_b.P15.pSD VSS.$606.Metal2 6.511e-08f
Cred_15116 v_b.P15.pSD VSS.$760.Metal3 3.85247e-09f
Cred_15117 v_b.P15.pSD VSS.P0.pSD 0.000530933f
Cred_15118 v_b.P17.nSD VSS.$17.Metal1 9.72824e-05f
Cred_15119 v_b.P17.nSD VSS.$301.Metal1 8.01151e-06f
Cred_15120 v_b.P17.nSD VSS.$606.Metal2 8.46508e-07f
Cred_15121 v_b.P17.nSD VSS.$760.Metal3 5.00868e-08f
Cred_15122 v_b.P17.nSD VSS.P0.pSD 0.00536656f
Cred_15123 v_b.P17.pSD VDD.$340.Metal1 3.84088e-06f
Cred_15124 v_b.P17.pSD VDD.$388.Metal2 7.39244e-07f
Cred_15125 v_b.P17.pSD VDD.$42.Metal1 3.47108e-05f
Cred_15126 v_b.P17.pSD VDD.$666.Metal3 3.25455e-08f
Cred_15127 v_b.P17.pSD VDD.P0.nSD 0.00870155f
Cred_15128 v_b.P19.nSD VSS.$17.Metal1 7.54771e-05f
Cred_15129 v_b.P19.nSD VSS.$301.Metal1 1.03581e-05f
Cred_15130 v_b.P19.nSD VSS.$606.Metal2 1.09445e-06f
Cred_15131 v_b.P19.nSD VSS.$760.Metal3 6.47574e-08f
Cred_15132 v_b.P19.nSD VSS.P0.pSD 0.00538576f
Cred_15133 v_b.P19.pSD VDD.$340.Metal1 4.96541e-06f
Cred_15134 v_b.P19.pSD VDD.$388.Metal2 5.73547e-07f
Cred_15135 v_b.P19.pSD VDD.$42.Metal1 2.69306e-05f
Cred_15136 v_b.P19.pSD VDD.$666.Metal3 2.52506e-08f
Cred_15137 v_b.P19.pSD VDD.P0.nSD 0.00870838f
Cred_15138 v_b.P21.nSD VDD.$340.Metal1 2.00469e-07f
Cred_15139 v_b.P21.nSD VDD.$388.Metal2 1.39819e-08f
Cred_15140 v_b.P21.nSD VDD.$42.Metal1 6.5651e-07f
Cred_15141 v_b.P21.nSD VDD.$666.Metal3 6.15557e-10f
Cred_15142 v_b.P21.nSD VDD.P0.nSD 0.000272112f
Cred_15143 v_b.P21.nSD VSS.$17.Metal1 6.19018e-05f
Cred_15144 v_b.P21.nSD VSS.$301.Metal1 1.41246e-05f
Cred_15145 v_b.P21.nSD VSS.$606.Metal2 1.49242e-06f
Cred_15146 v_b.P21.nSD VSS.$760.Metal3 8.83047e-08f
Cred_15147 v_b.P21.nSD VSS.P0.pSD 0.00569458f
Cred_15148 v_b.P21.pSD VDD.$340.Metal1 6.78356e-06f
Cred_15149 v_b.P21.pSD VDD.$388.Metal2 4.71298e-07f
Cred_15150 v_b.P21.pSD VDD.$42.Metal1 2.21295e-05f
Cred_15151 v_b.P21.pSD VDD.$666.Metal3 2.07491e-08f
Cred_15152 v_b.P21.pSD VDD.P0.nSD 0.00920754f
Cred_15153 v_b.P21.pSD VSS.$17.Metal1 5.85899e-06f
Cred_15154 v_b.P21.pSD VSS.$301.Metal1 1.3318e-06f
Cred_15155 v_b.P21.pSD VSS.$606.Metal2 1.4072e-07f
Cred_15156 v_b.P21.pSD VSS.$760.Metal3 8.3262e-09f
Cred_15157 v_b.P21.pSD VSS.P0.pSD 0.000536814f
Cred_15158 v_b.P23.nSD VSS.$17.Metal1 4.57699e-05f
Cred_15159 v_b.P23.nSD VSS.$301.Metal1 1.73135e-05f
Cred_15160 v_b.P23.nSD VSS.$606.Metal2 1.82937e-06f
Cred_15161 v_b.P23.nSD VSS.$760.Metal3 1.08241e-07f
Cred_15162 v_b.P23.nSD VSS.P0.pSD 0.00540773f
Cred_15163 v_b.P23.pSD VDD.$340.Metal1 8.29886e-06f
Cred_15164 v_b.P23.pSD VDD.$388.Metal2 3.47805e-07f
Cred_15165 v_b.P23.pSD VDD.$42.Metal1 1.6331e-05f
Cred_15166 v_b.P23.pSD VDD.$666.Metal3 1.53122e-08f
Cred_15167 v_b.P23.pSD VDD.P0.nSD 0.00871588f
Cred_15168 v_b.P25.nSD VDD.$340.Metal1 3.27593e-07f
Cred_15169 v_b.P25.nSD VDD.$388.Metal2 8.39937e-09f
Cred_15170 v_b.P25.nSD VDD.$42.Metal1 3.94388e-07f
Cred_15171 v_b.P25.nSD VDD.$666.Metal3 3.69786e-10f
Cred_15172 v_b.P25.nSD VDD.P0.nSD 0.000266811f
Cred_15173 v_b.P25.nSD VSS.$17.Metal1 3.89836e-05f
Cred_15174 v_b.P25.nSD VSS.$301.Metal1 2.4304e-05f
Cred_15175 v_b.P25.nSD VSS.$606.Metal2 2.56799e-06f
Cred_15176 v_b.P25.nSD VSS.$760.Metal3 1.51945e-07f
Cred_15177 v_b.P25.nSD VSS.P0.pSD 0.0058761f
Cred_15178 v_b.P25.pSD VDD.$340.Metal1 1.1455e-05f
Cred_15179 v_b.P25.pSD VDD.$388.Metal2 2.92517e-07f
Cred_15180 v_b.P25.pSD VDD.$42.Metal1 1.3735e-05f
Cred_15181 v_b.P25.pSD VDD.$666.Metal3 1.28782e-08f
Cred_15182 v_b.P25.pSD VDD.P0.nSD 0.00932789f
Cred_15183 v_b.P25.pSD VSS.$17.Metal1 3.57122e-06f
Cred_15184 v_b.P25.pSD VSS.$301.Metal1 2.2201e-06f
Cred_15185 v_b.P25.pSD VSS.$606.Metal2 2.34579e-07f
Cred_15186 v_b.P25.pSD VSS.$760.Metal3 1.38797e-08f
Cred_15187 v_b.P25.pSD VSS.P0.pSD 0.000536422f
Cred_15188 v_b.P27.nSD VSS.$17.Metal1 2.80803e-05f
Cred_15189 v_b.P27.nSD VSS.$301.Metal1 2.84606e-05f
Cred_15190 v_b.P27.nSD VSS.$606.Metal2 3.00719e-06f
Cred_15191 v_b.P27.nSD VSS.$760.Metal3 1.77931e-07f
Cred_15192 v_b.P27.nSD VSS.P0.pSD 0.00541303f
Cred_15193 v_b.P27.pSD VDD.$340.Metal1 1.36433e-05f
Cred_15194 v_b.P27.pSD VDD.$388.Metal2 2.13357e-07f
Cred_15195 v_b.P27.pSD VDD.$42.Metal1 1.00181e-05f
Cred_15196 v_b.P27.pSD VDD.$666.Metal3 9.39315e-09f
Cred_15197 v_b.P27.pSD VDD.P0.nSD 0.00871699f
Cred_15198 v_b.P29.nSD VDD.$340.Metal1 5.46254e-07f
Cred_15199 v_b.P29.nSD VDD.$388.Metal2 5.15715e-09f
Cred_15200 v_b.P29.nSD VDD.$42.Metal1 2.42151e-07f
Cred_15201 v_b.P29.nSD VDD.$666.Metal3 2.27046e-10f
Cred_15202 v_b.P29.nSD VDD.P0.nSD 0.00027219f
Cred_15203 v_b.P29.nSD VSS.$17.Metal1 2.29086e-05f
Cred_15204 v_b.P29.nSD VSS.$301.Metal1 3.83631e-05f
Cred_15205 v_b.P29.nSD VSS.$606.Metal2 4.0535e-06f
Cred_15206 v_b.P29.nSD VSS.$760.Metal3 2.3984e-07f
Cred_15207 v_b.P29.nSD VSS.P0.pSD 0.00570663f
Cred_15208 v_b.P29.pSD VDD.$340.Metal1 1.8425e-05f
Cred_15209 v_b.P29.pSD VDD.$388.Metal2 1.74405e-07f
Cred_15210 v_b.P29.pSD VDD.$42.Metal1 8.18911e-06f
Cred_15211 v_b.P29.pSD VDD.$666.Metal3 7.67827e-09f
Cred_15212 v_b.P29.pSD VDD.P0.nSD 0.00921015f
Cred_15213 v_b.P29.pSD VSS.$17.Metal1 2.16004e-06f
Cred_15214 v_b.P29.pSD VSS.$301.Metal1 3.63099e-06f
Cred_15215 v_b.P29.pSD VSS.$606.Metal2 3.83656e-07f
Cred_15216 v_b.P29.pSD VSS.$760.Metal3 2.27004e-08f
Cred_15217 v_b.P29.pSD VSS.P0.pSD 0.000537957f
Cred_15218 v_b.P3.nSD VDD.$340.Metal1 1.99728e-08f
Cred_15219 v_b.P3.nSD VDD.$388.Metal2 1.39638e-07f
Cred_15220 v_b.P3.nSD VDD.$42.Metal1 6.55662e-06f
Cred_15221 v_b.P3.nSD VDD.$666.Metal3 6.14761e-09f
Cred_15222 v_b.P3.nSD VDD.P0.nSD 0.000266898f
Cred_15223 v_b.P3.nSD VSS.$17.Metal1 0.000618006f
Cred_15224 v_b.P3.nSD VSS.$301.Metal1 1.39469e-06f
Cred_15225 v_b.P3.nSD VSS.$606.Metal2 1.47366e-07f
Cred_15226 v_b.P3.nSD VSS.$760.Metal3 8.71942e-09f
Cred_15227 v_b.P3.nSD VSS.P0.pSD 0.00516432f
Cred_15228 v_b.P3.pSD VDD.$340.Metal1 6.75718e-07f
Cred_15229 v_b.P3.pSD VDD.$388.Metal2 4.70585e-06f
Cred_15230 v_b.P3.pSD VDD.$42.Metal1 0.000220961f
Cred_15231 v_b.P3.pSD VDD.$666.Metal3 2.07177e-07f
Cred_15232 v_b.P3.pSD VDD.P0.nSD 0.00903025f
Cred_15233 v_b.P3.pSD VSS.$17.Metal1 5.85065e-05f
Cred_15234 v_b.P3.pSD VSS.$301.Metal1 1.31524e-07f
Cred_15235 v_b.P3.pSD VSS.$606.Metal2 1.38971e-08f
Cred_15236 v_b.P3.pSD VSS.$760.Metal3 8.22271e-10f
Cred_15237 v_b.P3.pSD VSS.P0.pSD 0.000486696f
Cred_15238 v_b.P31.nSD VSS.$17.Metal1 1.68002e-05f
Cred_15239 v_b.P31.nSD VSS.$301.Metal1 4.66813e-05f
Cred_15240 v_b.P31.nSD VSS.$606.Metal2 4.93241e-06f
Cred_15241 v_b.P31.nSD VSS.$760.Metal3 2.91844e-07f
Cred_15242 v_b.P31.nSD VSS.P0.pSD 0.00540405f
Cred_15243 v_b.P31.pSD VDD.$340.Metal1 2.23776e-05f
Cred_15244 v_b.P31.pSD VDD.$388.Metal2 1.27655e-07f
Cred_15245 v_b.P31.pSD VDD.$42.Metal1 5.99399e-06f
Cred_15246 v_b.P31.pSD VDD.$666.Metal3 5.62008e-09f
Cred_15247 v_b.P31.pSD VDD.P0.nSD 0.00871237f
Cred_15248 v_b.P33.nSD VDD.$340.Metal1 9.02713e-07f
Cred_15249 v_b.P33.nSD VDD.$388.Metal2 3.08565e-09f
Cred_15250 v_b.P33.nSD VDD.$42.Metal1 1.44885e-07f
Cred_15251 v_b.P33.nSD VDD.$666.Metal3 1.35847e-10f
Cred_15252 v_b.P33.nSD VDD.P0.nSD 0.000271933f
Cred_15253 v_b.P33.nSD VSS.$17.Metal1 1.37059e-05f
Cred_15254 v_b.P33.nSD VSS.$301.Metal1 6.33956e-05f
Cred_15255 v_b.P33.nSD VSS.$606.Metal2 6.69847e-06f
Cred_15256 v_b.P33.nSD VSS.$760.Metal3 3.9634e-07f
Cred_15257 v_b.P33.nSD VSS.P0.pSD 0.005688f
Cred_15258 v_b.P33.pSD VDD.$340.Metal1 3.04475e-05f
Cred_15259 v_b.P33.pSD VDD.$388.Metal2 1.04351e-07f
Cred_15260 v_b.P33.pSD VDD.$42.Metal1 4.89974e-06f
Cred_15261 v_b.P33.pSD VDD.$666.Metal3 4.59409e-09f
Cred_15262 v_b.P33.pSD VDD.P0.nSD 0.00920149f
Cred_15263 v_b.P33.pSD VSS.$17.Metal1 1.29232e-06f
Cred_15264 v_b.P33.pSD VSS.$301.Metal1 6.00053e-06f
Cred_15265 v_b.P33.pSD VSS.$606.Metal2 6.34025e-07f
Cred_15266 v_b.P33.pSD VSS.$760.Metal3 3.75144e-08f
Cred_15267 v_b.P33.pSD VSS.P0.pSD 0.00053619f
Cred_15268 v_b.P35.nSD VSS.$17.Metal1 1.01701e-05f
Cred_15269 v_b.P35.nSD VSS.$213.Metal1 0.00243034f
Cred_15270 v_b.P35.nSD VSS.$221.Metal1 0.00344133f
Cred_15271 v_b.P35.nSD VSS.$301.Metal1 7.84093e-05f
Cred_15272 v_b.P35.nSD VSS.$526.Metal2 0.00401058f
Cred_15273 v_b.P35.nSD VSS.$534.Metal2 0.000591731f
Cred_15274 v_b.P35.nSD VSS.$606.Metal2 8.28485e-06f
Cred_15275 v_b.P35.nSD VSS.$716.Metal3 0.00140508f
Cred_15276 v_b.P35.nSD VSS.$724.Metal3 0.000464953f
Cred_15277 v_b.P35.nSD VSS.$760.Metal3 4.90204e-07f
Cred_15278 v_b.P35.nSD VSS.P0.pSD 0.00544773f
Cred_15279 v_b.P35.pSD VDD.$230.Metal1 0.0041256f
Cred_15280 v_b.P35.pSD VDD.$238.Metal1 0.00584031f
Cred_15281 v_b.P35.pSD VDD.$340.Metal1 4.01746e-05f
Cred_15282 v_b.P35.pSD VDD.$388.Metal2 8.29462e-08f
Cred_15283 v_b.P35.pSD VDD.$42.Metal1 3.89469e-06f
Cred_15284 v_b.P35.pSD VDD.$560.Metal2 0.00868844f
Cred_15285 v_b.P35.pSD VDD.$568.Metal2 0.000828404f
Cred_15286 v_b.P35.pSD VDD.$666.Metal3 3.65174e-09f
Cred_15287 v_b.P35.pSD VDD.$750.Metal3 0.00451473f
Cred_15288 v_b.P35.pSD VDD.$758.Metal3 0.00202303f
Cred_15289 v_b.P35.pSD VDD.P0.nSD 0.00944224f
Cred_15290 v_b.P37.nSD VDD.$238.Metal1 1.1792e-06f
Cred_15291 v_b.P37.nSD VDD.$340.Metal1 3.27882e-08f
Cred_15292 v_b.P37.nSD VDD.$388.Metal2 5.20206e-11f
Cred_15293 v_b.P37.nSD VDD.$42.Metal1 2.4426e-09f
Cred_15294 v_b.P37.nSD VDD.$560.Metal2 6.32442e-07f
Cred_15295 v_b.P37.nSD VDD.$568.Metal2 6.32442e-07f
Cred_15296 v_b.P37.nSD VDD.$666.Metal3 2.29023e-12f
Cred_15297 v_b.P37.nSD VDD.$750.Metal3 1.77927e-06f
Cred_15298 v_b.P37.nSD VDD.$758.Metal3 1.77927e-06f
Cred_15299 v_b.P37.nSD VDD.P0.nSD 6.73984e-06f
Cred_15300 v_b.P37.nSD VSS.$17.Metal1 1.105e-05f
Cred_15301 v_b.P37.nSD VSS.$221.Metal1 0.00112909f
Cred_15302 v_b.P37.nSD VSS.$301.Metal1 0.000110524f
Cred_15303 v_b.P37.nSD VSS.$526.Metal2 0.000573881f
Cred_15304 v_b.P37.nSD VSS.$534.Metal2 0.000573881f
Cred_15305 v_b.P37.nSD VSS.$606.Metal2 1.16781e-05f
Cred_15306 v_b.P37.nSD VSS.$716.Metal3 0.000286515f
Cred_15307 v_b.P37.nSD VSS.$724.Metal3 0.000286515f
Cred_15308 v_b.P37.nSD VSS.$760.Metal3 6.9098e-07f
Cred_15309 v_b.P37.nSD VSS.P0.pSD 0.00671593f
Cred_15310 v_b.P37.pSD VDD.$238.Metal1 0.00206939f
Cred_15311 v_b.P37.pSD VDD.$340.Metal1 5.28309e-05f
Cred_15312 v_b.P37.pSD VDD.$388.Metal2 8.37815e-08f
Cred_15313 v_b.P37.pSD VDD.$42.Metal1 3.93391e-06f
Cred_15314 v_b.P37.pSD VDD.$560.Metal2 0.00107168f
Cred_15315 v_b.P37.pSD VDD.$568.Metal2 0.00107168f
Cred_15316 v_b.P37.pSD VDD.$666.Metal3 3.68851e-09f
Cred_15317 v_b.P37.pSD VDD.$750.Metal3 0.00110681f
Cred_15318 v_b.P37.pSD VDD.$758.Metal3 0.00110681f
Cred_15319 v_b.P37.pSD VDD.P0.nSD 0.0108573f
Cred_15320 v_b.P37.pSD VSS.$17.Metal1 2.60435e-08f
Cred_15321 v_b.P37.pSD VSS.$221.Metal1 3.02452e-06f
Cred_15322 v_b.P37.pSD VSS.$301.Metal1 2.60297e-07f
Cred_15323 v_b.P37.pSD VSS.$526.Metal2 2.24541e-06f
Cred_15324 v_b.P37.pSD VSS.$534.Metal2 2.24541e-06f
Cred_15325 v_b.P37.pSD VSS.$606.Metal2 2.75034e-08f
Cred_15326 v_b.P37.pSD VSS.$716.Metal3 6.87935e-06f
Cred_15327 v_b.P37.pSD VSS.$724.Metal3 6.87935e-06f
Cred_15328 v_b.P37.pSD VSS.$760.Metal3 1.62734e-09f
Cred_15329 v_b.P37.pSD VSS.P0.pSD 1.58228e-05f
Cred_15330 v_b.P39.nSD VSS.$17.Metal1 7.30296e-06f
Cred_15331 v_b.P39.nSD VSS.$301.Metal1 9.3968e-05f
Cred_15332 v_b.P39.nSD VSS.$606.Metal2 9.9288e-06f
Cred_15333 v_b.P39.nSD VSS.$760.Metal3 5.87474e-07f
Cred_15334 v_b.P39.nSD VSS.P0.pSD 0.00502936f
Cred_15335 v_b.P39.pSD VDD.$340.Metal1 4.50036e-05f
Cred_15336 v_b.P39.pSD VDD.$388.Metal2 5.54597e-08f
Cred_15337 v_b.P39.pSD VDD.$42.Metal1 2.60408e-06f
Cred_15338 v_b.P39.pSD VDD.$666.Metal3 2.44163e-09f
Cred_15339 v_b.P39.pSD VDD.P0.nSD 0.00815806f
Cred_15340 v_b.P41.nSD VSS.$17.Metal1 8.28229e-06f
Cred_15341 v_b.P41.nSD VSS.$301.Metal1 0.000138311f
Cred_15342 v_b.P41.nSD VSS.$606.Metal2 1.46141e-05f
Cred_15343 v_b.P41.nSD VSS.$760.Metal3 8.64699e-07f
Cred_15344 v_b.P41.nSD VSS.P0.pSD 0.00647616f
Cred_15345 v_b.P41.pSD VDD.$340.Metal1 6.50305e-05f
Cred_15346 v_b.P41.pSD VDD.$388.Metal2 6.17781e-08f
Cred_15347 v_b.P41.pSD VDD.$42.Metal1 2.90076e-06f
Cred_15348 v_b.P41.pSD VDD.$666.Metal3 2.71981e-09f
Cred_15349 v_b.P41.pSD VDD.P0.nSD 0.0103358f
Cred_15350 v_b.P43.nSD VSS.$17.Metal1 5.64823e-06f
Cred_15351 v_b.P43.nSD VSS.$301.Metal1 0.000121372f
Cred_15352 v_b.P43.nSD VSS.$606.Metal2 1.28244e-05f
Cred_15353 v_b.P43.nSD VSS.$760.Metal3 7.588e-07f
Cred_15354 v_b.P43.nSD VSS.P0.pSD 0.00500055f
Cred_15355 v_b.P43.pSD VDD.$340.Metal1 5.8128e-05f
Cred_15356 v_b.P43.pSD VDD.$388.Metal2 4.29019e-08f
Cred_15357 v_b.P43.pSD VDD.$42.Metal1 2.01443e-06f
Cred_15358 v_b.P43.pSD VDD.$666.Metal3 1.88877e-09f
Cred_15359 v_b.P43.pSD VDD.P0.nSD 0.00814554f
Cred_15360 v_b.P45.nSD VSS.$17.Metal1 6.40545e-06f
Cred_15361 v_b.P45.nSD VSS.$301.Metal1 0.000178684f
Cred_15362 v_b.P45.nSD VSS.$606.Metal2 1.88801e-05f
Cred_15363 v_b.P45.nSD VSS.$760.Metal3 1.11711e-06f
Cred_15364 v_b.P45.nSD VSS.P0.pSD 0.00643315f
Cred_15365 v_b.P45.pSD VDD.$340.Metal1 8.40131e-05f
Cred_15366 v_b.P45.pSD VDD.$388.Metal2 4.77909e-08f
Cred_15367 v_b.P45.pSD VDD.$42.Metal1 2.24399e-06f
Cred_15368 v_b.P45.pSD VDD.$666.Metal3 2.10401e-09f
Cred_15369 v_b.P45.pSD VDD.P0.nSD 0.0103174f
Cred_15370 v_b.P47.nSD VSS.$17.Metal1 4.36811e-06f
Cred_15371 v_b.P47.nSD VSS.$301.Metal1 0.000156826f
Cred_15372 v_b.P47.nSD VSS.$606.Metal2 1.65705e-05f
Cred_15373 v_b.P47.nSD VSS.$760.Metal3 9.80452e-07f
Cred_15374 v_b.P47.nSD VSS.P0.pSD 0.00496241f
Cred_15375 v_b.P47.pSD VDD.$340.Metal1 7.51076e-05f
Cred_15376 v_b.P47.pSD VDD.$388.Metal2 3.31895e-08f
Cred_15377 v_b.P47.pSD VDD.$42.Metal1 1.55839e-06f
Cred_15378 v_b.P47.pSD VDD.$666.Metal3 1.46118e-09f
Cred_15379 v_b.P47.pSD VDD.P0.nSD 0.00812903f
Cred_15380 v_b.P49.nSD VDD.$340.Metal1 5.82541e-08f
Cred_15381 v_b.P49.nSD VDD.$388.Metal2 1.98482e-11f
Cred_15382 v_b.P49.nSD VDD.$42.Metal1 9.3196e-10f
Cred_15383 v_b.P49.nSD VDD.$666.Metal3 8.73824e-13f
Cred_15384 v_b.P49.nSD VDD.P0.nSD 5.52446e-06f
Cred_15385 v_b.P49.nSD VSS.$17.Metal1 4.95747e-06f
Cred_15386 v_b.P49.nSD VSS.$301.Metal1 0.000231097f
Cred_15387 v_b.P49.nSD VSS.$606.Metal2 2.44181e-05f
Cred_15388 v_b.P49.nSD VSS.$760.Metal3 1.44479e-06f
Cred_15389 v_b.P49.nSD VSS.P0.pSD 0.00638173f
Cred_15390 v_b.P49.pSD VDD.$340.Metal1 0.000108711f
Cred_15391 v_b.P49.pSD VDD.$388.Metal2 3.7022e-08f
Cred_15392 v_b.P49.pSD VDD.$42.Metal1 1.73835e-06f
Cred_15393 v_b.P49.pSD VDD.$666.Metal3 1.62991e-09f
Cred_15394 v_b.P49.pSD VDD.P0.nSD 0.010307f
Cred_15395 v_b.P49.pSD VSS.$17.Metal1 9.92847e-09f
Cred_15396 v_b.P49.pSD VSS.$301.Metal1 4.62466e-07f
Cred_15397 v_b.P49.pSD VSS.$606.Metal2 4.88649e-08f
Cred_15398 v_b.P49.pSD VSS.$760.Metal3 2.89127e-09f
Cred_15399 v_b.P49.pSD VSS.P0.pSD 1.27761e-05f
Cred_15400 v_b.P5.nSD VSS.$17.Metal1 0.000482602f
Cred_15401 v_b.P5.nSD VSS.$301.Metal1 1.72145e-06f
Cred_15402 v_b.P5.nSD VSS.$606.Metal2 1.81891e-07f
Cred_15403 v_b.P5.nSD VSS.$760.Metal3 1.07622e-08f
Cred_15404 v_b.P5.nSD VSS.P0.pSD 0.00510577f
Cred_15405 v_b.P5.pSD VDD.$340.Metal1 8.32183e-07f
Cred_15406 v_b.P5.pSD VDD.$388.Metal2 3.76864e-06f
Cred_15407 v_b.P5.pSD VDD.$42.Metal1 0.000176955f
Cred_15408 v_b.P5.pSD VDD.$666.Metal3 1.65916e-07f
Cred_15409 v_b.P5.pSD VDD.P0.nSD 0.00882947f
Cred_15410 v_b.P51.nSD VSS.$17.Metal1 3.3777e-06f
Cred_15411 v_b.P51.nSD VSS.$301.Metal1 0.000202681f
Cred_15412 v_b.P51.nSD VSS.$606.Metal2 2.14156e-05f
Cred_15413 v_b.P51.nSD VSS.$760.Metal3 1.26713e-06f
Cred_15414 v_b.P51.nSD VSS.P0.pSD 0.00491241f
Cred_15415 v_b.P51.pSD VDD.$340.Metal1 9.70687e-05f
Cred_15416 v_b.P51.pSD VDD.$388.Metal2 2.56783e-08f
Cred_15417 v_b.P51.pSD VDD.$42.Metal1 1.20571e-06f
Cred_15418 v_b.P51.pSD VDD.$666.Metal3 1.1305e-09f
Cred_15419 v_b.P51.pSD VDD.P0.nSD 0.00810743f
Cred_15420 v_b.P53.nSD VSS.$17.Metal1 3.82995e-06f
Cred_15421 v_b.P53.nSD VSS.$301.Metal1 0.000298448f
Cred_15422 v_b.P53.nSD VSS.$606.Metal2 3.15345e-05f
Cred_15423 v_b.P53.nSD VSS.$760.Metal3 1.86585e-06f
Cred_15424 v_b.P53.nSD VSS.P0.pSD 0.00630256f
Cred_15425 v_b.P53.pSD VDD.$340.Metal1 0.000140323f
Cred_15426 v_b.P53.pSD VDD.$388.Metal2 2.86078e-08f
Cred_15427 v_b.P53.pSD VDD.$42.Metal1 1.34326e-06f
Cred_15428 v_b.P53.pSD VDD.$666.Metal3 1.25947e-09f
Cred_15429 v_b.P53.pSD VDD.P0.nSD 0.0102621f
Cred_15430 v_b.P55.nSD VSS.$17.Metal1 2.6113e-06f
Cred_15431 v_b.P55.nSD VSS.$301.Metal1 0.000261978f
Cred_15432 v_b.P55.nSD VSS.$606.Metal2 2.7681e-05f
Cred_15433 v_b.P55.nSD VSS.$760.Metal3 1.63785e-06f
Cred_15434 v_b.P55.nSD VSS.P0.pSD 0.00484724f
Cred_15435 v_b.P55.pSD VDD.$340.Metal1 0.000125468f
Cred_15436 v_b.P55.pSD VDD.$388.Metal2 1.98701e-08f
Cred_15437 v_b.P55.pSD VDD.$42.Metal1 9.32992e-07f
Cred_15438 v_b.P55.pSD VDD.$666.Metal3 8.74791e-10f
Cred_15439 v_b.P55.pSD VDD.P0.nSD 0.00807931f
Cred_15440 v_b.P57.nSD VSS.$17.Metal1 2.96048e-06f
Cred_15441 v_b.P57.nSD VSS.$301.Metal1 0.000385781f
Cred_15442 v_b.P57.nSD VSS.$606.Metal2 4.07622e-05f
Cred_15443 v_b.P57.nSD VSS.$760.Metal3 2.41185e-06f
Cred_15444 v_b.P57.nSD VSS.P0.pSD 0.00620632f
Cred_15445 v_b.P57.pSD VDD.$340.Metal1 0.000181385f
Cred_15446 v_b.P57.pSD VDD.$388.Metal2 2.21396e-08f
Cred_15447 v_b.P57.pSD VDD.$42.Metal1 1.03956e-06f
Cred_15448 v_b.P57.pSD VDD.$666.Metal3 9.74707e-10f
Cred_15449 v_b.P57.pSD VDD.P0.nSD 0.0102213f
Cred_15450 v_b.P59.nSD VSS.$17.Metal1 2.01809e-06f
Cred_15451 v_b.P59.nSD VSS.$301.Metal1 0.000338651f
Cred_15452 v_b.P59.nSD VSS.$606.Metal2 3.57824e-05f
Cred_15453 v_b.P59.nSD VSS.$760.Metal3 2.11719e-06f
Cred_15454 v_b.P59.nSD VSS.P0.pSD 0.00476258f
Cred_15455 v_b.P59.pSD VDD.$340.Metal1 0.000162188f
Cred_15456 v_b.P59.pSD VDD.$388.Metal2 1.53799e-08f
Cred_15457 v_b.P59.pSD VDD.$42.Metal1 7.22153e-07f
Cred_15458 v_b.P59.pSD VDD.$666.Metal3 6.77105e-10f
Cred_15459 v_b.P59.pSD VDD.P0.nSD 0.0080428f
Cred_15460 v_b.P61.nSD VSS.$17.Metal1 2.28735e-06f
Cred_15461 v_b.P61.nSD VSS.$301.Metal1 0.0004987f
Cred_15462 v_b.P61.nSD VSS.$606.Metal2 5.26934e-05f
Cred_15463 v_b.P61.nSD VSS.$760.Metal3 3.1178e-06f
Cred_15464 v_b.P61.nSD VSS.P0.pSD 0.00608144f
Cred_15465 v_b.P61.pSD VDD.$340.Metal1 9.70199e-05f
Cred_15466 v_b.P61.pSD VDD.$388.Metal2 7.11698e-09f
Cred_15467 v_b.P61.pSD VDD.$42.Metal1 3.34174e-07f
Cred_15468 v_b.P61.pSD VDD.$666.Metal3 3.13328e-10f
Cred_15469 v_b.P61.pSD VDD.P0.nSD 0.004215f
Cred_15470 v_b.P63.nSD VSS.$17.Metal1 1.55873e-06f
Cred_15471 v_b.P63.nSD VSS.$301.Metal1 0.000437784f
Cred_15472 v_b.P63.nSD VSS.$606.Metal2 4.62569e-05f
Cred_15473 v_b.P63.nSD VSS.$760.Metal3 2.73696e-06f
Cred_15474 v_b.P63.nSD VSS.P0.pSD 0.00465282f
Cred_15475 v_b.P63.pSD VDD.$340.Metal1 0.000210051f
Cred_15476 v_b.P63.pSD VDD.$388.Metal2 1.19315e-08f
Cred_15477 v_b.P63.pSD VDD.$42.Metal1 5.60239e-07f
Cred_15478 v_b.P63.pSD VDD.$666.Metal3 5.25291e-10f
Cred_15479 v_b.P63.pSD VDD.P0.nSD 0.00801019f
Cred_15480 v_b.P65.nSD VSS.$17.Metal1 1.76593e-06f
Cred_15481 v_b.P65.nSD VSS.$301.Metal1 0.000644695f
Cred_15482 v_b.P65.nSD VSS.$606.Metal2 6.81194e-05f
Cred_15483 v_b.P65.nSD VSS.$760.Metal3 4.03054e-06f
Cred_15484 v_b.P65.nSD VSS.P0.pSD 0.00591962f
Cred_15485 v_b.P65.pSD VDD.$340.Metal1 0.00030312f
Cred_15486 v_b.P65.pSD VDD.$388.Metal2 1.32769e-08f
Cred_15487 v_b.P65.pSD VDD.$42.Metal1 6.23412e-07f
Cred_15488 v_b.P65.pSD VDD.$666.Metal3 5.84523e-10f
Cred_15489 v_b.P65.pSD VDD.P0.nSD 0.0101f
Cred_15490 v_b.P67.nSD VSS.$17.Metal1 1.20275e-06f
Cred_15491 v_b.P67.nSD VSS.$301.Metal1 0.000565952f
Cred_15492 v_b.P67.nSD VSS.$606.Metal2 5.97993e-05f
Cred_15493 v_b.P67.nSD VSS.$760.Metal3 3.53825e-06f
Cred_15494 v_b.P67.nSD VSS.P0.pSD 0.00451066f
Cred_15495 v_b.P67.pSD VDD.$340.Metal1 0.000272791f
Cred_15496 v_b.P67.pSD VDD.$388.Metal2 9.28864e-09f
Cred_15497 v_b.P67.pSD VDD.$42.Metal1 4.36143e-07f
Cred_15498 v_b.P67.pSD VDD.$666.Metal3 4.08936e-10f
Cred_15499 v_b.P67.pSD VDD.P0.nSD 0.00798527f
Cred_15500 v_b.P69.nSD VSS.$17.Metal1 1.44306e-06f
Cred_15501 v_b.P69.nSD VSS.$301.Metal1 0.0020034f
Cred_15502 v_b.P69.nSD VSS.$606.Metal2 0.00119257f
Cred_15503 v_b.P69.nSD VSS.$760.Metal3 0.00052781f
Cred_15504 v_b.P69.nSD VSS.P0.pSD 0.0062443f
Cred_15505 v_b.P69.pSD VDD.$321.Metal1 0.000139294f
Cred_15506 v_b.P69.pSD VDD.$332.Metal1 0.00132194f
Cred_15507 v_b.P69.pSD VDD.$340.Metal1 0.000178629f
Cred_15508 v_b.P69.pSD VDD.$388.Metal2 4.27453e-09f
Cred_15509 v_b.P69.pSD VDD.$42.Metal1 2.00708e-07f
Cred_15510 v_b.P69.pSD VDD.$640.Metal2 8.11952e-07f
Cred_15511 v_b.P69.pSD VDD.$644.Metal2 0.00142934f
Cred_15512 v_b.P69.pSD VDD.$666.Metal3 1.88188e-10f
Cred_15513 v_b.P69.pSD VDD.$794.Metal3 0.000179826f
Cred_15514 v_b.P69.pSD VDD.P0.nSD 0.00415145f
Cred_15515 v_b.P7.nSD VDD.$340.Metal1 3.32437e-08f
Cred_15516 v_b.P7.nSD VDD.$388.Metal2 8.33714e-08f
Cred_15517 v_b.P7.nSD VDD.$42.Metal1 3.91466e-06f
Cred_15518 v_b.P7.nSD VDD.$666.Metal3 3.67046e-09f
Cred_15519 v_b.P7.nSD VDD.P0.nSD 0.000268949f
Cred_15520 v_b.P7.nSD VSS.$17.Metal1 0.000369093f
Cred_15521 v_b.P7.nSD VSS.$301.Metal1 2.33518e-06f
Cred_15522 v_b.P7.nSD VSS.$606.Metal2 2.46738e-07f
Cred_15523 v_b.P7.nSD VSS.$760.Metal3 1.45992e-08f
Cred_15524 v_b.P7.nSD VSS.P0.pSD 0.0054005f
Cred_15525 v_b.P7.pSD VDD.$340.Metal1 1.12491e-06f
Cred_15526 v_b.P7.pSD VDD.$388.Metal2 2.81013e-06f
Cred_15527 v_b.P7.pSD VDD.$42.Metal1 0.000131948f
Cred_15528 v_b.P7.pSD VDD.$666.Metal3 1.23717e-07f
Cred_15529 v_b.P7.pSD VDD.P0.nSD 0.00910094f
Cred_15530 v_b.P7.pSD VSS.$17.Metal1 3.49363e-05f
Cred_15531 v_b.P7.pSD VSS.$301.Metal1 2.20181e-07f
Cred_15532 v_b.P7.pSD VSS.$606.Metal2 2.32646e-08f
Cred_15533 v_b.P7.pSD VSS.$760.Metal3 1.37654e-09f
Cred_15534 v_b.P7.pSD VSS.P0.pSD 0.000508973f
Cred_15535 v_b.P71.nSD VSS.$17.Metal1 5.40955e-06f
Cred_15536 v_b.P71.nSD VSS.$301.Metal1 0.0294785f
Cred_15537 v_b.P71.nSD VSS.$606.Metal2 0.00642623f
Cred_15538 v_b.P71.nSD VSS.$760.Metal3 0.00230712f
Cred_15539 v_b.P71.nSD VSS.P0.pSD 0.0444136f
Cred_15540 v_b.P71.pSD VDD.$332.Metal1 0.00735873f
Cred_15541 v_b.P71.pSD VDD.$340.Metal1 0.0830441f
Cred_15542 v_b.P71.pSD VDD.$388.Metal2 6.44679e-08f
Cred_15543 v_b.P71.pSD VDD.$42.Metal1 3.02705e-06f
Cred_15544 v_b.P71.pSD VDD.$644.Metal2 0.00845113f
Cred_15545 v_b.P71.pSD VDD.$666.Metal3 2.83822e-09f
Cred_15546 v_b.P71.pSD VDD.$794.Metal3 0.00593361f
Cred_15547 v_b.P71.pSD VDD.P0.nSD 0.220116f
Cred_15548 VDD.$340.Metal1 VSS.$17.Metal1 7.02153e-06f
Cred_15549 VDD.$340.Metal1 VSS.$301.Metal1 0.000671129f
Cred_15550 VDD.$340.Metal1 VSS.$606.Metal2 7.09125e-05f
Cred_15551 VDD.$340.Metal1 VSS.$760.Metal3 4.1958e-06f
Cred_15552 VDD.$340.Metal1 VSS.P0.pSD 0.00618486f
Cred_15553 VDD.$388.Metal2 VSS.$17.Metal1 1.67419e-05f
Cred_15554 VDD.$388.Metal2 VSS.$301.Metal1 1.11217e-07f
Cred_15555 VDD.$388.Metal2 VSS.$606.Metal2 1.17514e-08f
Cred_15556 VDD.$388.Metal2 VSS.$760.Metal3 6.95314e-10f
Cred_15557 VDD.$388.Metal2 VSS.P0.pSD 0.000121032f
Cred_15558 VDD.$42.Metal1 VSS.$17.Metal1 0.000786108f
Cred_15559 VDD.$42.Metal1 VSS.$301.Metal1 5.22215e-06f
Cred_15560 VDD.$42.Metal1 VSS.$606.Metal2 5.5178e-07f
Cred_15561 VDD.$42.Metal1 VSS.$760.Metal3 3.26481e-08f
Cred_15562 VDD.$42.Metal1 VSS.P0.pSD 0.00568298f
Cred_15563 VDD.$666.Metal3 VSS.$17.Metal1 7.3707e-07f
Cred_15564 VDD.$666.Metal3 VSS.$301.Metal1 4.89639e-09f
Cred_15565 VDD.$666.Metal3 VSS.$606.Metal2 5.1736e-10f
Cred_15566 VDD.$666.Metal3 VSS.$760.Metal3 3.06115e-11f
Cred_15567 VDD.$666.Metal3 VSS.P0.pSD 5.32847e-06f
Cred_15568 VDD.P0.nSD VSS.$17.Metal1 0.0281798f
Cred_15569 VDD.P0.nSD VSS.$301.Metal1 0.0224453f
Cred_15570 VDD.P0.nSD VSS.$606.Metal2 0.00237161f
Cred_15571 VDD.P0.nSD VSS.$760.Metal3 0.000140325f
Cred_15572 VDD.P0.nSD VSS.P0.pSD 0.831801f
Rred_1 di_tg_ctrl di_tg_ctrl.$310.Metal2 1959.88464855
Rred_2 di_tg_ctrl di_tg_ctrl.$316.Metal2 1729.62920447
Rred_3 di_tg_ctrl di_tg_ctrl.$413.Metal3 22.1921440941
Rred_4 di_tg_ctrl di_tg_ctrl.$417.Metal3 8.44754933528
Rred_5 di_tg_ctrl di_tg_ctrl.$419.Metal3 8.04261042842
Rred_6 di_tg_ctrl di_tg_ctrl.$423.Metal3 16.4315869035
Rred_7 di_tg_ctrl di_tg_ctrl.$471.Metal4 0.533340258251
Rred_8 di_tg_ctrl di_tg_ctrl.$483.Metal4 0.624418285359
Rred_9 di_tg_ctrl.$100.GatPoly di_tg_ctrl.$103.GatPoly 17.1424550154
Rred_10 di_tg_ctrl.$100.GatPoly di_tg_ctrl.$234.Metal1 110.882296296
Rred_11 di_tg_ctrl.$100.GatPoly di_tg_ctrl.$236.Metal1 20.0550777063
Rred_12 di_tg_ctrl.$100.GatPoly di_tg_ctrl.$238.Metal1 32.222005523
Rred_13 di_tg_ctrl.$100.GatPoly di_tg_ctrl.$97.GatPoly 14.6611036214
Rred_14 di_tg_ctrl.$100.GatPoly di_tg_ctrl.P42.GatPoly 252
Rred_15 di_tg_ctrl.$100.GatPoly di_tg_ctrl.P43.GatPoly 2178.10016667
Rred_16 di_tg_ctrl.$103.GatPoly di_tg_ctrl.$105.GatPoly 10.9656296296
Rred_17 di_tg_ctrl.$103.GatPoly di_tg_ctrl.$238.Metal1 17.8364920157
Rred_18 di_tg_ctrl.$103.GatPoly di_tg_ctrl.$241.Metal1 22.2802284645
Rred_19 di_tg_ctrl.$103.GatPoly di_tg_ctrl.$366.Metal2 1903.40913269
Rred_20 di_tg_ctrl.$103.GatPoly di_tg_ctrl.P43.GatPoly 302.934654613
Rred_21 di_tg_ctrl.$105.GatPoly di_tg_ctrl.$109.GatPoly 37.7380623964
Rred_22 di_tg_ctrl.$105.GatPoly di_tg_ctrl.$241.Metal1 20.7333333333
Rred_23 di_tg_ctrl.$105.GatPoly di_tg_ctrl.$243.Metal1 27.8558623939
Rred_24 di_tg_ctrl.$105.GatPoly di_tg_ctrl.$245.Metal1 71.353479321
Rred_25 di_tg_ctrl.$105.GatPoly di_tg_ctrl.P44.GatPoly 252
Rred_26 di_tg_ctrl.$105.GatPoly di_tg_ctrl.P45.GatPoly 867.254507503
Rred_27 di_tg_ctrl.$109.GatPoly di_tg_ctrl.$112.GatPoly 17.1424550154
Rred_28 di_tg_ctrl.$109.GatPoly di_tg_ctrl.$243.Metal1 95.1379724279
Rred_29 di_tg_ctrl.$109.GatPoly di_tg_ctrl.$245.Metal1 15.8458030953
Rred_30 di_tg_ctrl.$109.GatPoly di_tg_ctrl.$249.Metal1 17.8364920157
Rred_31 di_tg_ctrl.$109.GatPoly di_tg_ctrl.$372.Metal2 1903.40913269
Rred_32 di_tg_ctrl.$109.GatPoly di_tg_ctrl.P45.GatPoly 666.892045948
Rred_33 di_tg_ctrl.$109.GatPoly di_tg_ctrl.P46.GatPoly 302.934654613
Rred_34 di_tg_ctrl.$112.GatPoly di_tg_ctrl.$115.GatPoly 14.6611036214
Rred_35 di_tg_ctrl.$112.GatPoly di_tg_ctrl.$249.Metal1 32.222005523
Rred_36 di_tg_ctrl.$112.GatPoly di_tg_ctrl.$250.Metal1 20.0550777063
Rred_37 di_tg_ctrl.$112.GatPoly di_tg_ctrl.$252.Metal1 110.882296296
Rred_38 di_tg_ctrl.$112.GatPoly di_tg_ctrl.P46.GatPoly 2178.10016667
Rred_39 di_tg_ctrl.$112.GatPoly di_tg_ctrl.P47.GatPoly 252
Rred_40 di_tg_ctrl.$115.GatPoly di_tg_ctrl.$119.GatPoly 37.7380623964
Rred_41 di_tg_ctrl.$115.GatPoly di_tg_ctrl.$250.Metal1 110.882296296
Rred_42 di_tg_ctrl.$115.GatPoly di_tg_ctrl.$252.Metal1 20.0550777063
Rred_43 di_tg_ctrl.$115.GatPoly di_tg_ctrl.$254.Metal1 27.8558623939
Rred_44 di_tg_ctrl.$115.GatPoly di_tg_ctrl.$256.Metal1 71.353479321
Rred_45 di_tg_ctrl.$115.GatPoly di_tg_ctrl.P48.GatPoly 252
Rred_46 di_tg_ctrl.$115.GatPoly di_tg_ctrl.P49.GatPoly 867.254507503
Rred_47 di_tg_ctrl.$119.GatPoly di_tg_ctrl.$122.GatPoly 17.1424550154
Rred_48 di_tg_ctrl.$119.GatPoly di_tg_ctrl.$254.Metal1 95.1379724279
Rred_49 di_tg_ctrl.$119.GatPoly di_tg_ctrl.$256.Metal1 15.8466185187
Rred_50 di_tg_ctrl.$119.GatPoly di_tg_ctrl.$260.Metal1 17.8414620566
Rred_51 di_tg_ctrl.$119.GatPoly di_tg_ctrl.$382.Metal2 1836.80456241
Rred_52 di_tg_ctrl.$119.GatPoly di_tg_ctrl.P49.GatPoly 666.892045948
Rred_53 di_tg_ctrl.$119.GatPoly di_tg_ctrl.P50.GatPoly 302.934654613
Rred_54 di_tg_ctrl.$12.GatPoly di_tg_ctrl.$138.Metal1 17.9542897419
Rred_55 di_tg_ctrl.$12.GatPoly di_tg_ctrl.$14.GatPoly 10.9656296296
Rred_56 di_tg_ctrl.$12.GatPoly di_tg_ctrl.$142.Metal1 22.2304810183
Rred_57 di_tg_ctrl.$12.GatPoly di_tg_ctrl.$276.Metal2 1903.40913269
Rred_58 di_tg_ctrl.$12.GatPoly di_tg_ctrl.$9.GatPoly 17.3428707176
Rred_59 di_tg_ctrl.$12.GatPoly di_tg_ctrl.P5.GatPoly 110.017140972
Rred_60 di_tg_ctrl.$122.GatPoly di_tg_ctrl.$124.GatPoly 10.9656296296
Rred_61 di_tg_ctrl.$122.GatPoly di_tg_ctrl.$260.Metal1 32.222005523
Rred_62 di_tg_ctrl.$122.GatPoly di_tg_ctrl.$261.Metal1 20.7333333333
Rred_63 di_tg_ctrl.$122.GatPoly di_tg_ctrl.P50.GatPoly 2178.10016667
Rred_64 di_tg_ctrl.$122.GatPoly di_tg_ctrl.P51.GatPoly 252
Rred_65 di_tg_ctrl.$124.GatPoly di_tg_ctrl.$126.GatPoly 7.93313604214
Rred_66 di_tg_ctrl.$124.GatPoly di_tg_ctrl.$261.Metal1 13.2125525831
Rred_67 di_tg_ctrl.$124.GatPoly di_tg_ctrl.$386.Metal2 659.546966828
Rred_68 di_tg_ctrl.$124.GatPoly di_tg_ctrl.$467.Metal3 46130.215797
Rred_69 di_tg_ctrl.$124.GatPoly di_tg_ctrl.P52.GatPoly 337.983333333
Rred_70 di_tg_ctrl.$126.GatPoly di_tg_ctrl.$261.Metal1 16.0430913423
Rred_71 di_tg_ctrl.$126.GatPoly di_tg_ctrl.$386.Metal2 486.998735169
Rred_72 di_tg_ctrl.$126.GatPoly di_tg_ctrl.$467.Metal3 31759.7674116
Rred_73 di_tg_ctrl.$126.GatPoly di_tg_ctrl.P52.GatPoly 1013.95
Rred_74 di_tg_ctrl.$126.GatPoly di_tg_ctrl.P53.GatPoly 269.732872698
Rred_75 di_tg_ctrl.$128.Metal1 di_tg_ctrl.$130.Metal1 0.214918195751
Rred_76 di_tg_ctrl.$128.Metal1 di_tg_ctrl.$270.Metal2 9.96667791072
Rred_77 di_tg_ctrl.$128.Metal1 di_tg_ctrl.$272.Metal2 10732.7449825
Rred_78 di_tg_ctrl.$128.Metal1 di_tg_ctrl.$3.GatPoly 20.7834220279
Rred_79 di_tg_ctrl.$128.Metal1 di_tg_ctrl.$394.Metal3 204.887533846
Rred_80 di_tg_ctrl.$128.Metal1 di_tg_ctrl.P0.GatPoly 192.767243239
Rred_81 di_tg_ctrl.$128.Metal1 di_tg_ctrl.P1.GatPoly 215.537574563
Rred_82 di_tg_ctrl.$130.Metal1 di_tg_ctrl.$132.Metal1 0.180745381708
Rred_83 di_tg_ctrl.$130.Metal1 di_tg_ctrl.$270.Metal2 9.6273019118
Rred_84 di_tg_ctrl.$130.Metal1 di_tg_ctrl.$272.Metal2 15946.9046903
Rred_85 di_tg_ctrl.$130.Metal1 di_tg_ctrl.$3.GatPoly 13.9161623848
Rred_86 di_tg_ctrl.$130.Metal1 di_tg_ctrl.$394.Metal3 304.425566788
Rred_87 di_tg_ctrl.$130.Metal1 di_tg_ctrl.P0.GatPoly 3601.09930207
Rred_88 di_tg_ctrl.$130.Metal1 di_tg_ctrl.P1.GatPoly 2079.30752155
Rred_89 di_tg_ctrl.$132.Metal1 di_tg_ctrl.$136.Metal1 0.362518504504
Rred_90 di_tg_ctrl.$132.Metal1 di_tg_ctrl.$270.Metal2 9.99519164984
Rred_91 di_tg_ctrl.$132.Metal1 di_tg_ctrl.$272.Metal2 30.3840343021
Rred_92 di_tg_ctrl.$132.Metal1 di_tg_ctrl.$3.GatPoly 37.3253435991
Rred_93 di_tg_ctrl.$132.Metal1 di_tg_ctrl.$7.GatPoly 17.0264750634
Rred_94 di_tg_ctrl.$132.Metal1 di_tg_ctrl.P2.GatPoly 1766.1219457
Rred_95 di_tg_ctrl.$132.Metal1 di_tg_ctrl.P3.GatPoly 1766.1219457
Rred_96 di_tg_ctrl.$136.Metal1 di_tg_ctrl.$138.Metal1 0.178931043267
Rred_97 di_tg_ctrl.$136.Metal1 di_tg_ctrl.$270.Metal2 95.8265697221
Rred_98 di_tg_ctrl.$136.Metal1 di_tg_ctrl.$272.Metal2 10.1717809154
Rred_99 di_tg_ctrl.$136.Metal1 di_tg_ctrl.$276.Metal2 46.4155560695
Rred_100 di_tg_ctrl.$136.Metal1 di_tg_ctrl.$394.Metal3 2431.41355242
Rred_101 di_tg_ctrl.$136.Metal1 di_tg_ctrl.$7.GatPoly 22.266970272
Rred_102 di_tg_ctrl.$136.Metal1 di_tg_ctrl.$9.GatPoly 20.7333333333
Rred_103 di_tg_ctrl.$138.Metal1 di_tg_ctrl.$142.Metal1 0.361706882048
Rred_104 di_tg_ctrl.$138.Metal1 di_tg_ctrl.$272.Metal2 30.5663418019
Rred_105 di_tg_ctrl.$138.Metal1 di_tg_ctrl.$276.Metal2 10.2033409876
Rred_106 di_tg_ctrl.$138.Metal1 di_tg_ctrl.$394.Metal3 1601.17477842
Rred_107 di_tg_ctrl.$138.Metal1 di_tg_ctrl.$9.GatPoly 32.2606653979
Rred_108 di_tg_ctrl.$138.Metal1 di_tg_ctrl.P5.GatPoly 1994.17624435
Rred_109 di_tg_ctrl.$14.GatPoly di_tg_ctrl.$142.Metal1 20.7333333333
Rred_110 di_tg_ctrl.$14.GatPoly di_tg_ctrl.$143.Metal1 32.2606653979
Rred_111 di_tg_ctrl.$14.GatPoly di_tg_ctrl.$17.GatPoly 17.3428707176
Rred_112 di_tg_ctrl.$14.GatPoly di_tg_ctrl.P6.GatPoly 90.4615384615
Rred_113 di_tg_ctrl.$14.GatPoly di_tg_ctrl.P7.GatPoly 791.023243591
Rred_114 di_tg_ctrl.$142.Metal1 di_tg_ctrl.$143.Metal1 0.178146302595
Rred_115 di_tg_ctrl.$142.Metal1 di_tg_ctrl.$276.Metal2 22.5992068453
Rred_116 di_tg_ctrl.$142.Metal1 di_tg_ctrl.$278.Metal2 9.13694740583
Rred_117 di_tg_ctrl.$143.Metal1 di_tg_ctrl.$147.Metal1 0.362599659797
Rred_118 di_tg_ctrl.$143.Metal1 di_tg_ctrl.$17.GatPoly 17.9292888599
Rred_119 di_tg_ctrl.$143.Metal1 di_tg_ctrl.$278.Metal2 612.175476189
Rred_120 di_tg_ctrl.$143.Metal1 di_tg_ctrl.$280.Metal2 10.1664024934
Rred_121 di_tg_ctrl.$143.Metal1 di_tg_ctrl.$282.Metal2 31.9493406534
Rred_122 di_tg_ctrl.$143.Metal1 di_tg_ctrl.P7.GatPoly 1994.17624435
Rred_123 di_tg_ctrl.$147.Metal1 di_tg_ctrl.$149.Metal1 0.178906882684
Rred_124 di_tg_ctrl.$147.Metal1 di_tg_ctrl.$17.GatPoly 22.2650577923
Rred_125 di_tg_ctrl.$147.Metal1 di_tg_ctrl.$19.GatPoly 20.7333333333
Rred_126 di_tg_ctrl.$147.Metal1 di_tg_ctrl.$280.Metal2 83.0682856989
Rred_127 di_tg_ctrl.$147.Metal1 di_tg_ctrl.$282.Metal2 10.166378698
Rred_128 di_tg_ctrl.$147.Metal1 di_tg_ctrl.$286.Metal2 50.1220317964
Rred_129 di_tg_ctrl.$147.Metal1 di_tg_ctrl.$399.Metal3 2625.57206472
Rred_130 di_tg_ctrl.$149.Metal1 di_tg_ctrl.$153.Metal1 0.36174266925
Rred_131 di_tg_ctrl.$149.Metal1 di_tg_ctrl.$19.GatPoly 32.2606653979
Rred_132 di_tg_ctrl.$149.Metal1 di_tg_ctrl.$22.GatPoly 17.9553366151
Rred_133 di_tg_ctrl.$149.Metal1 di_tg_ctrl.$282.Metal2 29.1407161607
Rred_134 di_tg_ctrl.$149.Metal1 di_tg_ctrl.$286.Metal2 10.2068763727
Rred_135 di_tg_ctrl.$149.Metal1 di_tg_ctrl.$399.Metal3 1526.49538646
Rred_136 di_tg_ctrl.$149.Metal1 di_tg_ctrl.P9.GatPoly 1994.17624435
Rred_137 di_tg_ctrl.$153.Metal1 di_tg_ctrl.$154.Metal1 0.178243858654
Rred_138 di_tg_ctrl.$153.Metal1 di_tg_ctrl.$22.GatPoly 22.2382019303
Rred_139 di_tg_ctrl.$153.Metal1 di_tg_ctrl.$24.GatPoly 20.7333333333
Rred_140 di_tg_ctrl.$153.Metal1 di_tg_ctrl.$286.Metal2 21.8084097251
Rred_141 di_tg_ctrl.$153.Metal1 di_tg_ctrl.$288.Metal2 9.42324175824
Rred_142 di_tg_ctrl.$154.Metal1 di_tg_ctrl.$158.Metal1 0.362668329822
Rred_143 di_tg_ctrl.$154.Metal1 di_tg_ctrl.$24.GatPoly 32.2606653979
Rred_144 di_tg_ctrl.$154.Metal1 di_tg_ctrl.$27.GatPoly 17.9305710523
Rred_145 di_tg_ctrl.$154.Metal1 di_tg_ctrl.$288.Metal2 204.170238095
Rred_146 di_tg_ctrl.$154.Metal1 di_tg_ctrl.$290.Metal2 10.3431464598
Rred_147 di_tg_ctrl.$154.Metal1 di_tg_ctrl.$292.Metal2 33.6827097476
Rred_148 di_tg_ctrl.$154.Metal1 di_tg_ctrl.P11.GatPoly 1994.17624435
Rred_149 di_tg_ctrl.$158.Metal1 di_tg_ctrl.$160.Metal1 0.178876681955
Rred_150 di_tg_ctrl.$158.Metal1 di_tg_ctrl.$27.GatPoly 22.2631413379
Rred_151 di_tg_ctrl.$158.Metal1 di_tg_ctrl.$29.GatPoly 20.7333333333
Rred_152 di_tg_ctrl.$158.Metal1 di_tg_ctrl.$290.Metal2 73.3094270978
Rred_153 di_tg_ctrl.$158.Metal1 di_tg_ctrl.$292.Metal2 10.1607538294
Rred_154 di_tg_ctrl.$158.Metal1 di_tg_ctrl.$296.Metal2 54.4712726609
Rred_155 di_tg_ctrl.$158.Metal1 di_tg_ctrl.$404.Metal3 2853.40092375
Rred_156 di_tg_ctrl.$160.Metal1 di_tg_ctrl.$163.Metal1 0.361772286805
Rred_157 di_tg_ctrl.$160.Metal1 di_tg_ctrl.$29.GatPoly 32.2606653979
Rred_158 di_tg_ctrl.$160.Metal1 di_tg_ctrl.$292.Metal2 27.8408726934
Rred_159 di_tg_ctrl.$160.Metal1 di_tg_ctrl.$296.Metal2 10.2100987226
Rred_160 di_tg_ctrl.$160.Metal1 di_tg_ctrl.$32.GatPoly 17.9562029449
Rred_161 di_tg_ctrl.$160.Metal1 di_tg_ctrl.$404.Metal3 1458.40491658
Rred_162 di_tg_ctrl.$160.Metal1 di_tg_ctrl.P13.GatPoly 1994.17624435
Rred_163 di_tg_ctrl.$163.Metal1 di_tg_ctrl.$165.Metal1 0.17833531746
Rred_164 di_tg_ctrl.$163.Metal1 di_tg_ctrl.$296.Metal2 21.0708666274
Rred_165 di_tg_ctrl.$163.Metal1 di_tg_ctrl.$298.Metal2 9.72738095238
Rred_166 di_tg_ctrl.$163.Metal1 di_tg_ctrl.$32.GatPoly 22.2462051089
Rred_167 di_tg_ctrl.$163.Metal1 di_tg_ctrl.$34.GatPoly 20.7333333333
Rred_168 di_tg_ctrl.$165.Metal1 di_tg_ctrl.$169.Metal1 0.362724514501
Rred_169 di_tg_ctrl.$165.Metal1 di_tg_ctrl.$298.Metal2 122.565
Rred_170 di_tg_ctrl.$165.Metal1 di_tg_ctrl.$300.Metal2 10.5257138212
Rred_171 di_tg_ctrl.$165.Metal1 di_tg_ctrl.$302.Metal2 35.6129523328
Rred_172 di_tg_ctrl.$165.Metal1 di_tg_ctrl.$34.GatPoly 32.2606653979
Rred_173 di_tg_ctrl.$165.Metal1 di_tg_ctrl.$37.GatPoly 17.9318492035
Rred_174 di_tg_ctrl.$165.Metal1 di_tg_ctrl.P15.GatPoly 1994.17624435
Rred_175 di_tg_ctrl.$169.Metal1 di_tg_ctrl.$171.Metal1 0.17884044108
Rred_176 di_tg_ctrl.$169.Metal1 di_tg_ctrl.$300.Metal2 65.6028069289
Rred_177 di_tg_ctrl.$169.Metal1 di_tg_ctrl.$302.Metal2 10.1549064678
Rred_178 di_tg_ctrl.$169.Metal1 di_tg_ctrl.$306.Metal2 59.6469258452
Rred_179 di_tg_ctrl.$169.Metal1 di_tg_ctrl.$37.GatPoly 22.2612207117
Rred_180 di_tg_ctrl.$169.Metal1 di_tg_ctrl.$39.GatPoly 20.7333333333
Rred_181 di_tg_ctrl.$169.Metal1 di_tg_ctrl.$409.Metal3 3124.52022858
Rred_182 di_tg_ctrl.$17.GatPoly di_tg_ctrl.$19.GatPoly 10.9656296296
Rred_183 di_tg_ctrl.$17.GatPoly di_tg_ctrl.$280.Metal2 6962.69289808
Rred_184 di_tg_ctrl.$17.GatPoly di_tg_ctrl.$282.Metal2 2681.79641039
Rred_185 di_tg_ctrl.$17.GatPoly di_tg_ctrl.P7.GatPoly 110.017140972
Rred_186 di_tg_ctrl.$171.Metal1 di_tg_ctrl.$174.Metal1 0.361795734713
Rred_187 di_tg_ctrl.$171.Metal1 di_tg_ctrl.$302.Metal2 26.6507541011
Rred_188 di_tg_ctrl.$171.Metal1 di_tg_ctrl.$306.Metal2 10.2129991727
Rred_189 di_tg_ctrl.$171.Metal1 di_tg_ctrl.$39.GatPoly 32.2606653979
Rred_190 di_tg_ctrl.$171.Metal1 di_tg_ctrl.$409.Metal3 1396.06222979
Rred_191 di_tg_ctrl.$171.Metal1 di_tg_ctrl.$42.GatPoly 17.9568887679
Rred_192 di_tg_ctrl.$171.Metal1 di_tg_ctrl.P17.GatPoly 1994.17624435
Rred_193 di_tg_ctrl.$174.Metal1 di_tg_ctrl.$176.Metal1 0.178417630876
Rred_194 di_tg_ctrl.$174.Metal1 di_tg_ctrl.$306.Metal2 10.2166786029
Rred_195 di_tg_ctrl.$174.Metal1 di_tg_ctrl.$310.Metal2 20.4856411611
Rred_196 di_tg_ctrl.$174.Metal1 di_tg_ctrl.$413.Metal3 1073.1114688
Rred_197 di_tg_ctrl.$174.Metal1 di_tg_ctrl.$42.GatPoly 22.2544914996
Rred_198 di_tg_ctrl.$174.Metal1 di_tg_ctrl.$44.GatPoly 20.7333333333
Rred_199 di_tg_ctrl.$176.Metal1 di_tg_ctrl.$180.Metal1 0.362768213765
Rred_200 di_tg_ctrl.$176.Metal1 di_tg_ctrl.$306.Metal2 178.517730119
Rred_201 di_tg_ctrl.$176.Metal1 di_tg_ctrl.$310.Metal2 10.1077601315
Rred_202 di_tg_ctrl.$176.Metal1 di_tg_ctrl.$312.Metal2 37.7758635821
Rred_203 di_tg_ctrl.$176.Metal1 di_tg_ctrl.$413.Metal3 9351.39994245
Rred_204 di_tg_ctrl.$176.Metal1 di_tg_ctrl.$44.GatPoly 32.2606653979
Rred_205 di_tg_ctrl.$176.Metal1 di_tg_ctrl.$47.GatPoly 17.933123444
Rred_206 di_tg_ctrl.$176.Metal1 di_tg_ctrl.P19.GatPoly 1994.17624435
Rred_207 di_tg_ctrl.$180.Metal1 di_tg_ctrl.$182.Metal1 0.17879816006
Rred_208 di_tg_ctrl.$180.Metal1 di_tg_ctrl.$310.Metal2 59.3620713434
Rred_209 di_tg_ctrl.$180.Metal1 di_tg_ctrl.$312.Metal2 10.1488367797
Rred_210 di_tg_ctrl.$180.Metal1 di_tg_ctrl.$316.Metal2 65.9099636609
Rred_211 di_tg_ctrl.$180.Metal1 di_tg_ctrl.$419.Metal3 3452.60064631
Rred_212 di_tg_ctrl.$180.Metal1 di_tg_ctrl.$47.GatPoly 22.259295717
Rred_213 di_tg_ctrl.$180.Metal1 di_tg_ctrl.$49.GatPoly 20.7333333333
Rred_214 di_tg_ctrl.$182.Metal1 di_tg_ctrl.$185.Metal1 0.361813012975
Rred_215 di_tg_ctrl.$182.Metal1 di_tg_ctrl.$312.Metal2 25.5569246849
Rred_216 di_tg_ctrl.$182.Metal1 di_tg_ctrl.$316.Metal2 10.2155688312
Rred_217 di_tg_ctrl.$182.Metal1 di_tg_ctrl.$419.Metal3 1338.76351592
Rred_218 di_tg_ctrl.$182.Metal1 di_tg_ctrl.$49.GatPoly 32.2606653979
Rred_219 di_tg_ctrl.$182.Metal1 di_tg_ctrl.$52.GatPoly 17.9573941128
Rred_220 di_tg_ctrl.$182.Metal1 di_tg_ctrl.P21.GatPoly 1994.17624435
Rred_221 di_tg_ctrl.$185.Metal1 di_tg_ctrl.$187.Metal1 0.178496152771
Rred_222 di_tg_ctrl.$185.Metal1 di_tg_ctrl.$316.Metal2 10.2182444783
Rred_223 di_tg_ctrl.$185.Metal1 di_tg_ctrl.$320.Metal2 21.1893910588
Rred_224 di_tg_ctrl.$185.Metal1 di_tg_ctrl.$423.Metal3 1109.97641633
Rred_225 di_tg_ctrl.$185.Metal1 di_tg_ctrl.$52.GatPoly 22.2630620995
Rred_226 di_tg_ctrl.$185.Metal1 di_tg_ctrl.$54.GatPoly 20.7333333333
Rred_227 di_tg_ctrl.$187.Metal1 di_tg_ctrl.$191.Metal1 0.362799427562
Rred_228 di_tg_ctrl.$187.Metal1 di_tg_ctrl.$316.Metal2 138.908230275
Rred_229 di_tg_ctrl.$187.Metal1 di_tg_ctrl.$320.Metal2 10.1151598329
Rred_230 di_tg_ctrl.$187.Metal1 di_tg_ctrl.$322.Metal2 40.2164761345
Rred_231 di_tg_ctrl.$187.Metal1 di_tg_ctrl.$423.Metal3 7276.51206261
Rred_232 di_tg_ctrl.$187.Metal1 di_tg_ctrl.$54.GatPoly 32.2606653979
Rred_233 di_tg_ctrl.$187.Metal1 di_tg_ctrl.$57.GatPoly 17.9343939036
Rred_234 di_tg_ctrl.$187.Metal1 di_tg_ctrl.P23.GatPoly 1994.17624435
Rred_235 di_tg_ctrl.$19.GatPoly di_tg_ctrl.$22.GatPoly 17.3428707176
Rred_236 di_tg_ctrl.$19.GatPoly di_tg_ctrl.P8.GatPoly 90.4615384615
Rred_237 di_tg_ctrl.$19.GatPoly di_tg_ctrl.P9.GatPoly 791.023243591
Rred_238 di_tg_ctrl.$191.Metal1 di_tg_ctrl.$193.Metal1 0.178749838894
Rred_239 di_tg_ctrl.$191.Metal1 di_tg_ctrl.$320.Metal2 54.2048156595
Rred_240 di_tg_ctrl.$191.Metal1 di_tg_ctrl.$322.Metal2 10.1425449396
Rred_241 di_tg_ctrl.$191.Metal1 di_tg_ctrl.$326.Metal2 73.644168919
Rred_242 di_tg_ctrl.$191.Metal1 di_tg_ctrl.$429.Metal3 3857.74609913
Rred_243 di_tg_ctrl.$191.Metal1 di_tg_ctrl.$57.GatPoly 22.2573661566
Rred_244 di_tg_ctrl.$191.Metal1 di_tg_ctrl.$59.GatPoly 20.7333333333
Rred_245 di_tg_ctrl.$193.Metal1 di_tg_ctrl.$196.Metal1 0.361824121591
Rred_246 di_tg_ctrl.$193.Metal1 di_tg_ctrl.$322.Metal2 24.5480563064
Rred_247 di_tg_ctrl.$193.Metal1 di_tg_ctrl.$326.Metal2 10.2177987813
Rred_248 di_tg_ctrl.$193.Metal1 di_tg_ctrl.$429.Metal3 1285.91536638
Rred_249 di_tg_ctrl.$193.Metal1 di_tg_ctrl.$59.GatPoly 32.2606653979
Rred_250 di_tg_ctrl.$193.Metal1 di_tg_ctrl.$62.GatPoly 17.9577190009
Rred_251 di_tg_ctrl.$193.Metal1 di_tg_ctrl.P25.GatPoly 1994.17624435
Rred_252 di_tg_ctrl.$196.Metal1 di_tg_ctrl.$198.Metal1 0.178401059915
Rred_253 di_tg_ctrl.$196.Metal1 di_tg_ctrl.$326.Metal2 19.1286039107
Rred_254 di_tg_ctrl.$196.Metal1 di_tg_ctrl.$328.Metal2 10.7656516291
Rred_255 di_tg_ctrl.$196.Metal1 di_tg_ctrl.$62.GatPoly 15.9731479683
Rred_256 di_tg_ctrl.$196.Metal1 di_tg_ctrl.$66.GatPoly 73.4485812831
Rred_257 di_tg_ctrl.$196.Metal1 di_tg_ctrl.P26.GatPoly 465.932258437
Rred_258 di_tg_ctrl.$198.Metal1 di_tg_ctrl.$200.Metal1 0.178906882684
Rred_259 di_tg_ctrl.$198.Metal1 di_tg_ctrl.$328.Metal2 19.1416854328
Rred_260 di_tg_ctrl.$198.Metal1 di_tg_ctrl.$332.Metal2 29.1407161607
Rred_261 di_tg_ctrl.$198.Metal1 di_tg_ctrl.$432.Metal3 1526.49538646
Rred_262 di_tg_ctrl.$198.Metal1 di_tg_ctrl.$62.GatPoly 97.9314417107
Rred_263 di_tg_ctrl.$198.Metal1 di_tg_ctrl.$66.GatPoly 28.0359186568
Rred_264 di_tg_ctrl.$198.Metal1 di_tg_ctrl.P26.GatPoly 807.890579942
Rred_265 di_tg_ctrl.$200.Metal1 di_tg_ctrl.$204.Metal1 0.362599659797
Rred_266 di_tg_ctrl.$200.Metal1 di_tg_ctrl.$328.Metal2 50.1220317964
Rred_267 di_tg_ctrl.$200.Metal1 di_tg_ctrl.$332.Metal2 10.166378698
Rred_268 di_tg_ctrl.$200.Metal1 di_tg_ctrl.$334.Metal2 83.0682856989
Rred_269 di_tg_ctrl.$200.Metal1 di_tg_ctrl.$432.Metal3 2625.57206472
Rred_270 di_tg_ctrl.$200.Metal1 di_tg_ctrl.$66.GatPoly 20.7333333333
Rred_271 di_tg_ctrl.$200.Metal1 di_tg_ctrl.$68.GatPoly 22.2650577923
Rred_272 di_tg_ctrl.$204.Metal1 di_tg_ctrl.$206.Metal1 0.178146302595
Rred_273 di_tg_ctrl.$204.Metal1 di_tg_ctrl.$332.Metal2 31.9493406534
Rred_274 di_tg_ctrl.$204.Metal1 di_tg_ctrl.$334.Metal2 10.1664024934
Rred_275 di_tg_ctrl.$204.Metal1 di_tg_ctrl.$336.Metal2 612.175476189
Rred_276 di_tg_ctrl.$204.Metal1 di_tg_ctrl.$68.GatPoly 17.9292888599
Rred_277 di_tg_ctrl.$204.Metal1 di_tg_ctrl.$71.GatPoly 32.2606653979
Rred_278 di_tg_ctrl.$204.Metal1 di_tg_ctrl.P28.GatPoly 1994.17624435
Rred_279 di_tg_ctrl.$206.Metal1 di_tg_ctrl.$209.Metal1 0.361706882048
Rred_280 di_tg_ctrl.$206.Metal1 di_tg_ctrl.$336.Metal2 9.13694740583
Rred_281 di_tg_ctrl.$206.Metal1 di_tg_ctrl.$338.Metal2 22.5992068453
Rred_282 di_tg_ctrl.$206.Metal1 di_tg_ctrl.$71.GatPoly 20.7333333333
Rred_283 di_tg_ctrl.$206.Metal1 di_tg_ctrl.$73.GatPoly 22.2304810183
Rred_284 di_tg_ctrl.$209.Metal1 di_tg_ctrl.$211.Metal1 0.178931043267
Rred_285 di_tg_ctrl.$209.Metal1 di_tg_ctrl.$338.Metal2 10.2033409876
Rred_286 di_tg_ctrl.$209.Metal1 di_tg_ctrl.$342.Metal2 30.5663418019
Rred_287 di_tg_ctrl.$209.Metal1 di_tg_ctrl.$437.Metal3 1601.17477842
Rred_288 di_tg_ctrl.$209.Metal1 di_tg_ctrl.$73.GatPoly 17.9542897419
Rred_289 di_tg_ctrl.$209.Metal1 di_tg_ctrl.$76.GatPoly 32.2606653979
Rred_290 di_tg_ctrl.$209.Metal1 di_tg_ctrl.P30.GatPoly 1994.17624435
Rred_291 di_tg_ctrl.$211.Metal1 di_tg_ctrl.$215.Metal1 0.362518504504
Rred_292 di_tg_ctrl.$211.Metal1 di_tg_ctrl.$338.Metal2 46.4155560695
Rred_293 di_tg_ctrl.$211.Metal1 di_tg_ctrl.$342.Metal2 10.1717809154
Rred_294 di_tg_ctrl.$211.Metal1 di_tg_ctrl.$344.Metal2 95.8265697221
Rred_295 di_tg_ctrl.$211.Metal1 di_tg_ctrl.$437.Metal3 2431.41355242
Rred_296 di_tg_ctrl.$211.Metal1 di_tg_ctrl.$76.GatPoly 20.7333333333
Rred_297 di_tg_ctrl.$211.Metal1 di_tg_ctrl.$78.GatPoly 22.266970272
Rred_298 di_tg_ctrl.$215.Metal1 di_tg_ctrl.$216.Metal1 0.180745381708
Rred_299 di_tg_ctrl.$215.Metal1 di_tg_ctrl.$342.Metal2 30.3840343021
Rred_300 di_tg_ctrl.$215.Metal1 di_tg_ctrl.$344.Metal2 9.99519164984
Rred_301 di_tg_ctrl.$215.Metal1 di_tg_ctrl.$78.GatPoly 17.0264750634
Rred_302 di_tg_ctrl.$215.Metal1 di_tg_ctrl.$82.GatPoly 37.3253435991
Rred_303 di_tg_ctrl.$215.Metal1 di_tg_ctrl.P32.GatPoly 1766.1219457
Rred_304 di_tg_ctrl.$215.Metal1 di_tg_ctrl.P33.GatPoly 1766.1219457
Rred_305 di_tg_ctrl.$216.Metal1 di_tg_ctrl.$219.Metal1 0.214918195751
Rred_306 di_tg_ctrl.$216.Metal1 di_tg_ctrl.$342.Metal2 15946.9046903
Rred_307 di_tg_ctrl.$216.Metal1 di_tg_ctrl.$344.Metal2 9.6273019118
Rred_308 di_tg_ctrl.$216.Metal1 di_tg_ctrl.$437.Metal3 304.425566788
Rred_309 di_tg_ctrl.$216.Metal1 di_tg_ctrl.$82.GatPoly 13.9161623848
Rred_310 di_tg_ctrl.$216.Metal1 di_tg_ctrl.P34.GatPoly 2079.30752155
Rred_311 di_tg_ctrl.$216.Metal1 di_tg_ctrl.P35.GatPoly 3601.09930207
Rred_312 di_tg_ctrl.$219.Metal1 di_tg_ctrl.$342.Metal2 10732.7449825
Rred_313 di_tg_ctrl.$219.Metal1 di_tg_ctrl.$344.Metal2 9.96667791072
Rred_314 di_tg_ctrl.$219.Metal1 di_tg_ctrl.$437.Metal3 204.887533846
Rred_315 di_tg_ctrl.$219.Metal1 di_tg_ctrl.$82.GatPoly 20.7834220279
Rred_316 di_tg_ctrl.$219.Metal1 di_tg_ctrl.P34.GatPoly 215.537574563
Rred_317 di_tg_ctrl.$219.Metal1 di_tg_ctrl.P35.GatPoly 192.767243239
Rred_318 di_tg_ctrl.$22.GatPoly di_tg_ctrl.$24.GatPoly 10.9656296296
Rred_319 di_tg_ctrl.$22.GatPoly di_tg_ctrl.$286.Metal2 1836.80456241
Rred_320 di_tg_ctrl.$22.GatPoly di_tg_ctrl.P9.GatPoly 110.017140972
Rred_321 di_tg_ctrl.$223.Metal1 di_tg_ctrl.$225.Metal1 0.178717932695
Rred_322 di_tg_ctrl.$223.Metal1 di_tg_ctrl.$350.Metal2 9.11612198323
Rred_323 di_tg_ctrl.$223.Metal1 di_tg_ctrl.$352.Metal2 36.1335714285
Rred_324 di_tg_ctrl.$223.Metal1 di_tg_ctrl.$87.GatPoly 10.4123568913
Rred_325 di_tg_ctrl.$223.Metal1 di_tg_ctrl.$90.GatPoly 110.882296296
Rred_326 di_tg_ctrl.$223.Metal1 di_tg_ctrl.P36.GatPoly 981.726950925
Rred_327 di_tg_ctrl.$225.Metal1 di_tg_ctrl.$227.Metal1 0.178242466648
Rred_328 di_tg_ctrl.$225.Metal1 di_tg_ctrl.$352.Metal2 11.7057139918
Rred_329 di_tg_ctrl.$225.Metal1 di_tg_ctrl.$356.Metal2 416.132424439
Rred_330 di_tg_ctrl.$225.Metal1 di_tg_ctrl.$446.Metal3 21798.5111471
Rred_331 di_tg_ctrl.$225.Metal1 di_tg_ctrl.$87.GatPoly 110.882296296
Rred_332 di_tg_ctrl.$225.Metal1 di_tg_ctrl.$90.GatPoly 20.0550777063
Rred_333 di_tg_ctrl.$227.Metal1 di_tg_ctrl.$230.Metal1 0.36174266925
Rred_334 di_tg_ctrl.$227.Metal1 di_tg_ctrl.$352.Metal2 19.2061118972
Rred_335 di_tg_ctrl.$227.Metal1 di_tg_ctrl.$356.Metal2 10.2123526232
Rred_336 di_tg_ctrl.$227.Metal1 di_tg_ctrl.$446.Metal3 1006.08512987
Rred_337 di_tg_ctrl.$227.Metal1 di_tg_ctrl.$90.GatPoly 32.222005523
Rred_338 di_tg_ctrl.$227.Metal1 di_tg_ctrl.$93.GatPoly 17.8414620566
Rred_339 di_tg_ctrl.$227.Metal1 di_tg_ctrl.P39.GatPoly 5491.00882354
Rred_340 di_tg_ctrl.$230.Metal1 di_tg_ctrl.$232.Metal1 0.178729123141
Rred_341 di_tg_ctrl.$230.Metal1 di_tg_ctrl.$356.Metal2 10.2068763727
Rred_342 di_tg_ctrl.$230.Metal1 di_tg_ctrl.$360.Metal2 29.1407161607
Rred_343 di_tg_ctrl.$230.Metal1 di_tg_ctrl.$450.Metal3 1526.49538646
Rred_344 di_tg_ctrl.$230.Metal1 di_tg_ctrl.$93.GatPoly 15.8466185187
Rred_345 di_tg_ctrl.$230.Metal1 di_tg_ctrl.$97.GatPoly 71.353479321
Rred_346 di_tg_ctrl.$230.Metal1 di_tg_ctrl.P40.GatPoly 1260.93033898
Rred_347 di_tg_ctrl.$232.Metal1 di_tg_ctrl.$234.Metal1 0.17895723734
Rred_348 di_tg_ctrl.$232.Metal1 di_tg_ctrl.$356.Metal2 50.1220317964
Rred_349 di_tg_ctrl.$232.Metal1 di_tg_ctrl.$360.Metal2 14.901201938
Rred_350 di_tg_ctrl.$232.Metal1 di_tg_ctrl.$450.Metal3 2625.57206472
Rred_351 di_tg_ctrl.$232.Metal1 di_tg_ctrl.$93.GatPoly 95.1379724279
Rred_352 di_tg_ctrl.$232.Metal1 di_tg_ctrl.$97.GatPoly 27.8558623939
Rred_353 di_tg_ctrl.$232.Metal1 di_tg_ctrl.P40.GatPoly 2186.35590127
Rred_354 di_tg_ctrl.$234.Metal1 di_tg_ctrl.$236.Metal1 0.178663080796
Rred_355 di_tg_ctrl.$234.Metal1 di_tg_ctrl.$360.Metal2 15.7682600733
Rred_356 di_tg_ctrl.$234.Metal1 di_tg_ctrl.$362.Metal2 40.9388095239
Rred_357 di_tg_ctrl.$234.Metal1 di_tg_ctrl.$97.GatPoly 20.0550777063
Rred_358 di_tg_ctrl.$236.Metal1 di_tg_ctrl.$238.Metal1 0.178145824316
Rred_359 di_tg_ctrl.$236.Metal1 di_tg_ctrl.$362.Metal2 11.4798524754
Rred_360 di_tg_ctrl.$236.Metal1 di_tg_ctrl.$366.Metal2 1247.72039745
Rred_361 di_tg_ctrl.$236.Metal1 di_tg_ctrl.$456.Metal3 65360.0762519
Rred_362 di_tg_ctrl.$236.Metal1 di_tg_ctrl.$97.GatPoly 110.882296296
Rred_363 di_tg_ctrl.$238.Metal1 di_tg_ctrl.$241.Metal1 0.361706882048
Rred_364 di_tg_ctrl.$238.Metal1 di_tg_ctrl.$362.Metal2 18.6226924993
Rred_365 di_tg_ctrl.$238.Metal1 di_tg_ctrl.$366.Metal2 10.2095751651
Rred_366 di_tg_ctrl.$238.Metal1 di_tg_ctrl.$456.Metal3 975.52352615
Rred_367 di_tg_ctrl.$238.Metal1 di_tg_ctrl.P43.GatPoly 5491.00882354
Rred_368 di_tg_ctrl.$24.GatPoly di_tg_ctrl.$27.GatPoly 17.3428707176
Rred_369 di_tg_ctrl.$24.GatPoly di_tg_ctrl.P10.GatPoly 90.4615384615
Rred_370 di_tg_ctrl.$24.GatPoly di_tg_ctrl.P11.GatPoly 791.023243591
Rred_371 di_tg_ctrl.$241.Metal1 di_tg_ctrl.$243.Metal1 0.178931043267
Rred_372 di_tg_ctrl.$241.Metal1 di_tg_ctrl.$366.Metal2 10.2033409876
Rred_373 di_tg_ctrl.$241.Metal1 di_tg_ctrl.$370.Metal2 30.5663418019
Rred_374 di_tg_ctrl.$241.Metal1 di_tg_ctrl.$459.Metal3 1601.17477842
Rred_375 di_tg_ctrl.$243.Metal1 di_tg_ctrl.$245.Metal1 0.178761122347
Rred_376 di_tg_ctrl.$243.Metal1 di_tg_ctrl.$366.Metal2 46.4155560695
Rred_377 di_tg_ctrl.$243.Metal1 di_tg_ctrl.$370.Metal2 15.2778745337
Rred_378 di_tg_ctrl.$243.Metal1 di_tg_ctrl.$459.Metal3 2431.41355242
Rred_379 di_tg_ctrl.$243.Metal1 di_tg_ctrl.P45.GatPoly 2186.35590127
Rred_380 di_tg_ctrl.$245.Metal1 di_tg_ctrl.$249.Metal1 0.361706882048
Rred_381 di_tg_ctrl.$245.Metal1 di_tg_ctrl.$370.Metal2 14.997543554
Rred_382 di_tg_ctrl.$245.Metal1 di_tg_ctrl.$372.Metal2 15.3159551971
Rred_383 di_tg_ctrl.$245.Metal1 di_tg_ctrl.P45.GatPoly 1260.93033898
Rred_384 di_tg_ctrl.$249.Metal1 di_tg_ctrl.$250.Metal1 0.178145824316
Rred_385 di_tg_ctrl.$249.Metal1 di_tg_ctrl.$372.Metal2 10.2095751651
Rred_386 di_tg_ctrl.$249.Metal1 di_tg_ctrl.$376.Metal2 18.6226924993
Rred_387 di_tg_ctrl.$249.Metal1 di_tg_ctrl.$462.Metal3 975.52352615
Rred_388 di_tg_ctrl.$249.Metal1 di_tg_ctrl.P46.GatPoly 5491.00882354
Rred_389 di_tg_ctrl.$250.Metal1 di_tg_ctrl.$252.Metal1 0.178663080796
Rred_390 di_tg_ctrl.$250.Metal1 di_tg_ctrl.$372.Metal2 1247.72039745
Rred_391 di_tg_ctrl.$250.Metal1 di_tg_ctrl.$376.Metal2 11.4798524754
Rred_392 di_tg_ctrl.$250.Metal1 di_tg_ctrl.$462.Metal3 65360.0762519
Rred_393 di_tg_ctrl.$252.Metal1 di_tg_ctrl.$254.Metal1 0.178949163705
Rred_394 di_tg_ctrl.$252.Metal1 di_tg_ctrl.$376.Metal2 18.0039446741
Rred_395 di_tg_ctrl.$252.Metal1 di_tg_ctrl.$380.Metal2 32.1371007206
Rred_396 di_tg_ctrl.$252.Metal1 di_tg_ctrl.$464.Metal3 1683.45677277
Rred_397 di_tg_ctrl.$254.Metal1 di_tg_ctrl.$256.Metal1 0.178736781778
Rred_398 di_tg_ctrl.$254.Metal1 di_tg_ctrl.$376.Metal2 43.2188595898
Rred_399 di_tg_ctrl.$254.Metal1 di_tg_ctrl.$380.Metal2 15.673820582
Rred_400 di_tg_ctrl.$254.Metal1 di_tg_ctrl.$464.Metal3 2263.95910822
Rred_401 di_tg_ctrl.$254.Metal1 di_tg_ctrl.P49.GatPoly 2186.35590127
Rred_402 di_tg_ctrl.$256.Metal1 di_tg_ctrl.$260.Metal1 0.36174266925
Rred_403 di_tg_ctrl.$256.Metal1 di_tg_ctrl.$380.Metal2 14.29803433
Rred_404 di_tg_ctrl.$256.Metal1 di_tg_ctrl.$382.Metal2 15.709211158
Rred_405 di_tg_ctrl.$256.Metal1 di_tg_ctrl.P49.GatPoly 1260.93033898
Rred_406 di_tg_ctrl.$260.Metal1 di_tg_ctrl.$261.Metal1 0.178242466648
Rred_407 di_tg_ctrl.$260.Metal1 di_tg_ctrl.$382.Metal2 10.2123526232
Rred_408 di_tg_ctrl.$260.Metal1 di_tg_ctrl.$386.Metal2 19.2061118972
Rred_409 di_tg_ctrl.$260.Metal1 di_tg_ctrl.$467.Metal3 1006.08512987
Rred_410 di_tg_ctrl.$260.Metal1 di_tg_ctrl.P50.GatPoly 5491.00882354
Rred_411 di_tg_ctrl.$261.Metal1 di_tg_ctrl.$382.Metal2 416.132424439
Rred_412 di_tg_ctrl.$261.Metal1 di_tg_ctrl.$386.Metal2 4.70240832482
Rred_413 di_tg_ctrl.$261.Metal1 di_tg_ctrl.$467.Metal3 536.214151185
Rred_414 di_tg_ctrl.$27.GatPoly di_tg_ctrl.$29.GatPoly 10.9656296296
Rred_415 di_tg_ctrl.$27.GatPoly di_tg_ctrl.$290.Metal2 6144.29735357
Rred_416 di_tg_ctrl.$27.GatPoly di_tg_ctrl.$292.Metal2 2826.42578246
Rred_417 di_tg_ctrl.$27.GatPoly di_tg_ctrl.P11.GatPoly 110.017140972
Rred_418 di_tg_ctrl.$270.Metal2 di_tg_ctrl.$272.Metal2 0.171653527178
Rred_419 di_tg_ctrl.$270.Metal2 di_tg_ctrl.$394.Metal3 3.69602125491
Rred_420 di_tg_ctrl.$270.Metal2 di_tg_ctrl.$7.GatPoly 8032.89938468
Rred_421 di_tg_ctrl.$272.Metal2 di_tg_ctrl.$276.Metal2 0.350163252448
Rred_422 di_tg_ctrl.$272.Metal2 di_tg_ctrl.$394.Metal3 6.31608963811
Rred_423 di_tg_ctrl.$272.Metal2 di_tg_ctrl.$7.GatPoly 2551.27661738
Rred_424 di_tg_ctrl.$276.Metal2 di_tg_ctrl.$278.Metal2 0.171789176047
Rred_425 di_tg_ctrl.$276.Metal2 di_tg_ctrl.$394.Metal3 7.84722573955
Rred_426 di_tg_ctrl.$276.Metal2 di_tg_ctrl.$397.Metal3 27.69051793
Rred_427 di_tg_ctrl.$278.Metal2 di_tg_ctrl.$280.Metal2 0.17180952381
Rred_428 di_tg_ctrl.$278.Metal2 di_tg_ctrl.$394.Metal3 27.69051793
Rred_429 di_tg_ctrl.$278.Metal2 di_tg_ctrl.$397.Metal3 13.7143558017
Rred_430 di_tg_ctrl.$280.Metal2 di_tg_ctrl.$282.Metal2 0.171805490937
Rred_431 di_tg_ctrl.$280.Metal2 di_tg_ctrl.$397.Metal3 9
Rred_432 di_tg_ctrl.$282.Metal2 di_tg_ctrl.$286.Metal2 0.350163697435
Rred_433 di_tg_ctrl.$282.Metal2 di_tg_ctrl.$397.Metal3 18.1718095238
Rred_434 di_tg_ctrl.$282.Metal2 di_tg_ctrl.$399.Metal3 9.12846019364
Rred_435 di_tg_ctrl.$286.Metal2 di_tg_ctrl.$288.Metal2 0.171789176047
Rred_436 di_tg_ctrl.$286.Metal2 di_tg_ctrl.$399.Metal3 7.84723000577
Rred_437 di_tg_ctrl.$286.Metal2 di_tg_ctrl.$402.Metal3 27.69051793
Rred_438 di_tg_ctrl.$288.Metal2 di_tg_ctrl.$290.Metal2 0.17180952381
Rred_439 di_tg_ctrl.$288.Metal2 di_tg_ctrl.$399.Metal3 27.69051793
Rred_440 di_tg_ctrl.$288.Metal2 di_tg_ctrl.$402.Metal3 13.7143558017
Rred_441 di_tg_ctrl.$29.GatPoly di_tg_ctrl.$32.GatPoly 17.3428707176
Rred_442 di_tg_ctrl.$29.GatPoly di_tg_ctrl.P12.GatPoly 90.4615384615
Rred_443 di_tg_ctrl.$29.GatPoly di_tg_ctrl.P13.GatPoly 791.023243591
Rred_444 di_tg_ctrl.$290.Metal2 di_tg_ctrl.$292.Metal2 0.171805188439
Rred_445 di_tg_ctrl.$290.Metal2 di_tg_ctrl.$402.Metal3 9
Rred_446 di_tg_ctrl.$292.Metal2 di_tg_ctrl.$296.Metal2 0.350164253841
Rred_447 di_tg_ctrl.$292.Metal2 di_tg_ctrl.$402.Metal3 18.1718095238
Rred_448 di_tg_ctrl.$292.Metal2 di_tg_ctrl.$404.Metal3 9.12846741217
Rred_449 di_tg_ctrl.$296.Metal2 di_tg_ctrl.$298.Metal2 0.171789176047
Rred_450 di_tg_ctrl.$296.Metal2 di_tg_ctrl.$32.GatPoly 1774.68529082
Rred_451 di_tg_ctrl.$296.Metal2 di_tg_ctrl.$404.Metal3 7.84723534018
Rred_452 di_tg_ctrl.$296.Metal2 di_tg_ctrl.$407.Metal3 27.69051793
Rred_453 di_tg_ctrl.$298.Metal2 di_tg_ctrl.$300.Metal2 0.17180952381
Rred_454 di_tg_ctrl.$298.Metal2 di_tg_ctrl.$404.Metal3 27.69051793
Rred_455 di_tg_ctrl.$298.Metal2 di_tg_ctrl.$407.Metal3 13.7143558017
Rred_456 di_tg_ctrl.$3.GatPoly di_tg_ctrl.$7.GatPoly 20.8161349411
Rred_457 di_tg_ctrl.$3.GatPoly di_tg_ctrl.P0.GatPoly 347.655072464
Rred_458 di_tg_ctrl.$3.GatPoly di_tg_ctrl.P1.GatPoly 200.739203905
Rred_459 di_tg_ctrl.$3.GatPoly di_tg_ctrl.P2.GatPoly 108.578309915
Rred_460 di_tg_ctrl.$3.GatPoly di_tg_ctrl.P3.GatPoly 949.441810889
Rred_461 di_tg_ctrl.$300.Metal2 di_tg_ctrl.$302.Metal2 0.171804941026
Rred_462 di_tg_ctrl.$300.Metal2 di_tg_ctrl.$37.GatPoly 5498.19357361
Rred_463 di_tg_ctrl.$300.Metal2 di_tg_ctrl.$407.Metal3 9
Rred_464 di_tg_ctrl.$302.Metal2 di_tg_ctrl.$306.Metal2 0.350164921777
Rred_465 di_tg_ctrl.$302.Metal2 di_tg_ctrl.$37.GatPoly 2987.58348254
Rred_466 di_tg_ctrl.$302.Metal2 di_tg_ctrl.$407.Metal3 18.1718095238
Rred_467 di_tg_ctrl.$302.Metal2 di_tg_ctrl.$409.Metal3 9.12847607763
Rred_468 di_tg_ctrl.$306.Metal2 di_tg_ctrl.$310.Metal2 0.35017273461
Rred_469 di_tg_ctrl.$306.Metal2 di_tg_ctrl.$409.Metal3 9.17045075369
Rred_470 di_tg_ctrl.$306.Metal2 di_tg_ctrl.$413.Metal3 9.17133843356
Rred_471 di_tg_ctrl.$306.Metal2 di_tg_ctrl.$42.GatPoly 1716.610141
Rred_472 di_tg_ctrl.$306.Metal2 di_tg_ctrl.$471.Metal4 978.54944145
Rred_473 di_tg_ctrl.$310.Metal2 di_tg_ctrl.$312.Metal2 0.171804748647
Rred_474 di_tg_ctrl.$310.Metal2 di_tg_ctrl.$413.Metal3 9.17070819578
Rred_475 di_tg_ctrl.$310.Metal2 di_tg_ctrl.$417.Metal3 18.3395537568
Rred_476 di_tg_ctrl.$310.Metal2 di_tg_ctrl.$47.GatPoly 4975.15540044
Rred_477 di_tg_ctrl.$310.Metal2 di_tg_ctrl.$471.Metal4 1976.02017426
Rred_478 di_tg_ctrl.$312.Metal2 di_tg_ctrl.$316.Metal2 0.350165701382
Rred_479 di_tg_ctrl.$312.Metal2 di_tg_ctrl.$417.Metal3 9
Rred_480 di_tg_ctrl.$312.Metal2 di_tg_ctrl.$419.Metal3 18.3429372398
Rred_481 di_tg_ctrl.$312.Metal2 di_tg_ctrl.$47.GatPoly 3168.27462302
Rred_482 di_tg_ctrl.$316.Metal2 di_tg_ctrl.$320.Metal2 0.350171280831
Rred_483 di_tg_ctrl.$316.Metal2 di_tg_ctrl.$419.Metal3 9.17048738103
Rred_484 di_tg_ctrl.$316.Metal2 di_tg_ctrl.$423.Metal3 9.17033058143
Rred_485 di_tg_ctrl.$316.Metal2 di_tg_ctrl.$483.Metal4 2313.46332845
Rred_486 di_tg_ctrl.$316.Metal2 di_tg_ctrl.$52.GatPoly 1662.19395849
Rred_487 di_tg_ctrl.$32.GatPoly di_tg_ctrl.$34.GatPoly 10.9656296296
Rred_488 di_tg_ctrl.$32.GatPoly di_tg_ctrl.P13.GatPoly 110.017140972
Rred_489 di_tg_ctrl.$320.Metal2 di_tg_ctrl.$322.Metal2 0.171784759644
Rred_490 di_tg_ctrl.$320.Metal2 di_tg_ctrl.$423.Metal3 7.91651061324
Rred_491 di_tg_ctrl.$320.Metal2 di_tg_ctrl.$429.Metal3 28.3810358599
Rred_492 di_tg_ctrl.$320.Metal2 di_tg_ctrl.$483.Metal4 492.433358919
Rred_493 di_tg_ctrl.$320.Metal2 di_tg_ctrl.$57.GatPoly 4543.078818
Rred_494 di_tg_ctrl.$322.Metal2 di_tg_ctrl.$326.Metal2 0.350166592815
Rred_495 di_tg_ctrl.$322.Metal2 di_tg_ctrl.$423.Metal3 28.3810358599
Rred_496 di_tg_ctrl.$322.Metal2 di_tg_ctrl.$429.Metal3 7.91567530735
Rred_497 di_tg_ctrl.$322.Metal2 di_tg_ctrl.$483.Metal4 495.566867841
Rred_498 di_tg_ctrl.$322.Metal2 di_tg_ctrl.$57.GatPoly 3372.27982918
Rred_499 di_tg_ctrl.$326.Metal2 di_tg_ctrl.$328.Metal2 0.171789176047
Rred_500 di_tg_ctrl.$326.Metal2 di_tg_ctrl.$429.Metal3 7.84725776444
Rred_501 di_tg_ctrl.$326.Metal2 di_tg_ctrl.$432.Metal3 27.69051793
Rred_502 di_tg_ctrl.$326.Metal2 di_tg_ctrl.$62.GatPoly 1611.09899248
Rred_503 di_tg_ctrl.$328.Metal2 di_tg_ctrl.$332.Metal2 0.350163697435
Rred_504 di_tg_ctrl.$328.Metal2 di_tg_ctrl.$429.Metal3 27.69051793
Rred_505 di_tg_ctrl.$328.Metal2 di_tg_ctrl.$432.Metal3 7.84723000577
Rred_506 di_tg_ctrl.$332.Metal2 di_tg_ctrl.$334.Metal2 0.171805490937
Rred_507 di_tg_ctrl.$332.Metal2 di_tg_ctrl.$432.Metal3 9.12846019364
Rred_508 di_tg_ctrl.$332.Metal2 di_tg_ctrl.$434.Metal3 18.1718095238
Rred_509 di_tg_ctrl.$332.Metal2 di_tg_ctrl.$68.GatPoly 2681.79641039
Rred_510 di_tg_ctrl.$334.Metal2 di_tg_ctrl.$336.Metal2 0.17180952381
Rred_511 di_tg_ctrl.$334.Metal2 di_tg_ctrl.$434.Metal3 9
Rred_512 di_tg_ctrl.$334.Metal2 di_tg_ctrl.$68.GatPoly 6962.69289808
Rred_513 di_tg_ctrl.$336.Metal2 di_tg_ctrl.$338.Metal2 0.171789176047
Rred_514 di_tg_ctrl.$336.Metal2 di_tg_ctrl.$434.Metal3 13.7143558017
Rred_515 di_tg_ctrl.$336.Metal2 di_tg_ctrl.$437.Metal3 27.69051793
Rred_516 di_tg_ctrl.$338.Metal2 di_tg_ctrl.$342.Metal2 0.350163252448
Rred_517 di_tg_ctrl.$338.Metal2 di_tg_ctrl.$434.Metal3 27.69051793
Rred_518 di_tg_ctrl.$338.Metal2 di_tg_ctrl.$437.Metal3 7.84722573955
Rred_519 di_tg_ctrl.$338.Metal2 di_tg_ctrl.$73.GatPoly 1903.40913269
Rred_520 di_tg_ctrl.$34.GatPoly di_tg_ctrl.$37.GatPoly 17.3428707176
Rred_521 di_tg_ctrl.$34.GatPoly di_tg_ctrl.P14.GatPoly 90.4615384615
Rred_522 di_tg_ctrl.$34.GatPoly di_tg_ctrl.P15.GatPoly 791.023243591
Rred_523 di_tg_ctrl.$342.Metal2 di_tg_ctrl.$344.Metal2 0.171653527178
Rred_524 di_tg_ctrl.$342.Metal2 di_tg_ctrl.$437.Metal3 6.31608963811
Rred_525 di_tg_ctrl.$342.Metal2 di_tg_ctrl.$78.GatPoly 2551.27661738
Rred_526 di_tg_ctrl.$344.Metal2 di_tg_ctrl.$437.Metal3 3.69602125491
Rred_527 di_tg_ctrl.$344.Metal2 di_tg_ctrl.$78.GatPoly 8032.89938468
Rred_528 di_tg_ctrl.$350.Metal2 di_tg_ctrl.$352.Metal2 0.171753301946
Rred_529 di_tg_ctrl.$350.Metal2 di_tg_ctrl.$446.Metal3 10.0196329442
Rred_530 di_tg_ctrl.$350.Metal2 di_tg_ctrl.$487.Metal4 181.145780818
Rred_531 di_tg_ctrl.$350.Metal2 di_tg_ctrl.$87.GatPoly 2400.55257794
Rred_532 di_tg_ctrl.$350.Metal2 di_tg_ctrl.P36.GatPoly 108824.864355
Rred_533 di_tg_ctrl.$352.Metal2 di_tg_ctrl.$356.Metal2 0.350175982317
Rred_534 di_tg_ctrl.$352.Metal2 di_tg_ctrl.$446.Metal3 6.32792590582
Rred_535 di_tg_ctrl.$352.Metal2 di_tg_ctrl.$487.Metal4 269.149644986
Rred_536 di_tg_ctrl.$356.Metal2 di_tg_ctrl.$360.Metal2 0.350163697435
Rred_537 di_tg_ctrl.$356.Metal2 di_tg_ctrl.$446.Metal3 9.17113224228
Rred_538 di_tg_ctrl.$356.Metal2 di_tg_ctrl.$450.Metal3 9.17048101751
Rred_539 di_tg_ctrl.$356.Metal2 di_tg_ctrl.$487.Metal4 1502.93346674
Rred_540 di_tg_ctrl.$356.Metal2 di_tg_ctrl.$495.Metal4 2823.9805248
Rred_541 di_tg_ctrl.$356.Metal2 di_tg_ctrl.$93.GatPoly 1836.80456241
Rred_542 di_tg_ctrl.$360.Metal2 di_tg_ctrl.$362.Metal2 0.171789671139
Rred_543 di_tg_ctrl.$360.Metal2 di_tg_ctrl.$450.Metal3 7.91644114171
Rred_544 di_tg_ctrl.$360.Metal2 di_tg_ctrl.$456.Metal3 28.3713784133
Rred_545 di_tg_ctrl.$360.Metal2 di_tg_ctrl.$495.Metal4 495.340278481
Rred_546 di_tg_ctrl.$362.Metal2 di_tg_ctrl.$366.Metal2 0.350177776915
Rred_547 di_tg_ctrl.$362.Metal2 di_tg_ctrl.$450.Metal3 28.3811542598
Rred_548 di_tg_ctrl.$362.Metal2 di_tg_ctrl.$456.Metal3 7.91425296708
Rred_549 di_tg_ctrl.$362.Metal2 di_tg_ctrl.$495.Metal4 501.60480191
Rred_550 di_tg_ctrl.$366.Metal2 di_tg_ctrl.$370.Metal2 0.350163252448
Rred_551 di_tg_ctrl.$366.Metal2 di_tg_ctrl.$456.Metal3 9.12864285024
Rred_552 di_tg_ctrl.$366.Metal2 di_tg_ctrl.$459.Metal3 9.12845442059
Rred_553 di_tg_ctrl.$37.GatPoly di_tg_ctrl.$39.GatPoly 10.9656296296
Rred_554 di_tg_ctrl.$37.GatPoly di_tg_ctrl.P15.GatPoly 110.017140972
Rred_555 di_tg_ctrl.$370.Metal2 di_tg_ctrl.$372.Metal2 0.171789176047
Rred_556 di_tg_ctrl.$370.Metal2 di_tg_ctrl.$459.Metal3 7.84722573955
Rred_557 di_tg_ctrl.$370.Metal2 di_tg_ctrl.$462.Metal3 27.69051793
Rred_558 di_tg_ctrl.$372.Metal2 di_tg_ctrl.$376.Metal2 0.350177776915
Rred_559 di_tg_ctrl.$372.Metal2 di_tg_ctrl.$459.Metal3 27.69051793
Rred_560 di_tg_ctrl.$372.Metal2 di_tg_ctrl.$462.Metal3 7.84736498652
Rred_561 di_tg_ctrl.$376.Metal2 di_tg_ctrl.$380.Metal2 0.350162918787
Rred_562 di_tg_ctrl.$376.Metal2 di_tg_ctrl.$462.Metal3 9.12864285024
Rred_563 di_tg_ctrl.$376.Metal2 di_tg_ctrl.$464.Metal3 9.12845009182
Rred_564 di_tg_ctrl.$380.Metal2 di_tg_ctrl.$382.Metal2 0.171789176047
Rred_565 di_tg_ctrl.$380.Metal2 di_tg_ctrl.$464.Metal3 7.84722254064
Rred_566 di_tg_ctrl.$380.Metal2 di_tg_ctrl.$467.Metal3 27.69051793
Rred_567 di_tg_ctrl.$382.Metal2 di_tg_ctrl.$386.Metal2 0.350175982317
Rred_568 di_tg_ctrl.$382.Metal2 di_tg_ctrl.$464.Metal3 27.69051793
Rred_569 di_tg_ctrl.$382.Metal2 di_tg_ctrl.$467.Metal3 7.84734778196
Rred_570 di_tg_ctrl.$386.Metal2 di_tg_ctrl.$467.Metal3 3.80325750669
Rred_571 di_tg_ctrl.$39.GatPoly di_tg_ctrl.$42.GatPoly 17.3428707176
Rred_572 di_tg_ctrl.$39.GatPoly di_tg_ctrl.P16.GatPoly 90.4615384615
Rred_573 di_tg_ctrl.$39.GatPoly di_tg_ctrl.P17.GatPoly 791.023243591
Rred_574 di_tg_ctrl.$394.Metal3 di_tg_ctrl.$397.Metal3 0.528610522178
Rred_575 di_tg_ctrl.$397.Metal3 di_tg_ctrl.$399.Metal3 0.346898882339
Rred_576 di_tg_ctrl.$399.Metal3 di_tg_ctrl.$402.Metal3 0.528610522178
Rred_577 di_tg_ctrl.$402.Metal3 di_tg_ctrl.$404.Metal3 0.346898882339
Rred_578 di_tg_ctrl.$404.Metal3 di_tg_ctrl.$407.Metal3 0.528610522178
Rred_579 di_tg_ctrl.$407.Metal3 di_tg_ctrl.$409.Metal3 0.346898882339
Rred_580 di_tg_ctrl.$409.Metal3 di_tg_ctrl.$413.Metal3 0.350088765223
Rred_581 di_tg_ctrl.$409.Metal3 di_tg_ctrl.$471.Metal4 6.22681902074
Rred_582 di_tg_ctrl.$413.Metal3 di_tg_ctrl.$417.Metal3 0.35004789942
Rred_583 di_tg_ctrl.$413.Metal3 di_tg_ctrl.$471.Metal4 5.84011255921
Rred_584 di_tg_ctrl.$417.Metal3 di_tg_ctrl.$419.Metal3 0.17180952381
Rred_585 di_tg_ctrl.$417.Metal3 di_tg_ctrl.$471.Metal4 22.5193589796
Rred_586 di_tg_ctrl.$419.Metal3 di_tg_ctrl.$423.Metal3 0.350002060736
Rred_587 di_tg_ctrl.$419.Metal3 di_tg_ctrl.$483.Metal4 26.3649692741
Rred_588 di_tg_ctrl.$42.GatPoly di_tg_ctrl.$44.GatPoly 10.9656296296
Rred_589 di_tg_ctrl.$42.GatPoly di_tg_ctrl.P17.GatPoly 110.017140972
Rred_590 di_tg_ctrl.$423.Metal3 di_tg_ctrl.$429.Metal3 0.541792472925
Rred_591 di_tg_ctrl.$423.Metal3 di_tg_ctrl.$483.Metal4 4.83308327342
Rred_592 di_tg_ctrl.$429.Metal3 di_tg_ctrl.$432.Metal3 0.528610522178
Rred_593 di_tg_ctrl.$429.Metal3 di_tg_ctrl.$483.Metal4 9.46034528664
Rred_594 di_tg_ctrl.$432.Metal3 di_tg_ctrl.$434.Metal3 0.346898882339
Rred_595 di_tg_ctrl.$434.Metal3 di_tg_ctrl.$437.Metal3 0.528610522178
Rred_596 di_tg_ctrl.$44.GatPoly di_tg_ctrl.$47.GatPoly 17.3428707176
Rred_597 di_tg_ctrl.$44.GatPoly di_tg_ctrl.P18.GatPoly 90.4615384615
Rred_598 di_tg_ctrl.$44.GatPoly di_tg_ctrl.P19.GatPoly 791.023243591
Rred_599 di_tg_ctrl.$446.Metal3 di_tg_ctrl.$450.Metal3 0.350080309309
Rred_600 di_tg_ctrl.$446.Metal3 di_tg_ctrl.$487.Metal4 2.96104545169
Rred_601 di_tg_ctrl.$446.Metal3 di_tg_ctrl.$495.Metal4 47.3395623215
Rred_602 di_tg_ctrl.$450.Metal3 di_tg_ctrl.$456.Metal3 0.54160811278
Rred_603 di_tg_ctrl.$450.Metal3 di_tg_ctrl.$487.Metal4 14.2779630485
Rred_604 di_tg_ctrl.$450.Metal3 di_tg_ctrl.$495.Metal4 5.04903798287
Rred_605 di_tg_ctrl.$456.Metal3 di_tg_ctrl.$459.Metal3 0.346898882339
Rred_606 di_tg_ctrl.$456.Metal3 di_tg_ctrl.$495.Metal4 4.77271718231
Rred_607 di_tg_ctrl.$459.Metal3 di_tg_ctrl.$462.Metal3 0.528610522178
Rred_608 di_tg_ctrl.$462.Metal3 di_tg_ctrl.$464.Metal3 0.346898882339
Rred_609 di_tg_ctrl.$464.Metal3 di_tg_ctrl.$467.Metal3 0.528610522178
Rred_610 di_tg_ctrl.$47.GatPoly di_tg_ctrl.$49.GatPoly 10.9656296296
Rred_611 di_tg_ctrl.$47.GatPoly di_tg_ctrl.P19.GatPoly 110.017140972
Rred_612 di_tg_ctrl.$471.Metal4 di_tg_ctrl.$487.Metal4 7.93593650614
Rred_613 di_tg_ctrl.$487.Metal4 di_tg_ctrl.$495.Metal4 0.542578221904
Rred_614 di_tg_ctrl.$49.GatPoly di_tg_ctrl.$52.GatPoly 17.3428707176
Rred_615 di_tg_ctrl.$49.GatPoly di_tg_ctrl.P20.GatPoly 90.4615384615
Rred_616 di_tg_ctrl.$49.GatPoly di_tg_ctrl.P21.GatPoly 791.023243591
Rred_617 di_tg_ctrl.$52.GatPoly di_tg_ctrl.$54.GatPoly 10.9656296296
Rred_618 di_tg_ctrl.$52.GatPoly di_tg_ctrl.P21.GatPoly 110.017140972
Rred_619 di_tg_ctrl.$54.GatPoly di_tg_ctrl.$57.GatPoly 17.3428707176
Rred_620 di_tg_ctrl.$54.GatPoly di_tg_ctrl.P22.GatPoly 90.4615384615
Rred_621 di_tg_ctrl.$54.GatPoly di_tg_ctrl.P23.GatPoly 791.023243591
Rred_622 di_tg_ctrl.$57.GatPoly di_tg_ctrl.$59.GatPoly 10.9656296296
Rred_623 di_tg_ctrl.$57.GatPoly di_tg_ctrl.P23.GatPoly 110.017140972
Rred_624 di_tg_ctrl.$59.GatPoly di_tg_ctrl.$62.GatPoly 17.3428707176
Rred_625 di_tg_ctrl.$59.GatPoly di_tg_ctrl.P24.GatPoly 90.4615384615
Rred_626 di_tg_ctrl.$59.GatPoly di_tg_ctrl.P25.GatPoly 791.023243591
Rred_627 di_tg_ctrl.$62.GatPoly di_tg_ctrl.$66.GatPoly 38.8461385453
Rred_628 di_tg_ctrl.$62.GatPoly di_tg_ctrl.P25.GatPoly 110.017140972
Rred_629 di_tg_ctrl.$62.GatPoly di_tg_ctrl.P26.GatPoly 246.426394462
Rred_630 di_tg_ctrl.$66.GatPoly di_tg_ctrl.$68.GatPoly 10.9656296296
Rred_631 di_tg_ctrl.$66.GatPoly di_tg_ctrl.P26.GatPoly 320.463263377
Rred_632 di_tg_ctrl.$66.GatPoly di_tg_ctrl.P27.GatPoly 90.4615384615
Rred_633 di_tg_ctrl.$68.GatPoly di_tg_ctrl.$71.GatPoly 17.3428707176
Rred_634 di_tg_ctrl.$68.GatPoly di_tg_ctrl.P28.GatPoly 110.017140972
Rred_635 di_tg_ctrl.$7.GatPoly di_tg_ctrl.$9.GatPoly 10.9656296296
Rred_636 di_tg_ctrl.$7.GatPoly di_tg_ctrl.P2.GatPoly 949.441810889
Rred_637 di_tg_ctrl.$7.GatPoly di_tg_ctrl.P3.GatPoly 108.578309915
Rred_638 di_tg_ctrl.$71.GatPoly di_tg_ctrl.$73.GatPoly 10.9656296296
Rred_639 di_tg_ctrl.$71.GatPoly di_tg_ctrl.P28.GatPoly 791.023243591
Rred_640 di_tg_ctrl.$71.GatPoly di_tg_ctrl.P29.GatPoly 90.4615384615
Rred_641 di_tg_ctrl.$73.GatPoly di_tg_ctrl.$76.GatPoly 17.3428707176
Rred_642 di_tg_ctrl.$73.GatPoly di_tg_ctrl.P30.GatPoly 110.017140972
Rred_643 di_tg_ctrl.$76.GatPoly di_tg_ctrl.$78.GatPoly 10.9656296296
Rred_644 di_tg_ctrl.$76.GatPoly di_tg_ctrl.P30.GatPoly 791.023243591
Rred_645 di_tg_ctrl.$76.GatPoly di_tg_ctrl.P31.GatPoly 90.4615384615
Rred_646 di_tg_ctrl.$78.GatPoly di_tg_ctrl.$82.GatPoly 20.8161349411
Rred_647 di_tg_ctrl.$78.GatPoly di_tg_ctrl.P32.GatPoly 108.578309915
Rred_648 di_tg_ctrl.$78.GatPoly di_tg_ctrl.P33.GatPoly 949.441810889
Rred_649 di_tg_ctrl.$82.GatPoly di_tg_ctrl.P32.GatPoly 949.441810889
Rred_650 di_tg_ctrl.$82.GatPoly di_tg_ctrl.P33.GatPoly 108.578309915
Rred_651 di_tg_ctrl.$82.GatPoly di_tg_ctrl.P34.GatPoly 200.739203905
Rred_652 di_tg_ctrl.$82.GatPoly di_tg_ctrl.P35.GatPoly 347.655072464
Rred_653 di_tg_ctrl.$87.GatPoly di_tg_ctrl.$90.GatPoly 14.6611036214
Rred_654 di_tg_ctrl.$87.GatPoly di_tg_ctrl.P36.GatPoly 381.426533219
Rred_655 di_tg_ctrl.$87.GatPoly di_tg_ctrl.P37.GatPoly 252
Rred_656 di_tg_ctrl.$9.GatPoly di_tg_ctrl.P4.GatPoly 90.4615384615
Rred_657 di_tg_ctrl.$9.GatPoly di_tg_ctrl.P5.GatPoly 791.023243591
Rred_658 di_tg_ctrl.$90.GatPoly di_tg_ctrl.$93.GatPoly 17.1424550154
Rred_659 di_tg_ctrl.$90.GatPoly di_tg_ctrl.P38.GatPoly 252
Rred_660 di_tg_ctrl.$90.GatPoly di_tg_ctrl.P39.GatPoly 2178.10016667
Rred_661 di_tg_ctrl.$93.GatPoly di_tg_ctrl.$97.GatPoly 37.7380623964
Rred_662 di_tg_ctrl.$93.GatPoly di_tg_ctrl.P39.GatPoly 302.934654613
Rred_663 di_tg_ctrl.$93.GatPoly di_tg_ctrl.P40.GatPoly 666.892045948
Rred_664 di_tg_ctrl.$97.GatPoly di_tg_ctrl.P40.GatPoly 867.254507503
Rred_665 di_tg_ctrl.$97.GatPoly di_tg_ctrl.P41.GatPoly 252
Rred_666 di_tg_ctrl.P0.GatPoly di_tg_ctrl.P1.GatPoly 2868.58477127
Rred_667 di_tg_ctrl.P2.GatPoly di_tg_ctrl.P3.GatPoly 43304.8572569
Rred_668 di_tg_ctrl.P32.GatPoly di_tg_ctrl.P33.GatPoly 43304.8572569
Rred_669 di_tg_ctrl.P34.GatPoly di_tg_ctrl.P35.GatPoly 2868.58477127
Rred_670 di_tg_ctrl_n di_tg_ctrl_n.$310.Metal2 1975.41137216
Rred_671 di_tg_ctrl_n di_tg_ctrl_n.$316.Metal2 1729.62920447
Rred_672 di_tg_ctrl_n di_tg_ctrl_n.$413.Metal3 22.6612095455
Rred_673 di_tg_ctrl_n di_tg_ctrl_n.$417.Metal3 8.47273663184
Rred_674 di_tg_ctrl_n di_tg_ctrl_n.$419.Metal3 8.04261042842
Rred_675 di_tg_ctrl_n di_tg_ctrl_n.$423.Metal3 16.4315869035
Rred_676 di_tg_ctrl_n di_tg_ctrl_n.$471.Metal4 0.528786356896
Rred_677 di_tg_ctrl_n di_tg_ctrl_n.$483.Metal4 0.624418285359
Rred_678 di_tg_ctrl_n.$103.GatPoly di_tg_ctrl_n.$105.GatPoly 10.9656296296
Rred_679 di_tg_ctrl_n.$103.GatPoly di_tg_ctrl_n.$238.Metal1 17.0210346997
Rred_680 di_tg_ctrl_n.$103.GatPoly di_tg_ctrl_n.$241.Metal1 22.2802284645
Rred_681 di_tg_ctrl_n.$103.GatPoly di_tg_ctrl_n.$366.Metal2 1903.40913269
Rred_682 di_tg_ctrl_n.$103.GatPoly di_tg_ctrl_n.$99.GatPoly 20.8161349411
Rred_683 di_tg_ctrl_n.$103.GatPoly di_tg_ctrl_n.P6.GatPoly 949.441810889
Rred_684 di_tg_ctrl_n.$103.GatPoly di_tg_ctrl_n.P7.GatPoly 108.578309915
Rred_685 di_tg_ctrl_n.$105.GatPoly di_tg_ctrl_n.$109.GatPoly 38.8461385453
Rred_686 di_tg_ctrl_n.$105.GatPoly di_tg_ctrl_n.$241.Metal1 20.7333333333
Rred_687 di_tg_ctrl_n.$105.GatPoly di_tg_ctrl_n.$243.Metal1 28.0359186568
Rred_688 di_tg_ctrl_n.$105.GatPoly di_tg_ctrl_n.$245.Metal1 73.4485812831
Rred_689 di_tg_ctrl_n.$105.GatPoly di_tg_ctrl_n.P8.GatPoly 90.4615384615
Rred_690 di_tg_ctrl_n.$105.GatPoly di_tg_ctrl_n.P9.GatPoly 320.463263377
Rred_691 di_tg_ctrl_n.$109.GatPoly di_tg_ctrl_n.$111.GatPoly 8.06341374657
Rred_692 di_tg_ctrl_n.$109.GatPoly di_tg_ctrl_n.$243.Metal1 97.9314417107
Rred_693 di_tg_ctrl_n.$109.GatPoly di_tg_ctrl_n.$245.Metal1 15.9172497747
Rred_694 di_tg_ctrl_n.$109.GatPoly di_tg_ctrl_n.$248.Metal1 30.6030419053
Rred_695 di_tg_ctrl_n.$109.GatPoly di_tg_ctrl_n.$372.Metal2 1889.78745154
Rred_696 di_tg_ctrl_n.$109.GatPoly di_tg_ctrl_n.P10.GatPoly 122.598717949
Rred_697 di_tg_ctrl_n.$109.GatPoly di_tg_ctrl_n.P9.GatPoly 246.426394462
Rred_698 di_tg_ctrl_n.$111.GatPoly di_tg_ctrl_n.$113.GatPoly 8.06378472222
Rred_699 di_tg_ctrl_n.$111.GatPoly di_tg_ctrl_n.$245.Metal1 2087.37438725
Rred_700 di_tg_ctrl_n.$111.GatPoly di_tg_ctrl_n.$248.Metal1 15.1142629303
Rred_701 di_tg_ctrl_n.$111.GatPoly di_tg_ctrl_n.$372.Metal2 130417.771633
Rred_702 di_tg_ctrl_n.$111.GatPoly di_tg_ctrl_n.P10.GatPoly 367.796153846
Rred_703 di_tg_ctrl_n.$111.GatPoly di_tg_ctrl_n.P11.GatPoly 367.796153846
Rred_704 di_tg_ctrl_n.$113.GatPoly di_tg_ctrl_n.$115.GatPoly 10.9656296296
Rred_705 di_tg_ctrl_n.$113.GatPoly di_tg_ctrl_n.$248.Metal1 30.1319501382
Rred_706 di_tg_ctrl_n.$113.GatPoly di_tg_ctrl_n.$252.Metal1 22.3982625001
Rred_707 di_tg_ctrl_n.$113.GatPoly di_tg_ctrl_n.$376.Metal2 1989.57191416
Rred_708 di_tg_ctrl_n.$113.GatPoly di_tg_ctrl_n.P11.GatPoly 122.598717949
Rred_709 di_tg_ctrl_n.$115.GatPoly di_tg_ctrl_n.$119.GatPoly 38.8461385453
Rred_710 di_tg_ctrl_n.$115.GatPoly di_tg_ctrl_n.$252.Metal1 20.7333333333
Rred_711 di_tg_ctrl_n.$115.GatPoly di_tg_ctrl_n.$254.Metal1 28.0359186568
Rred_712 di_tg_ctrl_n.$115.GatPoly di_tg_ctrl_n.$256.Metal1 73.4485812831
Rred_713 di_tg_ctrl_n.$115.GatPoly di_tg_ctrl_n.P12.GatPoly 90.4615384615
Rred_714 di_tg_ctrl_n.$115.GatPoly di_tg_ctrl_n.P13.GatPoly 320.463263377
Rred_715 di_tg_ctrl_n.$119.GatPoly di_tg_ctrl_n.$121.GatPoly 8.06268900155
Rred_716 di_tg_ctrl_n.$119.GatPoly di_tg_ctrl_n.$254.Metal1 97.9314417107
Rred_717 di_tg_ctrl_n.$119.GatPoly di_tg_ctrl_n.$256.Metal1 15.8018064615
Rred_718 di_tg_ctrl_n.$119.GatPoly di_tg_ctrl_n.$259.Metal1 31.0808130115
Rred_719 di_tg_ctrl_n.$119.GatPoly di_tg_ctrl_n.$382.Metal2 1798.51112443
Rred_720 di_tg_ctrl_n.$119.GatPoly di_tg_ctrl_n.P13.GatPoly 246.426394462
Rred_721 di_tg_ctrl_n.$119.GatPoly di_tg_ctrl_n.P14.GatPoly 122.598717949
Rred_722 di_tg_ctrl_n.$121.GatPoly di_tg_ctrl_n.$123.GatPoly 8.06378472222
Rred_723 di_tg_ctrl_n.$121.GatPoly di_tg_ctrl_n.$256.Metal1 706.388766599
Rred_724 di_tg_ctrl_n.$121.GatPoly di_tg_ctrl_n.$259.Metal1 15.3429438207
Rred_725 di_tg_ctrl_n.$121.GatPoly di_tg_ctrl_n.$382.Metal2 42586.1170293
Rred_726 di_tg_ctrl_n.$121.GatPoly di_tg_ctrl_n.P14.GatPoly 367.796153846
Rred_727 di_tg_ctrl_n.$121.GatPoly di_tg_ctrl_n.P15.GatPoly 367.796153846
Rred_728 di_tg_ctrl_n.$123.GatPoly di_tg_ctrl_n.$124.GatPoly 7.92454647125
Rred_729 di_tg_ctrl_n.$123.GatPoly di_tg_ctrl_n.$259.Metal1 25.2290771499
Rred_730 di_tg_ctrl_n.$123.GatPoly di_tg_ctrl_n.$264.Metal1 38.7266685517
Rred_731 di_tg_ctrl_n.$123.GatPoly di_tg_ctrl_n.$386.Metal2 1617.46850292
Rred_732 di_tg_ctrl_n.$123.GatPoly di_tg_ctrl_n.P15.GatPoly 122.598717949
Rred_733 di_tg_ctrl_n.$124.GatPoly di_tg_ctrl_n.$259.Metal1 81.2010792213
Rred_734 di_tg_ctrl_n.$124.GatPoly di_tg_ctrl_n.$264.Metal1 10.6101329096
Rred_735 di_tg_ctrl_n.$124.GatPoly di_tg_ctrl_n.$386.Metal2 3394.89556798
Rred_736 di_tg_ctrl_n.$124.GatPoly di_tg_ctrl_n.P16.GatPoly 101.790249031
Rred_737 di_tg_ctrl_n.$124.GatPoly di_tg_ctrl_n.P17.GatPoly 176.420733613
Rred_738 di_tg_ctrl_n.$128.Metal1 di_tg_ctrl_n.$130.Metal1 0.215132967211
Rred_739 di_tg_ctrl_n.$128.Metal1 di_tg_ctrl_n.$2.GatPoly 10.3547275329
Rred_740 di_tg_ctrl_n.$128.Metal1 di_tg_ctrl_n.$270.Metal2 9.96667791072
Rred_741 di_tg_ctrl_n.$128.Metal1 di_tg_ctrl_n.$272.Metal2 10732.7449825
Rred_742 di_tg_ctrl_n.$128.Metal1 di_tg_ctrl_n.$394.Metal3 204.887533846
Rred_743 di_tg_ctrl_n.$128.Metal1 di_tg_ctrl_n.P18.GatPoly 800.597140619
Rred_744 di_tg_ctrl_n.$128.Metal1 di_tg_ctrl_n.P19.GatPoly 3009.51627665
Rred_745 di_tg_ctrl_n.$13.GatPoly di_tg_ctrl_n.$138.Metal1 95.1379724279
Rred_746 di_tg_ctrl_n.$13.GatPoly di_tg_ctrl_n.$140.Metal1 15.8462237797
Rred_747 di_tg_ctrl_n.$13.GatPoly di_tg_ctrl_n.$143.Metal1 17.872042696
Rred_748 di_tg_ctrl_n.$13.GatPoly di_tg_ctrl_n.$16.GatPoly 17.1424550154
Rred_749 di_tg_ctrl_n.$13.GatPoly di_tg_ctrl_n.$278.Metal2 1563.02782058
Rred_750 di_tg_ctrl_n.$13.GatPoly di_tg_ctrl_n.$9.GatPoly 37.7380623964
Rred_751 di_tg_ctrl_n.$13.GatPoly di_tg_ctrl_n.P23.GatPoly 666.892045948
Rred_752 di_tg_ctrl_n.$13.GatPoly di_tg_ctrl_n.P24.GatPoly 302.934654613
Rred_753 di_tg_ctrl_n.$130.Metal1 di_tg_ctrl_n.$132.Metal1 0.180559146049
Rred_754 di_tg_ctrl_n.$130.Metal1 di_tg_ctrl_n.$2.GatPoly 23.8041282938
Rred_755 di_tg_ctrl_n.$130.Metal1 di_tg_ctrl_n.$270.Metal2 9.6273019118
Rred_756 di_tg_ctrl_n.$130.Metal1 di_tg_ctrl_n.$272.Metal2 15946.9046903
Rred_757 di_tg_ctrl_n.$130.Metal1 di_tg_ctrl_n.$394.Metal3 304.425566788
Rred_758 di_tg_ctrl_n.$130.Metal1 di_tg_ctrl_n.$6.GatPoly 72.4122606103
Rred_759 di_tg_ctrl_n.$130.Metal1 di_tg_ctrl_n.P20.GatPoly 1279.64070129
Rred_760 di_tg_ctrl_n.$132.Metal1 di_tg_ctrl_n.$134.Metal1 0.178640180146
Rred_761 di_tg_ctrl_n.$132.Metal1 di_tg_ctrl_n.$2.GatPoly 91.3215770751
Rred_762 di_tg_ctrl_n.$132.Metal1 di_tg_ctrl_n.$270.Metal2 11.1613203463
Rred_763 di_tg_ctrl_n.$132.Metal1 di_tg_ctrl_n.$6.GatPoly 27.699010556
Rred_764 di_tg_ctrl_n.$132.Metal1 di_tg_ctrl_n.P20.GatPoly 2132.71615364
Rred_765 di_tg_ctrl_n.$134.Metal1 di_tg_ctrl_n.$136.Metal1 0.178900772311
Rred_766 di_tg_ctrl_n.$134.Metal1 di_tg_ctrl_n.$270.Metal2 47.2209706961
Rred_767 di_tg_ctrl_n.$134.Metal1 di_tg_ctrl_n.$272.Metal2 14.997543554
Rred_768 di_tg_ctrl_n.$134.Metal1 di_tg_ctrl_n.$6.GatPoly 20.0550777063
Rred_769 di_tg_ctrl_n.$134.Metal1 di_tg_ctrl_n.$9.GatPoly 110.882296296
Rred_770 di_tg_ctrl_n.$136.Metal1 di_tg_ctrl_n.$138.Metal1 0.178931043267
Rred_771 di_tg_ctrl_n.$136.Metal1 di_tg_ctrl_n.$272.Metal2 15.2778745337
Rred_772 di_tg_ctrl_n.$136.Metal1 di_tg_ctrl_n.$276.Metal2 46.4155560695
Rred_773 di_tg_ctrl_n.$136.Metal1 di_tg_ctrl_n.$394.Metal3 2431.41355242
Rred_774 di_tg_ctrl_n.$136.Metal1 di_tg_ctrl_n.$6.GatPoly 110.882296296
Rred_775 di_tg_ctrl_n.$136.Metal1 di_tg_ctrl_n.$9.GatPoly 20.0550777063
Rred_776 di_tg_ctrl_n.$138.Metal1 di_tg_ctrl_n.$140.Metal1 0.17846294993
Rred_777 di_tg_ctrl_n.$138.Metal1 di_tg_ctrl_n.$272.Metal2 30.5663418019
Rred_778 di_tg_ctrl_n.$138.Metal1 di_tg_ctrl_n.$276.Metal2 18.5553695604
Rred_779 di_tg_ctrl_n.$138.Metal1 di_tg_ctrl_n.$394.Metal3 1601.17477842
Rred_780 di_tg_ctrl_n.$138.Metal1 di_tg_ctrl_n.$9.GatPoly 27.8558623939
Rred_781 di_tg_ctrl_n.$138.Metal1 di_tg_ctrl_n.P23.GatPoly 2186.35590127
Rred_782 di_tg_ctrl_n.$140.Metal1 di_tg_ctrl_n.$143.Metal1 0.36182906056
Rred_783 di_tg_ctrl_n.$140.Metal1 di_tg_ctrl_n.$276.Metal2 11.1613203463
Rred_784 di_tg_ctrl_n.$140.Metal1 di_tg_ctrl_n.$278.Metal2 18.5578541237
Rred_785 di_tg_ctrl_n.$140.Metal1 di_tg_ctrl_n.$9.GatPoly 71.353479321
Rred_786 di_tg_ctrl_n.$140.Metal1 di_tg_ctrl_n.P23.GatPoly 1260.93033898
Rred_787 di_tg_ctrl_n.$143.Metal1 di_tg_ctrl_n.$145.Metal1 0.178695477582
Rred_788 di_tg_ctrl_n.$143.Metal1 di_tg_ctrl_n.$16.GatPoly 32.222005523
Rred_789 di_tg_ctrl_n.$143.Metal1 di_tg_ctrl_n.$278.Metal2 10.2196800814
Rred_790 di_tg_ctrl_n.$143.Metal1 di_tg_ctrl_n.$282.Metal2 23.6145307349
Rred_791 di_tg_ctrl_n.$143.Metal1 di_tg_ctrl_n.$397.Metal3 1237.0139437
Rred_792 di_tg_ctrl_n.$143.Metal1 di_tg_ctrl_n.P24.GatPoly 5491.00882354
Rred_793 di_tg_ctrl_n.$145.Metal1 di_tg_ctrl_n.$147.Metal1 0.178919056269
Rred_794 di_tg_ctrl_n.$145.Metal1 di_tg_ctrl_n.$16.GatPoly 20.0550777063
Rred_795 di_tg_ctrl_n.$145.Metal1 di_tg_ctrl_n.$19.GatPoly 110.882296296
Rred_796 di_tg_ctrl_n.$145.Metal1 di_tg_ctrl_n.$278.Metal2 83.4380085969
Rred_797 di_tg_ctrl_n.$145.Metal1 di_tg_ctrl_n.$282.Metal2 13.2619867392
Rred_798 di_tg_ctrl_n.$145.Metal1 di_tg_ctrl_n.$397.Metal3 4370.7826011
Rred_799 di_tg_ctrl_n.$147.Metal1 di_tg_ctrl_n.$149.Metal1 0.178906882684
Rred_800 di_tg_ctrl_n.$147.Metal1 di_tg_ctrl_n.$16.GatPoly 110.882296296
Rred_801 di_tg_ctrl_n.$147.Metal1 di_tg_ctrl_n.$19.GatPoly 20.0550777063
Rred_802 di_tg_ctrl_n.$147.Metal1 di_tg_ctrl_n.$282.Metal2 14.901201938
Rred_803 di_tg_ctrl_n.$147.Metal1 di_tg_ctrl_n.$286.Metal2 50.1220317964
Rred_804 di_tg_ctrl_n.$147.Metal1 di_tg_ctrl_n.$399.Metal3 2625.57206472
Rred_805 di_tg_ctrl_n.$149.Metal1 di_tg_ctrl_n.$153.Metal1 0.36174266925
Rred_806 di_tg_ctrl_n.$149.Metal1 di_tg_ctrl_n.$19.GatPoly 32.222005523
Rred_807 di_tg_ctrl_n.$149.Metal1 di_tg_ctrl_n.$22.GatPoly 17.8695399574
Rred_808 di_tg_ctrl_n.$149.Metal1 di_tg_ctrl_n.$282.Metal2 29.1407161607
Rred_809 di_tg_ctrl_n.$149.Metal1 di_tg_ctrl_n.$286.Metal2 10.2068763727
Rred_810 di_tg_ctrl_n.$149.Metal1 di_tg_ctrl_n.$399.Metal3 1526.49538646
Rred_811 di_tg_ctrl_n.$149.Metal1 di_tg_ctrl_n.P27.GatPoly 5491.00882354
Rred_812 di_tg_ctrl_n.$153.Metal1 di_tg_ctrl_n.$154.Metal1 0.178067413564
Rred_813 di_tg_ctrl_n.$153.Metal1 di_tg_ctrl_n.$22.GatPoly 15.8245339788
Rred_814 di_tg_ctrl_n.$153.Metal1 di_tg_ctrl_n.$26.GatPoly 71.353479321
Rred_815 di_tg_ctrl_n.$153.Metal1 di_tg_ctrl_n.$286.Metal2 21.8084097251
Rred_816 di_tg_ctrl_n.$153.Metal1 di_tg_ctrl_n.$288.Metal2 9.42324175824
Rred_817 di_tg_ctrl_n.$153.Metal1 di_tg_ctrl_n.P28.GatPoly 1260.93033898
Rred_818 di_tg_ctrl_n.$154.Metal1 di_tg_ctrl_n.$156.Metal1 0.178749838894
Rred_819 di_tg_ctrl_n.$154.Metal1 di_tg_ctrl_n.$22.GatPoly 95.1379724279
Rred_820 di_tg_ctrl_n.$154.Metal1 di_tg_ctrl_n.$26.GatPoly 27.8558623939
Rred_821 di_tg_ctrl_n.$154.Metal1 di_tg_ctrl_n.$288.Metal2 21.9133432853
Rred_822 di_tg_ctrl_n.$154.Metal1 di_tg_ctrl_n.$292.Metal2 24.5480563064
Rred_823 di_tg_ctrl_n.$154.Metal1 di_tg_ctrl_n.$402.Metal3 1285.91536638
Rred_824 di_tg_ctrl_n.$154.Metal1 di_tg_ctrl_n.P28.GatPoly 2186.35590127
Rred_825 di_tg_ctrl_n.$156.Metal1 di_tg_ctrl_n.$158.Metal1 0.178931245573
Rred_826 di_tg_ctrl_n.$156.Metal1 di_tg_ctrl_n.$26.GatPoly 20.0550777063
Rred_827 di_tg_ctrl_n.$156.Metal1 di_tg_ctrl_n.$288.Metal2 73.644168919
Rred_828 di_tg_ctrl_n.$156.Metal1 di_tg_ctrl_n.$29.GatPoly 110.882296296
Rred_829 di_tg_ctrl_n.$156.Metal1 di_tg_ctrl_n.$292.Metal2 13.5609744942
Rred_830 di_tg_ctrl_n.$156.Metal1 di_tg_ctrl_n.$402.Metal3 3857.74609913
Rred_831 di_tg_ctrl_n.$158.Metal1 di_tg_ctrl_n.$160.Metal1 0.178876681955
Rred_832 di_tg_ctrl_n.$158.Metal1 di_tg_ctrl_n.$26.GatPoly 110.882296296
Rred_833 di_tg_ctrl_n.$158.Metal1 di_tg_ctrl_n.$29.GatPoly 20.0550777063
Rred_834 di_tg_ctrl_n.$158.Metal1 di_tg_ctrl_n.$292.Metal2 14.5423931418
Rred_835 di_tg_ctrl_n.$158.Metal1 di_tg_ctrl_n.$296.Metal2 54.4712726609
Rred_836 di_tg_ctrl_n.$158.Metal1 di_tg_ctrl_n.$404.Metal3 2853.40092375
Rred_837 di_tg_ctrl_n.$16.GatPoly di_tg_ctrl_n.$19.GatPoly 14.6611036214
Rred_838 di_tg_ctrl_n.$16.GatPoly di_tg_ctrl_n.P24.GatPoly 2178.10016667
Rred_839 di_tg_ctrl_n.$16.GatPoly di_tg_ctrl_n.P25.GatPoly 252
Rred_840 di_tg_ctrl_n.$160.Metal1 di_tg_ctrl_n.$163.Metal1 0.361772286805
Rred_841 di_tg_ctrl_n.$160.Metal1 di_tg_ctrl_n.$29.GatPoly 32.222005523
Rred_842 di_tg_ctrl_n.$160.Metal1 di_tg_ctrl_n.$292.Metal2 27.8408726934
Rred_843 di_tg_ctrl_n.$160.Metal1 di_tg_ctrl_n.$296.Metal2 10.2100987226
Rred_844 di_tg_ctrl_n.$160.Metal1 di_tg_ctrl_n.$32.GatPoly 17.8703980276
Rred_845 di_tg_ctrl_n.$160.Metal1 di_tg_ctrl_n.$404.Metal3 1458.40491658
Rred_846 di_tg_ctrl_n.$160.Metal1 di_tg_ctrl_n.P31.GatPoly 5491.00882354
Rred_847 di_tg_ctrl_n.$163.Metal1 di_tg_ctrl_n.$165.Metal1 0.178158691342
Rred_848 di_tg_ctrl_n.$163.Metal1 di_tg_ctrl_n.$296.Metal2 21.0708666274
Rred_849 di_tg_ctrl_n.$163.Metal1 di_tg_ctrl_n.$298.Metal2 9.72738095238
Rred_850 di_tg_ctrl_n.$163.Metal1 di_tg_ctrl_n.$32.GatPoly 15.8285860769
Rred_851 di_tg_ctrl_n.$163.Metal1 di_tg_ctrl_n.$36.GatPoly 71.353479321
Rred_852 di_tg_ctrl_n.$163.Metal1 di_tg_ctrl_n.P32.GatPoly 1260.93033898
Rred_853 di_tg_ctrl_n.$165.Metal1 di_tg_ctrl_n.$167.Metal1 0.17879816006
Rred_854 di_tg_ctrl_n.$165.Metal1 di_tg_ctrl_n.$298.Metal2 21.1473384556
Rred_855 di_tg_ctrl_n.$165.Metal1 di_tg_ctrl_n.$302.Metal2 25.5569246849
Rred_856 di_tg_ctrl_n.$165.Metal1 di_tg_ctrl_n.$32.GatPoly 95.1379724279
Rred_857 di_tg_ctrl_n.$165.Metal1 di_tg_ctrl_n.$36.GatPoly 27.8558623939
Rred_858 di_tg_ctrl_n.$165.Metal1 di_tg_ctrl_n.$407.Metal3 1338.76351592
Rred_859 di_tg_ctrl_n.$165.Metal1 di_tg_ctrl_n.P32.GatPoly 2186.35590127
Rred_860 di_tg_ctrl_n.$167.Metal1 di_tg_ctrl_n.$169.Metal1 0.178937340225
Rred_861 di_tg_ctrl_n.$167.Metal1 di_tg_ctrl_n.$298.Metal2 65.9099636609
Rred_862 di_tg_ctrl_n.$167.Metal1 di_tg_ctrl_n.$302.Metal2 13.8733837162
Rred_863 di_tg_ctrl_n.$167.Metal1 di_tg_ctrl_n.$36.GatPoly 20.0550777063
Rred_864 di_tg_ctrl_n.$167.Metal1 di_tg_ctrl_n.$39.GatPoly 110.882296296
Rred_865 di_tg_ctrl_n.$167.Metal1 di_tg_ctrl_n.$407.Metal3 3452.60064631
Rred_866 di_tg_ctrl_n.$169.Metal1 di_tg_ctrl_n.$171.Metal1 0.17884044108
Rred_867 di_tg_ctrl_n.$169.Metal1 di_tg_ctrl_n.$302.Metal2 14.2001726877
Rred_868 di_tg_ctrl_n.$169.Metal1 di_tg_ctrl_n.$306.Metal2 59.6469258452
Rred_869 di_tg_ctrl_n.$169.Metal1 di_tg_ctrl_n.$36.GatPoly 110.882296296
Rred_870 di_tg_ctrl_n.$169.Metal1 di_tg_ctrl_n.$39.GatPoly 20.0550777063
Rred_871 di_tg_ctrl_n.$169.Metal1 di_tg_ctrl_n.$409.Metal3 3124.52022858
Rred_872 di_tg_ctrl_n.$171.Metal1 di_tg_ctrl_n.$174.Metal1 0.361795734713
Rred_873 di_tg_ctrl_n.$171.Metal1 di_tg_ctrl_n.$302.Metal2 26.6507541011
Rred_874 di_tg_ctrl_n.$171.Metal1 di_tg_ctrl_n.$306.Metal2 10.2129991727
Rred_875 di_tg_ctrl_n.$171.Metal1 di_tg_ctrl_n.$39.GatPoly 32.222005523
Rred_876 di_tg_ctrl_n.$171.Metal1 di_tg_ctrl_n.$409.Metal3 1396.06222979
Rred_877 di_tg_ctrl_n.$171.Metal1 di_tg_ctrl_n.$42.GatPoly 17.8710773116
Rred_878 di_tg_ctrl_n.$171.Metal1 di_tg_ctrl_n.P35.GatPoly 5491.00882354
Rred_879 di_tg_ctrl_n.$174.Metal1 di_tg_ctrl_n.$176.Metal1 0.178240841752
Rred_880 di_tg_ctrl_n.$174.Metal1 di_tg_ctrl_n.$306.Metal2 10.2166786029
Rred_881 di_tg_ctrl_n.$174.Metal1 di_tg_ctrl_n.$310.Metal2 20.4856411611
Rred_882 di_tg_ctrl_n.$174.Metal1 di_tg_ctrl_n.$413.Metal3 1073.1114688
Rred_883 di_tg_ctrl_n.$174.Metal1 di_tg_ctrl_n.$42.GatPoly 15.8327806823
Rred_884 di_tg_ctrl_n.$174.Metal1 di_tg_ctrl_n.$46.GatPoly 71.353479321
Rred_885 di_tg_ctrl_n.$174.Metal1 di_tg_ctrl_n.P36.GatPoly 1260.93033898
Rred_886 di_tg_ctrl_n.$176.Metal1 di_tg_ctrl_n.$178.Metal1 0.178847486772
Rred_887 di_tg_ctrl_n.$176.Metal1 di_tg_ctrl_n.$306.Metal2 178.517730119
Rred_888 di_tg_ctrl_n.$176.Metal1 di_tg_ctrl_n.$310.Metal2 12.1838216983
Rred_889 di_tg_ctrl_n.$176.Metal1 di_tg_ctrl_n.$413.Metal3 9351.39994245
Rred_890 di_tg_ctrl_n.$176.Metal1 di_tg_ctrl_n.$42.GatPoly 95.1379724279
Rred_891 di_tg_ctrl_n.$176.Metal1 di_tg_ctrl_n.$46.GatPoly 27.8558623939
Rred_892 di_tg_ctrl_n.$176.Metal1 di_tg_ctrl_n.P36.GatPoly 2186.35590127
Rred_893 di_tg_ctrl_n.$178.Metal1 di_tg_ctrl_n.$180.Metal1 0.178929098784
Rred_894 di_tg_ctrl_n.$178.Metal1 di_tg_ctrl_n.$310.Metal2 16.5299544001
Rred_895 di_tg_ctrl_n.$178.Metal1 di_tg_ctrl_n.$314.Metal2 37.9840558281
Rred_896 di_tg_ctrl_n.$178.Metal1 di_tg_ctrl_n.$417.Metal3 1989.74128367
Rred_897 di_tg_ctrl_n.$178.Metal1 di_tg_ctrl_n.$46.GatPoly 20.0550777063
Rred_898 di_tg_ctrl_n.$178.Metal1 di_tg_ctrl_n.$49.GatPoly 110.882296296
Rred_899 di_tg_ctrl_n.$180.Metal1 di_tg_ctrl_n.$182.Metal1 0.178804805996
Rred_900 di_tg_ctrl_n.$180.Metal1 di_tg_ctrl_n.$310.Metal2 35.8135383522
Rred_901 di_tg_ctrl_n.$180.Metal1 di_tg_ctrl_n.$314.Metal2 16.9938112858
Rred_902 di_tg_ctrl_n.$180.Metal1 di_tg_ctrl_n.$417.Metal3 1876.04178175
Rred_903 di_tg_ctrl_n.$180.Metal1 di_tg_ctrl_n.$46.GatPoly 110.882296296
Rred_904 di_tg_ctrl_n.$180.Metal1 di_tg_ctrl_n.$49.GatPoly 20.0550777063
Rred_905 di_tg_ctrl_n.$182.Metal1 di_tg_ctrl_n.$185.Metal1 0.361813012975
Rred_906 di_tg_ctrl_n.$182.Metal1 di_tg_ctrl_n.$314.Metal2 12.5395578231
Rred_907 di_tg_ctrl_n.$182.Metal1 di_tg_ctrl_n.$316.Metal2 17.0179562826
Rred_908 di_tg_ctrl_n.$182.Metal1 di_tg_ctrl_n.$49.GatPoly 32.222005523
Rred_909 di_tg_ctrl_n.$182.Metal1 di_tg_ctrl_n.$52.GatPoly 17.8715778382
Rred_910 di_tg_ctrl_n.$182.Metal1 di_tg_ctrl_n.P39.GatPoly 5491.00882354
Rred_911 di_tg_ctrl_n.$185.Metal1 di_tg_ctrl_n.$187.Metal1 0.17831920808
Rred_912 di_tg_ctrl_n.$185.Metal1 di_tg_ctrl_n.$316.Metal2 10.2182444783
Rred_913 di_tg_ctrl_n.$185.Metal1 di_tg_ctrl_n.$320.Metal2 21.1893910588
Rred_914 di_tg_ctrl_n.$185.Metal1 di_tg_ctrl_n.$423.Metal3 1109.97641633
Rred_915 di_tg_ctrl_n.$185.Metal1 di_tg_ctrl_n.$52.GatPoly 15.8371182074
Rred_916 di_tg_ctrl_n.$185.Metal1 di_tg_ctrl_n.$56.GatPoly 71.353479321
Rred_917 di_tg_ctrl_n.$185.Metal1 di_tg_ctrl_n.P40.GatPoly 1260.93033898
Rred_918 di_tg_ctrl_n.$187.Metal1 di_tg_ctrl_n.$189.Metal1 0.178884070295
Rred_919 di_tg_ctrl_n.$187.Metal1 di_tg_ctrl_n.$316.Metal2 138.908230275
Rred_920 di_tg_ctrl_n.$187.Metal1 di_tg_ctrl_n.$320.Metal2 12.4371668616
Rred_921 di_tg_ctrl_n.$187.Metal1 di_tg_ctrl_n.$423.Metal3 7276.51206261
Rred_922 di_tg_ctrl_n.$187.Metal1 di_tg_ctrl_n.$52.GatPoly 95.1379724279
Rred_923 di_tg_ctrl_n.$187.Metal1 di_tg_ctrl_n.$56.GatPoly 27.8558623939
Rred_924 di_tg_ctrl_n.$187.Metal1 di_tg_ctrl_n.P40.GatPoly 2186.35590127
Rred_925 di_tg_ctrl_n.$189.Metal1 di_tg_ctrl_n.$191.Metal1 0.178931245573
Rred_926 di_tg_ctrl_n.$189.Metal1 di_tg_ctrl_n.$320.Metal2 26.726552795
Rred_927 di_tg_ctrl_n.$189.Metal1 di_tg_ctrl_n.$322.Metal2 19.8388402458
Rred_928 di_tg_ctrl_n.$189.Metal1 di_tg_ctrl_n.$56.GatPoly 20.0550777063
Rred_929 di_tg_ctrl_n.$189.Metal1 di_tg_ctrl_n.$59.GatPoly 110.882296296
Rred_930 di_tg_ctrl_n.$19.GatPoly di_tg_ctrl_n.$22.GatPoly 17.1424550154
Rred_931 di_tg_ctrl_n.$19.GatPoly di_tg_ctrl_n.P26.GatPoly 252
Rred_932 di_tg_ctrl_n.$19.GatPoly di_tg_ctrl_n.P27.GatPoly 2178.10016667
Rred_933 di_tg_ctrl_n.$191.Metal1 di_tg_ctrl_n.$193.Metal1 0.178749838894
Rred_934 di_tg_ctrl_n.$191.Metal1 di_tg_ctrl_n.$322.Metal2 13.5609744942
Rred_935 di_tg_ctrl_n.$191.Metal1 di_tg_ctrl_n.$326.Metal2 73.644168919
Rred_936 di_tg_ctrl_n.$191.Metal1 di_tg_ctrl_n.$429.Metal3 3857.74609913
Rred_937 di_tg_ctrl_n.$191.Metal1 di_tg_ctrl_n.$56.GatPoly 110.882296296
Rred_938 di_tg_ctrl_n.$191.Metal1 di_tg_ctrl_n.$59.GatPoly 20.0550777063
Rred_939 di_tg_ctrl_n.$193.Metal1 di_tg_ctrl_n.$196.Metal1 0.361824121591
Rred_940 di_tg_ctrl_n.$193.Metal1 di_tg_ctrl_n.$322.Metal2 24.5480563064
Rred_941 di_tg_ctrl_n.$193.Metal1 di_tg_ctrl_n.$326.Metal2 10.2177987813
Rred_942 di_tg_ctrl_n.$193.Metal1 di_tg_ctrl_n.$429.Metal3 1285.91536638
Rred_943 di_tg_ctrl_n.$193.Metal1 di_tg_ctrl_n.$59.GatPoly 32.222005523
Rred_944 di_tg_ctrl_n.$193.Metal1 di_tg_ctrl_n.$62.GatPoly 17.8718996284
Rred_945 di_tg_ctrl_n.$193.Metal1 di_tg_ctrl_n.P43.GatPoly 5491.00882354
Rred_946 di_tg_ctrl_n.$196.Metal1 di_tg_ctrl_n.$198.Metal1 0.178396013129
Rred_947 di_tg_ctrl_n.$196.Metal1 di_tg_ctrl_n.$326.Metal2 19.1286039107
Rred_948 di_tg_ctrl_n.$196.Metal1 di_tg_ctrl_n.$328.Metal2 10.7656516291
Rred_949 di_tg_ctrl_n.$196.Metal1 di_tg_ctrl_n.$62.GatPoly 15.8415990873
Rred_950 di_tg_ctrl_n.$196.Metal1 di_tg_ctrl_n.$66.GatPoly 71.353479321
Rred_951 di_tg_ctrl_n.$196.Metal1 di_tg_ctrl_n.P44.GatPoly 1260.93033898
Rred_952 di_tg_ctrl_n.$198.Metal1 di_tg_ctrl_n.$200.Metal1 0.178906882684
Rred_953 di_tg_ctrl_n.$198.Metal1 di_tg_ctrl_n.$328.Metal2 19.1416854328
Rred_954 di_tg_ctrl_n.$198.Metal1 di_tg_ctrl_n.$332.Metal2 29.1407161607
Rred_955 di_tg_ctrl_n.$198.Metal1 di_tg_ctrl_n.$432.Metal3 1526.49538646
Rred_956 di_tg_ctrl_n.$198.Metal1 di_tg_ctrl_n.$62.GatPoly 95.1379724279
Rred_957 di_tg_ctrl_n.$198.Metal1 di_tg_ctrl_n.$66.GatPoly 27.8558623939
Rred_958 di_tg_ctrl_n.$198.Metal1 di_tg_ctrl_n.P44.GatPoly 2186.35590127
Rred_959 di_tg_ctrl_n.$2.GatPoly di_tg_ctrl_n.$6.GatPoly 37.7365025757
Rred_960 di_tg_ctrl_n.$2.GatPoly di_tg_ctrl_n.P18.GatPoly 422.020958681
Rred_961 di_tg_ctrl_n.$2.GatPoly di_tg_ctrl_n.P19.GatPoly 278.623086049
Rred_962 di_tg_ctrl_n.$2.GatPoly di_tg_ctrl_n.P20.GatPoly 666.864481416
Rred_963 di_tg_ctrl_n.$200.Metal1 di_tg_ctrl_n.$202.Metal1 0.178919056269
Rred_964 di_tg_ctrl_n.$200.Metal1 di_tg_ctrl_n.$328.Metal2 50.1220317964
Rred_965 di_tg_ctrl_n.$200.Metal1 di_tg_ctrl_n.$332.Metal2 14.901201938
Rred_966 di_tg_ctrl_n.$200.Metal1 di_tg_ctrl_n.$432.Metal3 2625.57206472
Rred_967 di_tg_ctrl_n.$200.Metal1 di_tg_ctrl_n.$66.GatPoly 20.0550777063
Rred_968 di_tg_ctrl_n.$200.Metal1 di_tg_ctrl_n.$69.GatPoly 110.882296296
Rred_969 di_tg_ctrl_n.$202.Metal1 di_tg_ctrl_n.$204.Metal1 0.178695477582
Rred_970 di_tg_ctrl_n.$202.Metal1 di_tg_ctrl_n.$332.Metal2 13.2619867392
Rred_971 di_tg_ctrl_n.$202.Metal1 di_tg_ctrl_n.$336.Metal2 83.4380085969
Rred_972 di_tg_ctrl_n.$202.Metal1 di_tg_ctrl_n.$434.Metal3 4370.7826011
Rred_973 di_tg_ctrl_n.$202.Metal1 di_tg_ctrl_n.$66.GatPoly 110.882296296
Rred_974 di_tg_ctrl_n.$202.Metal1 di_tg_ctrl_n.$69.GatPoly 20.0550777063
Rred_975 di_tg_ctrl_n.$204.Metal1 di_tg_ctrl_n.$207.Metal1 0.36182906056
Rred_976 di_tg_ctrl_n.$204.Metal1 di_tg_ctrl_n.$332.Metal2 23.6145307349
Rred_977 di_tg_ctrl_n.$204.Metal1 di_tg_ctrl_n.$336.Metal2 10.2196800814
Rred_978 di_tg_ctrl_n.$204.Metal1 di_tg_ctrl_n.$434.Metal3 1237.0139437
Rred_979 di_tg_ctrl_n.$204.Metal1 di_tg_ctrl_n.$69.GatPoly 32.222005523
Rred_980 di_tg_ctrl_n.$204.Metal1 di_tg_ctrl_n.$72.GatPoly 17.872042696
Rred_981 di_tg_ctrl_n.$204.Metal1 di_tg_ctrl_n.P47.GatPoly 5491.00882354
Rred_982 di_tg_ctrl_n.$207.Metal1 di_tg_ctrl_n.$209.Metal1 0.17846294993
Rred_983 di_tg_ctrl_n.$207.Metal1 di_tg_ctrl_n.$336.Metal2 18.5578541237
Rred_984 di_tg_ctrl_n.$207.Metal1 di_tg_ctrl_n.$338.Metal2 11.1613203463
Rred_985 di_tg_ctrl_n.$207.Metal1 di_tg_ctrl_n.$72.GatPoly 15.8462237797
Rred_986 di_tg_ctrl_n.$207.Metal1 di_tg_ctrl_n.$76.GatPoly 71.353479321
Rred_987 di_tg_ctrl_n.$207.Metal1 di_tg_ctrl_n.P48.GatPoly 1260.93033898
Rred_988 di_tg_ctrl_n.$209.Metal1 di_tg_ctrl_n.$211.Metal1 0.178931043267
Rred_989 di_tg_ctrl_n.$209.Metal1 di_tg_ctrl_n.$338.Metal2 18.5553695604
Rred_990 di_tg_ctrl_n.$209.Metal1 di_tg_ctrl_n.$342.Metal2 30.5663418019
Rred_991 di_tg_ctrl_n.$209.Metal1 di_tg_ctrl_n.$437.Metal3 1601.17477842
Rred_992 di_tg_ctrl_n.$209.Metal1 di_tg_ctrl_n.$72.GatPoly 95.1379724279
Rred_993 di_tg_ctrl_n.$209.Metal1 di_tg_ctrl_n.$76.GatPoly 27.8558623939
Rred_994 di_tg_ctrl_n.$209.Metal1 di_tg_ctrl_n.P48.GatPoly 2186.35590127
Rred_995 di_tg_ctrl_n.$211.Metal1 di_tg_ctrl_n.$213.Metal1 0.178900772311
Rred_996 di_tg_ctrl_n.$211.Metal1 di_tg_ctrl_n.$338.Metal2 46.4155560695
Rred_997 di_tg_ctrl_n.$211.Metal1 di_tg_ctrl_n.$342.Metal2 15.2778745337
Rred_998 di_tg_ctrl_n.$211.Metal1 di_tg_ctrl_n.$437.Metal3 2431.41355242
Rred_999 di_tg_ctrl_n.$211.Metal1 di_tg_ctrl_n.$76.GatPoly 20.0550777063
Rred_1000 di_tg_ctrl_n.$211.Metal1 di_tg_ctrl_n.$79.GatPoly 110.882296296
Rred_1001 di_tg_ctrl_n.$213.Metal1 di_tg_ctrl_n.$215.Metal1 0.178640180146
Rred_1002 di_tg_ctrl_n.$213.Metal1 di_tg_ctrl_n.$342.Metal2 14.997543554
Rred_1003 di_tg_ctrl_n.$213.Metal1 di_tg_ctrl_n.$344.Metal2 47.2209706961
Rred_1004 di_tg_ctrl_n.$213.Metal1 di_tg_ctrl_n.$76.GatPoly 110.882296296
Rred_1005 di_tg_ctrl_n.$213.Metal1 di_tg_ctrl_n.$79.GatPoly 20.0550777063
Rred_1006 di_tg_ctrl_n.$215.Metal1 di_tg_ctrl_n.$216.Metal1 0.180559146049
Rred_1007 di_tg_ctrl_n.$215.Metal1 di_tg_ctrl_n.$344.Metal2 11.1613203463
Rred_1008 di_tg_ctrl_n.$215.Metal1 di_tg_ctrl_n.$79.GatPoly 27.699010556
Rred_1009 di_tg_ctrl_n.$215.Metal1 di_tg_ctrl_n.$83.GatPoly 91.3215770751
Rred_1010 di_tg_ctrl_n.$215.Metal1 di_tg_ctrl_n.P51.GatPoly 2132.71615364
Rred_1011 di_tg_ctrl_n.$216.Metal1 di_tg_ctrl_n.$219.Metal1 0.215132967211
Rred_1012 di_tg_ctrl_n.$216.Metal1 di_tg_ctrl_n.$342.Metal2 15946.9046903
Rred_1013 di_tg_ctrl_n.$216.Metal1 di_tg_ctrl_n.$344.Metal2 9.6273019118
Rred_1014 di_tg_ctrl_n.$216.Metal1 di_tg_ctrl_n.$437.Metal3 304.425566788
Rred_1015 di_tg_ctrl_n.$216.Metal1 di_tg_ctrl_n.$79.GatPoly 72.4122606103
Rred_1016 di_tg_ctrl_n.$216.Metal1 di_tg_ctrl_n.$83.GatPoly 23.8041282938
Rred_1017 di_tg_ctrl_n.$216.Metal1 di_tg_ctrl_n.P51.GatPoly 1279.64070129
Rred_1018 di_tg_ctrl_n.$219.Metal1 di_tg_ctrl_n.$342.Metal2 10732.7449825
Rred_1019 di_tg_ctrl_n.$219.Metal1 di_tg_ctrl_n.$344.Metal2 9.96667791072
Rred_1020 di_tg_ctrl_n.$219.Metal1 di_tg_ctrl_n.$437.Metal3 204.887533846
Rred_1021 di_tg_ctrl_n.$219.Metal1 di_tg_ctrl_n.$83.GatPoly 10.3547275329
Rred_1022 di_tg_ctrl_n.$219.Metal1 di_tg_ctrl_n.P52.GatPoly 3009.51627665
Rred_1023 di_tg_ctrl_n.$219.Metal1 di_tg_ctrl_n.P53.GatPoly 800.597140619
Rred_1024 di_tg_ctrl_n.$22.GatPoly di_tg_ctrl_n.$26.GatPoly 37.7380623964
Rred_1025 di_tg_ctrl_n.$22.GatPoly di_tg_ctrl_n.$286.Metal2 1836.80456241
Rred_1026 di_tg_ctrl_n.$22.GatPoly di_tg_ctrl_n.P27.GatPoly 302.934654613
Rred_1027 di_tg_ctrl_n.$22.GatPoly di_tg_ctrl_n.P28.GatPoly 666.892045948
Rred_1028 di_tg_ctrl_n.$223.Metal1 di_tg_ctrl_n.$227.Metal1 0.361925452953
Rred_1029 di_tg_ctrl_n.$223.Metal1 di_tg_ctrl_n.$352.Metal2 5.74305434374
Rred_1030 di_tg_ctrl_n.$223.Metal1 di_tg_ctrl_n.$354.Metal2 414.569155201
Rred_1031 di_tg_ctrl_n.$223.Metal1 di_tg_ctrl_n.$443.Metal3 505.721145647
Rred_1032 di_tg_ctrl_n.$223.Metal1 di_tg_ctrl_n.$86.GatPoly 11.0185075656
Rred_1033 di_tg_ctrl_n.$223.Metal1 di_tg_ctrl_n.$89.GatPoly 17.0363077751
Rred_1034 di_tg_ctrl_n.$223.Metal1 di_tg_ctrl_n.P1.GatPoly 597.457315233
Rred_1035 di_tg_ctrl_n.$227.Metal1 di_tg_ctrl_n.$230.Metal1 0.36174266925
Rred_1036 di_tg_ctrl_n.$227.Metal1 di_tg_ctrl_n.$352.Metal2 24.3864208943
Rred_1037 di_tg_ctrl_n.$227.Metal1 di_tg_ctrl_n.$354.Metal2 9.21322159853
Rred_1038 di_tg_ctrl_n.$227.Metal1 di_tg_ctrl_n.$356.Metal2 21.8084097251
Rred_1039 di_tg_ctrl_n.$227.Metal1 di_tg_ctrl_n.$89.GatPoly 17.0206131331
Rred_1040 di_tg_ctrl_n.$227.Metal1 di_tg_ctrl_n.$93.GatPoly 17.0255606258
Rred_1041 di_tg_ctrl_n.$227.Metal1 di_tg_ctrl_n.P2.GatPoly 1766.1219457
Rred_1042 di_tg_ctrl_n.$227.Metal1 di_tg_ctrl_n.P3.GatPoly 1766.1219457
Rred_1043 di_tg_ctrl_n.$230.Metal1 di_tg_ctrl_n.$232.Metal1 0.178914556563
Rred_1044 di_tg_ctrl_n.$230.Metal1 di_tg_ctrl_n.$356.Metal2 15.709211158
Rred_1045 di_tg_ctrl_n.$230.Metal1 di_tg_ctrl_n.$358.Metal2 14.29803433
Rred_1046 di_tg_ctrl_n.$230.Metal1 di_tg_ctrl_n.$93.GatPoly 22.2818406054
Rred_1047 di_tg_ctrl_n.$230.Metal1 di_tg_ctrl_n.$95.GatPoly 20.7333333333
Rred_1048 di_tg_ctrl_n.$232.Metal1 di_tg_ctrl_n.$234.Metal1 0.178776388217
Rred_1049 di_tg_ctrl_n.$232.Metal1 di_tg_ctrl_n.$358.Metal2 15.673820582
Rred_1050 di_tg_ctrl_n.$232.Metal1 di_tg_ctrl_n.$362.Metal2 43.2188595898
Rred_1051 di_tg_ctrl_n.$232.Metal1 di_tg_ctrl_n.$451.Metal3 2263.95910822
Rred_1052 di_tg_ctrl_n.$232.Metal1 di_tg_ctrl_n.$95.GatPoly 28.0359186568
Rred_1053 di_tg_ctrl_n.$232.Metal1 di_tg_ctrl_n.$99.GatPoly 97.9314417107
Rred_1054 di_tg_ctrl_n.$232.Metal1 di_tg_ctrl_n.P5.GatPoly 807.890579942
Rred_1055 di_tg_ctrl_n.$234.Metal1 di_tg_ctrl_n.$238.Metal1 0.361769388616
Rred_1056 di_tg_ctrl_n.$234.Metal1 di_tg_ctrl_n.$358.Metal2 32.1371007206
Rred_1057 di_tg_ctrl_n.$234.Metal1 di_tg_ctrl_n.$362.Metal2 10.1995107514
Rred_1058 di_tg_ctrl_n.$234.Metal1 di_tg_ctrl_n.$364.Metal2 1243.17117179
Rred_1059 di_tg_ctrl_n.$234.Metal1 di_tg_ctrl_n.$451.Metal3 1683.45677277
Rred_1060 di_tg_ctrl_n.$234.Metal1 di_tg_ctrl_n.$95.GatPoly 73.4485812831
Rred_1061 di_tg_ctrl_n.$234.Metal1 di_tg_ctrl_n.$99.GatPoly 15.9764677614
Rred_1062 di_tg_ctrl_n.$234.Metal1 di_tg_ctrl_n.P5.GatPoly 465.932258437
Rred_1063 di_tg_ctrl_n.$238.Metal1 di_tg_ctrl_n.$241.Metal1 0.361706882048
Rred_1064 di_tg_ctrl_n.$238.Metal1 di_tg_ctrl_n.$362.Metal2 23.456059845
Rred_1065 di_tg_ctrl_n.$238.Metal1 di_tg_ctrl_n.$364.Metal2 9.07007734385
Rred_1066 di_tg_ctrl_n.$238.Metal1 di_tg_ctrl_n.$366.Metal2 22.5992068453
Rred_1067 di_tg_ctrl_n.$238.Metal1 di_tg_ctrl_n.$99.GatPoly 17.0194277612
Rred_1068 di_tg_ctrl_n.$238.Metal1 di_tg_ctrl_n.P6.GatPoly 1766.1219457
Rred_1069 di_tg_ctrl_n.$238.Metal1 di_tg_ctrl_n.P7.GatPoly 1766.1219457
Rred_1070 di_tg_ctrl_n.$241.Metal1 di_tg_ctrl_n.$243.Metal1 0.178938945578
Rred_1071 di_tg_ctrl_n.$241.Metal1 di_tg_ctrl_n.$366.Metal2 15.3159551971
Rred_1072 di_tg_ctrl_n.$241.Metal1 di_tg_ctrl_n.$368.Metal2 14.997543554
Rred_1073 di_tg_ctrl_n.$243.Metal1 di_tg_ctrl_n.$245.Metal1 0.178758302752
Rred_1074 di_tg_ctrl_n.$243.Metal1 di_tg_ctrl_n.$368.Metal2 15.2778745337
Rred_1075 di_tg_ctrl_n.$243.Metal1 di_tg_ctrl_n.$372.Metal2 46.4155560695
Rred_1076 di_tg_ctrl_n.$243.Metal1 di_tg_ctrl_n.$460.Metal3 2431.41355242
Rred_1077 di_tg_ctrl_n.$243.Metal1 di_tg_ctrl_n.P9.GatPoly 807.890579942
Rred_1078 di_tg_ctrl_n.$245.Metal1 di_tg_ctrl_n.$248.Metal1 0.364462194599
Rred_1079 di_tg_ctrl_n.$245.Metal1 di_tg_ctrl_n.$368.Metal2 30.5663418019
Rred_1080 di_tg_ctrl_n.$245.Metal1 di_tg_ctrl_n.$372.Metal2 10.1703438894
Rred_1081 di_tg_ctrl_n.$245.Metal1 di_tg_ctrl_n.$460.Metal3 1601.17477842
Rred_1082 di_tg_ctrl_n.$245.Metal1 di_tg_ctrl_n.P9.GatPoly 465.932258437
Rred_1083 di_tg_ctrl_n.$248.Metal1 di_tg_ctrl_n.$252.Metal1 0.358974281487
Rred_1084 di_tg_ctrl_n.$248.Metal1 di_tg_ctrl_n.$372.Metal2 10.157570931
Rred_1085 di_tg_ctrl_n.$248.Metal1 di_tg_ctrl_n.$376.Metal2 10.2565388215
Rred_1086 di_tg_ctrl_n.$248.Metal1 di_tg_ctrl_n.$460.Metal3 1995.18706866
Rred_1087 di_tg_ctrl_n.$248.Metal1 di_tg_ctrl_n.$464.Metal3 1995.18706866
Rred_1088 di_tg_ctrl_n.$252.Metal1 di_tg_ctrl_n.$254.Metal1 0.178949163705
Rred_1089 di_tg_ctrl_n.$252.Metal1 di_tg_ctrl_n.$376.Metal2 10.2319718846
Rred_1090 di_tg_ctrl_n.$252.Metal1 di_tg_ctrl_n.$380.Metal2 32.1371007206
Rred_1091 di_tg_ctrl_n.$252.Metal1 di_tg_ctrl_n.$464.Metal3 1683.45677277
Rred_1092 di_tg_ctrl_n.$254.Metal1 di_tg_ctrl_n.$256.Metal1 0.178741847863
Rred_1093 di_tg_ctrl_n.$254.Metal1 di_tg_ctrl_n.$376.Metal2 43.2188595898
Rred_1094 di_tg_ctrl_n.$254.Metal1 di_tg_ctrl_n.$380.Metal2 15.673820582
Rred_1095 di_tg_ctrl_n.$254.Metal1 di_tg_ctrl_n.$464.Metal3 2263.95910822
Rred_1096 di_tg_ctrl_n.$254.Metal1 di_tg_ctrl_n.P13.GatPoly 807.890579942
Rred_1097 di_tg_ctrl_n.$256.Metal1 di_tg_ctrl_n.$259.Metal1 0.370013163456
Rred_1098 di_tg_ctrl_n.$256.Metal1 di_tg_ctrl_n.$380.Metal2 14.29803433
Rred_1099 di_tg_ctrl_n.$256.Metal1 di_tg_ctrl_n.$382.Metal2 15.4725431492
Rred_1100 di_tg_ctrl_n.$256.Metal1 di_tg_ctrl_n.P13.GatPoly 465.932258437
Rred_1101 di_tg_ctrl_n.$259.Metal1 di_tg_ctrl_n.$264.Metal1 0.439516952611
Rred_1102 di_tg_ctrl_n.$259.Metal1 di_tg_ctrl_n.$382.Metal2 10.0660514633
Rred_1103 di_tg_ctrl_n.$259.Metal1 di_tg_ctrl_n.$386.Metal2 9.17514949595
Rred_1104 di_tg_ctrl_n.$259.Metal1 di_tg_ctrl_n.$467.Metal3 960.904656317
Rred_1105 di_tg_ctrl_n.$26.GatPoly di_tg_ctrl_n.$29.GatPoly 14.6611036214
Rred_1106 di_tg_ctrl_n.$26.GatPoly di_tg_ctrl_n.P28.GatPoly 867.254507503
Rred_1107 di_tg_ctrl_n.$26.GatPoly di_tg_ctrl_n.P29.GatPoly 252
Rred_1108 di_tg_ctrl_n.$264.Metal1 di_tg_ctrl_n.$386.Metal2 6.18989098339
Rred_1109 di_tg_ctrl_n.$264.Metal1 di_tg_ctrl_n.$467.Metal3 517.314655612
Rred_1110 di_tg_ctrl_n.$264.Metal1 di_tg_ctrl_n.P16.GatPoly 1122.79629221
Rred_1111 di_tg_ctrl_n.$264.Metal1 di_tg_ctrl_n.P17.GatPoly 330.292425347
Rred_1112 di_tg_ctrl_n.$270.Metal2 di_tg_ctrl_n.$272.Metal2 0.17165719589
Rred_1113 di_tg_ctrl_n.$270.Metal2 di_tg_ctrl_n.$394.Metal3 3.69602125491
Rred_1114 di_tg_ctrl_n.$272.Metal2 di_tg_ctrl_n.$276.Metal2 0.350163252448
Rred_1115 di_tg_ctrl_n.$272.Metal2 di_tg_ctrl_n.$394.Metal3 6.31608963811
Rred_1116 di_tg_ctrl_n.$276.Metal2 di_tg_ctrl_n.$278.Metal2 0.171789176047
Rred_1117 di_tg_ctrl_n.$276.Metal2 di_tg_ctrl_n.$394.Metal3 7.84722573955
Rred_1118 di_tg_ctrl_n.$276.Metal2 di_tg_ctrl_n.$397.Metal3 27.69051793
Rred_1119 di_tg_ctrl_n.$278.Metal2 di_tg_ctrl_n.$282.Metal2 0.350167596259
Rred_1120 di_tg_ctrl_n.$278.Metal2 di_tg_ctrl_n.$394.Metal3 27.69051793
Rred_1121 di_tg_ctrl_n.$278.Metal2 di_tg_ctrl_n.$397.Metal3 7.84726738463
Rred_1122 di_tg_ctrl_n.$282.Metal2 di_tg_ctrl_n.$286.Metal2 0.350163697435
Rred_1123 di_tg_ctrl_n.$282.Metal2 di_tg_ctrl_n.$397.Metal3 9.12851077479
Rred_1124 di_tg_ctrl_n.$282.Metal2 di_tg_ctrl_n.$399.Metal3 9.12846019364
Rred_1125 di_tg_ctrl_n.$286.Metal2 di_tg_ctrl_n.$288.Metal2 0.171789176047
Rred_1126 di_tg_ctrl_n.$286.Metal2 di_tg_ctrl_n.$399.Metal3 7.84723000577
Rred_1127 di_tg_ctrl_n.$286.Metal2 di_tg_ctrl_n.$402.Metal3 27.69051793
Rred_1128 di_tg_ctrl_n.$288.Metal2 di_tg_ctrl_n.$292.Metal2 0.350166592815
Rred_1129 di_tg_ctrl_n.$288.Metal2 di_tg_ctrl_n.$399.Metal3 27.69051793
Rred_1130 di_tg_ctrl_n.$288.Metal2 di_tg_ctrl_n.$402.Metal3 7.84725776444
Rred_1131 di_tg_ctrl_n.$29.GatPoly di_tg_ctrl_n.$32.GatPoly 17.1424550154
Rred_1132 di_tg_ctrl_n.$29.GatPoly di_tg_ctrl_n.P30.GatPoly 252
Rred_1133 di_tg_ctrl_n.$29.GatPoly di_tg_ctrl_n.P31.GatPoly 2178.10016667
Rred_1134 di_tg_ctrl_n.$292.Metal2 di_tg_ctrl_n.$296.Metal2 0.350164253841
Rred_1135 di_tg_ctrl_n.$292.Metal2 di_tg_ctrl_n.$402.Metal3 9.12849775673
Rred_1136 di_tg_ctrl_n.$292.Metal2 di_tg_ctrl_n.$404.Metal3 9.12846741217
Rred_1137 di_tg_ctrl_n.$296.Metal2 di_tg_ctrl_n.$298.Metal2 0.171789176047
Rred_1138 di_tg_ctrl_n.$296.Metal2 di_tg_ctrl_n.$32.GatPoly 1774.68529082
Rred_1139 di_tg_ctrl_n.$296.Metal2 di_tg_ctrl_n.$404.Metal3 7.84723534018
Rred_1140 di_tg_ctrl_n.$296.Metal2 di_tg_ctrl_n.$407.Metal3 27.69051793
Rred_1141 di_tg_ctrl_n.$298.Metal2 di_tg_ctrl_n.$302.Metal2 0.350165701382
Rred_1142 di_tg_ctrl_n.$298.Metal2 di_tg_ctrl_n.$404.Metal3 27.69051793
Rred_1143 di_tg_ctrl_n.$298.Metal2 di_tg_ctrl_n.$407.Metal3 7.8472492181
Rred_1144 di_tg_ctrl_n.$302.Metal2 di_tg_ctrl_n.$306.Metal2 0.350164921777
Rred_1145 di_tg_ctrl_n.$302.Metal2 di_tg_ctrl_n.$407.Metal3 9.12848619179
Rred_1146 di_tg_ctrl_n.$302.Metal2 di_tg_ctrl_n.$409.Metal3 9.12847607763
Rred_1147 di_tg_ctrl_n.$306.Metal2 di_tg_ctrl_n.$310.Metal2 0.35017273461
Rred_1148 di_tg_ctrl_n.$306.Metal2 di_tg_ctrl_n.$409.Metal3 9.17039297049
Rred_1149 di_tg_ctrl_n.$306.Metal2 di_tg_ctrl_n.$413.Metal3 9.17131916869
Rred_1150 di_tg_ctrl_n.$306.Metal2 di_tg_ctrl_n.$42.GatPoly 1716.610141
Rred_1151 di_tg_ctrl_n.$306.Metal2 di_tg_ctrl_n.$471.Metal4 979.431680707
Rred_1152 di_tg_ctrl_n.$310.Metal2 di_tg_ctrl_n.$314.Metal2 0.350162585194
Rred_1153 di_tg_ctrl_n.$310.Metal2 di_tg_ctrl_n.$413.Metal3 9.17072936822
Rred_1154 di_tg_ctrl_n.$310.Metal2 di_tg_ctrl_n.$417.Metal3 9.17058985711
Rred_1155 di_tg_ctrl_n.$310.Metal2 di_tg_ctrl_n.$471.Metal4 1959.14801655
Rred_1156 di_tg_ctrl_n.$314.Metal2 di_tg_ctrl_n.$316.Metal2 0.17180952381
Rred_1157 di_tg_ctrl_n.$314.Metal2 di_tg_ctrl_n.$417.Metal3 18.3427740026
Rred_1158 di_tg_ctrl_n.$314.Metal2 di_tg_ctrl_n.$419.Metal3 9
Rred_1159 di_tg_ctrl_n.$316.Metal2 di_tg_ctrl_n.$320.Metal2 0.350171280831
Rred_1160 di_tg_ctrl_n.$316.Metal2 di_tg_ctrl_n.$419.Metal3 18.3390127043
Rred_1161 di_tg_ctrl_n.$316.Metal2 di_tg_ctrl_n.$423.Metal3 9.17033058143
Rred_1162 di_tg_ctrl_n.$316.Metal2 di_tg_ctrl_n.$483.Metal4 2313.46332845
Rred_1163 di_tg_ctrl_n.$316.Metal2 di_tg_ctrl_n.$52.GatPoly 1662.19395849
Rred_1164 di_tg_ctrl_n.$32.GatPoly di_tg_ctrl_n.$36.GatPoly 37.7380623964
Rred_1165 di_tg_ctrl_n.$32.GatPoly di_tg_ctrl_n.P31.GatPoly 302.934654613
Rred_1166 di_tg_ctrl_n.$32.GatPoly di_tg_ctrl_n.P32.GatPoly 666.892045948
Rred_1167 di_tg_ctrl_n.$320.Metal2 di_tg_ctrl_n.$322.Metal2 0.171789671056
Rred_1168 di_tg_ctrl_n.$320.Metal2 di_tg_ctrl_n.$423.Metal3 7.91651061324
Rred_1169 di_tg_ctrl_n.$320.Metal2 di_tg_ctrl_n.$429.Metal3 28.3810358599
Rred_1170 di_tg_ctrl_n.$320.Metal2 di_tg_ctrl_n.$483.Metal4 492.433358919
Rred_1171 di_tg_ctrl_n.$322.Metal2 di_tg_ctrl_n.$326.Metal2 0.350166592815
Rred_1172 di_tg_ctrl_n.$322.Metal2 di_tg_ctrl_n.$423.Metal3 28.3810358599
Rred_1173 di_tg_ctrl_n.$322.Metal2 di_tg_ctrl_n.$429.Metal3 7.91567530735
Rred_1174 di_tg_ctrl_n.$322.Metal2 di_tg_ctrl_n.$483.Metal4 495.566867841
Rred_1175 di_tg_ctrl_n.$326.Metal2 di_tg_ctrl_n.$328.Metal2 0.171789176047
Rred_1176 di_tg_ctrl_n.$326.Metal2 di_tg_ctrl_n.$429.Metal3 7.84725776444
Rred_1177 di_tg_ctrl_n.$326.Metal2 di_tg_ctrl_n.$432.Metal3 27.69051793
Rred_1178 di_tg_ctrl_n.$326.Metal2 di_tg_ctrl_n.$62.GatPoly 1611.09899248
Rred_1179 di_tg_ctrl_n.$328.Metal2 di_tg_ctrl_n.$332.Metal2 0.350163697435
Rred_1180 di_tg_ctrl_n.$328.Metal2 di_tg_ctrl_n.$429.Metal3 27.69051793
Rred_1181 di_tg_ctrl_n.$328.Metal2 di_tg_ctrl_n.$432.Metal3 7.84723000577
Rred_1182 di_tg_ctrl_n.$332.Metal2 di_tg_ctrl_n.$336.Metal2 0.350167596259
Rred_1183 di_tg_ctrl_n.$332.Metal2 di_tg_ctrl_n.$432.Metal3 9.12846019364
Rred_1184 di_tg_ctrl_n.$332.Metal2 di_tg_ctrl_n.$434.Metal3 9.12851077479
Rred_1185 di_tg_ctrl_n.$336.Metal2 di_tg_ctrl_n.$338.Metal2 0.171789176047
Rred_1186 di_tg_ctrl_n.$336.Metal2 di_tg_ctrl_n.$434.Metal3 7.84726738463
Rred_1187 di_tg_ctrl_n.$336.Metal2 di_tg_ctrl_n.$437.Metal3 27.69051793
Rred_1188 di_tg_ctrl_n.$336.Metal2 di_tg_ctrl_n.$72.GatPoly 1563.02782058
Rred_1189 di_tg_ctrl_n.$338.Metal2 di_tg_ctrl_n.$342.Metal2 0.350163252448
Rred_1190 di_tg_ctrl_n.$338.Metal2 di_tg_ctrl_n.$434.Metal3 27.69051793
Rred_1191 di_tg_ctrl_n.$338.Metal2 di_tg_ctrl_n.$437.Metal3 7.84722573955
Rred_1192 di_tg_ctrl_n.$342.Metal2 di_tg_ctrl_n.$344.Metal2 0.17165719589
Rred_1193 di_tg_ctrl_n.$342.Metal2 di_tg_ctrl_n.$437.Metal3 6.31608963811
Rred_1194 di_tg_ctrl_n.$344.Metal2 di_tg_ctrl_n.$437.Metal3 3.69602125491
Rred_1195 di_tg_ctrl_n.$352.Metal2 di_tg_ctrl_n.$354.Metal2 0.171808467076
Rred_1196 di_tg_ctrl_n.$352.Metal2 di_tg_ctrl_n.$443.Metal3 4.62567704864
Rred_1197 di_tg_ctrl_n.$352.Metal2 di_tg_ctrl_n.$86.GatPoly 1761.51419425
Rred_1198 di_tg_ctrl_n.$352.Metal2 di_tg_ctrl_n.$89.GatPoly 2052.22393734
Rred_1199 di_tg_ctrl_n.$354.Metal2 di_tg_ctrl_n.$356.Metal2 0.17180952381
Rred_1200 di_tg_ctrl_n.$354.Metal2 di_tg_ctrl_n.$443.Metal3 18.3254953184
Rred_1201 di_tg_ctrl_n.$354.Metal2 di_tg_ctrl_n.$447.Metal3 18.3314754816
Rred_1202 di_tg_ctrl_n.$354.Metal2 di_tg_ctrl_n.$488.Metal4 1052.28241234
Rred_1203 di_tg_ctrl_n.$354.Metal2 di_tg_ctrl_n.$89.GatPoly 34787.8468702
Rred_1204 di_tg_ctrl_n.$356.Metal2 di_tg_ctrl_n.$358.Metal2 0.17180952381
Rred_1205 di_tg_ctrl_n.$356.Metal2 di_tg_ctrl_n.$447.Metal3 9
Rred_1206 di_tg_ctrl_n.$356.Metal2 di_tg_ctrl_n.$93.GatPoly 1836.80456241
Rred_1207 di_tg_ctrl_n.$358.Metal2 di_tg_ctrl_n.$362.Metal2 0.350162918787
Rred_1208 di_tg_ctrl_n.$358.Metal2 di_tg_ctrl_n.$447.Metal3 18.3436190476
Rred_1209 di_tg_ctrl_n.$358.Metal2 di_tg_ctrl_n.$451.Metal3 9.17160262659
Rred_1210 di_tg_ctrl_n.$358.Metal2 di_tg_ctrl_n.$488.Metal4 960.904656317
Rred_1211 di_tg_ctrl_n.$36.GatPoly di_tg_ctrl_n.$39.GatPoly 14.6611036214
Rred_1212 di_tg_ctrl_n.$36.GatPoly di_tg_ctrl_n.P32.GatPoly 867.254507503
Rred_1213 di_tg_ctrl_n.$36.GatPoly di_tg_ctrl_n.P33.GatPoly 252
Rred_1214 di_tg_ctrl_n.$362.Metal2 di_tg_ctrl_n.$364.Metal2 0.171809157592
Rred_1215 di_tg_ctrl_n.$362.Metal2 di_tg_ctrl_n.$451.Metal3 18.3427914774
Rred_1216 di_tg_ctrl_n.$362.Metal2 di_tg_ctrl_n.$453.Metal3 9
Rred_1217 di_tg_ctrl_n.$362.Metal2 di_tg_ctrl_n.$99.GatPoly 1975.01094634
Rred_1218 di_tg_ctrl_n.$364.Metal2 di_tg_ctrl_n.$366.Metal2 0.17180952381
Rred_1219 di_tg_ctrl_n.$364.Metal2 di_tg_ctrl_n.$453.Metal3 18.3427871479
Rred_1220 di_tg_ctrl_n.$364.Metal2 di_tg_ctrl_n.$457.Metal3 18.3411235748
Rred_1221 di_tg_ctrl_n.$364.Metal2 di_tg_ctrl_n.$491.Metal4 970.168168512
Rred_1222 di_tg_ctrl_n.$364.Metal2 di_tg_ctrl_n.$99.GatPoly 104350.572432
Rred_1223 di_tg_ctrl_n.$366.Metal2 di_tg_ctrl_n.$368.Metal2 0.17180952381
Rred_1224 di_tg_ctrl_n.$366.Metal2 di_tg_ctrl_n.$457.Metal3 9
Rred_1225 di_tg_ctrl_n.$368.Metal2 di_tg_ctrl_n.$372.Metal2 0.350163252448
Rred_1226 di_tg_ctrl_n.$368.Metal2 di_tg_ctrl_n.$457.Metal3 18.1718095238
Rred_1227 di_tg_ctrl_n.$368.Metal2 di_tg_ctrl_n.$460.Metal3 9.12845442059
Rred_1228 di_tg_ctrl_n.$372.Metal2 di_tg_ctrl_n.$376.Metal2 0.349933042217
Rred_1229 di_tg_ctrl_n.$372.Metal2 di_tg_ctrl_n.$460.Metal3 6.16121082367
Rred_1230 di_tg_ctrl_n.$372.Metal2 di_tg_ctrl_n.$464.Metal3 18.9544034194
Rred_1231 di_tg_ctrl_n.$376.Metal2 di_tg_ctrl_n.$380.Metal2 0.350162918787
Rred_1232 di_tg_ctrl_n.$376.Metal2 di_tg_ctrl_n.$460.Metal3 18.9544034194
Rred_1233 di_tg_ctrl_n.$376.Metal2 di_tg_ctrl_n.$464.Metal3 6.1612088517
Rred_1234 di_tg_ctrl_n.$380.Metal2 di_tg_ctrl_n.$382.Metal2 0.171789176047
Rred_1235 di_tg_ctrl_n.$380.Metal2 di_tg_ctrl_n.$464.Metal3 7.84722254064
Rred_1236 di_tg_ctrl_n.$380.Metal2 di_tg_ctrl_n.$467.Metal3 27.69051793
Rred_1237 di_tg_ctrl_n.$382.Metal2 di_tg_ctrl_n.$386.Metal2 0.350178717058
Rred_1238 di_tg_ctrl_n.$382.Metal2 di_tg_ctrl_n.$464.Metal3 27.69051793
Rred_1239 di_tg_ctrl_n.$382.Metal2 di_tg_ctrl_n.$467.Metal3 7.84737399951
Rred_1240 di_tg_ctrl_n.$386.Metal2 di_tg_ctrl_n.$467.Metal3 3.80413066107
Rred_1241 di_tg_ctrl_n.$39.GatPoly di_tg_ctrl_n.$42.GatPoly 17.1424550154
Rred_1242 di_tg_ctrl_n.$39.GatPoly di_tg_ctrl_n.P34.GatPoly 252
Rred_1243 di_tg_ctrl_n.$39.GatPoly di_tg_ctrl_n.P35.GatPoly 2178.10016667
Rred_1244 di_tg_ctrl_n.$394.Metal3 di_tg_ctrl_n.$397.Metal3 0.528610522178
Rred_1245 di_tg_ctrl_n.$397.Metal3 di_tg_ctrl_n.$399.Metal3 0.346898882339
Rred_1246 di_tg_ctrl_n.$399.Metal3 di_tg_ctrl_n.$402.Metal3 0.528610522178
Rred_1247 di_tg_ctrl_n.$402.Metal3 di_tg_ctrl_n.$404.Metal3 0.346898882339
Rred_1248 di_tg_ctrl_n.$404.Metal3 di_tg_ctrl_n.$407.Metal3 0.528610522178
Rred_1249 di_tg_ctrl_n.$407.Metal3 di_tg_ctrl_n.$409.Metal3 0.346898882339
Rred_1250 di_tg_ctrl_n.$409.Metal3 di_tg_ctrl_n.$413.Metal3 0.350084353897
Rred_1251 di_tg_ctrl_n.$409.Metal3 di_tg_ctrl_n.$471.Metal4 6.23243298765
Rred_1252 di_tg_ctrl_n.$413.Metal3 di_tg_ctrl_n.$417.Metal3 0.35005060623
Rred_1253 di_tg_ctrl_n.$413.Metal3 di_tg_ctrl_n.$471.Metal4 5.8073706383
Rred_1254 di_tg_ctrl_n.$417.Metal3 di_tg_ctrl_n.$419.Metal3 0.17180952381
Rred_1255 di_tg_ctrl_n.$417.Metal3 di_tg_ctrl_n.$471.Metal4 22.3270784649
Rred_1256 di_tg_ctrl_n.$419.Metal3 di_tg_ctrl_n.$423.Metal3 0.350002060736
Rred_1257 di_tg_ctrl_n.$419.Metal3 di_tg_ctrl_n.$483.Metal4 26.3649692741
Rred_1258 di_tg_ctrl_n.$42.GatPoly di_tg_ctrl_n.$46.GatPoly 37.7380623964
Rred_1259 di_tg_ctrl_n.$42.GatPoly di_tg_ctrl_n.P35.GatPoly 302.934654613
Rred_1260 di_tg_ctrl_n.$42.GatPoly di_tg_ctrl_n.P36.GatPoly 666.892045948
Rred_1261 di_tg_ctrl_n.$423.Metal3 di_tg_ctrl_n.$429.Metal3 0.541792472925
Rred_1262 di_tg_ctrl_n.$423.Metal3 di_tg_ctrl_n.$483.Metal4 4.83308327342
Rred_1263 di_tg_ctrl_n.$429.Metal3 di_tg_ctrl_n.$432.Metal3 0.528610522178
Rred_1264 di_tg_ctrl_n.$429.Metal3 di_tg_ctrl_n.$483.Metal4 9.46034528664
Rred_1265 di_tg_ctrl_n.$432.Metal3 di_tg_ctrl_n.$434.Metal3 0.346898882339
Rred_1266 di_tg_ctrl_n.$434.Metal3 di_tg_ctrl_n.$437.Metal3 0.528610522178
Rred_1267 di_tg_ctrl_n.$443.Metal3 di_tg_ctrl_n.$447.Metal3 0.34948417654
Rred_1268 di_tg_ctrl_n.$443.Metal3 di_tg_ctrl_n.$488.Metal4 6.69600519178
Rred_1269 di_tg_ctrl_n.$443.Metal3 di_tg_ctrl_n.$86.GatPoly 94035.9550792
Rred_1270 di_tg_ctrl_n.$447.Metal3 di_tg_ctrl_n.$451.Metal3 0.350178717058
Rred_1271 di_tg_ctrl_n.$447.Metal3 di_tg_ctrl_n.$488.Metal4 4.77150052447
Rred_1272 di_tg_ctrl_n.$451.Metal3 di_tg_ctrl_n.$453.Metal3 0.171792925507
Rred_1273 di_tg_ctrl_n.$451.Metal3 di_tg_ctrl_n.$488.Metal4 8.05574505892
Rred_1274 di_tg_ctrl_n.$451.Metal3 di_tg_ctrl_n.$491.Metal4 25.2527999235
Rred_1275 di_tg_ctrl_n.$453.Metal3 di_tg_ctrl_n.$457.Metal3 0.350131078614
Rred_1276 di_tg_ctrl_n.$453.Metal3 di_tg_ctrl_n.$488.Metal4 33.9463867824
Rred_1277 di_tg_ctrl_n.$453.Metal3 di_tg_ctrl_n.$491.Metal4 7.46550371572
Rred_1278 di_tg_ctrl_n.$457.Metal3 di_tg_ctrl_n.$460.Metal3 0.346898882339
Rred_1279 di_tg_ctrl_n.$457.Metal3 di_tg_ctrl_n.$491.Metal4 6.1734863351
Rred_1280 di_tg_ctrl_n.$46.GatPoly di_tg_ctrl_n.$49.GatPoly 14.6611036214
Rred_1281 di_tg_ctrl_n.$46.GatPoly di_tg_ctrl_n.P36.GatPoly 867.254507503
Rred_1282 di_tg_ctrl_n.$46.GatPoly di_tg_ctrl_n.P37.GatPoly 252
Rred_1283 di_tg_ctrl_n.$460.Metal3 di_tg_ctrl_n.$464.Metal3 0.720288073978
Rred_1284 di_tg_ctrl_n.$464.Metal3 di_tg_ctrl_n.$467.Metal3 0.528610522178
Rred_1285 di_tg_ctrl_n.$471.Metal4 di_tg_ctrl_n.$491.Metal4 8.21941191598
Rred_1286 di_tg_ctrl_n.$488.Metal4 di_tg_ctrl_n.$491.Metal4 0.482074614414
Rred_1287 di_tg_ctrl_n.$49.GatPoly di_tg_ctrl_n.$52.GatPoly 17.1424550154
Rred_1288 di_tg_ctrl_n.$49.GatPoly di_tg_ctrl_n.P38.GatPoly 252
Rred_1289 di_tg_ctrl_n.$49.GatPoly di_tg_ctrl_n.P39.GatPoly 2178.10016667
Rred_1290 di_tg_ctrl_n.$52.GatPoly di_tg_ctrl_n.$56.GatPoly 37.7380623964
Rred_1291 di_tg_ctrl_n.$52.GatPoly di_tg_ctrl_n.P39.GatPoly 302.934654613
Rred_1292 di_tg_ctrl_n.$52.GatPoly di_tg_ctrl_n.P40.GatPoly 666.892045948
Rred_1293 di_tg_ctrl_n.$56.GatPoly di_tg_ctrl_n.$59.GatPoly 14.6611036214
Rred_1294 di_tg_ctrl_n.$56.GatPoly di_tg_ctrl_n.P40.GatPoly 867.254507503
Rred_1295 di_tg_ctrl_n.$56.GatPoly di_tg_ctrl_n.P41.GatPoly 252
Rred_1296 di_tg_ctrl_n.$59.GatPoly di_tg_ctrl_n.$62.GatPoly 17.1424550154
Rred_1297 di_tg_ctrl_n.$59.GatPoly di_tg_ctrl_n.P42.GatPoly 252
Rred_1298 di_tg_ctrl_n.$59.GatPoly di_tg_ctrl_n.P43.GatPoly 2178.10016667
Rred_1299 di_tg_ctrl_n.$6.GatPoly di_tg_ctrl_n.$9.GatPoly 14.6611036214
Rred_1300 di_tg_ctrl_n.$6.GatPoly di_tg_ctrl_n.P20.GatPoly 867.232933908
Rred_1301 di_tg_ctrl_n.$6.GatPoly di_tg_ctrl_n.P21.GatPoly 252
Rred_1302 di_tg_ctrl_n.$62.GatPoly di_tg_ctrl_n.$66.GatPoly 37.7380623964
Rred_1303 di_tg_ctrl_n.$62.GatPoly di_tg_ctrl_n.P43.GatPoly 302.934654613
Rred_1304 di_tg_ctrl_n.$62.GatPoly di_tg_ctrl_n.P44.GatPoly 666.892045948
Rred_1305 di_tg_ctrl_n.$66.GatPoly di_tg_ctrl_n.$69.GatPoly 14.6611036214
Rred_1306 di_tg_ctrl_n.$66.GatPoly di_tg_ctrl_n.P44.GatPoly 867.254507503
Rred_1307 di_tg_ctrl_n.$66.GatPoly di_tg_ctrl_n.P45.GatPoly 252
Rred_1308 di_tg_ctrl_n.$69.GatPoly di_tg_ctrl_n.$72.GatPoly 17.1424550154
Rred_1309 di_tg_ctrl_n.$69.GatPoly di_tg_ctrl_n.P46.GatPoly 252
Rred_1310 di_tg_ctrl_n.$69.GatPoly di_tg_ctrl_n.P47.GatPoly 2178.10016667
Rred_1311 di_tg_ctrl_n.$72.GatPoly di_tg_ctrl_n.$76.GatPoly 37.7380623964
Rred_1312 di_tg_ctrl_n.$72.GatPoly di_tg_ctrl_n.P47.GatPoly 302.934654613
Rred_1313 di_tg_ctrl_n.$72.GatPoly di_tg_ctrl_n.P48.GatPoly 666.892045948
Rred_1314 di_tg_ctrl_n.$76.GatPoly di_tg_ctrl_n.$79.GatPoly 14.6611036214
Rred_1315 di_tg_ctrl_n.$76.GatPoly di_tg_ctrl_n.P48.GatPoly 867.254507503
Rred_1316 di_tg_ctrl_n.$76.GatPoly di_tg_ctrl_n.P49.GatPoly 252
Rred_1317 di_tg_ctrl_n.$79.GatPoly di_tg_ctrl_n.$83.GatPoly 37.7365025757
Rred_1318 di_tg_ctrl_n.$79.GatPoly di_tg_ctrl_n.P50.GatPoly 252
Rred_1319 di_tg_ctrl_n.$79.GatPoly di_tg_ctrl_n.P51.GatPoly 867.232933908
Rred_1320 di_tg_ctrl_n.$83.GatPoly di_tg_ctrl_n.P51.GatPoly 666.864481416
Rred_1321 di_tg_ctrl_n.$83.GatPoly di_tg_ctrl_n.P52.GatPoly 278.623086049
Rred_1322 di_tg_ctrl_n.$83.GatPoly di_tg_ctrl_n.P53.GatPoly 422.020958681
Rred_1323 di_tg_ctrl_n.$86.GatPoly di_tg_ctrl_n.$89.GatPoly 20.7837697531
Rred_1324 di_tg_ctrl_n.$86.GatPoly di_tg_ctrl_n.P0.GatPoly 108.194411159
Rred_1325 di_tg_ctrl_n.$86.GatPoly di_tg_ctrl_n.P1.GatPoly 171.45680188
Rred_1326 di_tg_ctrl_n.$89.GatPoly di_tg_ctrl_n.$93.GatPoly 20.8161349411
Rred_1327 di_tg_ctrl_n.$89.GatPoly di_tg_ctrl_n.P1.GatPoly 315.988535612
Rred_1328 di_tg_ctrl_n.$89.GatPoly di_tg_ctrl_n.P2.GatPoly 108.578309915
Rred_1329 di_tg_ctrl_n.$89.GatPoly di_tg_ctrl_n.P3.GatPoly 949.441810889
Rred_1330 di_tg_ctrl_n.$9.GatPoly di_tg_ctrl_n.P22.GatPoly 252
Rred_1331 di_tg_ctrl_n.$9.GatPoly di_tg_ctrl_n.P23.GatPoly 867.254507503
Rred_1332 di_tg_ctrl_n.$93.GatPoly di_tg_ctrl_n.$95.GatPoly 10.9656296296
Rred_1333 di_tg_ctrl_n.$93.GatPoly di_tg_ctrl_n.P2.GatPoly 949.441810889
Rred_1334 di_tg_ctrl_n.$93.GatPoly di_tg_ctrl_n.P3.GatPoly 108.578309915
Rred_1335 di_tg_ctrl_n.$95.GatPoly di_tg_ctrl_n.$99.GatPoly 38.8461385453
Rred_1336 di_tg_ctrl_n.$95.GatPoly di_tg_ctrl_n.P4.GatPoly 90.4615384615
Rred_1337 di_tg_ctrl_n.$95.GatPoly di_tg_ctrl_n.P5.GatPoly 320.463263377
Rred_1338 di_tg_ctrl_n.$99.GatPoly di_tg_ctrl_n.P5.GatPoly 246.426394462
Rred_1339 di_tg_ctrl_n.$99.GatPoly di_tg_ctrl_n.P6.GatPoly 108.578309915
Rred_1340 di_tg_ctrl_n.$99.GatPoly di_tg_ctrl_n.P7.GatPoly 949.441810889
Rred_1341 di_tg_ctrl_n.P16.GatPoly di_tg_ctrl_n.P17.GatPoly 8046.70133402
Rred_1342 di_tg_ctrl_n.P18.GatPoly di_tg_ctrl_n.P19.GatPoly 53621.4865148
Rred_1343 di_tg_ctrl_n.P2.GatPoly di_tg_ctrl_n.P3.GatPoly 43304.8572569
Rred_1344 di_tg_ctrl_n.P52.GatPoly di_tg_ctrl_n.P53.GatPoly 53621.4865148
Rred_1345 di_tg_ctrl_n.P6.GatPoly di_tg_ctrl_n.P7.GatPoly 43304.8572569
Rred_1346 v_a v_a.$1152.Metal2 20.857347685
Rred_1347 v_a v_a.$2187.Metal3 0.457250455712
Rred_1348 v_a v_a.$2215.Metal3 0.261774831272
Rred_1349 v_a v_a.$2237.Metal3 0.0908198394209
Rred_1350 v_a v_a.$39.Metal1 436.522572402
Rred_1351 v_a v_a.P0.nSD 5.15232451283
Rred_1352 v_a v_a.P0.pSD 17672.1543388
Rred_1353 v_a v_a.P2.nSD 10.0701647318
Rred_1354 v_a.$102.Metal1 v_a.$104.Metal1 0.370783637491
Rred_1355 v_a.$102.Metal1 v_a.$1208.Metal2 4.86558821398
Rred_1356 v_a.$102.Metal1 v_a.$1210.Metal2 12.0284307344
Rred_1357 v_a.$102.Metal1 v_a.$1212.Metal2 55.3977134276
Rred_1358 v_a.$102.Metal1 v_a.$2215.Metal3 529.941924087
Rred_1359 v_a.$102.Metal1 v_a.P2.pSD 5.04909626568
Rred_1360 v_a.$104.Metal1 v_a.$105.Metal1 0.18382334016
Rred_1361 v_a.$104.Metal1 v_a.$1210.Metal2 37.4749237892
Rred_1362 v_a.$104.Metal1 v_a.$1212.Metal2 9.93878641563
Rred_1363 v_a.$104.Metal1 v_a.$1216.Metal2 117.044118683
Rred_1364 v_a.$104.Metal1 v_a.$2219.Metal3 6131.19136113
Rred_1365 v_a.$104.Metal1 v_a.P2.pSD 11.4106916049
Rred_1366 v_a.$1047.Metal1 v_a.$1049.Metal1 0.370783637491
Rred_1367 v_a.$1047.Metal1 v_a.$2080.Metal2 3.63996241826
Rred_1368 v_a.$1047.Metal1 v_a.$2082.Metal2 55.3977134276
Rred_1369 v_a.$1047.Metal1 v_a.$2657.Metal3 206.732285942
Rred_1370 v_a.$1047.Metal1 v_a.$2668.Metal3 245.947735453
Rred_1371 v_a.$1047.Metal1 v_a.P32.pSD 5.04522893958
Rred_1372 v_a.$1049.Metal1 v_a.$1052.Metal1 0.569471076618
Rred_1373 v_a.$1049.Metal1 v_a.$2080.Metal2 37.4749237892
Rred_1374 v_a.$1049.Metal1 v_a.$2082.Metal2 10.861051193
Rred_1375 v_a.$1049.Metal1 v_a.$2084.Metal2 12.813283074
Rred_1376 v_a.$1049.Metal1 v_a.$2086.Metal2 28.7780838184
Rred_1377 v_a.$1049.Metal1 v_a.P32.pSD 6.90745785884
Rred_1378 v_a.$105.Metal1 v_a.$108.Metal1 0.566512086328
Rred_1379 v_a.$105.Metal1 v_a.$1212.Metal2 21.8217848391
Rred_1380 v_a.$105.Metal1 v_a.$1216.Metal2 8.52904190919
Rred_1381 v_a.$105.Metal1 v_a.$1218.Metal2 35.3953006003
Rred_1382 v_a.$105.Metal1 v_a.$2219.Metal3 1143.10347411
Rred_1383 v_a.$105.Metal1 v_a.P2.pSD 8.6177018446
Rred_1384 v_a.$1052.Metal1 v_a.$1054.Metal1 0.370503170053
Rred_1385 v_a.$1052.Metal1 v_a.$2084.Metal2 33.167961011
Rred_1386 v_a.$1052.Metal1 v_a.$2086.Metal2 13.6637463445
Rred_1387 v_a.$1052.Metal1 v_a.$2088.Metal2 10.0549886197
Rred_1388 v_a.$1052.Metal1 v_a.$2090.Metal2 29.6089214123
Rred_1389 v_a.$1052.Metal1 v_a.P32.pSD 6.88527440099
Rred_1390 v_a.$1054.Metal1 v_a.$1056.Metal1 0.370659032818
Rred_1391 v_a.$1054.Metal1 v_a.$2088.Metal2 90.9416871948
Rred_1392 v_a.$1054.Metal1 v_a.$2090.Metal2 13.176950573
Rred_1393 v_a.$1054.Metal1 v_a.$2092.Metal2 12.6410773702
Rred_1394 v_a.$1054.Metal1 v_a.$2094.Metal2 70.7621789924
Rred_1395 v_a.$1054.Metal1 v_a.P32.pSD 8.59117890847
Rred_1396 v_a.$1056.Metal1 v_a.$1058.Metal1 0.369657961965
Rred_1397 v_a.$1056.Metal1 v_a.$2092.Metal2 32.6594672273
Rred_1398 v_a.$1056.Metal1 v_a.$2094.Metal2 10.3991171827
Rred_1399 v_a.$1056.Metal1 v_a.$2096.Metal2 16.9226643368
Rred_1400 v_a.$1056.Metal1 v_a.P32.pSD 8.56005138923
Rred_1401 v_a.$1058.Metal1 v_a.$1060.Metal1 0.372830884673
Rred_1402 v_a.$1058.Metal1 v_a.$2096.Metal2 19.8481121624
Rred_1403 v_a.$1058.Metal1 v_a.$2098.Metal2 9.49733677338
Rred_1404 v_a.$1058.Metal1 v_a.$2100.Metal2 25.1212253845
Rred_1405 v_a.$1058.Metal1 v_a.P32.pSD 8.54074022007
Rred_1406 v_a.$1060.Metal1 v_a.$1062.Metal1 0.370821071381
Rred_1407 v_a.$1060.Metal1 v_a.$2098.Metal2 183.026070658
Rred_1408 v_a.$1060.Metal1 v_a.$2100.Metal2 14.3353397481
Rred_1409 v_a.$1060.Metal1 v_a.$2102.Metal2 11.6871559391
Rred_1410 v_a.$1060.Metal1 v_a.$2104.Metal2 49.0106171266
Rred_1411 v_a.$1060.Metal1 v_a.P32.pSD 8.54535706926
Rred_1412 v_a.$1062.Metal1 v_a.$2102.Metal2 41.1056788804
Rred_1413 v_a.$1062.Metal1 v_a.$2104.Metal2 11.1573275969
Rred_1414 v_a.$1062.Metal1 v_a.$2106.Metal2 2.71289515932
Rred_1415 v_a.$1062.Metal1 v_a.$2681.Metal3 15.990728426
Rred_1416 v_a.$1062.Metal1 v_a.P32.pSD 2.60065146165
Rred_1417 v_a.$108.Metal1 v_a.$110.Metal1 0.373579208763
Rred_1418 v_a.$108.Metal1 v_a.$1216.Metal2 27.4106868732
Rred_1419 v_a.$108.Metal1 v_a.$1218.Metal2 12.4877480346
Rred_1420 v_a.$108.Metal1 v_a.$1220.Metal2 11.2407084582
Rred_1421 v_a.$108.Metal1 v_a.$1222.Metal2 41.4114196223
Rred_1422 v_a.$108.Metal1 v_a.P2.pSD 6.89722592916
Rred_1423 v_a.$110.Metal1 v_a.$111.Metal1 0.181413945578
Rred_1424 v_a.$110.Metal1 v_a.$1220.Metal2 47.5464447516
Rred_1425 v_a.$110.Metal1 v_a.$1222.Metal2 11.6633971016
Rred_1426 v_a.$110.Metal1 v_a.$1224.Metal2 34.6335714285
Rred_1427 v_a.$110.Metal1 v_a.P2.pSD 11.3855792088
Rred_1428 v_a.$111.Metal1 v_a.$114.Metal1 0.569502917927
Rred_1429 v_a.$111.Metal1 v_a.$1224.Metal2 12.2236134454
Rred_1430 v_a.$111.Metal1 v_a.$1226.Metal2 13.2729560748
Rred_1431 v_a.$111.Metal1 v_a.$1228.Metal2 31.0637955233
Rred_1432 v_a.$111.Metal1 v_a.P2.pSD 8.62251782257
Rred_1433 v_a.$114.Metal1 v_a.$116.Metal1 0.370690076472
Rred_1434 v_a.$114.Metal1 v_a.$1226.Metal2 30.5784237182
Rred_1435 v_a.$114.Metal1 v_a.$1228.Metal2 13.1785511559
Rred_1436 v_a.$114.Metal1 v_a.$1230.Metal2 10.4883410906
Rred_1437 v_a.$114.Metal1 v_a.$1232.Metal2 33.5217341882
Rred_1438 v_a.$114.Metal1 v_a.P2.pSD 6.90649642181
Rred_1439 v_a.$1152.Metal2 v_a.$1154.Metal2 0.171804251886
Rred_1440 v_a.$1152.Metal2 v_a.$2187.Metal3 3.79196831658
Rred_1441 v_a.$1152.Metal2 v_a.$39.Metal1 3.64044681882
Rred_1442 v_a.$1152.Metal2 v_a.$41.Metal1 37.4749237892
Rred_1443 v_a.$1152.Metal2 v_a.P0.pSD 217.981582362
Rred_1444 v_a.$1154.Metal2 v_a.$1156.Metal2 0.171796584217
Rred_1445 v_a.$1154.Metal2 v_a.$1158.Metal2 4580.45571151
Rred_1446 v_a.$1154.Metal2 v_a.$2187.Metal3 12.1119512228
Rred_1447 v_a.$1154.Metal2 v_a.$2191.Metal3 36.7250760159
Rred_1448 v_a.$1154.Metal2 v_a.$39.Metal1 55.3977134276
Rred_1449 v_a.$1154.Metal2 v_a.$41.Metal1 10.861051193
Rred_1450 v_a.$1154.Metal2 v_a.P0.pSD 5185.30247334
Rred_1451 v_a.$1156.Metal2 v_a.$1158.Metal2 0.171778977614
Rred_1452 v_a.$1156.Metal2 v_a.$2187.Metal3 18.2892185628
Rred_1453 v_a.$1156.Metal2 v_a.$2191.Metal3 18.2892185628
Rred_1454 v_a.$1156.Metal2 v_a.$41.Metal1 12.813283074
Rred_1455 v_a.$1156.Metal2 v_a.$44.Metal1 33.167961011
Rred_1456 v_a.$1156.Metal2 v_a.P0.pSD 1019.41923732
Rred_1457 v_a.$1158.Metal2 v_a.$1160.Metal2 0.17180952381
Rred_1458 v_a.$1158.Metal2 v_a.$2187.Metal3 36.7250760159
Rred_1459 v_a.$1158.Metal2 v_a.$2191.Metal3 12.1119512228
Rred_1460 v_a.$1158.Metal2 v_a.$41.Metal1 28.7780838184
Rred_1461 v_a.$1158.Metal2 v_a.$44.Metal1 13.6637463445
Rred_1462 v_a.$1158.Metal2 v_a.P0.pSD 883.996133429
Rred_1463 v_a.$116.Metal1 v_a.$118.Metal1 0.370456410009
Rred_1464 v_a.$116.Metal1 v_a.$1230.Metal2 67.0434683763
Rred_1465 v_a.$116.Metal1 v_a.$1232.Metal2 12.5143710493
Rred_1466 v_a.$116.Metal1 v_a.$1234.Metal2 13.3178882685
Rred_1467 v_a.$116.Metal1 v_a.$1236.Metal2 97.9248412472
Rred_1468 v_a.$116.Metal1 v_a.P2.pSD 8.56044363188
Rred_1469 v_a.$1160.Metal2 v_a.$1162.Metal2 0.171805462272
Rred_1470 v_a.$1160.Metal2 v_a.$2191.Metal3 9
Rred_1471 v_a.$1160.Metal2 v_a.$44.Metal1 10.0549886197
Rred_1472 v_a.$1160.Metal2 v_a.$46.Metal1 90.9416871948
Rred_1473 v_a.$1160.Metal2 v_a.P0.pSD 8392.26908714
Rred_1474 v_a.$1162.Metal2 v_a.$1164.Metal2 0.17180952381
Rred_1475 v_a.$1162.Metal2 v_a.$2191.Metal3 18.07216
Rred_1476 v_a.$1162.Metal2 v_a.$2193.Metal3 18.07216
Rred_1477 v_a.$1162.Metal2 v_a.$44.Metal1 29.6089214123
Rred_1478 v_a.$1162.Metal2 v_a.$46.Metal1 13.176950573
Rred_1479 v_a.$1162.Metal2 v_a.P0.pSD 2776.32918515
Rred_1480 v_a.$1164.Metal2 v_a.$1166.Metal2 0.171804789608
Rred_1481 v_a.$1164.Metal2 v_a.$2193.Metal3 9
Rred_1482 v_a.$1164.Metal2 v_a.$46.Metal1 12.6410773702
Rred_1483 v_a.$1164.Metal2 v_a.$48.Metal1 32.6594672273
Rred_1484 v_a.$1164.Metal2 v_a.P0.pSD 3060.46451443
Rred_1485 v_a.$1166.Metal2 v_a.$1168.Metal2 0.171796584217
Rred_1486 v_a.$1166.Metal2 v_a.$1170.Metal2 4580.45571151
Rred_1487 v_a.$1166.Metal2 v_a.$2193.Metal3 12.1119512228
Rred_1488 v_a.$1166.Metal2 v_a.$2197.Metal3 36.7250760159
Rred_1489 v_a.$1166.Metal2 v_a.$46.Metal1 70.7621789924
Rred_1490 v_a.$1166.Metal2 v_a.$48.Metal1 10.3991171827
Rred_1491 v_a.$1166.Metal2 v_a.P0.pSD 6528.76976999
Rred_1492 v_a.$1168.Metal2 v_a.$1170.Metal2 0.171638104538
Rred_1493 v_a.$1168.Metal2 v_a.$2193.Metal3 18.2892185628
Rred_1494 v_a.$1168.Metal2 v_a.$2197.Metal3 17.7909243628
Rred_1495 v_a.$1168.Metal2 v_a.$48.Metal1 10.4209010807
Rred_1496 v_a.$1168.Metal2 v_a.P0.pSD 154.872911299
Rred_1497 v_a.$1170.Metal2 v_a.$2193.Metal3 36.7250760159
Rred_1498 v_a.$1170.Metal2 v_a.$2197.Metal3 1.70299888045
Rred_1499 v_a.$1170.Metal2 v_a.$48.Metal1 3.46525750559
Rred_1500 v_a.$1170.Metal2 v_a.P0.pSD 6.25273450038
Rred_1501 v_a.$118.Metal1 v_a.$1234.Metal2 28.9323394594
Rred_1502 v_a.$118.Metal1 v_a.$1236.Metal2 9.97223435282
Rred_1503 v_a.$118.Metal1 v_a.$1238.Metal2 10.2922018166
Rred_1504 v_a.$118.Metal1 v_a.$1240.Metal2 3.3929280778
Rred_1505 v_a.$118.Metal1 v_a.$2233.Metal3 36.1827777085
Rred_1506 v_a.$118.Metal1 v_a.P2.pSD 2.75258093262
Rred_1507 v_a.$1208.Metal2 v_a.$1210.Metal2 0.171796584217
Rred_1508 v_a.$1208.Metal2 v_a.$1212.Metal2 4580.45571151
Rred_1509 v_a.$1208.Metal2 v_a.$2215.Metal3 5.27192426225
Rred_1510 v_a.$1208.Metal2 v_a.$2219.Metal3 36.7250760159
Rred_1511 v_a.$1208.Metal2 v_a.P2.pSD 216.839777795
Rred_1512 v_a.$1210.Metal2 v_a.$1212.Metal2 0.171791313087
Rred_1513 v_a.$1210.Metal2 v_a.$2215.Metal3 18.2892185628
Rred_1514 v_a.$1210.Metal2 v_a.$2219.Metal3 18.2892185628
Rred_1515 v_a.$1210.Metal2 v_a.P2.pSD 3459.40109225
Rred_1516 v_a.$1212.Metal2 v_a.$1216.Metal2 0.350169891761
Rred_1517 v_a.$1212.Metal2 v_a.$2215.Metal3 36.7250760159
Rred_1518 v_a.$1212.Metal2 v_a.$2219.Metal3 7.29504620414
Rred_1519 v_a.$1212.Metal2 v_a.P2.pSD 5185.30247334
Rred_1520 v_a.$1216.Metal2 v_a.$1218.Metal2 0.171779352476
Rred_1521 v_a.$1216.Metal2 v_a.$1220.Metal2 4580.45571151
Rred_1522 v_a.$1216.Metal2 v_a.$2219.Metal3 7.29504620414
Rred_1523 v_a.$1216.Metal2 v_a.$2223.Metal3 36.7250760159
Rred_1524 v_a.$1216.Metal2 v_a.P2.pSD 870.857438241
Rred_1525 v_a.$1218.Metal2 v_a.$1220.Metal2 0.171796584217
Rred_1526 v_a.$1218.Metal2 v_a.$2219.Metal3 18.2892185628
Rred_1527 v_a.$1218.Metal2 v_a.$2223.Metal3 18.2892185628
Rred_1528 v_a.$1218.Metal2 v_a.P2.pSD 1093.25820632
Rred_1529 v_a.$1220.Metal2 v_a.$1222.Metal2 0.171803923335
Rred_1530 v_a.$1220.Metal2 v_a.$2219.Metal3 36.7250760159
Rred_1531 v_a.$1220.Metal2 v_a.$2223.Metal3 12.1119512228
Rred_1532 v_a.$1220.Metal2 v_a.P2.pSD 4386.8037359
Rred_1533 v_a.$1222.Metal2 v_a.$1224.Metal2 0.17180952381
Rred_1534 v_a.$1222.Metal2 v_a.$2223.Metal3 9
Rred_1535 v_a.$1222.Metal2 v_a.P2.pSD 3821.52330214
Rred_1536 v_a.$1224.Metal2 v_a.$1226.Metal2 0.171796584217
Rred_1537 v_a.$1224.Metal2 v_a.$1228.Metal2 4580.45571151
Rred_1538 v_a.$1224.Metal2 v_a.$2223.Metal3 12.1119512228
Rred_1539 v_a.$1224.Metal2 v_a.$2227.Metal3 36.7250760159
Rred_1540 v_a.$1226.Metal2 v_a.$1228.Metal2 0.171778890843
Rred_1541 v_a.$1226.Metal2 v_a.$2223.Metal3 18.2892185628
Rred_1542 v_a.$1226.Metal2 v_a.$2227.Metal3 18.2892185628
Rred_1543 v_a.$1226.Metal2 v_a.P2.pSD 939.482403583
Rred_1544 v_a.$1228.Metal2 v_a.$1230.Metal2 0.17180952381
Rred_1545 v_a.$1228.Metal2 v_a.$2223.Metal3 36.7250760159
Rred_1546 v_a.$1228.Metal2 v_a.$2227.Metal3 12.1119512228
Rred_1547 v_a.$1228.Metal2 v_a.P2.pSD 954.454780465
Rred_1548 v_a.$1230.Metal2 v_a.$1232.Metal2 0.171804655142
Rred_1549 v_a.$1230.Metal2 v_a.$2227.Metal3 9
Rred_1550 v_a.$1230.Metal2 v_a.P2.pSD 6275.67724127
Rred_1551 v_a.$1232.Metal2 v_a.$1234.Metal2 0.17180952381
Rred_1552 v_a.$1232.Metal2 v_a.$2227.Metal3 18.07216
Rred_1553 v_a.$1232.Metal2 v_a.$2229.Metal3 18.07216
Rred_1554 v_a.$1232.Metal2 v_a.P2.pSD 3095.90760546
Rred_1555 v_a.$1234.Metal2 v_a.$1236.Metal2 0.171805664182
Rred_1556 v_a.$1234.Metal2 v_a.$2229.Metal3 9
Rred_1557 v_a.$1234.Metal2 v_a.P2.pSD 2713.36743915
Rred_1558 v_a.$1236.Metal2 v_a.$1238.Metal2 0.171796584217
Rred_1559 v_a.$1236.Metal2 v_a.$1240.Metal2 4580.45571151
Rred_1560 v_a.$1236.Metal2 v_a.$2229.Metal3 12.1119512228
Rred_1561 v_a.$1236.Metal2 v_a.$2233.Metal3 36.7250760159
Rred_1562 v_a.$1236.Metal2 v_a.P2.pSD 9037.32323601
Rred_1563 v_a.$1238.Metal2 v_a.$1240.Metal2 0.171622097226
Rred_1564 v_a.$1238.Metal2 v_a.$2229.Metal3 18.2892185628
Rred_1565 v_a.$1238.Metal2 v_a.$2233.Metal3 18.1054578221
Rred_1566 v_a.$1238.Metal2 v_a.P2.pSD 180.95309757
Rred_1567 v_a.$1240.Metal2 v_a.$2229.Metal3 36.7250760159
Rred_1568 v_a.$1240.Metal2 v_a.$2233.Metal3 2.31478851444
Rred_1569 v_a.$1240.Metal2 v_a.P2.pSD 14.9103963342
Rred_1570 v_a.$1268.Metal2 v_a.$1270.Metal2 0.171804251886
Rred_1571 v_a.$1268.Metal2 v_a.$165.Metal1 3.64086945112
Rred_1572 v_a.$1268.Metal2 v_a.$167.Metal1 37.4749237892
Rred_1573 v_a.$1268.Metal2 v_a.$2237.Metal3 12.6445413137
Rred_1574 v_a.$1268.Metal2 v_a.$2247.Metal3 4.28679467249
Rred_1575 v_a.$1268.Metal2 v_a.P4.pSD 218.019013607
Rred_1576 v_a.$1270.Metal2 v_a.$1272.Metal2 0.171796584217
Rred_1577 v_a.$1270.Metal2 v_a.$1274.Metal2 4580.45571151
Rred_1578 v_a.$1270.Metal2 v_a.$165.Metal1 55.3977134276
Rred_1579 v_a.$1270.Metal2 v_a.$167.Metal1 10.861051193
Rred_1580 v_a.$1270.Metal2 v_a.$2247.Metal3 12.1119512228
Rred_1581 v_a.$1270.Metal2 v_a.$2251.Metal3 36.7250760159
Rred_1582 v_a.$1270.Metal2 v_a.P4.pSD 5185.30247334
Rred_1583 v_a.$1272.Metal2 v_a.$1274.Metal2 0.171796584217
Rred_1584 v_a.$1272.Metal2 v_a.$138.Metal1 21.8469840974
Rred_1585 v_a.$1272.Metal2 v_a.$167.Metal1 15.691422922
Rred_1586 v_a.$1272.Metal2 v_a.$2247.Metal3 18.2892185628
Rred_1587 v_a.$1272.Metal2 v_a.$2251.Metal3 18.2892185628
Rred_1588 v_a.$1272.Metal2 v_a.P4.pSD 1941.99314977
Rred_1589 v_a.$1274.Metal2 v_a.$1276.Metal2 0.17180952381
Rred_1590 v_a.$1274.Metal2 v_a.$138.Metal1 9
Rred_1591 v_a.$1274.Metal2 v_a.$2247.Metal3 36.7250760159
Rred_1592 v_a.$1274.Metal2 v_a.$2251.Metal3 12.1119512228
Rred_1593 v_a.$1276.Metal2 v_a.$1278.Metal2 0.17180952381
Rred_1594 v_a.$1276.Metal2 v_a.$138.Metal1 22.7516135642
Rred_1595 v_a.$1276.Metal2 v_a.$171.Metal1 15.232982625
Rred_1596 v_a.$1276.Metal2 v_a.$2251.Metal3 9
Rred_1597 v_a.$1276.Metal2 v_a.P4.pSD 2171.74493113
Rred_1598 v_a.$1278.Metal2 v_a.$1280.Metal2 0.171803923335
Rred_1599 v_a.$1278.Metal2 v_a.$171.Metal1 11.2407084582
Rred_1600 v_a.$1278.Metal2 v_a.$173.Metal1 47.5464447516
Rred_1601 v_a.$1278.Metal2 v_a.$2251.Metal3 18.07216
Rred_1602 v_a.$1278.Metal2 v_a.$2253.Metal3 18.07216
Rred_1603 v_a.$1278.Metal2 v_a.P4.pSD 4386.8037359
Rred_1604 v_a.$1280.Metal2 v_a.$1282.Metal2 0.17180952381
Rred_1605 v_a.$1280.Metal2 v_a.$171.Metal1 41.4114196223
Rred_1606 v_a.$1280.Metal2 v_a.$173.Metal1 11.6633971016
Rred_1607 v_a.$1280.Metal2 v_a.$2253.Metal3 9
Rred_1608 v_a.$1280.Metal2 v_a.P4.pSD 3821.52330214
Rred_1609 v_a.$1282.Metal2 v_a.$1284.Metal2 0.171794517426
Rred_1610 v_a.$1282.Metal2 v_a.$1286.Metal2 4580.45571151
Rred_1611 v_a.$1282.Metal2 v_a.$173.Metal1 14.3947435612
Rred_1612 v_a.$1282.Metal2 v_a.$175.Metal1 24.9332770497
Rred_1613 v_a.$1282.Metal2 v_a.$2253.Metal3 12.1119512228
Rred_1614 v_a.$1282.Metal2 v_a.$2257.Metal3 36.7250760159
Rred_1615 v_a.$1282.Metal2 v_a.P4.pSD 2308.30986002
Rred_1616 v_a.$1284.Metal2 v_a.$1286.Metal2 0.171796584217
Rred_1617 v_a.$1284.Metal2 v_a.$173.Metal1 211.932854922
Rred_1618 v_a.$1284.Metal2 v_a.$175.Metal1 9.42622357707
Rred_1619 v_a.$1284.Metal2 v_a.$2253.Metal3 18.2892185628
Rred_1620 v_a.$1284.Metal2 v_a.$2257.Metal3 18.2892185628
Rred_1621 v_a.$1284.Metal2 v_a.P4.pSD 19859.8763849
Rred_1622 v_a.$1286.Metal2 v_a.$1290.Metal2 0.350165557764
Rred_1623 v_a.$1286.Metal2 v_a.$175.Metal1 20.1626878851
Rred_1624 v_a.$1286.Metal2 v_a.$177.Metal1 10.0553586782
Rred_1625 v_a.$1286.Metal2 v_a.$178.Metal1 67.8514471145
Rred_1626 v_a.$1286.Metal2 v_a.$2253.Metal3 36.7250760159
Rred_1627 v_a.$1286.Metal2 v_a.$2257.Metal3 7.29501029581
Rred_1628 v_a.$1286.Metal2 v_a.P4.pSD 1896.72716074
Rred_1629 v_a.$1290.Metal2 v_a.$1292.Metal2 0.171791151867
Rred_1630 v_a.$1290.Metal2 v_a.$1294.Metal2 4580.45571151
Rred_1631 v_a.$1290.Metal2 v_a.$177.Metal1 25.2779901015
Rred_1632 v_a.$1290.Metal2 v_a.$178.Metal1 9.96988144972
Rred_1633 v_a.$1290.Metal2 v_a.$180.Metal1 41.1056788804
Rred_1634 v_a.$1290.Metal2 v_a.$2257.Metal3 7.29501029581
Rred_1635 v_a.$1290.Metal2 v_a.$2261.Metal3 36.7250760159
Rred_1636 v_a.$1290.Metal2 v_a.P4.pSD 3793.5757888
Rred_1637 v_a.$1292.Metal2 v_a.$1294.Metal2 0.171796584217
Rred_1638 v_a.$1292.Metal2 v_a.$178.Metal1 49.0106171266
Rred_1639 v_a.$1292.Metal2 v_a.$180.Metal1 11.1573275969
Rred_1640 v_a.$1292.Metal2 v_a.$2257.Metal3 18.2892185628
Rred_1641 v_a.$1292.Metal2 v_a.$2261.Metal3 18.2892185628
Rred_1642 v_a.$1292.Metal2 v_a.P4.pSD 4587.69246179
Rred_1643 v_a.$1294.Metal2 v_a.$180.Metal1 2.71289515932
Rred_1644 v_a.$1294.Metal2 v_a.$2257.Metal3 36.7250760159
Rred_1645 v_a.$1294.Metal2 v_a.$2261.Metal3 1.94343606645
Rred_1646 v_a.$1294.Metal2 v_a.P4.pSD 12.9001973441
Rred_1647 v_a.$1324.Metal2 v_a.$1326.Metal2 0.171796584217
Rred_1648 v_a.$1324.Metal2 v_a.$1328.Metal2 4580.45571151
Rred_1649 v_a.$1324.Metal2 v_a.$2275.Metal3 5.27192426225
Rred_1650 v_a.$1324.Metal2 v_a.$2279.Metal3 36.7250760159
Rred_1651 v_a.$1324.Metal2 v_a.$228.Metal1 4.86558821398
Rred_1652 v_a.$1324.Metal2 v_a.P6.pSD 216.839777795
Rred_1653 v_a.$1326.Metal2 v_a.$1328.Metal2 0.171791313087
Rred_1654 v_a.$1326.Metal2 v_a.$2275.Metal3 18.2892185628
Rred_1655 v_a.$1326.Metal2 v_a.$2279.Metal3 18.2892185628
Rred_1656 v_a.$1326.Metal2 v_a.$228.Metal1 12.0284307344
Rred_1657 v_a.$1326.Metal2 v_a.$230.Metal1 37.4749237892
Rred_1658 v_a.$1326.Metal2 v_a.P6.pSD 3459.40109225
Rred_1659 v_a.$1328.Metal2 v_a.$1332.Metal2 0.350169891761
Rred_1660 v_a.$1328.Metal2 v_a.$2275.Metal3 36.7250760159
Rred_1661 v_a.$1328.Metal2 v_a.$2279.Metal3 7.29504620414
Rred_1662 v_a.$1328.Metal2 v_a.$228.Metal1 55.3977134276
Rred_1663 v_a.$1328.Metal2 v_a.$230.Metal1 9.93878641563
Rred_1664 v_a.$1328.Metal2 v_a.$231.Metal1 21.8217848391
Rred_1665 v_a.$1328.Metal2 v_a.P6.pSD 5185.30247334
Rred_1666 v_a.$1332.Metal2 v_a.$1334.Metal2 0.171796584217
Rred_1667 v_a.$1332.Metal2 v_a.$1336.Metal2 4580.45571151
Rred_1668 v_a.$1332.Metal2 v_a.$2279.Metal3 7.29504620414
Rred_1669 v_a.$1332.Metal2 v_a.$2283.Metal3 36.7250760159
Rred_1670 v_a.$1332.Metal2 v_a.$230.Metal1 117.044118683
Rred_1671 v_a.$1332.Metal2 v_a.$231.Metal1 10.0649687733
Rred_1672 v_a.$1332.Metal2 v_a.$233.Metal1 17.886835549
Rred_1673 v_a.$1332.Metal2 v_a.P6.pSD 1757.39510867
Rred_1674 v_a.$1334.Metal2 v_a.$1336.Metal2 0.17179252329
Rred_1675 v_a.$1334.Metal2 v_a.$2279.Metal3 18.2892185628
Rred_1676 v_a.$1334.Metal2 v_a.$2283.Metal3 18.2892185628
Rred_1677 v_a.$1334.Metal2 v_a.$233.Metal1 10.0549886197
Rred_1678 v_a.$1334.Metal2 v_a.$235.Metal1 90.9416871948
Rred_1679 v_a.$1334.Metal2 v_a.P6.pSD 8392.26908714
Rred_1680 v_a.$1336.Metal2 v_a.$1338.Metal2 0.17180952381
Rred_1681 v_a.$1336.Metal2 v_a.$2279.Metal3 36.7250760159
Rred_1682 v_a.$1336.Metal2 v_a.$2283.Metal3 12.1119512228
Rred_1683 v_a.$1336.Metal2 v_a.$233.Metal1 29.6089214123
Rred_1684 v_a.$1336.Metal2 v_a.$235.Metal1 13.176950573
Rred_1685 v_a.$1336.Metal2 v_a.P6.pSD 2776.32918515
Rred_1686 v_a.$1338.Metal2 v_a.$1340.Metal2 0.171804789608
Rred_1687 v_a.$1338.Metal2 v_a.$2283.Metal3 9
Rred_1688 v_a.$1338.Metal2 v_a.$235.Metal1 12.6410773702
Rred_1689 v_a.$1338.Metal2 v_a.$237.Metal1 32.6594672273
Rred_1690 v_a.$1338.Metal2 v_a.P6.pSD 3060.46451443
Rred_1691 v_a.$1340.Metal2 v_a.$1342.Metal2 0.171796584217
Rred_1692 v_a.$1340.Metal2 v_a.$1344.Metal2 4580.45571151
Rred_1693 v_a.$1340.Metal2 v_a.$2283.Metal3 12.1119512228
Rred_1694 v_a.$1340.Metal2 v_a.$2287.Metal3 36.7250760159
Rred_1695 v_a.$1340.Metal2 v_a.$235.Metal1 70.7621789924
Rred_1696 v_a.$1340.Metal2 v_a.$237.Metal1 10.3991171827
Rred_1697 v_a.$1340.Metal2 v_a.P6.pSD 6528.76976999
Rred_1698 v_a.$1342.Metal2 v_a.$1344.Metal2 0.171778890843
Rred_1699 v_a.$1342.Metal2 v_a.$2283.Metal3 18.2892185628
Rred_1700 v_a.$1342.Metal2 v_a.$2287.Metal3 18.2892185628
Rred_1701 v_a.$1342.Metal2 v_a.$237.Metal1 13.2729560748
Rred_1702 v_a.$1342.Metal2 v_a.$240.Metal1 30.5784237182
Rred_1703 v_a.$1342.Metal2 v_a.P6.pSD 939.482403583
Rred_1704 v_a.$1344.Metal2 v_a.$1346.Metal2 0.17180952381
Rred_1705 v_a.$1344.Metal2 v_a.$2283.Metal3 36.7250760159
Rred_1706 v_a.$1344.Metal2 v_a.$2287.Metal3 12.1119512228
Rred_1707 v_a.$1344.Metal2 v_a.$237.Metal1 31.0637955233
Rred_1708 v_a.$1344.Metal2 v_a.$240.Metal1 13.1785511559
Rred_1709 v_a.$1344.Metal2 v_a.P6.pSD 954.454780465
Rred_1710 v_a.$1346.Metal2 v_a.$1348.Metal2 0.171804655142
Rred_1711 v_a.$1346.Metal2 v_a.$2287.Metal3 9
Rred_1712 v_a.$1346.Metal2 v_a.$240.Metal1 10.4883410906
Rred_1713 v_a.$1346.Metal2 v_a.$242.Metal1 67.0434683763
Rred_1714 v_a.$1346.Metal2 v_a.P6.pSD 6275.67724127
Rred_1715 v_a.$1348.Metal2 v_a.$1350.Metal2 0.171796584217
Rred_1716 v_a.$1348.Metal2 v_a.$1352.Metal2 4580.45571151
Rred_1717 v_a.$1348.Metal2 v_a.$2287.Metal3 12.1119512228
Rred_1718 v_a.$1348.Metal2 v_a.$2291.Metal3 36.7250760159
Rred_1719 v_a.$1348.Metal2 v_a.$240.Metal1 33.5217341882
Rred_1720 v_a.$1348.Metal2 v_a.$242.Metal1 12.5143710493
Rred_1721 v_a.$1348.Metal2 v_a.P6.pSD 3095.90760546
Rred_1722 v_a.$1350.Metal2 v_a.$1352.Metal2 0.171676348971
Rred_1723 v_a.$1350.Metal2 v_a.$2287.Metal3 18.2892185628
Rred_1724 v_a.$1350.Metal2 v_a.$2291.Metal3 18.060762443
Rred_1725 v_a.$1350.Metal2 v_a.$242.Metal1 9.88981728846
Rred_1726 v_a.$1350.Metal2 v_a.P6.pSD 254.193435339
Rred_1727 v_a.$1352.Metal2 v_a.$2287.Metal3 36.7250760159
Rred_1728 v_a.$1352.Metal2 v_a.$2291.Metal3 1.92968162701
Rred_1729 v_a.$1352.Metal2 v_a.$242.Metal1 3.1408468373
Rred_1730 v_a.$1352.Metal2 v_a.P6.pSD 10.1646717066
Rred_1731 v_a.$138.Metal1 v_a.$167.Metal1 0.375097689926
Rred_1732 v_a.$138.Metal1 v_a.$171.Metal1 0.364146195935
Rred_1733 v_a.$138.Metal1 v_a.P4.pSD 8.61500439093
Rred_1734 v_a.$1384.Metal2 v_a.$1386.Metal2 0.171804251886
Rred_1735 v_a.$1384.Metal2 v_a.$2297.Metal3 12.6445413137
Rred_1736 v_a.$1384.Metal2 v_a.$2307.Metal3 4.28679467249
Rred_1737 v_a.$1384.Metal2 v_a.$291.Metal1 3.64086945112
Rred_1738 v_a.$1384.Metal2 v_a.$293.Metal1 37.4749237892
Rred_1739 v_a.$1384.Metal2 v_a.P8.pSD 218.019013607
Rred_1740 v_a.$1386.Metal2 v_a.$1388.Metal2 0.171796584217
Rred_1741 v_a.$1386.Metal2 v_a.$1390.Metal2 4580.45571151
Rred_1742 v_a.$1386.Metal2 v_a.$2307.Metal3 12.1119512228
Rred_1743 v_a.$1386.Metal2 v_a.$2311.Metal3 36.7250760159
Rred_1744 v_a.$1386.Metal2 v_a.$291.Metal1 55.3977134276
Rred_1745 v_a.$1386.Metal2 v_a.$293.Metal1 10.861051193
Rred_1746 v_a.$1386.Metal2 v_a.P8.pSD 5185.30247334
Rred_1747 v_a.$1388.Metal2 v_a.$1390.Metal2 0.171778977614
Rred_1748 v_a.$1388.Metal2 v_a.$2307.Metal3 18.2892185628
Rred_1749 v_a.$1388.Metal2 v_a.$2311.Metal3 18.2892185628
Rred_1750 v_a.$1388.Metal2 v_a.$293.Metal1 12.813283074
Rred_1751 v_a.$1388.Metal2 v_a.$296.Metal1 33.167961011
Rred_1752 v_a.$1388.Metal2 v_a.P8.pSD 1019.41923732
Rred_1753 v_a.$1390.Metal2 v_a.$1392.Metal2 0.17180952381
Rred_1754 v_a.$1390.Metal2 v_a.$2307.Metal3 36.7250760159
Rred_1755 v_a.$1390.Metal2 v_a.$2311.Metal3 12.1119512228
Rred_1756 v_a.$1390.Metal2 v_a.$293.Metal1 28.7780838184
Rred_1757 v_a.$1390.Metal2 v_a.$296.Metal1 13.6637463445
Rred_1758 v_a.$1390.Metal2 v_a.P8.pSD 883.996133429
Rred_1759 v_a.$1392.Metal2 v_a.$1394.Metal2 0.171805462272
Rred_1760 v_a.$1392.Metal2 v_a.$2311.Metal3 9
Rred_1761 v_a.$1392.Metal2 v_a.$296.Metal1 10.0549886197
Rred_1762 v_a.$1392.Metal2 v_a.$298.Metal1 90.9416871948
Rred_1763 v_a.$1392.Metal2 v_a.P8.pSD 8392.26908714
Rred_1764 v_a.$1394.Metal2 v_a.$1396.Metal2 0.17180952381
Rred_1765 v_a.$1394.Metal2 v_a.$2311.Metal3 18.07216
Rred_1766 v_a.$1394.Metal2 v_a.$2313.Metal3 18.07216
Rred_1767 v_a.$1394.Metal2 v_a.$296.Metal1 29.6089214123
Rred_1768 v_a.$1394.Metal2 v_a.$298.Metal1 13.176950573
Rred_1769 v_a.$1394.Metal2 v_a.P8.pSD 2776.32918515
Rred_1770 v_a.$1396.Metal2 v_a.$1398.Metal2 0.171804789608
Rred_1771 v_a.$1396.Metal2 v_a.$2313.Metal3 9
Rred_1772 v_a.$1396.Metal2 v_a.$298.Metal1 12.6410773702
Rred_1773 v_a.$1396.Metal2 v_a.$300.Metal1 32.6594672273
Rred_1774 v_a.$1396.Metal2 v_a.P8.pSD 3060.46451443
Rred_1775 v_a.$1398.Metal2 v_a.$1400.Metal2 0.171796584217
Rred_1776 v_a.$1398.Metal2 v_a.$1402.Metal2 4580.45571151
Rred_1777 v_a.$1398.Metal2 v_a.$2313.Metal3 12.1119512228
Rred_1778 v_a.$1398.Metal2 v_a.$2317.Metal3 36.7250760159
Rred_1779 v_a.$1398.Metal2 v_a.$298.Metal1 70.7621789924
Rred_1780 v_a.$1398.Metal2 v_a.$300.Metal1 10.3991171827
Rred_1781 v_a.$1398.Metal2 v_a.P8.pSD 6528.76976999
Rred_1782 v_a.$1400.Metal2 v_a.$1402.Metal2 0.171778890843
Rred_1783 v_a.$1400.Metal2 v_a.$2313.Metal3 18.2892185628
Rred_1784 v_a.$1400.Metal2 v_a.$2317.Metal3 18.2892185628
Rred_1785 v_a.$1400.Metal2 v_a.$300.Metal1 13.2729560748
Rred_1786 v_a.$1400.Metal2 v_a.$303.Metal1 30.5784237182
Rred_1787 v_a.$1400.Metal2 v_a.P8.pSD 939.482403583
Rred_1788 v_a.$1402.Metal2 v_a.$1404.Metal2 0.17180952381
Rred_1789 v_a.$1402.Metal2 v_a.$2313.Metal3 36.7250760159
Rred_1790 v_a.$1402.Metal2 v_a.$2317.Metal3 12.1119512228
Rred_1791 v_a.$1402.Metal2 v_a.$300.Metal1 31.0637955233
Rred_1792 v_a.$1402.Metal2 v_a.$303.Metal1 13.1785511559
Rred_1793 v_a.$1402.Metal2 v_a.P8.pSD 954.454780465
Rred_1794 v_a.$1404.Metal2 v_a.$1406.Metal2 0.171804655142
Rred_1795 v_a.$1404.Metal2 v_a.$2317.Metal3 9
Rred_1796 v_a.$1404.Metal2 v_a.$303.Metal1 10.4883410906
Rred_1797 v_a.$1404.Metal2 v_a.$305.Metal1 67.0434683763
Rred_1798 v_a.$1404.Metal2 v_a.P8.pSD 6275.67724127
Rred_1799 v_a.$1406.Metal2 v_a.$1408.Metal2 0.171796584217
Rred_1800 v_a.$1406.Metal2 v_a.$1410.Metal2 4580.45571151
Rred_1801 v_a.$1406.Metal2 v_a.$2317.Metal3 12.1119512228
Rred_1802 v_a.$1406.Metal2 v_a.$2321.Metal3 36.7250760159
Rred_1803 v_a.$1406.Metal2 v_a.$303.Metal1 33.5217341882
Rred_1804 v_a.$1406.Metal2 v_a.$305.Metal1 12.5143710493
Rred_1805 v_a.$1406.Metal2 v_a.P8.pSD 3095.90760546
Rred_1806 v_a.$1408.Metal2 v_a.$1410.Metal2 0.171676348971
Rred_1807 v_a.$1408.Metal2 v_a.$2317.Metal3 18.2892185628
Rred_1808 v_a.$1408.Metal2 v_a.$2321.Metal3 18.060762443
Rred_1809 v_a.$1408.Metal2 v_a.$305.Metal1 9.88981728846
Rred_1810 v_a.$1408.Metal2 v_a.P8.pSD 254.193435339
Rred_1811 v_a.$1410.Metal2 v_a.$2317.Metal3 36.7250760159
Rred_1812 v_a.$1410.Metal2 v_a.$2321.Metal3 1.92968162701
Rred_1813 v_a.$1410.Metal2 v_a.$305.Metal1 3.1408468373
Rred_1814 v_a.$1410.Metal2 v_a.P8.pSD 10.1646717066
Rred_1815 v_a.$1442.Metal2 v_a.$1444.Metal2 0.171804251886
Rred_1816 v_a.$1442.Metal2 v_a.$2327.Metal3 12.6445413137
Rred_1817 v_a.$1442.Metal2 v_a.$2337.Metal3 4.28679467249
Rred_1818 v_a.$1442.Metal2 v_a.$354.Metal1 3.64086945112
Rred_1819 v_a.$1442.Metal2 v_a.$356.Metal1 37.4749237892
Rred_1820 v_a.$1442.Metal2 v_a.P10.pSD 218.019013607
Rred_1821 v_a.$1444.Metal2 v_a.$1446.Metal2 0.171796584217
Rred_1822 v_a.$1444.Metal2 v_a.$1448.Metal2 4580.45571151
Rred_1823 v_a.$1444.Metal2 v_a.$2337.Metal3 12.1119512228
Rred_1824 v_a.$1444.Metal2 v_a.$2341.Metal3 36.7250760159
Rred_1825 v_a.$1444.Metal2 v_a.$354.Metal1 55.3977134276
Rred_1826 v_a.$1444.Metal2 v_a.$356.Metal1 10.861051193
Rred_1827 v_a.$1444.Metal2 v_a.P10.pSD 5185.30247334
Rred_1828 v_a.$1446.Metal2 v_a.$1448.Metal2 0.171778977614
Rred_1829 v_a.$1446.Metal2 v_a.$2337.Metal3 18.2892185628
Rred_1830 v_a.$1446.Metal2 v_a.$2341.Metal3 18.2892185628
Rred_1831 v_a.$1446.Metal2 v_a.$356.Metal1 12.813283074
Rred_1832 v_a.$1446.Metal2 v_a.$359.Metal1 33.167961011
Rred_1833 v_a.$1446.Metal2 v_a.P10.pSD 1019.41923732
Rred_1834 v_a.$1448.Metal2 v_a.$1450.Metal2 0.17180952381
Rred_1835 v_a.$1448.Metal2 v_a.$2337.Metal3 36.7250760159
Rred_1836 v_a.$1448.Metal2 v_a.$2341.Metal3 12.1119512228
Rred_1837 v_a.$1448.Metal2 v_a.$356.Metal1 28.7780838184
Rred_1838 v_a.$1448.Metal2 v_a.$359.Metal1 13.6637463445
Rred_1839 v_a.$1448.Metal2 v_a.P10.pSD 883.996133429
Rred_1840 v_a.$1450.Metal2 v_a.$1452.Metal2 0.171805462272
Rred_1841 v_a.$1450.Metal2 v_a.$2341.Metal3 9
Rred_1842 v_a.$1450.Metal2 v_a.$359.Metal1 10.0549886197
Rred_1843 v_a.$1450.Metal2 v_a.$361.Metal1 90.9416871948
Rred_1844 v_a.$1450.Metal2 v_a.P10.pSD 8392.26908714
Rred_1845 v_a.$1452.Metal2 v_a.$1454.Metal2 0.17180952381
Rred_1846 v_a.$1452.Metal2 v_a.$2341.Metal3 18.07216
Rred_1847 v_a.$1452.Metal2 v_a.$2343.Metal3 18.07216
Rred_1848 v_a.$1452.Metal2 v_a.$359.Metal1 29.6089214123
Rred_1849 v_a.$1452.Metal2 v_a.$361.Metal1 13.176950573
Rred_1850 v_a.$1452.Metal2 v_a.P10.pSD 2776.32918515
Rred_1851 v_a.$1454.Metal2 v_a.$1456.Metal2 0.171804789608
Rred_1852 v_a.$1454.Metal2 v_a.$2343.Metal3 9
Rred_1853 v_a.$1454.Metal2 v_a.$361.Metal1 12.6410773702
Rred_1854 v_a.$1454.Metal2 v_a.$363.Metal1 32.6594672273
Rred_1855 v_a.$1454.Metal2 v_a.P10.pSD 3060.46451443
Rred_1856 v_a.$1456.Metal2 v_a.$1458.Metal2 0.171796584217
Rred_1857 v_a.$1456.Metal2 v_a.$1460.Metal2 4580.45571151
Rred_1858 v_a.$1456.Metal2 v_a.$2343.Metal3 12.1119512228
Rred_1859 v_a.$1456.Metal2 v_a.$2347.Metal3 36.7250760159
Rred_1860 v_a.$1456.Metal2 v_a.$361.Metal1 70.7621789924
Rred_1861 v_a.$1456.Metal2 v_a.$363.Metal1 10.3991171827
Rred_1862 v_a.$1456.Metal2 v_a.P10.pSD 6528.76976999
Rred_1863 v_a.$1458.Metal2 v_a.$1460.Metal2 0.171778890843
Rred_1864 v_a.$1458.Metal2 v_a.$2343.Metal3 18.2892185628
Rred_1865 v_a.$1458.Metal2 v_a.$2347.Metal3 18.2892185628
Rred_1866 v_a.$1458.Metal2 v_a.$363.Metal1 13.2729560748
Rred_1867 v_a.$1458.Metal2 v_a.$366.Metal1 30.5784237182
Rred_1868 v_a.$1458.Metal2 v_a.P10.pSD 939.482403583
Rred_1869 v_a.$1460.Metal2 v_a.$1462.Metal2 0.17180952381
Rred_1870 v_a.$1460.Metal2 v_a.$2343.Metal3 36.7250760159
Rred_1871 v_a.$1460.Metal2 v_a.$2347.Metal3 12.1119512228
Rred_1872 v_a.$1460.Metal2 v_a.$363.Metal1 31.0637955233
Rred_1873 v_a.$1460.Metal2 v_a.$366.Metal1 13.1785511559
Rred_1874 v_a.$1460.Metal2 v_a.P10.pSD 954.454780465
Rred_1875 v_a.$1462.Metal2 v_a.$1464.Metal2 0.171804655142
Rred_1876 v_a.$1462.Metal2 v_a.$2347.Metal3 9
Rred_1877 v_a.$1462.Metal2 v_a.$366.Metal1 10.4883410906
Rred_1878 v_a.$1462.Metal2 v_a.$368.Metal1 67.0434683763
Rred_1879 v_a.$1462.Metal2 v_a.P10.pSD 6275.67724127
Rred_1880 v_a.$1464.Metal2 v_a.$1466.Metal2 0.171796584217
Rred_1881 v_a.$1464.Metal2 v_a.$1468.Metal2 4580.45571151
Rred_1882 v_a.$1464.Metal2 v_a.$2347.Metal3 12.1119512228
Rred_1883 v_a.$1464.Metal2 v_a.$2351.Metal3 36.7250760159
Rred_1884 v_a.$1464.Metal2 v_a.$366.Metal1 33.5217341882
Rred_1885 v_a.$1464.Metal2 v_a.$368.Metal1 12.5143710493
Rred_1886 v_a.$1464.Metal2 v_a.P10.pSD 3095.90760546
Rred_1887 v_a.$1466.Metal2 v_a.$1468.Metal2 0.171676348971
Rred_1888 v_a.$1466.Metal2 v_a.$2347.Metal3 18.2892185628
Rred_1889 v_a.$1466.Metal2 v_a.$2351.Metal3 18.060762443
Rred_1890 v_a.$1466.Metal2 v_a.$368.Metal1 9.88981728846
Rred_1891 v_a.$1466.Metal2 v_a.P10.pSD 254.193435339
Rred_1892 v_a.$1468.Metal2 v_a.$2347.Metal3 36.7250760159
Rred_1893 v_a.$1468.Metal2 v_a.$2351.Metal3 1.92968162701
Rred_1894 v_a.$1468.Metal2 v_a.$368.Metal1 3.1408468373
Rred_1895 v_a.$1468.Metal2 v_a.P10.pSD 10.1646717066
Rred_1896 v_a.$1500.Metal2 v_a.$1502.Metal2 0.171804251886
Rred_1897 v_a.$1500.Metal2 v_a.$2365.Metal3 6.60812863076
Rred_1898 v_a.$1500.Metal2 v_a.$2367.Metal3 6.14797312204
Rred_1899 v_a.$1500.Metal2 v_a.$417.Metal1 3.64185029076
Rred_1900 v_a.$1500.Metal2 v_a.$419.Metal1 37.4749237892
Rred_1901 v_a.$1500.Metal2 v_a.P12.pSD 218.105899607
Rred_1902 v_a.$1502.Metal2 v_a.$1504.Metal2 0.171796584217
Rred_1903 v_a.$1502.Metal2 v_a.$1506.Metal2 4580.45571151
Rred_1904 v_a.$1502.Metal2 v_a.$2367.Metal3 12.1119512228
Rred_1905 v_a.$1502.Metal2 v_a.$2371.Metal3 36.7250760159
Rred_1906 v_a.$1502.Metal2 v_a.$417.Metal1 55.3977134276
Rred_1907 v_a.$1502.Metal2 v_a.$419.Metal1 10.861051193
Rred_1908 v_a.$1502.Metal2 v_a.P12.pSD 5185.30247334
Rred_1909 v_a.$1504.Metal2 v_a.$1506.Metal2 0.171778977614
Rred_1910 v_a.$1504.Metal2 v_a.$2367.Metal3 18.2892185628
Rred_1911 v_a.$1504.Metal2 v_a.$2371.Metal3 18.2892185628
Rred_1912 v_a.$1504.Metal2 v_a.$419.Metal1 12.813283074
Rred_1913 v_a.$1504.Metal2 v_a.$422.Metal1 33.167961011
Rred_1914 v_a.$1504.Metal2 v_a.P12.pSD 1019.41923732
Rred_1915 v_a.$1506.Metal2 v_a.$1508.Metal2 0.17180952381
Rred_1916 v_a.$1506.Metal2 v_a.$2367.Metal3 36.7250760159
Rred_1917 v_a.$1506.Metal2 v_a.$2371.Metal3 12.1119512228
Rred_1918 v_a.$1506.Metal2 v_a.$419.Metal1 28.7780838184
Rred_1919 v_a.$1506.Metal2 v_a.$422.Metal1 13.6637463445
Rred_1920 v_a.$1506.Metal2 v_a.P12.pSD 883.996133429
Rred_1921 v_a.$1508.Metal2 v_a.$1510.Metal2 0.171805462272
Rred_1922 v_a.$1508.Metal2 v_a.$2371.Metal3 9
Rred_1923 v_a.$1508.Metal2 v_a.$422.Metal1 10.0549886197
Rred_1924 v_a.$1508.Metal2 v_a.$424.Metal1 90.9416871948
Rred_1925 v_a.$1508.Metal2 v_a.P12.pSD 8392.26908714
Rred_1926 v_a.$1510.Metal2 v_a.$1512.Metal2 0.17180952381
Rred_1927 v_a.$1510.Metal2 v_a.$2371.Metal3 18.07216
Rred_1928 v_a.$1510.Metal2 v_a.$2373.Metal3 18.07216
Rred_1929 v_a.$1510.Metal2 v_a.$422.Metal1 29.6089214123
Rred_1930 v_a.$1510.Metal2 v_a.$424.Metal1 13.176950573
Rred_1931 v_a.$1510.Metal2 v_a.P12.pSD 2776.32918515
Rred_1932 v_a.$1512.Metal2 v_a.$1514.Metal2 0.171804789608
Rred_1933 v_a.$1512.Metal2 v_a.$2373.Metal3 9
Rred_1934 v_a.$1512.Metal2 v_a.$424.Metal1 12.6410773702
Rred_1935 v_a.$1512.Metal2 v_a.$426.Metal1 32.6594672273
Rred_1936 v_a.$1512.Metal2 v_a.P12.pSD 3060.46451443
Rred_1937 v_a.$1514.Metal2 v_a.$1516.Metal2 0.171796584217
Rred_1938 v_a.$1514.Metal2 v_a.$1518.Metal2 4580.45571151
Rred_1939 v_a.$1514.Metal2 v_a.$2373.Metal3 12.1119512228
Rred_1940 v_a.$1514.Metal2 v_a.$2377.Metal3 36.7250760159
Rred_1941 v_a.$1514.Metal2 v_a.$424.Metal1 70.7621789924
Rred_1942 v_a.$1514.Metal2 v_a.$426.Metal1 10.3991171827
Rred_1943 v_a.$1514.Metal2 v_a.P12.pSD 6528.76976999
Rred_1944 v_a.$1516.Metal2 v_a.$1518.Metal2 0.171778890843
Rred_1945 v_a.$1516.Metal2 v_a.$2373.Metal3 18.2892185628
Rred_1946 v_a.$1516.Metal2 v_a.$2377.Metal3 18.2892185628
Rred_1947 v_a.$1516.Metal2 v_a.$426.Metal1 13.2729560748
Rred_1948 v_a.$1516.Metal2 v_a.$429.Metal1 30.5784237182
Rred_1949 v_a.$1516.Metal2 v_a.P12.pSD 939.482403583
Rred_1950 v_a.$1518.Metal2 v_a.$1520.Metal2 0.17180952381
Rred_1951 v_a.$1518.Metal2 v_a.$2373.Metal3 36.7250760159
Rred_1952 v_a.$1518.Metal2 v_a.$2377.Metal3 12.1119512228
Rred_1953 v_a.$1518.Metal2 v_a.$426.Metal1 31.0637955233
Rred_1954 v_a.$1518.Metal2 v_a.$429.Metal1 13.1785511559
Rred_1955 v_a.$1518.Metal2 v_a.P12.pSD 954.454780465
Rred_1956 v_a.$1520.Metal2 v_a.$1522.Metal2 0.171804655142
Rred_1957 v_a.$1520.Metal2 v_a.$2377.Metal3 9
Rred_1958 v_a.$1520.Metal2 v_a.$429.Metal1 10.4883410906
Rred_1959 v_a.$1520.Metal2 v_a.$431.Metal1 67.0434683763
Rred_1960 v_a.$1520.Metal2 v_a.P12.pSD 6275.67724127
Rred_1961 v_a.$1522.Metal2 v_a.$1524.Metal2 0.171796584217
Rred_1962 v_a.$1522.Metal2 v_a.$1526.Metal2 4580.45571151
Rred_1963 v_a.$1522.Metal2 v_a.$2377.Metal3 12.1119512228
Rred_1964 v_a.$1522.Metal2 v_a.$2381.Metal3 36.7250760159
Rred_1965 v_a.$1522.Metal2 v_a.$429.Metal1 33.5217341882
Rred_1966 v_a.$1522.Metal2 v_a.$431.Metal1 12.5143710493
Rred_1967 v_a.$1522.Metal2 v_a.P12.pSD 3095.90760546
Rred_1968 v_a.$1524.Metal2 v_a.$1526.Metal2 0.171676348971
Rred_1969 v_a.$1524.Metal2 v_a.$2377.Metal3 18.2892185628
Rred_1970 v_a.$1524.Metal2 v_a.$2381.Metal3 18.060762443
Rred_1971 v_a.$1524.Metal2 v_a.$431.Metal1 9.88981728846
Rred_1972 v_a.$1524.Metal2 v_a.P12.pSD 254.193435339
Rred_1973 v_a.$1526.Metal2 v_a.$2377.Metal3 36.7250760159
Rred_1974 v_a.$1526.Metal2 v_a.$2381.Metal3 1.92968162701
Rred_1975 v_a.$1526.Metal2 v_a.$431.Metal1 3.1408468373
Rred_1976 v_a.$1526.Metal2 v_a.P12.pSD 10.1646717066
Rred_1977 v_a.$1558.Metal2 v_a.$1560.Metal2 0.171804251886
Rred_1978 v_a.$1558.Metal2 v_a.$2387.Metal3 12.6445413137
Rred_1979 v_a.$1558.Metal2 v_a.$2397.Metal3 4.28679467249
Rred_1980 v_a.$1558.Metal2 v_a.$480.Metal1 3.64086945112
Rred_1981 v_a.$1558.Metal2 v_a.$482.Metal1 37.4749237892
Rred_1982 v_a.$1558.Metal2 v_a.P14.pSD 218.019013607
Rred_1983 v_a.$1560.Metal2 v_a.$1562.Metal2 0.171796584217
Rred_1984 v_a.$1560.Metal2 v_a.$1564.Metal2 4580.45571151
Rred_1985 v_a.$1560.Metal2 v_a.$2397.Metal3 12.1119512228
Rred_1986 v_a.$1560.Metal2 v_a.$2401.Metal3 36.7250760159
Rred_1987 v_a.$1560.Metal2 v_a.$480.Metal1 55.3977134276
Rred_1988 v_a.$1560.Metal2 v_a.$482.Metal1 10.861051193
Rred_1989 v_a.$1560.Metal2 v_a.P14.pSD 5185.30247334
Rred_1990 v_a.$1562.Metal2 v_a.$1564.Metal2 0.171778977614
Rred_1991 v_a.$1562.Metal2 v_a.$2397.Metal3 18.2892185628
Rred_1992 v_a.$1562.Metal2 v_a.$2401.Metal3 18.2892185628
Rred_1993 v_a.$1562.Metal2 v_a.$482.Metal1 12.813283074
Rred_1994 v_a.$1562.Metal2 v_a.$485.Metal1 33.167961011
Rred_1995 v_a.$1562.Metal2 v_a.P14.pSD 1019.41923732
Rred_1996 v_a.$1564.Metal2 v_a.$1566.Metal2 0.17180952381
Rred_1997 v_a.$1564.Metal2 v_a.$2397.Metal3 36.7250760159
Rred_1998 v_a.$1564.Metal2 v_a.$2401.Metal3 12.1119512228
Rred_1999 v_a.$1564.Metal2 v_a.$482.Metal1 28.7780838184
Rred_2000 v_a.$1564.Metal2 v_a.$485.Metal1 13.6637463445
Rred_2001 v_a.$1564.Metal2 v_a.P14.pSD 883.996133429
Rred_2002 v_a.$1566.Metal2 v_a.$1568.Metal2 0.171805462272
Rred_2003 v_a.$1566.Metal2 v_a.$2401.Metal3 9
Rred_2004 v_a.$1566.Metal2 v_a.$485.Metal1 10.0549886197
Rred_2005 v_a.$1566.Metal2 v_a.$487.Metal1 90.9416871948
Rred_2006 v_a.$1566.Metal2 v_a.P14.pSD 8392.26908714
Rred_2007 v_a.$1568.Metal2 v_a.$1570.Metal2 0.17180952381
Rred_2008 v_a.$1568.Metal2 v_a.$2401.Metal3 18.07216
Rred_2009 v_a.$1568.Metal2 v_a.$2403.Metal3 18.07216
Rred_2010 v_a.$1568.Metal2 v_a.$485.Metal1 29.6089214123
Rred_2011 v_a.$1568.Metal2 v_a.$487.Metal1 13.176950573
Rred_2012 v_a.$1568.Metal2 v_a.P14.pSD 2776.32918515
Rred_2013 v_a.$1570.Metal2 v_a.$1572.Metal2 0.171804789608
Rred_2014 v_a.$1570.Metal2 v_a.$2403.Metal3 9
Rred_2015 v_a.$1570.Metal2 v_a.$487.Metal1 12.6410773702
Rred_2016 v_a.$1570.Metal2 v_a.$489.Metal1 32.6594672273
Rred_2017 v_a.$1570.Metal2 v_a.P14.pSD 3060.46451443
Rred_2018 v_a.$1572.Metal2 v_a.$1574.Metal2 0.171796584217
Rred_2019 v_a.$1572.Metal2 v_a.$1576.Metal2 4580.45571151
Rred_2020 v_a.$1572.Metal2 v_a.$2403.Metal3 12.1119512228
Rred_2021 v_a.$1572.Metal2 v_a.$2407.Metal3 36.7250760159
Rred_2022 v_a.$1572.Metal2 v_a.$487.Metal1 70.7621789924
Rred_2023 v_a.$1572.Metal2 v_a.$489.Metal1 10.3991171827
Rred_2024 v_a.$1572.Metal2 v_a.P14.pSD 6528.76976999
Rred_2025 v_a.$1574.Metal2 v_a.$1576.Metal2 0.171638104538
Rred_2026 v_a.$1574.Metal2 v_a.$2403.Metal3 18.2892185628
Rred_2027 v_a.$1574.Metal2 v_a.$2407.Metal3 17.7909243628
Rred_2028 v_a.$1574.Metal2 v_a.$489.Metal1 10.4209010807
Rred_2029 v_a.$1574.Metal2 v_a.P14.pSD 154.872911299
Rred_2030 v_a.$1576.Metal2 v_a.$2403.Metal3 36.7250760159
Rred_2031 v_a.$1576.Metal2 v_a.$2407.Metal3 1.70299888045
Rred_2032 v_a.$1576.Metal2 v_a.$489.Metal1 3.46525750559
Rred_2033 v_a.$1576.Metal2 v_a.P14.pSD 6.25273450038
Rred_2034 v_a.$165.Metal1 v_a.$167.Metal1 0.370783637491
Rred_2035 v_a.$165.Metal1 v_a.$2237.Metal3 264.637085427
Rred_2036 v_a.$165.Metal1 v_a.$2247.Metal3 192.51795956
Rred_2037 v_a.$165.Metal1 v_a.P4.pSD 5.04522986703
Rred_2038 v_a.$167.Metal1 v_a.P4.pSD 8.50132726037
Rred_2039 v_a.$1674.Metal2 v_a.$1676.Metal2 0.171804251886
Rred_2040 v_a.$1674.Metal2 v_a.$2447.Metal3 7.89774698854
Rred_2041 v_a.$1674.Metal2 v_a.$2458.Metal3 5.4765147338
Rred_2042 v_a.$1674.Metal2 v_a.$606.Metal1 3.63996241826
Rred_2043 v_a.$1674.Metal2 v_a.$608.Metal1 37.4749237892
Rred_2044 v_a.$1674.Metal2 v_a.P18.pSD 217.94126282
Rred_2045 v_a.$1676.Metal2 v_a.$1678.Metal2 0.17180952381
Rred_2046 v_a.$1676.Metal2 v_a.$2458.Metal3 9
Rred_2047 v_a.$1676.Metal2 v_a.$606.Metal1 55.3977134276
Rred_2048 v_a.$1676.Metal2 v_a.$608.Metal1 10.861051193
Rred_2049 v_a.$1676.Metal2 v_a.P18.pSD 5185.30247334
Rred_2050 v_a.$1678.Metal2 v_a.$1680.Metal2 0.171778977614
Rred_2051 v_a.$1678.Metal2 v_a.$1682.Metal2 4580.45571151
Rred_2052 v_a.$1678.Metal2 v_a.$2458.Metal3 12.1119512228
Rred_2053 v_a.$1678.Metal2 v_a.$2462.Metal3 36.7250760159
Rred_2054 v_a.$1678.Metal2 v_a.$608.Metal1 12.813283074
Rred_2055 v_a.$1678.Metal2 v_a.$611.Metal1 33.167961011
Rred_2056 v_a.$1678.Metal2 v_a.P18.pSD 1019.41923732
Rred_2057 v_a.$1680.Metal2 v_a.$1682.Metal2 0.171796584217
Rred_2058 v_a.$1680.Metal2 v_a.$2458.Metal3 18.2892185628
Rred_2059 v_a.$1680.Metal2 v_a.$2462.Metal3 18.2892185628
Rred_2060 v_a.$1680.Metal2 v_a.$608.Metal1 28.7780838184
Rred_2061 v_a.$1680.Metal2 v_a.$611.Metal1 13.6637463445
Rred_2062 v_a.$1680.Metal2 v_a.P18.pSD 883.996133429
Rred_2063 v_a.$1682.Metal2 v_a.$2458.Metal3 36.7250760159
Rred_2064 v_a.$1682.Metal2 v_a.$2462.Metal3 1.71373932507
Rred_2065 v_a.$1682.Metal2 v_a.$611.Metal1 2.6908076635
Rred_2066 v_a.$1682.Metal2 v_a.P18.pSD 6.35159917262
Rred_2067 v_a.$171.Metal1 v_a.$173.Metal1 0.373579208763
Rred_2068 v_a.$171.Metal1 v_a.P4.pSD 8.57593577924
Rred_2069 v_a.$173.Metal1 v_a.$175.Metal1 0.370041492721
Rred_2070 v_a.$173.Metal1 v_a.P4.pSD 8.54551478917
Rred_2071 v_a.$1732.Metal2 v_a.$1734.Metal2 0.171804251886
Rred_2072 v_a.$1732.Metal2 v_a.$2485.Metal3 4.8784056912
Rred_2073 v_a.$1732.Metal2 v_a.$2488.Metal3 9.28330943793
Rred_2074 v_a.$1732.Metal2 v_a.$669.Metal1 3.64166265892
Rred_2075 v_a.$1732.Metal2 v_a.$671.Metal1 37.4749237892
Rred_2076 v_a.$1732.Metal2 v_a.P20.pSD 218.090799297
Rred_2077 v_a.$1734.Metal2 v_a.$1736.Metal2 0.17180952381
Rred_2078 v_a.$1734.Metal2 v_a.$2488.Metal3 9
Rred_2079 v_a.$1734.Metal2 v_a.$669.Metal1 55.3977134276
Rred_2080 v_a.$1734.Metal2 v_a.$671.Metal1 10.861051193
Rred_2081 v_a.$1734.Metal2 v_a.P20.pSD 5185.30247334
Rred_2082 v_a.$1736.Metal2 v_a.$1738.Metal2 0.171791914555
Rred_2083 v_a.$1736.Metal2 v_a.$2488.Metal3 18.07216
Rred_2084 v_a.$1736.Metal2 v_a.$2490.Metal3 18.07216
Rred_2085 v_a.$1736.Metal2 v_a.$671.Metal1 12.813283074
Rred_2086 v_a.$1736.Metal2 v_a.$674.Metal1 33.167961011
Rred_2087 v_a.$1736.Metal2 v_a.P20.pSD 1019.41923732
Rred_2088 v_a.$1738.Metal2 v_a.$1740.Metal2 0.17180952381
Rred_2089 v_a.$1738.Metal2 v_a.$2490.Metal3 9
Rred_2090 v_a.$1738.Metal2 v_a.$671.Metal1 28.7780838184
Rred_2091 v_a.$1738.Metal2 v_a.$674.Metal1 13.6637463445
Rred_2092 v_a.$1738.Metal2 v_a.P20.pSD 883.996133429
Rred_2093 v_a.$1740.Metal2 v_a.$1742.Metal2 0.171796790359
Rred_2094 v_a.$1740.Metal2 v_a.$2490.Metal3 13.5901279684
Rred_2095 v_a.$1740.Metal2 v_a.$2493.Metal3 27.2892185628
Rred_2096 v_a.$1740.Metal2 v_a.$674.Metal1 10.0549886197
Rred_2097 v_a.$1740.Metal2 v_a.$676.Metal1 90.9416871948
Rred_2098 v_a.$1740.Metal2 v_a.P20.pSD 8392.26908714
Rred_2099 v_a.$1742.Metal2 v_a.$1744.Metal2 0.17180952381
Rred_2100 v_a.$1742.Metal2 v_a.$2490.Metal3 27.2892185628
Rred_2101 v_a.$1742.Metal2 v_a.$2493.Metal3 13.5901279684
Rred_2102 v_a.$1742.Metal2 v_a.$674.Metal1 29.6089214123
Rred_2103 v_a.$1742.Metal2 v_a.$676.Metal1 13.176950573
Rred_2104 v_a.$1742.Metal2 v_a.P20.pSD 2776.32918515
Rred_2105 v_a.$1744.Metal2 v_a.$1746.Metal2 0.171804789608
Rred_2106 v_a.$1744.Metal2 v_a.$2493.Metal3 9
Rred_2107 v_a.$1744.Metal2 v_a.$676.Metal1 12.6410773702
Rred_2108 v_a.$1744.Metal2 v_a.$678.Metal1 32.6594672273
Rred_2109 v_a.$1744.Metal2 v_a.P20.pSD 3060.46451443
Rred_2110 v_a.$1746.Metal2 v_a.$1748.Metal2 0.171796584217
Rred_2111 v_a.$1746.Metal2 v_a.$1750.Metal2 4580.45571151
Rred_2112 v_a.$1746.Metal2 v_a.$2493.Metal3 12.1119512228
Rred_2113 v_a.$1746.Metal2 v_a.$2497.Metal3 36.7250760159
Rred_2114 v_a.$1746.Metal2 v_a.$676.Metal1 70.7621789924
Rred_2115 v_a.$1746.Metal2 v_a.$678.Metal1 10.3991171827
Rred_2116 v_a.$1746.Metal2 v_a.P20.pSD 6528.76976999
Rred_2117 v_a.$1748.Metal2 v_a.$1750.Metal2 0.171778890843
Rred_2118 v_a.$1748.Metal2 v_a.$2493.Metal3 18.2892185628
Rred_2119 v_a.$1748.Metal2 v_a.$2497.Metal3 18.2892185628
Rred_2120 v_a.$1748.Metal2 v_a.$678.Metal1 13.2729560748
Rred_2121 v_a.$1748.Metal2 v_a.$681.Metal1 30.5784237182
Rred_2122 v_a.$1748.Metal2 v_a.P20.pSD 939.482403583
Rred_2123 v_a.$175.Metal1 v_a.$177.Metal1 0.369649277894
Rred_2124 v_a.$175.Metal1 v_a.P4.pSD 8.55506091425
Rred_2125 v_a.$1750.Metal2 v_a.$1752.Metal2 0.17180952381
Rred_2126 v_a.$1750.Metal2 v_a.$2493.Metal3 36.7250760159
Rred_2127 v_a.$1750.Metal2 v_a.$2497.Metal3 12.1119512228
Rred_2128 v_a.$1750.Metal2 v_a.$678.Metal1 31.0637955233
Rred_2129 v_a.$1750.Metal2 v_a.$681.Metal1 13.1785511559
Rred_2130 v_a.$1750.Metal2 v_a.P20.pSD 954.454780465
Rred_2131 v_a.$1752.Metal2 v_a.$1754.Metal2 0.171804655142
Rred_2132 v_a.$1752.Metal2 v_a.$2497.Metal3 9
Rred_2133 v_a.$1752.Metal2 v_a.$681.Metal1 10.4883410906
Rred_2134 v_a.$1752.Metal2 v_a.$683.Metal1 67.0434683763
Rred_2135 v_a.$1752.Metal2 v_a.P20.pSD 6275.67724127
Rred_2136 v_a.$1754.Metal2 v_a.$1756.Metal2 0.171796584217
Rred_2137 v_a.$1754.Metal2 v_a.$1758.Metal2 4580.45571151
Rred_2138 v_a.$1754.Metal2 v_a.$2497.Metal3 12.1119512228
Rred_2139 v_a.$1754.Metal2 v_a.$2501.Metal3 36.7250760159
Rred_2140 v_a.$1754.Metal2 v_a.$681.Metal1 33.5217341882
Rred_2141 v_a.$1754.Metal2 v_a.$683.Metal1 12.5143710493
Rred_2142 v_a.$1754.Metal2 v_a.P20.pSD 3095.90760546
Rred_2143 v_a.$1756.Metal2 v_a.$1758.Metal2 0.171676348971
Rred_2144 v_a.$1756.Metal2 v_a.$2497.Metal3 18.2892185628
Rred_2145 v_a.$1756.Metal2 v_a.$2501.Metal3 18.060762443
Rred_2146 v_a.$1756.Metal2 v_a.$683.Metal1 9.88981728846
Rred_2147 v_a.$1756.Metal2 v_a.P20.pSD 254.193435339
Rred_2148 v_a.$1758.Metal2 v_a.$2497.Metal3 36.7250760159
Rred_2149 v_a.$1758.Metal2 v_a.$2501.Metal3 1.92968162701
Rred_2150 v_a.$1758.Metal2 v_a.$683.Metal1 3.1408468373
Rred_2151 v_a.$1758.Metal2 v_a.P20.pSD 10.1646717066
Rred_2152 v_a.$177.Metal1 v_a.$178.Metal1 0.18406494599
Rred_2153 v_a.$177.Metal1 v_a.$2257.Metal3 1324.1519205
Rred_2154 v_a.$177.Metal1 v_a.P4.pSD 11.4179755706
Rred_2155 v_a.$178.Metal1 v_a.$180.Metal1 0.370821071381
Rred_2156 v_a.$178.Metal1 v_a.$2257.Metal3 3554.30252345
Rred_2157 v_a.$178.Metal1 v_a.P4.pSD 11.3579447987
Rred_2158 v_a.$1790.Metal2 v_a.$1792.Metal2 0.171804251886
Rred_2159 v_a.$1790.Metal2 v_a.$2507.Metal3 7.89774698854
Rred_2160 v_a.$1790.Metal2 v_a.$2518.Metal3 5.4765147338
Rred_2161 v_a.$1790.Metal2 v_a.$732.Metal1 3.63996241826
Rred_2162 v_a.$1790.Metal2 v_a.$734.Metal1 37.4749237892
Rred_2163 v_a.$1790.Metal2 v_a.P22.pSD 217.94126282
Rred_2164 v_a.$1792.Metal2 v_a.$1794.Metal2 0.17180952381
Rred_2165 v_a.$1792.Metal2 v_a.$2518.Metal3 9
Rred_2166 v_a.$1792.Metal2 v_a.$732.Metal1 55.3977134276
Rred_2167 v_a.$1792.Metal2 v_a.$734.Metal1 10.861051193
Rred_2168 v_a.$1792.Metal2 v_a.P22.pSD 5185.30247334
Rred_2169 v_a.$1794.Metal2 v_a.$1796.Metal2 0.171791914555
Rred_2170 v_a.$1794.Metal2 v_a.$2518.Metal3 18.07216
Rred_2171 v_a.$1794.Metal2 v_a.$2520.Metal3 18.07216
Rred_2172 v_a.$1794.Metal2 v_a.$734.Metal1 12.813283074
Rred_2173 v_a.$1794.Metal2 v_a.$737.Metal1 33.167961011
Rred_2174 v_a.$1794.Metal2 v_a.P22.pSD 1019.41923732
Rred_2175 v_a.$1796.Metal2 v_a.$1798.Metal2 0.17180952381
Rred_2176 v_a.$1796.Metal2 v_a.$2520.Metal3 9
Rred_2177 v_a.$1796.Metal2 v_a.$734.Metal1 28.7780838184
Rred_2178 v_a.$1796.Metal2 v_a.$737.Metal1 13.6637463445
Rred_2179 v_a.$1796.Metal2 v_a.P22.pSD 883.996133429
Rred_2180 v_a.$1798.Metal2 v_a.$1800.Metal2 0.171796790359
Rred_2181 v_a.$1798.Metal2 v_a.$2520.Metal3 13.5901279684
Rred_2182 v_a.$1798.Metal2 v_a.$2523.Metal3 27.2892185628
Rred_2183 v_a.$1798.Metal2 v_a.$737.Metal1 10.0549886197
Rred_2184 v_a.$1798.Metal2 v_a.$739.Metal1 90.9416871948
Rred_2185 v_a.$1798.Metal2 v_a.P22.pSD 8392.26908714
Rred_2186 v_a.$180.Metal1 v_a.$2261.Metal3 15.990728426
Rred_2187 v_a.$180.Metal1 v_a.P4.pSD 2.60065146165
Rred_2188 v_a.$1800.Metal2 v_a.$1802.Metal2 0.17180952381
Rred_2189 v_a.$1800.Metal2 v_a.$2520.Metal3 27.2892185628
Rred_2190 v_a.$1800.Metal2 v_a.$2523.Metal3 13.5901279684
Rred_2191 v_a.$1800.Metal2 v_a.$737.Metal1 29.6089214123
Rred_2192 v_a.$1800.Metal2 v_a.$739.Metal1 13.176950573
Rred_2193 v_a.$1800.Metal2 v_a.P22.pSD 2776.32918515
Rred_2194 v_a.$1802.Metal2 v_a.$1804.Metal2 0.171804789608
Rred_2195 v_a.$1802.Metal2 v_a.$2523.Metal3 9
Rred_2196 v_a.$1802.Metal2 v_a.$739.Metal1 12.6410773702
Rred_2197 v_a.$1802.Metal2 v_a.$741.Metal1 32.6594672273
Rred_2198 v_a.$1802.Metal2 v_a.P22.pSD 3060.46451443
Rred_2199 v_a.$1804.Metal2 v_a.$1806.Metal2 0.171796584217
Rred_2200 v_a.$1804.Metal2 v_a.$1808.Metal2 4580.45571151
Rred_2201 v_a.$1804.Metal2 v_a.$2523.Metal3 12.1119512228
Rred_2202 v_a.$1804.Metal2 v_a.$2527.Metal3 36.7250760159
Rred_2203 v_a.$1804.Metal2 v_a.$739.Metal1 70.7621789924
Rred_2204 v_a.$1804.Metal2 v_a.$741.Metal1 10.3991171827
Rred_2205 v_a.$1804.Metal2 v_a.P22.pSD 6528.76976999
Rred_2206 v_a.$1806.Metal2 v_a.$1808.Metal2 0.171778890843
Rred_2207 v_a.$1806.Metal2 v_a.$2523.Metal3 18.2892185628
Rred_2208 v_a.$1806.Metal2 v_a.$2527.Metal3 18.2892185628
Rred_2209 v_a.$1806.Metal2 v_a.$741.Metal1 13.2729560748
Rred_2210 v_a.$1806.Metal2 v_a.$744.Metal1 30.5784237182
Rred_2211 v_a.$1806.Metal2 v_a.P22.pSD 939.482403583
Rred_2212 v_a.$1808.Metal2 v_a.$1810.Metal2 0.17180952381
Rred_2213 v_a.$1808.Metal2 v_a.$2523.Metal3 36.7250760159
Rred_2214 v_a.$1808.Metal2 v_a.$2527.Metal3 12.1119512228
Rred_2215 v_a.$1808.Metal2 v_a.$741.Metal1 31.0637955233
Rred_2216 v_a.$1808.Metal2 v_a.$744.Metal1 13.1785511559
Rred_2217 v_a.$1808.Metal2 v_a.P22.pSD 954.454780465
Rred_2218 v_a.$1810.Metal2 v_a.$1812.Metal2 0.171804655142
Rred_2219 v_a.$1810.Metal2 v_a.$2527.Metal3 9
Rred_2220 v_a.$1810.Metal2 v_a.$744.Metal1 10.4883410906
Rred_2221 v_a.$1810.Metal2 v_a.$746.Metal1 67.0434683763
Rred_2222 v_a.$1810.Metal2 v_a.P22.pSD 6275.67724127
Rred_2223 v_a.$1812.Metal2 v_a.$1814.Metal2 0.171796584217
Rred_2224 v_a.$1812.Metal2 v_a.$1816.Metal2 4580.45571151
Rred_2225 v_a.$1812.Metal2 v_a.$2527.Metal3 12.1119512228
Rred_2226 v_a.$1812.Metal2 v_a.$2531.Metal3 36.7250760159
Rred_2227 v_a.$1812.Metal2 v_a.$744.Metal1 33.5217341882
Rred_2228 v_a.$1812.Metal2 v_a.$746.Metal1 12.5143710493
Rred_2229 v_a.$1812.Metal2 v_a.P22.pSD 3095.90760546
Rred_2230 v_a.$1814.Metal2 v_a.$1816.Metal2 0.171676348971
Rred_2231 v_a.$1814.Metal2 v_a.$2527.Metal3 18.2892185628
Rred_2232 v_a.$1814.Metal2 v_a.$2531.Metal3 18.060762443
Rred_2233 v_a.$1814.Metal2 v_a.$746.Metal1 9.88981728846
Rred_2234 v_a.$1814.Metal2 v_a.P22.pSD 254.193435339
Rred_2235 v_a.$1816.Metal2 v_a.$2527.Metal3 36.7250760159
Rred_2236 v_a.$1816.Metal2 v_a.$2531.Metal3 1.92968162701
Rred_2237 v_a.$1816.Metal2 v_a.$746.Metal1 3.1408468373
Rred_2238 v_a.$1816.Metal2 v_a.P22.pSD 10.1646717066
Rred_2239 v_a.$1848.Metal2 v_a.$1850.Metal2 0.171804251886
Rred_2240 v_a.$1848.Metal2 v_a.$2545.Metal3 4.8784056912
Rred_2241 v_a.$1848.Metal2 v_a.$2548.Metal3 9.28330943793
Rred_2242 v_a.$1848.Metal2 v_a.$795.Metal1 3.64166265892
Rred_2243 v_a.$1848.Metal2 v_a.$797.Metal1 37.4749237892
Rred_2244 v_a.$1848.Metal2 v_a.P24.pSD 218.090799297
Rred_2245 v_a.$1850.Metal2 v_a.$1852.Metal2 0.17180952381
Rred_2246 v_a.$1850.Metal2 v_a.$2548.Metal3 9
Rred_2247 v_a.$1850.Metal2 v_a.$795.Metal1 55.3977134276
Rred_2248 v_a.$1850.Metal2 v_a.$797.Metal1 10.861051193
Rred_2249 v_a.$1850.Metal2 v_a.P24.pSD 5185.30247334
Rred_2250 v_a.$1852.Metal2 v_a.$1854.Metal2 0.171791914555
Rred_2251 v_a.$1852.Metal2 v_a.$2548.Metal3 18.07216
Rred_2252 v_a.$1852.Metal2 v_a.$2550.Metal3 18.07216
Rred_2253 v_a.$1852.Metal2 v_a.$797.Metal1 12.813283074
Rred_2254 v_a.$1852.Metal2 v_a.$800.Metal1 33.167961011
Rred_2255 v_a.$1852.Metal2 v_a.P24.pSD 1019.41923732
Rred_2256 v_a.$1854.Metal2 v_a.$1856.Metal2 0.17180952381
Rred_2257 v_a.$1854.Metal2 v_a.$2550.Metal3 9
Rred_2258 v_a.$1854.Metal2 v_a.$797.Metal1 28.7780838184
Rred_2259 v_a.$1854.Metal2 v_a.$800.Metal1 13.6637463445
Rred_2260 v_a.$1854.Metal2 v_a.P24.pSD 883.996133429
Rred_2261 v_a.$1856.Metal2 v_a.$1858.Metal2 0.171796790359
Rred_2262 v_a.$1856.Metal2 v_a.$2550.Metal3 13.5901279684
Rred_2263 v_a.$1856.Metal2 v_a.$2553.Metal3 27.2892185628
Rred_2264 v_a.$1856.Metal2 v_a.$800.Metal1 10.0549886197
Rred_2265 v_a.$1856.Metal2 v_a.$802.Metal1 90.9416871948
Rred_2266 v_a.$1856.Metal2 v_a.P24.pSD 8392.26908714
Rred_2267 v_a.$1858.Metal2 v_a.$1860.Metal2 0.17180952381
Rred_2268 v_a.$1858.Metal2 v_a.$2550.Metal3 27.2892185628
Rred_2269 v_a.$1858.Metal2 v_a.$2553.Metal3 13.5901279684
Rred_2270 v_a.$1858.Metal2 v_a.$800.Metal1 29.6089214123
Rred_2271 v_a.$1858.Metal2 v_a.$802.Metal1 13.176950573
Rred_2272 v_a.$1858.Metal2 v_a.P24.pSD 2776.32918515
Rred_2273 v_a.$1860.Metal2 v_a.$1862.Metal2 0.171804789608
Rred_2274 v_a.$1860.Metal2 v_a.$2553.Metal3 9
Rred_2275 v_a.$1860.Metal2 v_a.$802.Metal1 12.6410773702
Rred_2276 v_a.$1860.Metal2 v_a.$804.Metal1 32.6594672273
Rred_2277 v_a.$1860.Metal2 v_a.P24.pSD 3060.46451443
Rred_2278 v_a.$1862.Metal2 v_a.$1864.Metal2 0.171796584217
Rred_2279 v_a.$1862.Metal2 v_a.$1866.Metal2 4580.45571151
Rred_2280 v_a.$1862.Metal2 v_a.$2553.Metal3 12.1119512228
Rred_2281 v_a.$1862.Metal2 v_a.$2557.Metal3 36.7250760159
Rred_2282 v_a.$1862.Metal2 v_a.$802.Metal1 70.7621789924
Rred_2283 v_a.$1862.Metal2 v_a.$804.Metal1 10.3991171827
Rred_2284 v_a.$1862.Metal2 v_a.P24.pSD 6528.76976999
Rred_2285 v_a.$1864.Metal2 v_a.$1866.Metal2 0.171778890843
Rred_2286 v_a.$1864.Metal2 v_a.$2553.Metal3 18.2892185628
Rred_2287 v_a.$1864.Metal2 v_a.$2557.Metal3 18.2892185628
Rred_2288 v_a.$1864.Metal2 v_a.$804.Metal1 13.2729560748
Rred_2289 v_a.$1864.Metal2 v_a.$807.Metal1 30.5784237182
Rred_2290 v_a.$1864.Metal2 v_a.P24.pSD 939.482403583
Rred_2291 v_a.$1866.Metal2 v_a.$1868.Metal2 0.17180952381
Rred_2292 v_a.$1866.Metal2 v_a.$2553.Metal3 36.7250760159
Rred_2293 v_a.$1866.Metal2 v_a.$2557.Metal3 12.1119512228
Rred_2294 v_a.$1866.Metal2 v_a.$804.Metal1 31.0637955233
Rred_2295 v_a.$1866.Metal2 v_a.$807.Metal1 13.1785511559
Rred_2296 v_a.$1866.Metal2 v_a.P24.pSD 954.454780465
Rred_2297 v_a.$1868.Metal2 v_a.$1870.Metal2 0.171804655142
Rred_2298 v_a.$1868.Metal2 v_a.$2557.Metal3 9
Rred_2299 v_a.$1868.Metal2 v_a.$807.Metal1 10.4883410906
Rred_2300 v_a.$1868.Metal2 v_a.$809.Metal1 67.0434683763
Rred_2301 v_a.$1868.Metal2 v_a.P24.pSD 6275.67724127
Rred_2302 v_a.$1870.Metal2 v_a.$1872.Metal2 0.171796584217
Rred_2303 v_a.$1870.Metal2 v_a.$1874.Metal2 4580.45571151
Rred_2304 v_a.$1870.Metal2 v_a.$2557.Metal3 12.1119512228
Rred_2305 v_a.$1870.Metal2 v_a.$2561.Metal3 36.7250760159
Rred_2306 v_a.$1870.Metal2 v_a.$807.Metal1 33.5217341882
Rred_2307 v_a.$1870.Metal2 v_a.$809.Metal1 12.5143710493
Rred_2308 v_a.$1870.Metal2 v_a.P24.pSD 3095.90760546
Rred_2309 v_a.$1872.Metal2 v_a.$1874.Metal2 0.171676348971
Rred_2310 v_a.$1872.Metal2 v_a.$2557.Metal3 18.2892185628
Rred_2311 v_a.$1872.Metal2 v_a.$2561.Metal3 18.060762443
Rred_2312 v_a.$1872.Metal2 v_a.$809.Metal1 9.88981728846
Rred_2313 v_a.$1872.Metal2 v_a.P24.pSD 254.193435339
Rred_2314 v_a.$1874.Metal2 v_a.$2557.Metal3 36.7250760159
Rred_2315 v_a.$1874.Metal2 v_a.$2561.Metal3 1.92968162701
Rred_2316 v_a.$1874.Metal2 v_a.$809.Metal1 3.1408468373
Rred_2317 v_a.$1874.Metal2 v_a.P24.pSD 10.1646717066
Rred_2318 v_a.$1906.Metal2 v_a.$1908.Metal2 0.171804251886
Rred_2319 v_a.$1906.Metal2 v_a.$2567.Metal3 7.89774698854
Rred_2320 v_a.$1906.Metal2 v_a.$2578.Metal3 5.4765147338
Rred_2321 v_a.$1906.Metal2 v_a.$858.Metal1 3.63996241826
Rred_2322 v_a.$1906.Metal2 v_a.$860.Metal1 37.4749237892
Rred_2323 v_a.$1906.Metal2 v_a.P26.pSD 217.94126282
Rred_2324 v_a.$1908.Metal2 v_a.$1910.Metal2 0.17180952381
Rred_2325 v_a.$1908.Metal2 v_a.$2578.Metal3 9
Rred_2326 v_a.$1908.Metal2 v_a.$858.Metal1 55.3977134276
Rred_2327 v_a.$1908.Metal2 v_a.$860.Metal1 10.861051193
Rred_2328 v_a.$1908.Metal2 v_a.P26.pSD 5185.30247334
Rred_2329 v_a.$1910.Metal2 v_a.$1912.Metal2 0.171791914555
Rred_2330 v_a.$1910.Metal2 v_a.$2578.Metal3 18.07216
Rred_2331 v_a.$1910.Metal2 v_a.$2580.Metal3 18.07216
Rred_2332 v_a.$1910.Metal2 v_a.$860.Metal1 12.813283074
Rred_2333 v_a.$1910.Metal2 v_a.$863.Metal1 33.167961011
Rred_2334 v_a.$1910.Metal2 v_a.P26.pSD 1019.41923732
Rred_2335 v_a.$1912.Metal2 v_a.$1914.Metal2 0.17180952381
Rred_2336 v_a.$1912.Metal2 v_a.$2580.Metal3 9
Rred_2337 v_a.$1912.Metal2 v_a.$860.Metal1 28.7780838184
Rred_2338 v_a.$1912.Metal2 v_a.$863.Metal1 13.6637463445
Rred_2339 v_a.$1912.Metal2 v_a.P26.pSD 883.996133429
Rred_2340 v_a.$1914.Metal2 v_a.$1916.Metal2 0.171796790359
Rred_2341 v_a.$1914.Metal2 v_a.$2580.Metal3 13.5901279684
Rred_2342 v_a.$1914.Metal2 v_a.$2583.Metal3 27.2892185628
Rred_2343 v_a.$1914.Metal2 v_a.$863.Metal1 10.0549886197
Rred_2344 v_a.$1914.Metal2 v_a.$865.Metal1 90.9416871948
Rred_2345 v_a.$1914.Metal2 v_a.P26.pSD 8392.26908714
Rred_2346 v_a.$1916.Metal2 v_a.$1918.Metal2 0.17180952381
Rred_2347 v_a.$1916.Metal2 v_a.$2580.Metal3 27.2892185628
Rred_2348 v_a.$1916.Metal2 v_a.$2583.Metal3 13.5901279684
Rred_2349 v_a.$1916.Metal2 v_a.$863.Metal1 29.6089214123
Rred_2350 v_a.$1916.Metal2 v_a.$865.Metal1 13.176950573
Rred_2351 v_a.$1916.Metal2 v_a.P26.pSD 2776.32918515
Rred_2352 v_a.$1918.Metal2 v_a.$1920.Metal2 0.171804789608
Rred_2353 v_a.$1918.Metal2 v_a.$2583.Metal3 9
Rred_2354 v_a.$1918.Metal2 v_a.$865.Metal1 12.6410773702
Rred_2355 v_a.$1918.Metal2 v_a.$867.Metal1 32.6594672273
Rred_2356 v_a.$1918.Metal2 v_a.P26.pSD 3060.46451443
Rred_2357 v_a.$1920.Metal2 v_a.$1922.Metal2 0.171796584217
Rred_2358 v_a.$1920.Metal2 v_a.$1924.Metal2 4580.45571151
Rred_2359 v_a.$1920.Metal2 v_a.$2583.Metal3 12.1119512228
Rred_2360 v_a.$1920.Metal2 v_a.$2587.Metal3 36.7250760159
Rred_2361 v_a.$1920.Metal2 v_a.$865.Metal1 70.7621789924
Rred_2362 v_a.$1920.Metal2 v_a.$867.Metal1 10.3991171827
Rred_2363 v_a.$1920.Metal2 v_a.P26.pSD 6528.76976999
Rred_2364 v_a.$1922.Metal2 v_a.$1924.Metal2 0.171778890843
Rred_2365 v_a.$1922.Metal2 v_a.$2583.Metal3 18.2892185628
Rred_2366 v_a.$1922.Metal2 v_a.$2587.Metal3 18.2892185628
Rred_2367 v_a.$1922.Metal2 v_a.$867.Metal1 13.2729560748
Rred_2368 v_a.$1922.Metal2 v_a.$870.Metal1 30.5784237182
Rred_2369 v_a.$1922.Metal2 v_a.P26.pSD 939.482403583
Rred_2370 v_a.$1924.Metal2 v_a.$1926.Metal2 0.17180952381
Rred_2371 v_a.$1924.Metal2 v_a.$2583.Metal3 36.7250760159
Rred_2372 v_a.$1924.Metal2 v_a.$2587.Metal3 12.1119512228
Rred_2373 v_a.$1924.Metal2 v_a.$867.Metal1 31.0637955233
Rred_2374 v_a.$1924.Metal2 v_a.$870.Metal1 13.1785511559
Rred_2375 v_a.$1924.Metal2 v_a.P26.pSD 954.454780465
Rred_2376 v_a.$1926.Metal2 v_a.$1928.Metal2 0.171804655142
Rred_2377 v_a.$1926.Metal2 v_a.$2587.Metal3 9
Rred_2378 v_a.$1926.Metal2 v_a.$870.Metal1 10.4883410906
Rred_2379 v_a.$1926.Metal2 v_a.$872.Metal1 67.0434683763
Rred_2380 v_a.$1926.Metal2 v_a.P26.pSD 6275.67724127
Rred_2381 v_a.$1928.Metal2 v_a.$1930.Metal2 0.171796584217
Rred_2382 v_a.$1928.Metal2 v_a.$1932.Metal2 4580.45571151
Rred_2383 v_a.$1928.Metal2 v_a.$2587.Metal3 12.1119512228
Rred_2384 v_a.$1928.Metal2 v_a.$2591.Metal3 36.7250760159
Rred_2385 v_a.$1928.Metal2 v_a.$870.Metal1 33.5217341882
Rred_2386 v_a.$1928.Metal2 v_a.$872.Metal1 12.5143710493
Rred_2387 v_a.$1928.Metal2 v_a.P26.pSD 3095.90760546
Rred_2388 v_a.$1930.Metal2 v_a.$1932.Metal2 0.171676348971
Rred_2389 v_a.$1930.Metal2 v_a.$2587.Metal3 18.2892185628
Rred_2390 v_a.$1930.Metal2 v_a.$2591.Metal3 18.060762443
Rred_2391 v_a.$1930.Metal2 v_a.$872.Metal1 9.88981728846
Rred_2392 v_a.$1930.Metal2 v_a.P26.pSD 254.193435339
Rred_2393 v_a.$1932.Metal2 v_a.$2587.Metal3 36.7250760159
Rred_2394 v_a.$1932.Metal2 v_a.$2591.Metal3 1.92968162701
Rred_2395 v_a.$1932.Metal2 v_a.$872.Metal1 3.1408468373
Rred_2396 v_a.$1932.Metal2 v_a.P26.pSD 10.1646717066
Rred_2397 v_a.$1964.Metal2 v_a.$1966.Metal2 0.171804251886
Rred_2398 v_a.$1964.Metal2 v_a.$2597.Metal3 7.89774698854
Rred_2399 v_a.$1964.Metal2 v_a.$2608.Metal3 5.4765147338
Rred_2400 v_a.$1964.Metal2 v_a.$921.Metal1 3.63996241826
Rred_2401 v_a.$1964.Metal2 v_a.$923.Metal1 37.4749237892
Rred_2402 v_a.$1964.Metal2 v_a.P28.pSD 217.94126282
Rred_2403 v_a.$1966.Metal2 v_a.$1968.Metal2 0.17180952381
Rred_2404 v_a.$1966.Metal2 v_a.$2608.Metal3 9
Rred_2405 v_a.$1966.Metal2 v_a.$921.Metal1 55.3977134276
Rred_2406 v_a.$1966.Metal2 v_a.$923.Metal1 10.861051193
Rred_2407 v_a.$1966.Metal2 v_a.P28.pSD 5185.30247334
Rred_2408 v_a.$1968.Metal2 v_a.$1970.Metal2 0.171791914555
Rred_2409 v_a.$1968.Metal2 v_a.$2608.Metal3 18.07216
Rred_2410 v_a.$1968.Metal2 v_a.$2610.Metal3 18.07216
Rred_2411 v_a.$1968.Metal2 v_a.$923.Metal1 12.813283074
Rred_2412 v_a.$1968.Metal2 v_a.$926.Metal1 33.167961011
Rred_2413 v_a.$1968.Metal2 v_a.P28.pSD 1019.41923732
Rred_2414 v_a.$1970.Metal2 v_a.$1972.Metal2 0.17180952381
Rred_2415 v_a.$1970.Metal2 v_a.$2610.Metal3 9
Rred_2416 v_a.$1970.Metal2 v_a.$923.Metal1 28.7780838184
Rred_2417 v_a.$1970.Metal2 v_a.$926.Metal1 13.6637463445
Rred_2418 v_a.$1970.Metal2 v_a.P28.pSD 883.996133429
Rred_2419 v_a.$1972.Metal2 v_a.$1974.Metal2 0.171796790359
Rred_2420 v_a.$1972.Metal2 v_a.$2610.Metal3 13.5901279684
Rred_2421 v_a.$1972.Metal2 v_a.$2613.Metal3 27.2892185628
Rred_2422 v_a.$1972.Metal2 v_a.$926.Metal1 10.0549886197
Rred_2423 v_a.$1972.Metal2 v_a.$928.Metal1 90.9416871948
Rred_2424 v_a.$1972.Metal2 v_a.P28.pSD 8392.26908714
Rred_2425 v_a.$1974.Metal2 v_a.$1976.Metal2 0.17180952381
Rred_2426 v_a.$1974.Metal2 v_a.$2610.Metal3 27.2892185628
Rred_2427 v_a.$1974.Metal2 v_a.$2613.Metal3 13.5901279684
Rred_2428 v_a.$1974.Metal2 v_a.$926.Metal1 29.6089214123
Rred_2429 v_a.$1974.Metal2 v_a.$928.Metal1 13.176950573
Rred_2430 v_a.$1974.Metal2 v_a.P28.pSD 2776.32918515
Rred_2431 v_a.$1976.Metal2 v_a.$1978.Metal2 0.171804789608
Rred_2432 v_a.$1976.Metal2 v_a.$2613.Metal3 9
Rred_2433 v_a.$1976.Metal2 v_a.$928.Metal1 12.6410773702
Rred_2434 v_a.$1976.Metal2 v_a.$930.Metal1 32.6594672273
Rred_2435 v_a.$1976.Metal2 v_a.P28.pSD 3060.46451443
Rred_2436 v_a.$1978.Metal2 v_a.$1980.Metal2 0.171796584217
Rred_2437 v_a.$1978.Metal2 v_a.$1982.Metal2 4580.45571151
Rred_2438 v_a.$1978.Metal2 v_a.$2613.Metal3 12.1119512228
Rred_2439 v_a.$1978.Metal2 v_a.$2617.Metal3 36.7250760159
Rred_2440 v_a.$1978.Metal2 v_a.$928.Metal1 70.7621789924
Rred_2441 v_a.$1978.Metal2 v_a.$930.Metal1 10.3991171827
Rred_2442 v_a.$1978.Metal2 v_a.P28.pSD 6528.76976999
Rred_2443 v_a.$1980.Metal2 v_a.$1982.Metal2 0.171796584217
Rred_2444 v_a.$1980.Metal2 v_a.$2613.Metal3 18.2892185628
Rred_2445 v_a.$1980.Metal2 v_a.$2617.Metal3 18.2892185628
Rred_2446 v_a.$1980.Metal2 v_a.$930.Metal1 16.9226643368
Rred_2447 v_a.$1980.Metal2 v_a.$932.Metal1 19.8481121624
Rred_2448 v_a.$1980.Metal2 v_a.P28.pSD 1867.13466192
Rred_2449 v_a.$1982.Metal2 v_a.$1984.Metal2 0.171807130238
Rred_2450 v_a.$1982.Metal2 v_a.$2613.Metal3 36.7250760159
Rred_2451 v_a.$1982.Metal2 v_a.$2617.Metal3 12.1119512228
Rred_2452 v_a.$1982.Metal2 v_a.$932.Metal1 9.49733677338
Rred_2453 v_a.$1982.Metal2 v_a.$934.Metal1 183.026070658
Rred_2454 v_a.$1982.Metal2 v_a.P28.pSD 16903.415586
Rred_2455 v_a.$1984.Metal2 v_a.$1986.Metal2 0.17180952381
Rred_2456 v_a.$1984.Metal2 v_a.$2617.Metal3 9
Rred_2457 v_a.$1984.Metal2 v_a.$932.Metal1 25.1212253845
Rred_2458 v_a.$1984.Metal2 v_a.$934.Metal1 14.3353397481
Rred_2459 v_a.$1984.Metal2 v_a.P28.pSD 2325.15992427
Rred_2460 v_a.$1986.Metal2 v_a.$1988.Metal2 0.171791151867
Rred_2461 v_a.$1986.Metal2 v_a.$1990.Metal2 4580.45571151
Rred_2462 v_a.$1986.Metal2 v_a.$2617.Metal3 12.1119512228
Rred_2463 v_a.$1986.Metal2 v_a.$2621.Metal3 36.7250760159
Rred_2464 v_a.$1986.Metal2 v_a.$934.Metal1 11.6871559391
Rred_2465 v_a.$1986.Metal2 v_a.$936.Metal1 41.1056788804
Rred_2466 v_a.$1986.Metal2 v_a.P28.pSD 3793.5757888
Rred_2467 v_a.$1988.Metal2 v_a.$1990.Metal2 0.171796584217
Rred_2468 v_a.$1988.Metal2 v_a.$2617.Metal3 18.2892185628
Rred_2469 v_a.$1988.Metal2 v_a.$2621.Metal3 18.2892185628
Rred_2470 v_a.$1988.Metal2 v_a.$934.Metal1 49.0106171266
Rred_2471 v_a.$1988.Metal2 v_a.$936.Metal1 11.1573275969
Rred_2472 v_a.$1988.Metal2 v_a.P28.pSD 4587.69246179
Rred_2473 v_a.$1990.Metal2 v_a.$2617.Metal3 36.7250760159
Rred_2474 v_a.$1990.Metal2 v_a.$2621.Metal3 1.94343606645
Rred_2475 v_a.$1990.Metal2 v_a.$936.Metal1 2.71289515932
Rred_2476 v_a.$1990.Metal2 v_a.P28.pSD 12.9001973441
Rred_2477 v_a.$2022.Metal2 v_a.$2024.Metal2 0.171804251886
Rred_2478 v_a.$2022.Metal2 v_a.$2635.Metal3 4.8784056912
Rred_2479 v_a.$2022.Metal2 v_a.$2638.Metal3 9.28330943793
Rred_2480 v_a.$2022.Metal2 v_a.$984.Metal1 3.64166265892
Rred_2481 v_a.$2022.Metal2 v_a.$986.Metal1 37.4749237892
Rred_2482 v_a.$2022.Metal2 v_a.P30.pSD 218.090799297
Rred_2483 v_a.$2024.Metal2 v_a.$2026.Metal2 0.17180952381
Rred_2484 v_a.$2024.Metal2 v_a.$2638.Metal3 9
Rred_2485 v_a.$2024.Metal2 v_a.$984.Metal1 55.3977134276
Rred_2486 v_a.$2024.Metal2 v_a.$986.Metal1 10.861051193
Rred_2487 v_a.$2024.Metal2 v_a.P30.pSD 5185.30247334
Rred_2488 v_a.$2026.Metal2 v_a.$2028.Metal2 0.171791914555
Rred_2489 v_a.$2026.Metal2 v_a.$2638.Metal3 18.07216
Rred_2490 v_a.$2026.Metal2 v_a.$2640.Metal3 18.07216
Rred_2491 v_a.$2026.Metal2 v_a.$986.Metal1 12.813283074
Rred_2492 v_a.$2026.Metal2 v_a.$989.Metal1 33.167961011
Rred_2493 v_a.$2026.Metal2 v_a.P30.pSD 1019.41923732
Rred_2494 v_a.$2028.Metal2 v_a.$2030.Metal2 0.17180952381
Rred_2495 v_a.$2028.Metal2 v_a.$2640.Metal3 9
Rred_2496 v_a.$2028.Metal2 v_a.$986.Metal1 28.7780838184
Rred_2497 v_a.$2028.Metal2 v_a.$989.Metal1 13.6637463445
Rred_2498 v_a.$2028.Metal2 v_a.P30.pSD 883.996133429
Rred_2499 v_a.$2030.Metal2 v_a.$2032.Metal2 0.171796790359
Rred_2500 v_a.$2030.Metal2 v_a.$2640.Metal3 13.5901279684
Rred_2501 v_a.$2030.Metal2 v_a.$2643.Metal3 27.2892185628
Rred_2502 v_a.$2030.Metal2 v_a.$989.Metal1 10.0549886197
Rred_2503 v_a.$2030.Metal2 v_a.$991.Metal1 90.9416871948
Rred_2504 v_a.$2030.Metal2 v_a.P30.pSD 8392.26908714
Rred_2505 v_a.$2032.Metal2 v_a.$2034.Metal2 0.17180952381
Rred_2506 v_a.$2032.Metal2 v_a.$2640.Metal3 27.2892185628
Rred_2507 v_a.$2032.Metal2 v_a.$2643.Metal3 13.5901279684
Rred_2508 v_a.$2032.Metal2 v_a.$989.Metal1 29.6089214123
Rred_2509 v_a.$2032.Metal2 v_a.$991.Metal1 13.176950573
Rred_2510 v_a.$2032.Metal2 v_a.P30.pSD 2776.32918515
Rred_2511 v_a.$2034.Metal2 v_a.$2036.Metal2 0.171804789608
Rred_2512 v_a.$2034.Metal2 v_a.$2643.Metal3 9
Rred_2513 v_a.$2034.Metal2 v_a.$991.Metal1 12.6410773702
Rred_2514 v_a.$2034.Metal2 v_a.$993.Metal1 32.6594672273
Rred_2515 v_a.$2034.Metal2 v_a.P30.pSD 3060.46451443
Rred_2516 v_a.$2036.Metal2 v_a.$2038.Metal2 0.171796584217
Rred_2517 v_a.$2036.Metal2 v_a.$2040.Metal2 4580.45571151
Rred_2518 v_a.$2036.Metal2 v_a.$2643.Metal3 12.1119512228
Rred_2519 v_a.$2036.Metal2 v_a.$2647.Metal3 36.7250760159
Rred_2520 v_a.$2036.Metal2 v_a.$991.Metal1 70.7621789924
Rred_2521 v_a.$2036.Metal2 v_a.$993.Metal1 10.3991171827
Rred_2522 v_a.$2036.Metal2 v_a.P30.pSD 6528.76976999
Rred_2523 v_a.$2038.Metal2 v_a.$2040.Metal2 0.171778890843
Rred_2524 v_a.$2038.Metal2 v_a.$2643.Metal3 18.2892185628
Rred_2525 v_a.$2038.Metal2 v_a.$2647.Metal3 18.2892185628
Rred_2526 v_a.$2038.Metal2 v_a.$993.Metal1 13.2729560748
Rred_2527 v_a.$2038.Metal2 v_a.$996.Metal1 30.5784237182
Rred_2528 v_a.$2038.Metal2 v_a.P30.pSD 939.482403583
Rred_2529 v_a.$2040.Metal2 v_a.$2042.Metal2 0.17180952381
Rred_2530 v_a.$2040.Metal2 v_a.$2643.Metal3 36.7250760159
Rred_2531 v_a.$2040.Metal2 v_a.$2647.Metal3 12.1119512228
Rred_2532 v_a.$2040.Metal2 v_a.$993.Metal1 31.0637955233
Rred_2533 v_a.$2040.Metal2 v_a.$996.Metal1 13.1785511559
Rred_2534 v_a.$2040.Metal2 v_a.P30.pSD 954.454780465
Rred_2535 v_a.$2042.Metal2 v_a.$2044.Metal2 0.171804655142
Rred_2536 v_a.$2042.Metal2 v_a.$2647.Metal3 9
Rred_2537 v_a.$2042.Metal2 v_a.$996.Metal1 10.4883410906
Rred_2538 v_a.$2042.Metal2 v_a.$998.Metal1 67.0434683763
Rred_2539 v_a.$2042.Metal2 v_a.P30.pSD 6275.67724127
Rred_2540 v_a.$2044.Metal2 v_a.$2046.Metal2 0.171796584217
Rred_2541 v_a.$2044.Metal2 v_a.$2048.Metal2 4580.45571151
Rred_2542 v_a.$2044.Metal2 v_a.$2647.Metal3 12.1119512228
Rred_2543 v_a.$2044.Metal2 v_a.$2651.Metal3 36.7250760159
Rred_2544 v_a.$2044.Metal2 v_a.$996.Metal1 33.5217341882
Rred_2545 v_a.$2044.Metal2 v_a.$998.Metal1 12.5143710493
Rred_2546 v_a.$2044.Metal2 v_a.P30.pSD 3095.90760546
Rred_2547 v_a.$2046.Metal2 v_a.$2048.Metal2 0.171676348971
Rred_2548 v_a.$2046.Metal2 v_a.$2647.Metal3 18.2892185628
Rred_2549 v_a.$2046.Metal2 v_a.$2651.Metal3 18.060762443
Rred_2550 v_a.$2046.Metal2 v_a.$998.Metal1 9.88981728846
Rred_2551 v_a.$2046.Metal2 v_a.P30.pSD 254.193435339
Rred_2552 v_a.$2048.Metal2 v_a.$2647.Metal3 36.7250760159
Rred_2553 v_a.$2048.Metal2 v_a.$2651.Metal3 1.92968162701
Rred_2554 v_a.$2048.Metal2 v_a.$998.Metal1 3.1408468373
Rred_2555 v_a.$2048.Metal2 v_a.P30.pSD 10.1646717066
Rred_2556 v_a.$2080.Metal2 v_a.$2082.Metal2 0.171804251886
Rred_2557 v_a.$2080.Metal2 v_a.$2657.Metal3 7.89774698854
Rred_2558 v_a.$2080.Metal2 v_a.$2668.Metal3 5.4765147338
Rred_2559 v_a.$2080.Metal2 v_a.P32.pSD 217.94126282
Rred_2560 v_a.$2082.Metal2 v_a.$2084.Metal2 0.17180952381
Rred_2561 v_a.$2082.Metal2 v_a.$2668.Metal3 9
Rred_2562 v_a.$2082.Metal2 v_a.P32.pSD 5185.30247334
Rred_2563 v_a.$2084.Metal2 v_a.$2086.Metal2 0.171791914555
Rred_2564 v_a.$2084.Metal2 v_a.$2668.Metal3 18.07216
Rred_2565 v_a.$2084.Metal2 v_a.$2670.Metal3 18.07216
Rred_2566 v_a.$2084.Metal2 v_a.P32.pSD 1019.41923732
Rred_2567 v_a.$2086.Metal2 v_a.$2088.Metal2 0.17180952381
Rred_2568 v_a.$2086.Metal2 v_a.$2670.Metal3 9
Rred_2569 v_a.$2086.Metal2 v_a.P32.pSD 883.996133429
Rred_2570 v_a.$2088.Metal2 v_a.$2090.Metal2 0.171796790359
Rred_2571 v_a.$2088.Metal2 v_a.$2670.Metal3 13.5901279684
Rred_2572 v_a.$2088.Metal2 v_a.$2673.Metal3 27.2892185628
Rred_2573 v_a.$2088.Metal2 v_a.P32.pSD 8392.26908714
Rred_2574 v_a.$2090.Metal2 v_a.$2092.Metal2 0.17180952381
Rred_2575 v_a.$2090.Metal2 v_a.$2670.Metal3 27.2892185628
Rred_2576 v_a.$2090.Metal2 v_a.$2673.Metal3 13.5901279684
Rred_2577 v_a.$2090.Metal2 v_a.P32.pSD 2776.32918515
Rred_2578 v_a.$2092.Metal2 v_a.$2094.Metal2 0.171804789608
Rred_2579 v_a.$2092.Metal2 v_a.$2673.Metal3 9
Rred_2580 v_a.$2092.Metal2 v_a.P32.pSD 3060.46451443
Rred_2581 v_a.$2094.Metal2 v_a.$2096.Metal2 0.171796584217
Rred_2582 v_a.$2094.Metal2 v_a.$2098.Metal2 4580.45571151
Rred_2583 v_a.$2094.Metal2 v_a.$2673.Metal3 12.1119512228
Rred_2584 v_a.$2094.Metal2 v_a.$2677.Metal3 36.7250760159
Rred_2585 v_a.$2094.Metal2 v_a.P32.pSD 6528.76976999
Rred_2586 v_a.$2096.Metal2 v_a.$2098.Metal2 0.171796584217
Rred_2587 v_a.$2096.Metal2 v_a.$2673.Metal3 18.2892185628
Rred_2588 v_a.$2096.Metal2 v_a.$2677.Metal3 18.2892185628
Rred_2589 v_a.$2096.Metal2 v_a.P32.pSD 1867.13466192
Rred_2590 v_a.$2098.Metal2 v_a.$2100.Metal2 0.171807130238
Rred_2591 v_a.$2098.Metal2 v_a.$2673.Metal3 36.7250760159
Rred_2592 v_a.$2098.Metal2 v_a.$2677.Metal3 12.1119512228
Rred_2593 v_a.$2098.Metal2 v_a.P32.pSD 16903.415586
Rred_2594 v_a.$2100.Metal2 v_a.$2102.Metal2 0.17180952381
Rred_2595 v_a.$2100.Metal2 v_a.$2677.Metal3 9
Rred_2596 v_a.$2100.Metal2 v_a.P32.pSD 2325.15992427
Rred_2597 v_a.$2102.Metal2 v_a.$2104.Metal2 0.171791151867
Rred_2598 v_a.$2102.Metal2 v_a.$2106.Metal2 4580.45571151
Rred_2599 v_a.$2102.Metal2 v_a.$2677.Metal3 12.1119512228
Rred_2600 v_a.$2102.Metal2 v_a.$2681.Metal3 36.7250760159
Rred_2601 v_a.$2102.Metal2 v_a.P32.pSD 3793.5757888
Rred_2602 v_a.$2104.Metal2 v_a.$2106.Metal2 0.171796584217
Rred_2603 v_a.$2104.Metal2 v_a.$2677.Metal3 18.2892185628
Rred_2604 v_a.$2104.Metal2 v_a.$2681.Metal3 18.2892185628
Rred_2605 v_a.$2104.Metal2 v_a.P32.pSD 4587.69246179
Rred_2606 v_a.$2106.Metal2 v_a.$2677.Metal3 36.7250760159
Rred_2607 v_a.$2106.Metal2 v_a.$2681.Metal3 1.94343606645
Rred_2608 v_a.$2106.Metal2 v_a.P32.pSD 12.9001973441
Rred_2609 v_a.$2187.Metal3 v_a.$2191.Metal3 0.294453498367
Rred_2610 v_a.$2187.Metal3 v_a.$39.Metal1 150.403062346
Rred_2611 v_a.$2187.Metal3 v_a.P0.pSD 6245.50835274
Rred_2612 v_a.$2191.Metal3 v_a.$2193.Metal3 0.144898562844
Rred_2613 v_a.$2193.Metal3 v_a.$2197.Metal3 0.294453498367
Rred_2614 v_a.$2197.Metal3 v_a.$48.Metal1 12.1615432995
Rred_2615 v_a.$2197.Metal3 v_a.P0.pSD 11.7584434988
Rred_2616 v_a.$2215.Metal3 v_a.$2219.Metal3 0.294453498367
Rred_2617 v_a.$2215.Metal3 v_a.$2237.Metal3 0.346766659607
Rred_2618 v_a.$2215.Metal3 v_a.P2.nSD 38.4497198849
Rred_2619 v_a.$2215.Metal3 v_a.P2.pSD 17035.4743833
Rred_2620 v_a.$2219.Metal3 v_a.$2223.Metal3 0.294453498367
Rred_2621 v_a.$2223.Metal3 v_a.$2227.Metal3 0.294453498367
Rred_2622 v_a.$2227.Metal3 v_a.$2229.Metal3 0.144898562844
Rred_2623 v_a.$2229.Metal3 v_a.$2233.Metal3 0.294453498367
Rred_2624 v_a.$2233.Metal3 v_a.P2.pSD 125.483219491
Rred_2625 v_a.$2237.Metal3 v_a.$2247.Metal3 0.277203140364
Rred_2626 v_a.$2237.Metal3 v_a.$2275.Metal3 0.304766659607
Rred_2627 v_a.$2237.Metal3 v_a.$2297.Metal3 0.1057353717
Rred_2628 v_a.$2237.Metal3 v_a.P2.nSD 13.3396987356
Rred_2629 v_a.$2237.Metal3 v_a.P4.nSD 4.97632451283
Rred_2630 v_a.$2237.Metal3 v_a.P4.pSD 10713.552318
Rred_2631 v_a.$2237.Metal3 v_a.P6.nSD 11.7240089587
Rred_2632 v_a.$2247.Metal3 v_a.$2251.Metal3 0.294453498367
Rred_2633 v_a.$2247.Metal3 v_a.P4.pSD 8052.32516846
Rred_2634 v_a.$2251.Metal3 v_a.$2253.Metal3 0.144898562844
Rred_2635 v_a.$2253.Metal3 v_a.$2257.Metal3 0.294453498367
Rred_2636 v_a.$2257.Metal3 v_a.$2261.Metal3 0.294453498367
Rred_2637 v_a.$2261.Metal3 v_a.P4.pSD 48.6463927648
Rred_2638 v_a.$2275.Metal3 v_a.$2279.Metal3 0.294453498367
Rred_2639 v_a.$2275.Metal3 v_a.$228.Metal1 529.941924087
Rred_2640 v_a.$2275.Metal3 v_a.$2297.Metal3 0.304766659607
Rred_2641 v_a.$2275.Metal3 v_a.P6.nSD 33.7927317044
Rred_2642 v_a.$2275.Metal3 v_a.P6.pSD 17035.4743833
Rred_2643 v_a.$2279.Metal3 v_a.$2283.Metal3 0.294453498367
Rred_2644 v_a.$2279.Metal3 v_a.$230.Metal1 6131.19136113
Rred_2645 v_a.$2279.Metal3 v_a.$231.Metal1 1143.10347411
Rred_2646 v_a.$228.Metal1 v_a.$230.Metal1 0.370783637491
Rred_2647 v_a.$228.Metal1 v_a.P6.pSD 5.04909626568
Rred_2648 v_a.$2283.Metal3 v_a.$2287.Metal3 0.294453498367
Rred_2649 v_a.$2287.Metal3 v_a.$2291.Metal3 0.294453498367
Rred_2650 v_a.$2291.Metal3 v_a.$242.Metal1 18.5132214307
Rred_2651 v_a.$2291.Metal3 v_a.P6.pSD 41.5010148887
Rred_2652 v_a.$2297.Metal3 v_a.$2307.Metal3 0.277203140364
Rred_2653 v_a.$2297.Metal3 v_a.$2327.Metal3 0.04488
Rred_2654 v_a.$2297.Metal3 v_a.$291.Metal1 264.637085427
Rred_2655 v_a.$2297.Metal3 v_a.P6.nSD 11.7240089587
Rred_2656 v_a.$2297.Metal3 v_a.P8.nSD 4.97632451283
Rred_2657 v_a.$2297.Metal3 v_a.P8.pSD 10713.552318
Rred_2658 v_a.$230.Metal1 v_a.$231.Metal1 0.18382334016
Rred_2659 v_a.$230.Metal1 v_a.P6.pSD 11.4106916049
Rred_2660 v_a.$2307.Metal3 v_a.$2311.Metal3 0.294453498367
Rred_2661 v_a.$2307.Metal3 v_a.$291.Metal1 192.51795956
Rred_2662 v_a.$2307.Metal3 v_a.P8.pSD 8052.32516846
Rred_2663 v_a.$231.Metal1 v_a.$233.Metal1 0.369677293078
Rred_2664 v_a.$231.Metal1 v_a.P6.pSD 11.3620533996
Rred_2665 v_a.$2311.Metal3 v_a.$2313.Metal3 0.144898562844
Rred_2666 v_a.$2313.Metal3 v_a.$2317.Metal3 0.294453498367
Rred_2667 v_a.$2317.Metal3 v_a.$2321.Metal3 0.294453498367
Rred_2668 v_a.$2321.Metal3 v_a.$305.Metal1 18.5132214307
Rred_2669 v_a.$2321.Metal3 v_a.P8.pSD 41.5010148887
Rred_2670 v_a.$2327.Metal3 v_a.$2337.Metal3 0.277203140364
Rred_2671 v_a.$2327.Metal3 v_a.$2365.Metal3 0.304766659607
Rred_2672 v_a.$2327.Metal3 v_a.$2387.Metal3 0.1057353717
Rred_2673 v_a.$2327.Metal3 v_a.$354.Metal1 264.637085427
Rred_2674 v_a.$2327.Metal3 v_a.P10.nSD 4.97632451283
Rred_2675 v_a.$2327.Metal3 v_a.P10.pSD 10713.552318
Rred_2676 v_a.$2327.Metal3 v_a.P12.nSD 11.7240089587
Rred_2677 v_a.$233.Metal1 v_a.$235.Metal1 0.370503170053
Rred_2678 v_a.$233.Metal1 v_a.P6.pSD 8.55968582736
Rred_2679 v_a.$2337.Metal3 v_a.$2341.Metal3 0.294453498367
Rred_2680 v_a.$2337.Metal3 v_a.$354.Metal1 192.51795956
Rred_2681 v_a.$2337.Metal3 v_a.P10.pSD 8052.32516846
Rred_2682 v_a.$2341.Metal3 v_a.$2343.Metal3 0.144898562844
Rred_2683 v_a.$2343.Metal3 v_a.$2347.Metal3 0.294453498367
Rred_2684 v_a.$2347.Metal3 v_a.$2351.Metal3 0.294453498367
Rred_2685 v_a.$235.Metal1 v_a.$237.Metal1 0.370659032818
Rred_2686 v_a.$235.Metal1 v_a.P6.pSD 8.59117890847
Rred_2687 v_a.$2351.Metal3 v_a.$368.Metal1 18.5132214307
Rred_2688 v_a.$2351.Metal3 v_a.P10.pSD 41.5010148887
Rred_2689 v_a.$2365.Metal3 v_a.$2367.Metal3 0.144868363583
Rred_2690 v_a.$2365.Metal3 v_a.$2387.Metal3 0.304766659607
Rred_2691 v_a.$2365.Metal3 v_a.$417.Metal1 138.3012525
Rred_2692 v_a.$2365.Metal3 v_a.P12.nSD 33.7927317044
Rred_2693 v_a.$2365.Metal3 v_a.P12.pSD 5598.97983276
Rred_2694 v_a.$2367.Metal3 v_a.$2371.Metal3 0.294453498367
Rred_2695 v_a.$2367.Metal3 v_a.$417.Metal1 549.42570258
Rred_2696 v_a.$2367.Metal3 v_a.P12.pSD 24485.7028632
Rred_2697 v_a.$237.Metal1 v_a.$240.Metal1 0.569502917927
Rred_2698 v_a.$237.Metal1 v_a.P6.pSD 6.88626460739
Rred_2699 v_a.$2371.Metal3 v_a.$2373.Metal3 0.144898562844
Rred_2700 v_a.$2373.Metal3 v_a.$2377.Metal3 0.294453498367
Rred_2701 v_a.$2377.Metal3 v_a.$2381.Metal3 0.294453498367
Rred_2702 v_a.$2381.Metal3 v_a.$431.Metal1 18.5132214307
Rred_2703 v_a.$2381.Metal3 v_a.P12.pSD 41.5010148887
Rred_2704 v_a.$2387.Metal3 v_a.$2397.Metal3 0.277203140364
Rred_2705 v_a.$2387.Metal3 v_a.$2447.Metal3 0.091159488349
Rred_2706 v_a.$2387.Metal3 v_a.$480.Metal1 264.637085427
Rred_2707 v_a.$2387.Metal3 v_a.P12.nSD 11.7240089587
Rred_2708 v_a.$2387.Metal3 v_a.P14.nSD 4.97632451283
Rred_2709 v_a.$2387.Metal3 v_a.P14.pSD 10713.552318
Rred_2710 v_a.$2387.Metal3 v_a.P16.nSD 10.1078252328
Rred_2711 v_a.$2387.Metal3 v_a.P16.pSD 4.1129174628
Rred_2712 v_a.$2397.Metal3 v_a.$2401.Metal3 0.294453498367
Rred_2713 v_a.$2397.Metal3 v_a.$480.Metal1 192.51795956
Rred_2714 v_a.$2397.Metal3 v_a.P14.pSD 8052.32516846
Rred_2715 v_a.$240.Metal1 v_a.$242.Metal1 0.370690076472
Rred_2716 v_a.$240.Metal1 v_a.P6.pSD 6.90649642181
Rred_2717 v_a.$2401.Metal3 v_a.$2403.Metal3 0.144898562844
Rred_2718 v_a.$2403.Metal3 v_a.$2407.Metal3 0.294453498367
Rred_2719 v_a.$2407.Metal3 v_a.$489.Metal1 12.1615432995
Rred_2720 v_a.$2407.Metal3 v_a.P14.pSD 11.7584434988
Rred_2721 v_a.$242.Metal1 v_a.P6.pSD 2.52987570285
Rred_2722 v_a.$2447.Metal3 v_a.$2458.Metal3 0.354135711748
Rred_2723 v_a.$2447.Metal3 v_a.$2485.Metal3 0.304766659607
Rred_2724 v_a.$2447.Metal3 v_a.$2507.Metal3 0.1057353717
Rred_2725 v_a.$2447.Metal3 v_a.$606.Metal1 206.732285942
Rred_2726 v_a.$2447.Metal3 v_a.P16.nSD 10.1078252328
Rred_2727 v_a.$2447.Metal3 v_a.P16.pSD 4.1129174628
Rred_2728 v_a.$2447.Metal3 v_a.P18.nSD 4.97632451283
Rred_2729 v_a.$2447.Metal3 v_a.P18.pSD 8428.52841992
Rred_2730 v_a.$2447.Metal3 v_a.P20.nSD 11.7240089587
Rred_2731 v_a.$2458.Metal3 v_a.$2462.Metal3 0.294453498367
Rred_2732 v_a.$2458.Metal3 v_a.$606.Metal1 245.947735453
Rred_2733 v_a.$2458.Metal3 v_a.P18.pSD 10287.0981224
Rred_2734 v_a.$2462.Metal3 v_a.$611.Metal1 8.07701361806
Rred_2735 v_a.$2462.Metal3 v_a.P18.pSD 6.23214661354
Rred_2736 v_a.$2485.Metal3 v_a.$2488.Metal3 0.2187481663
Rred_2737 v_a.$2485.Metal3 v_a.$2507.Metal3 0.304766659607
Rred_2738 v_a.$2485.Metal3 v_a.$669.Metal1 127.697679067
Rred_2739 v_a.$2485.Metal3 v_a.P20.nSD 33.7927317044
Rred_2740 v_a.$2485.Metal3 v_a.P20.pSD 5206.26718884
Rred_2741 v_a.$2488.Metal3 v_a.$2490.Metal3 0.144898562844
Rred_2742 v_a.$2488.Metal3 v_a.$669.Metal1 829.621195303
Rred_2743 v_a.$2488.Metal3 v_a.P20.pSD 36972.8936631
Rred_2744 v_a.$2490.Metal3 v_a.$2493.Metal3 0.218798890166
Rred_2745 v_a.$2493.Metal3 v_a.$2497.Metal3 0.294453498367
Rred_2746 v_a.$2497.Metal3 v_a.$2501.Metal3 0.294453498367
Rred_2747 v_a.$2501.Metal3 v_a.$683.Metal1 18.5132214307
Rred_2748 v_a.$2501.Metal3 v_a.P20.pSD 41.5010148887
Rred_2749 v_a.$2507.Metal3 v_a.$2518.Metal3 0.354135711748
Rred_2750 v_a.$2507.Metal3 v_a.$2545.Metal3 0.304766659607
Rred_2751 v_a.$2507.Metal3 v_a.$2567.Metal3 0.1057353717
Rred_2752 v_a.$2507.Metal3 v_a.$732.Metal1 206.732285942
Rred_2753 v_a.$2507.Metal3 v_a.P20.nSD 11.7240089587
Rred_2754 v_a.$2507.Metal3 v_a.P22.nSD 4.97632451283
Rred_2755 v_a.$2507.Metal3 v_a.P22.pSD 8428.52841992
Rred_2756 v_a.$2507.Metal3 v_a.P24.nSD 11.7240089587
Rred_2757 v_a.$2518.Metal3 v_a.$2520.Metal3 0.144898562844
Rred_2758 v_a.$2518.Metal3 v_a.$732.Metal1 245.947735453
Rred_2759 v_a.$2518.Metal3 v_a.P22.pSD 10287.0981224
Rred_2760 v_a.$2520.Metal3 v_a.$2523.Metal3 0.218798890166
Rred_2761 v_a.$2523.Metal3 v_a.$2527.Metal3 0.294453498367
Rred_2762 v_a.$2527.Metal3 v_a.$2531.Metal3 0.294453498367
Rred_2763 v_a.$2531.Metal3 v_a.$746.Metal1 18.5132214307
Rred_2764 v_a.$2531.Metal3 v_a.P22.pSD 41.5010148887
Rred_2765 v_a.$2545.Metal3 v_a.$2548.Metal3 0.2187481663
Rred_2766 v_a.$2545.Metal3 v_a.$2567.Metal3 0.304766659607
Rred_2767 v_a.$2545.Metal3 v_a.$795.Metal1 127.697679067
Rred_2768 v_a.$2545.Metal3 v_a.P24.nSD 33.7927317044
Rred_2769 v_a.$2545.Metal3 v_a.P24.pSD 5206.26718884
Rred_2770 v_a.$2548.Metal3 v_a.$2550.Metal3 0.144898562844
Rred_2771 v_a.$2548.Metal3 v_a.$795.Metal1 829.621195303
Rred_2772 v_a.$2548.Metal3 v_a.P24.pSD 36972.8936631
Rred_2773 v_a.$2550.Metal3 v_a.$2553.Metal3 0.218798890166
Rred_2774 v_a.$2553.Metal3 v_a.$2557.Metal3 0.294453498367
Rred_2775 v_a.$2557.Metal3 v_a.$2561.Metal3 0.294453498367
Rred_2776 v_a.$2561.Metal3 v_a.$809.Metal1 18.5132214307
Rred_2777 v_a.$2561.Metal3 v_a.P24.pSD 41.5010148887
Rred_2778 v_a.$2567.Metal3 v_a.$2578.Metal3 0.354135711748
Rred_2779 v_a.$2567.Metal3 v_a.$2597.Metal3 0.04488
Rred_2780 v_a.$2567.Metal3 v_a.$858.Metal1 206.732285942
Rred_2781 v_a.$2567.Metal3 v_a.P24.nSD 11.7240089587
Rred_2782 v_a.$2567.Metal3 v_a.P26.nSD 4.97632451283
Rred_2783 v_a.$2567.Metal3 v_a.P26.pSD 8428.52841992
Rred_2784 v_a.$2578.Metal3 v_a.$2580.Metal3 0.144898562844
Rred_2785 v_a.$2578.Metal3 v_a.$858.Metal1 245.947735453
Rred_2786 v_a.$2578.Metal3 v_a.P26.pSD 10287.0981224
Rred_2787 v_a.$2580.Metal3 v_a.$2583.Metal3 0.218798890166
Rred_2788 v_a.$2583.Metal3 v_a.$2587.Metal3 0.294453498367
Rred_2789 v_a.$2587.Metal3 v_a.$2591.Metal3 0.294453498367
Rred_2790 v_a.$2591.Metal3 v_a.$872.Metal1 18.5132214307
Rred_2791 v_a.$2591.Metal3 v_a.P26.pSD 41.5010148887
Rred_2792 v_a.$2597.Metal3 v_a.$2608.Metal3 0.354135711748
Rred_2793 v_a.$2597.Metal3 v_a.$2635.Metal3 0.304766659607
Rred_2794 v_a.$2597.Metal3 v_a.$2657.Metal3 0.1057353717
Rred_2795 v_a.$2597.Metal3 v_a.$921.Metal1 206.732285942
Rred_2796 v_a.$2597.Metal3 v_a.P28.nSD 4.97632451283
Rred_2797 v_a.$2597.Metal3 v_a.P28.pSD 8428.52841992
Rred_2798 v_a.$2597.Metal3 v_a.P30.nSD 11.7240089587
Rred_2799 v_a.$2608.Metal3 v_a.$2610.Metal3 0.144898562844
Rred_2800 v_a.$2608.Metal3 v_a.$921.Metal1 245.947735453
Rred_2801 v_a.$2608.Metal3 v_a.P28.pSD 10287.0981224
Rred_2802 v_a.$2610.Metal3 v_a.$2613.Metal3 0.218798890166
Rred_2803 v_a.$2613.Metal3 v_a.$2617.Metal3 0.294453498367
Rred_2804 v_a.$2617.Metal3 v_a.$2621.Metal3 0.294453498367
Rred_2805 v_a.$2621.Metal3 v_a.$936.Metal1 15.990728426
Rred_2806 v_a.$2621.Metal3 v_a.P28.pSD 48.6463927648
Rred_2807 v_a.$2635.Metal3 v_a.$2638.Metal3 0.2187481663
Rred_2808 v_a.$2635.Metal3 v_a.$2657.Metal3 0.304766659607
Rred_2809 v_a.$2635.Metal3 v_a.$984.Metal1 127.697679067
Rred_2810 v_a.$2635.Metal3 v_a.P30.nSD 33.7927317044
Rred_2811 v_a.$2635.Metal3 v_a.P30.pSD 5206.26718884
Rred_2812 v_a.$2638.Metal3 v_a.$2640.Metal3 0.144898562844
Rred_2813 v_a.$2638.Metal3 v_a.$984.Metal1 829.621195303
Rred_2814 v_a.$2638.Metal3 v_a.P30.pSD 36972.8936631
Rred_2815 v_a.$2640.Metal3 v_a.$2643.Metal3 0.218798890166
Rred_2816 v_a.$2643.Metal3 v_a.$2647.Metal3 0.294453498367
Rred_2817 v_a.$2647.Metal3 v_a.$2651.Metal3 0.294453498367
Rred_2818 v_a.$2651.Metal3 v_a.$998.Metal1 18.5132214307
Rred_2819 v_a.$2651.Metal3 v_a.P30.pSD 41.5010148887
Rred_2820 v_a.$2657.Metal3 v_a.$2668.Metal3 0.354135711748
Rred_2821 v_a.$2657.Metal3 v_a.P30.nSD 11.7240089587
Rred_2822 v_a.$2657.Metal3 v_a.P32.nSD 4.97632451283
Rred_2823 v_a.$2657.Metal3 v_a.P32.pSD 8428.52841992
Rred_2824 v_a.$2657.Metal3 v_a.P34.nSD 5.26551830364
Rred_2825 v_a.$2657.Metal3 v_a.P34.pSD 2.24924011707
Rred_2826 v_a.$2668.Metal3 v_a.$2670.Metal3 0.144898562844
Rred_2827 v_a.$2668.Metal3 v_a.P32.pSD 10287.0981224
Rred_2828 v_a.$2670.Metal3 v_a.$2673.Metal3 0.218798890166
Rred_2829 v_a.$2673.Metal3 v_a.$2677.Metal3 0.294453498367
Rred_2830 v_a.$2677.Metal3 v_a.$2681.Metal3 0.294453498367
Rred_2831 v_a.$2681.Metal3 v_a.P32.pSD 48.6463927648
Rred_2832 v_a.$291.Metal1 v_a.$293.Metal1 0.370783637491
Rred_2833 v_a.$291.Metal1 v_a.P8.pSD 5.04522986703
Rred_2834 v_a.$293.Metal1 v_a.$296.Metal1 0.569471076618
Rred_2835 v_a.$293.Metal1 v_a.P8.pSD 6.90745785884
Rred_2836 v_a.$296.Metal1 v_a.$298.Metal1 0.370503170053
Rred_2837 v_a.$296.Metal1 v_a.P8.pSD 6.88527440099
Rred_2838 v_a.$298.Metal1 v_a.$300.Metal1 0.370659032818
Rred_2839 v_a.$298.Metal1 v_a.P8.pSD 8.59117890847
Rred_2840 v_a.$300.Metal1 v_a.$303.Metal1 0.569502917927
Rred_2841 v_a.$300.Metal1 v_a.P8.pSD 6.88626460739
Rred_2842 v_a.$303.Metal1 v_a.$305.Metal1 0.370690076472
Rred_2843 v_a.$303.Metal1 v_a.P8.pSD 6.90649642181
Rred_2844 v_a.$305.Metal1 v_a.P8.pSD 2.52987570285
Rred_2845 v_a.$354.Metal1 v_a.$356.Metal1 0.370783637491
Rred_2846 v_a.$354.Metal1 v_a.P10.pSD 5.04522986703
Rred_2847 v_a.$356.Metal1 v_a.$359.Metal1 0.569471076618
Rred_2848 v_a.$356.Metal1 v_a.P10.pSD 6.90745785884
Rred_2849 v_a.$359.Metal1 v_a.$361.Metal1 0.370503170053
Rred_2850 v_a.$359.Metal1 v_a.P10.pSD 6.88527440099
Rred_2851 v_a.$361.Metal1 v_a.$363.Metal1 0.370659032818
Rred_2852 v_a.$361.Metal1 v_a.P10.pSD 8.59117890847
Rred_2853 v_a.$363.Metal1 v_a.$366.Metal1 0.569502917927
Rred_2854 v_a.$363.Metal1 v_a.P10.pSD 6.88626460739
Rred_2855 v_a.$366.Metal1 v_a.$368.Metal1 0.370690076472
Rred_2856 v_a.$366.Metal1 v_a.P10.pSD 6.90649642181
Rred_2857 v_a.$368.Metal1 v_a.P10.pSD 2.52987570285
Rred_2858 v_a.$39.Metal1 v_a.$41.Metal1 0.370783637491
Rred_2859 v_a.$39.Metal1 v_a.P0.pSD 5.0452289091
Rred_2860 v_a.$41.Metal1 v_a.$44.Metal1 0.569471076618
Rred_2861 v_a.$41.Metal1 v_a.P0.pSD 6.90745785884
Rred_2862 v_a.$417.Metal1 v_a.$419.Metal1 0.370783637491
Rred_2863 v_a.$417.Metal1 v_a.P12.pSD 5.04523208933
Rred_2864 v_a.$419.Metal1 v_a.$422.Metal1 0.569471076618
Rred_2865 v_a.$419.Metal1 v_a.P12.pSD 6.90745785884
Rred_2866 v_a.$422.Metal1 v_a.$424.Metal1 0.370503170053
Rred_2867 v_a.$422.Metal1 v_a.P12.pSD 6.88527440099
Rred_2868 v_a.$424.Metal1 v_a.$426.Metal1 0.370659032818
Rred_2869 v_a.$424.Metal1 v_a.P12.pSD 8.59117890847
Rred_2870 v_a.$426.Metal1 v_a.$429.Metal1 0.569502917927
Rred_2871 v_a.$426.Metal1 v_a.P12.pSD 6.88626460739
Rred_2872 v_a.$429.Metal1 v_a.$431.Metal1 0.370690076472
Rred_2873 v_a.$429.Metal1 v_a.P12.pSD 6.90649642181
Rred_2874 v_a.$431.Metal1 v_a.P12.pSD 2.52987570285
Rred_2875 v_a.$44.Metal1 v_a.$46.Metal1 0.370503170053
Rred_2876 v_a.$44.Metal1 v_a.P0.pSD 6.88527440099
Rred_2877 v_a.$46.Metal1 v_a.$48.Metal1 0.370659032818
Rred_2878 v_a.$46.Metal1 v_a.P0.pSD 8.59117890847
Rred_2879 v_a.$48.Metal1 v_a.P0.pSD 2.30013748601
Rred_2880 v_a.$480.Metal1 v_a.$482.Metal1 0.370783637491
Rred_2881 v_a.$480.Metal1 v_a.P14.pSD 5.04522986703
Rred_2882 v_a.$482.Metal1 v_a.$485.Metal1 0.569471076618
Rred_2883 v_a.$482.Metal1 v_a.P14.pSD 6.90745785884
Rred_2884 v_a.$485.Metal1 v_a.$487.Metal1 0.370503170053
Rred_2885 v_a.$485.Metal1 v_a.P14.pSD 6.88527440099
Rred_2886 v_a.$487.Metal1 v_a.$489.Metal1 0.370659032818
Rred_2887 v_a.$487.Metal1 v_a.P14.pSD 8.59117890847
Rred_2888 v_a.$489.Metal1 v_a.P14.pSD 2.30013748601
Rred_2889 v_a.$606.Metal1 v_a.$608.Metal1 0.370783637491
Rred_2890 v_a.$606.Metal1 v_a.P18.pSD 5.04522893958
Rred_2891 v_a.$608.Metal1 v_a.$611.Metal1 0.569471076618
Rred_2892 v_a.$608.Metal1 v_a.P18.pSD 6.90745785884
Rred_2893 v_a.$611.Metal1 v_a.P18.pSD 2.02782672077
Rred_2894 v_a.$669.Metal1 v_a.$671.Metal1 0.370783637491
Rred_2895 v_a.$669.Metal1 v_a.P20.pSD 5.04523199891
Rred_2896 v_a.$671.Metal1 v_a.$674.Metal1 0.569471076618
Rred_2897 v_a.$671.Metal1 v_a.P20.pSD 6.90745785884
Rred_2898 v_a.$674.Metal1 v_a.$676.Metal1 0.370503170053
Rred_2899 v_a.$674.Metal1 v_a.P20.pSD 6.88527440099
Rred_2900 v_a.$676.Metal1 v_a.$678.Metal1 0.370659032818
Rred_2901 v_a.$676.Metal1 v_a.P20.pSD 8.59117890847
Rred_2902 v_a.$678.Metal1 v_a.$681.Metal1 0.569502917927
Rred_2903 v_a.$678.Metal1 v_a.P20.pSD 6.88626460739
Rred_2904 v_a.$681.Metal1 v_a.$683.Metal1 0.370690076472
Rred_2905 v_a.$681.Metal1 v_a.P20.pSD 6.90649642181
Rred_2906 v_a.$683.Metal1 v_a.P20.pSD 2.52987570285
Rred_2907 v_a.$732.Metal1 v_a.$734.Metal1 0.370783637491
Rred_2908 v_a.$732.Metal1 v_a.P22.pSD 5.04522893958
Rred_2909 v_a.$734.Metal1 v_a.$737.Metal1 0.569471076618
Rred_2910 v_a.$734.Metal1 v_a.P22.pSD 6.90745785884
Rred_2911 v_a.$737.Metal1 v_a.$739.Metal1 0.370503170053
Rred_2912 v_a.$737.Metal1 v_a.P22.pSD 6.88527440099
Rred_2913 v_a.$739.Metal1 v_a.$741.Metal1 0.370659032818
Rred_2914 v_a.$739.Metal1 v_a.P22.pSD 8.59117890847
Rred_2915 v_a.$741.Metal1 v_a.$744.Metal1 0.569502917927
Rred_2916 v_a.$741.Metal1 v_a.P22.pSD 6.88626460739
Rred_2917 v_a.$744.Metal1 v_a.$746.Metal1 0.370690076472
Rred_2918 v_a.$744.Metal1 v_a.P22.pSD 6.90649642181
Rred_2919 v_a.$746.Metal1 v_a.P22.pSD 2.52987570285
Rred_2920 v_a.$795.Metal1 v_a.$797.Metal1 0.370783637491
Rred_2921 v_a.$795.Metal1 v_a.P24.pSD 5.04523199891
Rred_2922 v_a.$797.Metal1 v_a.$800.Metal1 0.569471076618
Rred_2923 v_a.$797.Metal1 v_a.P24.pSD 6.90745785884
Rred_2924 v_a.$800.Metal1 v_a.$802.Metal1 0.370503170053
Rred_2925 v_a.$800.Metal1 v_a.P24.pSD 6.88527440099
Rred_2926 v_a.$802.Metal1 v_a.$804.Metal1 0.370659032818
Rred_2927 v_a.$802.Metal1 v_a.P24.pSD 8.59117890847
Rred_2928 v_a.$804.Metal1 v_a.$807.Metal1 0.569502917927
Rred_2929 v_a.$804.Metal1 v_a.P24.pSD 6.88626460739
Rred_2930 v_a.$807.Metal1 v_a.$809.Metal1 0.370690076472
Rred_2931 v_a.$807.Metal1 v_a.P24.pSD 6.90649642181
Rred_2932 v_a.$809.Metal1 v_a.P24.pSD 2.52987570285
Rred_2933 v_a.$858.Metal1 v_a.$860.Metal1 0.370783637491
Rred_2934 v_a.$858.Metal1 v_a.P26.pSD 5.04522893958
Rred_2935 v_a.$860.Metal1 v_a.$863.Metal1 0.569471076618
Rred_2936 v_a.$860.Metal1 v_a.P26.pSD 6.90745785884
Rred_2937 v_a.$863.Metal1 v_a.$865.Metal1 0.370503170053
Rred_2938 v_a.$863.Metal1 v_a.P26.pSD 6.88527440099
Rred_2939 v_a.$865.Metal1 v_a.$867.Metal1 0.370659032818
Rred_2940 v_a.$865.Metal1 v_a.P26.pSD 8.59117890847
Rred_2941 v_a.$867.Metal1 v_a.$870.Metal1 0.569502917927
Rred_2942 v_a.$867.Metal1 v_a.P26.pSD 6.88626460739
Rred_2943 v_a.$870.Metal1 v_a.$872.Metal1 0.370690076472
Rred_2944 v_a.$870.Metal1 v_a.P26.pSD 6.90649642181
Rred_2945 v_a.$872.Metal1 v_a.P26.pSD 2.52987570285
Rred_2946 v_a.$921.Metal1 v_a.$923.Metal1 0.370783637491
Rred_2947 v_a.$921.Metal1 v_a.P28.pSD 5.04522893958
Rred_2948 v_a.$923.Metal1 v_a.$926.Metal1 0.569471076618
Rred_2949 v_a.$923.Metal1 v_a.P28.pSD 6.90745785884
Rred_2950 v_a.$926.Metal1 v_a.$928.Metal1 0.370503170053
Rred_2951 v_a.$926.Metal1 v_a.P28.pSD 6.88527440099
Rred_2952 v_a.$928.Metal1 v_a.$930.Metal1 0.370659032818
Rred_2953 v_a.$928.Metal1 v_a.P28.pSD 8.59117890847
Rred_2954 v_a.$930.Metal1 v_a.$932.Metal1 0.369657961965
Rred_2955 v_a.$930.Metal1 v_a.P28.pSD 8.56005138923
Rred_2956 v_a.$932.Metal1 v_a.$934.Metal1 0.372830884673
Rred_2957 v_a.$932.Metal1 v_a.P28.pSD 8.54074022007
Rred_2958 v_a.$934.Metal1 v_a.$936.Metal1 0.370821071381
Rred_2959 v_a.$934.Metal1 v_a.P28.pSD 8.54535706926
Rred_2960 v_a.$936.Metal1 v_a.P28.pSD 2.60065146165
Rred_2961 v_a.$984.Metal1 v_a.$986.Metal1 0.370783637491
Rred_2962 v_a.$984.Metal1 v_a.P30.pSD 5.04523199891
Rred_2963 v_a.$986.Metal1 v_a.$989.Metal1 0.569471076618
Rred_2964 v_a.$986.Metal1 v_a.P30.pSD 6.90745785884
Rred_2965 v_a.$989.Metal1 v_a.$991.Metal1 0.370503170053
Rred_2966 v_a.$989.Metal1 v_a.P30.pSD 6.88527440099
Rred_2967 v_a.$991.Metal1 v_a.$993.Metal1 0.370659032818
Rred_2968 v_a.$991.Metal1 v_a.P30.pSD 8.59117890847
Rred_2969 v_a.$993.Metal1 v_a.$996.Metal1 0.569502917927
Rred_2970 v_a.$993.Metal1 v_a.P30.pSD 6.88626460739
Rred_2971 v_a.$996.Metal1 v_a.$998.Metal1 0.370690076472
Rred_2972 v_a.$996.Metal1 v_a.P30.pSD 6.90649642181
Rred_2973 v_a.$998.Metal1 v_a.P30.pSD 2.52987570285
Rred_2974 v_a.P16.nSD v_a.P16.pSD 456.043047891
Rred_2975 v_a.P34.nSD v_a.P34.pSD 342.054751783
Rred_2976 v_b v_b.$3629.Metal2 0.0403215648
Rred_2977 v_b v_b.$4042.Metal3 22.90998
Rred_2978 v_b v_b.P71.nSD 4.47488544804
Rred_2979 v_b v_b.P71.pSD 2.6509177845
Rred_2980 v_b.$1992.Metal1 v_b.$1993.Metal1 0.181612757399
Rred_2981 v_b.$1992.Metal1 v_b.$3487.Metal2 4.29071512113
Rred_2982 v_b.$1992.Metal1 v_b.$3491.Metal2 36.3429298463
Rred_2983 v_b.$1992.Metal1 v_b.$3970.Metal3 1014.32437783
Rred_2984 v_b.$1992.Metal1 v_b.$3980.Metal3 711.527296573
Rred_2985 v_b.$1992.Metal1 v_b.P61.pSD 5.92278984051
Rred_2986 v_b.$1993.Metal1 v_b.$1994.Metal1 0.184157224742
Rred_2987 v_b.$1993.Metal1 v_b.$3487.Metal2 37.4118395477
Rred_2988 v_b.$1993.Metal1 v_b.$3491.Metal2 15.8543651426
Rred_2989 v_b.$1993.Metal1 v_b.$3980.Metal3 1959.76653949
Rred_2990 v_b.$1993.Metal1 v_b.P61.pSD 17
Rred_2991 v_b.$1994.Metal1 v_b.$1995.Metal1 0.18382334016
Rred_2992 v_b.$1994.Metal1 v_b.$3491.Metal2 12.0753698923
Rred_2993 v_b.$1994.Metal1 v_b.$3495.Metal2 117.044118683
Rred_2994 v_b.$1994.Metal1 v_b.$3982.Metal3 6131.19136113
Rred_2995 v_b.$1994.Metal1 v_b.P61.pSD 17
Rred_2996 v_b.$1995.Metal1 v_b.$1997.Metal1 0.369677293078
Rred_2997 v_b.$1995.Metal1 v_b.$3491.Metal2 21.8217848391
Rred_2998 v_b.$1995.Metal1 v_b.$3495.Metal2 10.0649687733
Rred_2999 v_b.$1995.Metal1 v_b.$3982.Metal3 1143.10347411
Rred_3000 v_b.$1995.Metal1 v_b.P61.pSD 11.3620533996
Rred_3001 v_b.$1997.Metal1 v_b.$1998.Metal1 0.181295649746
Rred_3002 v_b.$1997.Metal1 v_b.$3495.Metal2 10.0784531488
Rred_3003 v_b.$1997.Metal1 v_b.$3499.Metal2 23.0869371942
Rred_3004 v_b.$1997.Metal1 v_b.$3984.Metal3 1209.37669891
Rred_3005 v_b.$1997.Metal1 v_b.P61.pSD 11.4182596982
Rred_3006 v_b.$1998.Metal1 v_b.$1999.Metal1 0.184218197279
Rred_3007 v_b.$1998.Metal1 v_b.$3495.Metal2 90.6986818343
Rred_3008 v_b.$1998.Metal1 v_b.$3499.Metal2 12.6659814628
Rred_3009 v_b.$1998.Metal1 v_b.$3984.Metal3 4751.12274574
Rred_3010 v_b.$1998.Metal1 v_b.P61.pSD 17
Rred_3011 v_b.$1999.Metal1 v_b.$2000.Metal1 0.184246150364
Rred_3012 v_b.$1999.Metal1 v_b.$3499.Metal2 14.9983556959
Rred_3013 v_b.$1999.Metal1 v_b.$3503.Metal2 41.6273108849
Rred_3014 v_b.$1999.Metal1 v_b.$3986.Metal3 2180.58807018
Rred_3015 v_b.$1999.Metal1 v_b.P61.pSD 17
Rred_3016 v_b.$2000.Metal1 v_b.$2003.Metal1 0.566394146755
Rred_3017 v_b.$2000.Metal1 v_b.$3499.Metal2 33.0883753187
Rred_3018 v_b.$2000.Metal1 v_b.$3503.Metal2 8.88979836456
Rred_3019 v_b.$2000.Metal1 v_b.$3505.Metal2 25.9290993678
Rred_3020 v_b.$2000.Metal1 v_b.$3986.Metal3 1733.28795322
Rred_3021 v_b.$2000.Metal1 v_b.P61.pSD 8.62194684835
Rred_3022 v_b.$2003.Metal1 v_b.$3503.Metal2 38.1634558777
Rred_3023 v_b.$2003.Metal1 v_b.$3505.Metal2 14.4279978464
Rred_3024 v_b.$2003.Metal1 v_b.$3507.Metal2 2.53578165998
Rred_3025 v_b.$2003.Metal1 v_b.$3990.Metal3 8.8994882505
Rred_3026 v_b.$2003.Metal1 v_b.P61.pSD 2.16205103107
Rred_3027 v_b.$2244.Metal1 v_b.$2246.Metal1 0.370783637491
Rred_3028 v_b.$2244.Metal1 v_b.$3678.Metal2 4.86558821398
Rred_3029 v_b.$2244.Metal1 v_b.$3680.Metal2 12.0284307344
Rred_3030 v_b.$2244.Metal1 v_b.$3682.Metal2 55.3977134276
Rred_3031 v_b.$2244.Metal1 v_b.$4053.Metal3 529.941924087
Rred_3032 v_b.$2244.Metal1 v_b.P69.pSD 5.04909626568
Rred_3033 v_b.$2246.Metal1 v_b.$2247.Metal1 0.18382334016
Rred_3034 v_b.$2246.Metal1 v_b.$3680.Metal2 37.4749237892
Rred_3035 v_b.$2246.Metal1 v_b.$3682.Metal2 9.93878641563
Rred_3036 v_b.$2246.Metal1 v_b.$3686.Metal2 117.044118683
Rred_3037 v_b.$2246.Metal1 v_b.$4057.Metal3 6131.19136113
Rred_3038 v_b.$2246.Metal1 v_b.P69.pSD 11.4106916049
Rred_3039 v_b.$2247.Metal1 v_b.$2249.Metal1 0.369677293078
Rred_3040 v_b.$2247.Metal1 v_b.$3682.Metal2 21.8217848391
Rred_3041 v_b.$2247.Metal1 v_b.$3686.Metal2 10.0649687733
Rred_3042 v_b.$2247.Metal1 v_b.$4057.Metal3 1143.10347411
Rred_3043 v_b.$2247.Metal1 v_b.P69.pSD 11.3620533996
Rred_3044 v_b.$2249.Metal1 v_b.$2251.Metal1 0.370503170053
Rred_3045 v_b.$2249.Metal1 v_b.$3686.Metal2 17.886835549
Rred_3046 v_b.$2249.Metal1 v_b.$3688.Metal2 10.0549886197
Rred_3047 v_b.$2249.Metal1 v_b.$3690.Metal2 29.6089214123
Rred_3048 v_b.$2249.Metal1 v_b.P69.pSD 8.55968582736
Rred_3049 v_b.$2251.Metal1 v_b.$2252.Metal1 0.184246150364
Rred_3050 v_b.$2251.Metal1 v_b.$3688.Metal2 90.9416871948
Rred_3051 v_b.$2251.Metal1 v_b.$3690.Metal2 10.0087293109
Rred_3052 v_b.$2251.Metal1 v_b.$3694.Metal2 41.6273108849
Rred_3053 v_b.$2251.Metal1 v_b.$4061.Metal3 2180.58807018
Rred_3054 v_b.$2251.Metal1 v_b.P69.pSD 11.414470136
Rred_3055 v_b.$2252.Metal1 v_b.$2255.Metal1 0.566394146755
Rred_3056 v_b.$2252.Metal1 v_b.$3690.Metal2 33.0883753187
Rred_3057 v_b.$2252.Metal1 v_b.$3694.Metal2 8.88979836456
Rred_3058 v_b.$2252.Metal1 v_b.$3696.Metal2 25.9290993678
Rred_3059 v_b.$2252.Metal1 v_b.$4061.Metal3 1733.28795322
Rred_3060 v_b.$2252.Metal1 v_b.P69.pSD 8.62194684835
Rred_3061 v_b.$2255.Metal1 v_b.$3694.Metal2 38.1634558777
Rred_3062 v_b.$2255.Metal1 v_b.$3696.Metal2 14.4279978464
Rred_3063 v_b.$2255.Metal1 v_b.$3698.Metal2 2.53578165998
Rred_3064 v_b.$2255.Metal1 v_b.$4065.Metal3 8.8994882505
Rred_3065 v_b.$2255.Metal1 v_b.P69.pSD 2.16205103107
Rred_3066 v_b.$2361.Metal2 v_b.$2421.Metal2 0.0911590993431
Rred_3067 v_b.$2361.Metal2 v_b.P0.nSD 4.58310639695
Rred_3068 v_b.$2361.Metal2 v_b.P0.pSD 2.71502776932
Rred_3069 v_b.$2361.Metal2 v_b.P1.nSD 4.05583782899
Rred_3070 v_b.$2361.Metal2 v_b.P1.pSD 2.23187016546
Rred_3071 v_b.$2361.Metal2 v_b.P3.nSD 8.23811327033
Rred_3072 v_b.$2361.Metal2 v_b.P3.pSD 4.53331715984
Rred_3073 v_b.$2421.Metal2 v_b.$2481.Metal2 0.0911590993431
Rred_3074 v_b.$2421.Metal2 v_b.P3.nSD 8.23811327033
Rred_3075 v_b.$2421.Metal2 v_b.P3.pSD 4.53331715984
Rred_3076 v_b.$2421.Metal2 v_b.P5.nSD 4.05583782899
Rred_3077 v_b.$2421.Metal2 v_b.P5.pSD 2.23187016546
Rred_3078 v_b.$2421.Metal2 v_b.P7.nSD 8.23811327033
Rred_3079 v_b.$2421.Metal2 v_b.P7.pSD 4.53331715984
Rred_3080 v_b.$2481.Metal2 v_b.$2541.Metal2 0.0911590993431
Rred_3081 v_b.$2481.Metal2 v_b.P10.nSD 4.05583782899
Rred_3082 v_b.$2481.Metal2 v_b.P10.pSD 2.23187016546
Rred_3083 v_b.$2481.Metal2 v_b.P11.nSD 8.23811327033
Rred_3084 v_b.$2481.Metal2 v_b.P11.pSD 4.53331715984
Rred_3085 v_b.$2481.Metal2 v_b.P7.nSD 8.23811327033
Rred_3086 v_b.$2481.Metal2 v_b.P7.pSD 4.53331715984
Rred_3087 v_b.$2541.Metal2 v_b.$2601.Metal2 0.0911590993431
Rred_3088 v_b.$2541.Metal2 v_b.P11.nSD 8.23811327033
Rred_3089 v_b.$2541.Metal2 v_b.P11.pSD 4.53331715984
Rred_3090 v_b.$2541.Metal2 v_b.P13.nSD 4.05583782899
Rred_3091 v_b.$2541.Metal2 v_b.P13.pSD 2.23187016546
Rred_3092 v_b.$2541.Metal2 v_b.P15.nSD 8.23811327033
Rred_3093 v_b.$2541.Metal2 v_b.P15.pSD 4.53331715984
Rred_3094 v_b.$2601.Metal2 v_b.$2631.Metal2 0.04488
Rred_3095 v_b.$2601.Metal2 v_b.P15.nSD 8.23811327033
Rred_3096 v_b.$2601.Metal2 v_b.P15.pSD 4.53331715984
Rred_3097 v_b.$2601.Metal2 v_b.P17.nSD 4.05583782899
Rred_3098 v_b.$2601.Metal2 v_b.P17.pSD 2.23187016546
Rred_3099 v_b.$2631.Metal2 v_b.$2691.Metal2 0.0911590993431
Rred_3100 v_b.$2631.Metal2 v_b.P19.nSD 4.05583782899
Rred_3101 v_b.$2631.Metal2 v_b.P19.pSD 2.23187016546
Rred_3102 v_b.$2631.Metal2 v_b.P21.nSD 8.23811327033
Rred_3103 v_b.$2631.Metal2 v_b.P21.pSD 4.53331715984
Rred_3104 v_b.$2691.Metal2 v_b.$2751.Metal2 0.0911590993431
Rred_3105 v_b.$2691.Metal2 v_b.P21.nSD 8.23811327033
Rred_3106 v_b.$2691.Metal2 v_b.P21.pSD 4.53331715984
Rred_3107 v_b.$2691.Metal2 v_b.P23.nSD 4.05583782899
Rred_3108 v_b.$2691.Metal2 v_b.P23.pSD 2.23187016546
Rred_3109 v_b.$2691.Metal2 v_b.P25.nSD 8.23811327033
Rred_3110 v_b.$2691.Metal2 v_b.P25.pSD 4.53331715984
Rred_3111 v_b.$2751.Metal2 v_b.$2811.Metal2 0.0911590993431
Rred_3112 v_b.$2751.Metal2 v_b.P25.nSD 8.23811327033
Rred_3113 v_b.$2751.Metal2 v_b.P25.pSD 4.53331715984
Rred_3114 v_b.$2751.Metal2 v_b.P27.nSD 4.05583782899
Rred_3115 v_b.$2751.Metal2 v_b.P27.pSD 2.23187016546
Rred_3116 v_b.$2751.Metal2 v_b.P29.nSD 8.23811327033
Rred_3117 v_b.$2751.Metal2 v_b.P29.pSD 4.53331715984
Rred_3118 v_b.$2811.Metal2 v_b.$2871.Metal2 0.0911590993431
Rred_3119 v_b.$2811.Metal2 v_b.P29.nSD 8.23811327033
Rred_3120 v_b.$2811.Metal2 v_b.P29.pSD 4.53331715984
Rred_3121 v_b.$2811.Metal2 v_b.P31.nSD 4.05583782899
Rred_3122 v_b.$2811.Metal2 v_b.P31.pSD 2.23187016546
Rred_3123 v_b.$2811.Metal2 v_b.P33.nSD 8.23811327033
Rred_3124 v_b.$2811.Metal2 v_b.P33.pSD 4.53331715984
Rred_3125 v_b.$2871.Metal2 v_b.$2962.Metal2 0.044949696
Rred_3126 v_b.$2871.Metal2 v_b.$3779.Metal3 25.5396
Rred_3127 v_b.$2871.Metal2 v_b.P33.nSD 8.23811327033
Rred_3128 v_b.$2871.Metal2 v_b.P33.pSD 4.53331715984
Rred_3129 v_b.$2871.Metal2 v_b.P35.nSD 4.05583782899
Rred_3130 v_b.$2871.Metal2 v_b.P35.pSD 2.23187016546
Rred_3131 v_b.$2962.Metal2 v_b.$3053.Metal2 0.0308765693458
Rred_3132 v_b.$2962.Metal2 v_b.$3779.Metal3 2.76603438764
Rred_3133 v_b.$2962.Metal2 v_b.$3785.Metal3 7.90644894706
Rred_3134 v_b.$2962.Metal2 v_b.P39.nSD 4.05583782899
Rred_3135 v_b.$2962.Metal2 v_b.P39.pSD 2.23187016546
Rred_3136 v_b.$3053.Metal2 v_b.$3056.Metal2 0.0140799382542
Rred_3137 v_b.$3053.Metal2 v_b.$3089.Metal2 12916.2953092
Rred_3138 v_b.$3053.Metal2 v_b.$3779.Metal3 20.8318819436
Rred_3139 v_b.$3053.Metal2 v_b.$3785.Metal3 2.77829638555
Rred_3140 v_b.$3053.Metal2 v_b.$3821.Metal3 16.2025415619
Rred_3141 v_b.$3056.Metal2 v_b.$3089.Metal2 0.0220237154776
Rred_3142 v_b.$3056.Metal2 v_b.$3785.Metal3 8.94707860677
Rred_3143 v_b.$3056.Metal2 v_b.$3821.Metal3 6.25194662514
Rred_3144 v_b.$3056.Metal2 v_b.P43.nSD 4.05583782899
Rred_3145 v_b.$3056.Metal2 v_b.P43.pSD 2.23187016546
Rred_3146 v_b.$3089.Metal2 v_b.$3153.Metal2 0.0229090183619
Rred_3147 v_b.$3089.Metal2 v_b.$3785.Metal3 35.9934095949
Rred_3148 v_b.$3089.Metal2 v_b.$3821.Metal3 2.49593873983
Rred_3149 v_b.$3089.Metal2 v_b.$3857.Metal3 28.8399928182
Rred_3150 v_b.$3153.Metal2 v_b.$3247.Metal2 0.0451617907629
Rred_3151 v_b.$3153.Metal2 v_b.$3821.Metal3 7.54883809637
Rred_3152 v_b.$3153.Metal2 v_b.$3857.Metal3 2.74973734892
Rred_3153 v_b.$3153.Metal2 v_b.$3890.Metal3 9.93294518245
Rred_3154 v_b.$3153.Metal2 v_b.P47.nSD 4.05583782899
Rred_3155 v_b.$3153.Metal2 v_b.P47.pSD 2.23187016546
Rred_3156 v_b.$3247.Metal2 v_b.$3294.Metal2 0.0224663793527
Rred_3157 v_b.$3247.Metal2 v_b.$3857.Metal3 10.2640433552
Rred_3158 v_b.$3247.Metal2 v_b.$3890.Metal3 2.74278674354
Rred_3159 v_b.$3247.Metal2 v_b.$3903.Metal3 7.49465463415
Rred_3160 v_b.$3247.Metal2 v_b.P51.nSD 4.05583782899
Rred_3161 v_b.$3247.Metal2 v_b.P51.pSD 2.23187016546
Rred_3162 v_b.$3294.Metal2 v_b.$3344.Metal2 0.022466341957
Rred_3163 v_b.$3294.Metal2 v_b.$3435.Metal2 30431.8773193
Rred_3164 v_b.$3294.Metal2 v_b.$3890.Metal3 30.728084
Rred_3165 v_b.$3294.Metal2 v_b.$3903.Metal3 2.47057724942
Rred_3166 v_b.$3294.Metal2 v_b.$3934.Metal3 38.3350815818
Rred_3167 v_b.$3344.Metal2 v_b.$3435.Metal2 0.0317616930991
Rred_3168 v_b.$3344.Metal2 v_b.$3903.Metal3 5.09323270967
Rred_3169 v_b.$3344.Metal2 v_b.$3934.Metal3 3.86536517614
Rred_3170 v_b.$3344.Metal2 v_b.P55.nSD 4.05583782899
Rred_3171 v_b.$3344.Metal2 v_b.P55.pSD 2.23187016546
Rred_3172 v_b.$3435.Metal2 v_b.$3438.Metal2 0.013199945089
Rred_3173 v_b.$3435.Metal2 v_b.$3529.Metal2 11827.0862148
Rred_3174 v_b.$3435.Metal2 v_b.$3903.Metal3 35.8395112455
Rred_3175 v_b.$3435.Metal2 v_b.$3934.Metal3 2.64098853846
Rred_3176 v_b.$3435.Metal2 v_b.$3970.Metal3 14.6590701622
Rred_3177 v_b.$3438.Metal2 v_b.$3529.Metal2 0.022909001157
Rred_3178 v_b.$3438.Metal2 v_b.$3934.Metal3 9.77321173065
Rred_3179 v_b.$3438.Metal2 v_b.$3970.Metal3 6.29248152676
Rred_3180 v_b.$3438.Metal2 v_b.P59.nSD 4.05583782899
Rred_3181 v_b.$3438.Metal2 v_b.P59.pSD 2.23187016546
Rred_3182 v_b.$3487.Metal2 v_b.$3491.Metal2 0.350162338467
Rred_3183 v_b.$3487.Metal2 v_b.$3970.Metal3 11.7819257254
Rred_3184 v_b.$3487.Metal2 v_b.$3980.Metal3 5.38720394696
Rred_3185 v_b.$3487.Metal2 v_b.P61.pSD 216.80947751
Rred_3186 v_b.$3491.Metal2 v_b.$3495.Metal2 0.350169891761
Rred_3187 v_b.$3491.Metal2 v_b.$3980.Metal3 9.10322755705
Rred_3188 v_b.$3491.Metal2 v_b.$3982.Metal3 9.1033250085
Rred_3189 v_b.$3495.Metal2 v_b.$3499.Metal2 0.350168100435
Rred_3190 v_b.$3495.Metal2 v_b.$3982.Metal3 9.1033250085
Rred_3191 v_b.$3495.Metal2 v_b.$3984.Metal3 9.10330189728
Rred_3192 v_b.$3495.Metal2 v_b.P61.pSD 1757.39510867
Rred_3193 v_b.$3499.Metal2 v_b.$3503.Metal2 0.350162314795
Rred_3194 v_b.$3499.Metal2 v_b.$3984.Metal3 9.10330189728
Rred_3195 v_b.$3499.Metal2 v_b.$3986.Metal3 9.10322725163
Rred_3196 v_b.$3503.Metal2 v_b.$3505.Metal2 0.171779692648
Rred_3197 v_b.$3503.Metal2 v_b.$3507.Metal2 4580.45571151
Rred_3198 v_b.$3503.Metal2 v_b.$3986.Metal3 7.29498342661
Rred_3199 v_b.$3503.Metal2 v_b.$3990.Metal3 36.7250760159
Rred_3200 v_b.$3503.Metal2 v_b.P61.pSD 1178.7998989
Rred_3201 v_b.$3505.Metal2 v_b.$3507.Metal2 0.171796584217
Rred_3202 v_b.$3505.Metal2 v_b.$3986.Metal3 18.2892185628
Rred_3203 v_b.$3505.Metal2 v_b.$3990.Metal3 18.2892185628
Rred_3204 v_b.$3505.Metal2 v_b.P61.pSD 870.821827437
Rred_3205 v_b.$3507.Metal2 v_b.$3986.Metal3 36.7250760159
Rred_3206 v_b.$3507.Metal2 v_b.$3990.Metal3 1.73848719522
Rred_3207 v_b.$3507.Metal2 v_b.P61.pSD 8.80417177783
Rred_3208 v_b.$3529.Metal2 v_b.$3535.Metal2 0.0220237154776
Rred_3209 v_b.$3529.Metal2 v_b.$3565.Metal2 12916.2953092
Rred_3210 v_b.$3529.Metal2 v_b.$3934.Metal3 36.4274255415
Rred_3211 v_b.$3529.Metal2 v_b.$3970.Metal3 2.45250143453
Rred_3212 v_b.$3529.Metal2 v_b.$4009.Metal3 35.9934095949
Rred_3213 v_b.$3535.Metal2 v_b.$3565.Metal2 0.0140799382542
Rred_3214 v_b.$3535.Metal2 v_b.$3970.Metal3 6.25194662514
Rred_3215 v_b.$3535.Metal2 v_b.$4009.Metal3 8.94707860677
Rred_3216 v_b.$3535.Metal2 v_b.P63.nSD 4.05583782899
Rred_3217 v_b.$3535.Metal2 v_b.P63.pSD 2.23187016546
Rred_3218 v_b.$3565.Metal2 v_b.$3629.Metal2 0.0308765693458
Rred_3219 v_b.$3565.Metal2 v_b.$3970.Metal3 16.2025415619
Rred_3220 v_b.$3565.Metal2 v_b.$4009.Metal3 2.77829638555
Rred_3221 v_b.$3565.Metal2 v_b.$4042.Metal3 20.8318819436
Rred_3222 v_b.$3629.Metal2 v_b.$4009.Metal3 7.90644894706
Rred_3223 v_b.$3629.Metal2 v_b.$4042.Metal3 2.80079029852
Rred_3224 v_b.$3629.Metal2 v_b.P67.nSD 4.05583782899
Rred_3225 v_b.$3629.Metal2 v_b.P67.pSD 2.23187016546
Rred_3226 v_b.$3678.Metal2 v_b.$3680.Metal2 0.171796584217
Rred_3227 v_b.$3678.Metal2 v_b.$3682.Metal2 4580.45571151
Rred_3228 v_b.$3678.Metal2 v_b.$4053.Metal3 5.27192426225
Rred_3229 v_b.$3678.Metal2 v_b.$4057.Metal3 36.7250760159
Rred_3230 v_b.$3678.Metal2 v_b.P69.pSD 216.839777795
Rred_3231 v_b.$3680.Metal2 v_b.$3682.Metal2 0.171791313087
Rred_3232 v_b.$3680.Metal2 v_b.$4053.Metal3 18.2892185628
Rred_3233 v_b.$3680.Metal2 v_b.$4057.Metal3 18.2892185628
Rred_3234 v_b.$3680.Metal2 v_b.P69.pSD 3459.40109225
Rred_3235 v_b.$3682.Metal2 v_b.$3686.Metal2 0.350169891761
Rred_3236 v_b.$3682.Metal2 v_b.$4053.Metal3 36.7250760159
Rred_3237 v_b.$3682.Metal2 v_b.$4057.Metal3 7.29504620414
Rred_3238 v_b.$3682.Metal2 v_b.P69.pSD 5185.30247334
Rred_3239 v_b.$3686.Metal2 v_b.$3688.Metal2 0.171796584217
Rred_3240 v_b.$3686.Metal2 v_b.$3690.Metal2 4580.45571151
Rred_3241 v_b.$3686.Metal2 v_b.$4057.Metal3 7.29504620414
Rred_3242 v_b.$3686.Metal2 v_b.$4061.Metal3 36.7250760159
Rred_3243 v_b.$3686.Metal2 v_b.P69.pSD 1757.39510867
Rred_3244 v_b.$3688.Metal2 v_b.$3690.Metal2 0.17179252329
Rred_3245 v_b.$3688.Metal2 v_b.$4057.Metal3 18.2892185628
Rred_3246 v_b.$3688.Metal2 v_b.$4061.Metal3 18.2892185628
Rred_3247 v_b.$3688.Metal2 v_b.P69.pSD 8392.26908714
Rred_3248 v_b.$3690.Metal2 v_b.$3694.Metal2 0.350162314795
Rred_3249 v_b.$3690.Metal2 v_b.$4057.Metal3 36.7250760159
Rred_3250 v_b.$3690.Metal2 v_b.$4061.Metal3 7.29498342661
Rred_3251 v_b.$3690.Metal2 v_b.P69.pSD 2776.32918515
Rred_3252 v_b.$3694.Metal2 v_b.$3696.Metal2 0.171779692648
Rred_3253 v_b.$3694.Metal2 v_b.$3698.Metal2 4580.45571151
Rred_3254 v_b.$3694.Metal2 v_b.$4061.Metal3 7.29498342661
Rred_3255 v_b.$3694.Metal2 v_b.$4065.Metal3 36.7250760159
Rred_3256 v_b.$3694.Metal2 v_b.P69.pSD 1178.7998989
Rred_3257 v_b.$3696.Metal2 v_b.$3698.Metal2 0.171796584217
Rred_3258 v_b.$3696.Metal2 v_b.$4061.Metal3 18.2892185628
Rred_3259 v_b.$3696.Metal2 v_b.$4065.Metal3 18.2892185628
Rred_3260 v_b.$3696.Metal2 v_b.P69.pSD 870.821827437
Rred_3261 v_b.$3698.Metal2 v_b.$4061.Metal3 36.7250760159
Rred_3262 v_b.$3698.Metal2 v_b.$4065.Metal3 1.73848719522
Rred_3263 v_b.$3698.Metal2 v_b.P69.pSD 8.80417177783
Rred_3264 v_b.$3779.Metal3 v_b.$3785.Metal3 0.0277780644144
Rred_3265 v_b.$3779.Metal3 v_b.P37.nSD 5.17290520207
Rred_3266 v_b.$3779.Metal3 v_b.P37.pSD 2.20967912964
Rred_3267 v_b.$3785.Metal3 v_b.$3821.Metal3 0.0451510824859
Rred_3268 v_b.$3785.Metal3 v_b.P41.nSD 4.97632451283
Rred_3269 v_b.$3785.Metal3 v_b.P41.pSD 2.0248877991
Rred_3270 v_b.$3821.Metal3 v_b.$3857.Metal3 0.0357457002106
Rred_3271 v_b.$3821.Metal3 v_b.P45.nSD 4.97632451283
Rred_3272 v_b.$3821.Metal3 v_b.P45.pSD 2.0248877991
Rred_3273 v_b.$3857.Metal3 v_b.$3890.Metal3 0.0180963510053
Rred_3274 v_b.$3857.Metal3 v_b.P49.nSD 10.2334132939
Rred_3275 v_b.$3857.Metal3 v_b.P49.pSD 4.16401978381
Rred_3276 v_b.$3890.Metal3 v_b.$3903.Metal3 0.0361883527762
Rred_3277 v_b.$3890.Metal3 v_b.P49.nSD 9.746107899
Rred_3278 v_b.$3890.Metal3 v_b.P49.pSD 3.96573312744
Rred_3279 v_b.$3903.Metal3 v_b.$3934.Metal3 0.0451470861635
Rred_3280 v_b.$3903.Metal3 v_b.P53.nSD 4.97632451283
Rred_3281 v_b.$3903.Metal3 v_b.P53.pSD 2.0248877991
Rred_3282 v_b.$3934.Metal3 v_b.$3970.Metal3 0.0451499360995
Rred_3283 v_b.$3934.Metal3 v_b.P57.nSD 4.97632451283
Rred_3284 v_b.$3934.Metal3 v_b.P57.pSD 2.0248877991
Rred_3285 v_b.$3970.Metal3 v_b.$3980.Metal3 0.277340096953
Rred_3286 v_b.$3970.Metal3 v_b.$4009.Metal3 0.0451510824859
Rred_3287 v_b.$3970.Metal3 v_b.P61.nSD 4.97632451283
Rred_3288 v_b.$3970.Metal3 v_b.P61.pSD 32606.3973606
Rred_3289 v_b.$3980.Metal3 v_b.$3982.Metal3 0.144898562844
Rred_3290 v_b.$3980.Metal3 v_b.P61.pSD 36523.0373925
Rred_3291 v_b.$3982.Metal3 v_b.$3984.Metal3 0.144898562844
Rred_3292 v_b.$3984.Metal3 v_b.$3986.Metal3 0.144898562844
Rred_3293 v_b.$3986.Metal3 v_b.$3990.Metal3 0.294453498367
Rred_3294 v_b.$3990.Metal3 v_b.P61.pSD 13.9199746813
Rred_3295 v_b.$4009.Metal3 v_b.$4042.Metal3 0.0277780644144
Rred_3296 v_b.$4009.Metal3 v_b.P65.nSD 4.97632451283
Rred_3297 v_b.$4009.Metal3 v_b.P65.pSD 2.0248877991
Rred_3298 v_b.$4042.Metal3 v_b.$4053.Metal3 0.311885081352
Rred_3299 v_b.$4042.Metal3 v_b.P69.nSD 5.26242189493
Rred_3300 v_b.$4053.Metal3 v_b.$4057.Metal3 0.294453498367
Rred_3301 v_b.$4053.Metal3 v_b.P69.nSD 260.865771077
Rred_3302 v_b.$4053.Metal3 v_b.P69.pSD 17035.4743833
Rred_3303 v_b.$4057.Metal3 v_b.$4061.Metal3 0.294453498367
Rred_3304 v_b.$4061.Metal3 v_b.$4065.Metal3 0.294453498367
Rred_3305 v_b.$4065.Metal3 v_b.P69.pSD 13.9199746813
Rred_3306 v_b.P0.nSD v_b.P0.pSD 301.774422652
Rred_3307 v_b.P11.nSD v_b.P11.pSD 409.679127177
Rred_3308 v_b.P15.nSD v_b.P15.pSD 409.679127177
Rred_3309 v_b.P21.nSD v_b.P21.pSD 409.679127177
Rred_3310 v_b.P25.nSD v_b.P25.pSD 409.679127177
Rred_3311 v_b.P29.nSD v_b.P29.pSD 409.679127177
Rred_3312 v_b.P3.nSD v_b.P3.pSD 409.679127177
Rred_3313 v_b.P33.nSD v_b.P33.pSD 409.679127177
Rred_3314 v_b.P37.nSD v_b.P37.pSD 1848.21167941
Rred_3315 v_b.P49.nSD v_b.P49.pSD 2242.58806516
Rred_3316 v_b.P7.nSD v_b.P7.pSD 409.679127177
Rred_3317 VDD VDD.$183.Metal1 0.027957443787
Rred_3318 VDD VDD.$189.Metal1 0.0279661816028
Rred_3319 VDD VDD.$512.Metal2 8.78019073461
Rred_3320 VDD VDD.$520.Metal2 18.7402145634
Rred_3321 VDD VDD.$730.Metal3 2337.33274765
Rred_3322 VDD.$107.Metal1 VDD.$111.Metal1 0.0288021931713
Rred_3323 VDD.$107.Metal1 VDD.$436.Metal2 25.6251826424
Rred_3324 VDD.$107.Metal1 VDD.$440.Metal2 5.03351754079
Rred_3325 VDD.$107.Metal1 VDD.$448.Metal2 38.6008563911
Rred_3326 VDD.$107.Metal1 VDD.$694.Metal3 4814.40836364
Rred_3327 VDD.$107.Metal1 VDD.$99.Metal1 0.0578209249365
Rred_3328 VDD.$107.Metal1 VDD.P0.nSD 11.346314439
Rred_3329 VDD.$111.Metal1 VDD.$121.Metal1 0.0871963262325
Rred_3330 VDD.$111.Metal1 VDD.$440.Metal2 11.8771865819
Rred_3331 VDD.$111.Metal1 VDD.$448.Metal2 4.28099630984
Rred_3332 VDD.$111.Metal1 VDD.$452.Metal2 16.5616398851
Rred_3333 VDD.$111.Metal1 VDD.$694.Metal3 1481.35641958
Rred_3334 VDD.$111.Metal1 VDD.P0.nSD 8.53106210171
Rred_3335 VDD.$121.Metal1 VDD.$129.Metal1 0.0578215648921
Rred_3336 VDD.$121.Metal1 VDD.$448.Metal2 14.0523005085
Rred_3337 VDD.$121.Metal1 VDD.$452.Metal2 6.23769563491
Rred_3338 VDD.$121.Metal1 VDD.$456.Metal2 5.57645878556
Rred_3339 VDD.$121.Metal1 VDD.$460.Metal2 21.9646853648
Rred_3340 VDD.$121.Metal1 VDD.P0.nSD 6.82495918626
Rred_3341 VDD.$129.Metal1 VDD.$134.Metal1 0.0577633289959
Rred_3342 VDD.$129.Metal1 VDD.$456.Metal2 23.6542765468
Rred_3343 VDD.$129.Metal1 VDD.$460.Metal2 5.68043958372
Rred_3344 VDD.$129.Metal1 VDD.$464.Metal2 7.49041837501
Rred_3345 VDD.$129.Metal1 VDD.P0.nSD 8.51551239762
Rred_3346 VDD.$134.Metal1 VDD.$143.Metal1 0.0577633289959
Rred_3347 VDD.$134.Metal1 VDD.$464.Metal2 5.04742343815
Rred_3348 VDD.$134.Metal1 VDD.$472.Metal2 5.04742343815
Rred_3349 VDD.$134.Metal1 VDD.$704.Metal3 2272.04716647
Rred_3350 VDD.$134.Metal1 VDD.$708.Metal3 2272.04716647
Rred_3351 VDD.$134.Metal1 VDD.P0.nSD 8.51213716047
Rred_3352 VDD.$143.Metal1 VDD.$151.Metal1 0.0578215648921
Rred_3353 VDD.$143.Metal1 VDD.$472.Metal2 7.49041837501
Rred_3354 VDD.$143.Metal1 VDD.$476.Metal2 5.68043958372
Rred_3355 VDD.$143.Metal1 VDD.$480.Metal2 23.6542765468
Rred_3356 VDD.$143.Metal1 VDD.P0.nSD 8.51551239762
Rred_3357 VDD.$151.Metal1 VDD.$161.Metal1 0.0871963262325
Rred_3358 VDD.$151.Metal1 VDD.$476.Metal2 21.9646853648
Rred_3359 VDD.$151.Metal1 VDD.$480.Metal2 5.57645878556
Rred_3360 VDD.$151.Metal1 VDD.$484.Metal2 6.23769563491
Rred_3361 VDD.$151.Metal1 VDD.$488.Metal2 14.0523005085
Rred_3362 VDD.$151.Metal1 VDD.P0.nSD 6.82495918626
Rred_3363 VDD.$161.Metal1 VDD.$165.Metal1 0.0288021931713
Rred_3364 VDD.$161.Metal1 VDD.$484.Metal2 16.5616398851
Rred_3365 VDD.$161.Metal1 VDD.$488.Metal2 4.28099630984
Rred_3366 VDD.$161.Metal1 VDD.$496.Metal2 11.8771865819
Rred_3367 VDD.$161.Metal1 VDD.$718.Metal3 1481.35641958
Rred_3368 VDD.$161.Metal1 VDD.P0.nSD 8.53106210171
Rred_3369 VDD.$165.Metal1 VDD.$169.Metal1 0.0288145759369
Rred_3370 VDD.$165.Metal1 VDD.$488.Metal2 38.6008563911
Rred_3371 VDD.$165.Metal1 VDD.$496.Metal2 6.67139258545
Rred_3372 VDD.$165.Metal1 VDD.$718.Metal3 4814.40836364
Rred_3373 VDD.$165.Metal1 VDD.P0.nSD 17
Rred_3374 VDD.$169.Metal1 VDD.$173.Metal1 0.0288110676642
Rred_3375 VDD.$169.Metal1 VDD.$496.Metal2 7.31356599054
Rred_3376 VDD.$169.Metal1 VDD.$504.Metal2 25.7418333567
Rred_3377 VDD.$169.Metal1 VDD.$722.Metal3 3210.59451511
Rred_3378 VDD.$169.Metal1 VDD.P0.nSD 17
Rred_3379 VDD.$173.Metal1 VDD.$179.Metal1 0.0577671356891
Rred_3380 VDD.$173.Metal1 VDD.$496.Metal2 14.0410000127
Rred_3381 VDD.$173.Metal1 VDD.$504.Metal2 5.04556141131
Rred_3382 VDD.$173.Metal1 VDD.$722.Metal3 1751.23337187
Rred_3383 VDD.$173.Metal1 VDD.P0.nSD 11.348307618
Rred_3384 VDD.$179.Metal1 VDD.$183.Metal1 0.0287793730468
Rred_3385 VDD.$179.Metal1 VDD.$504.Metal2 5.04788177258
Rred_3386 VDD.$179.Metal1 VDD.$512.Metal2 9.64256818393
Rred_3387 VDD.$179.Metal1 VDD.$726.Metal3 1202.64847083
Rred_3388 VDD.$179.Metal1 VDD.P0.nSD 11.3452829979
Rred_3389 VDD.$183.Metal1 VDD.$504.Metal2 154.281090943
Rred_3390 VDD.$183.Metal1 VDD.$512.Metal2 5.95595560195
Rred_3391 VDD.$183.Metal1 VDD.$726.Metal3 19242.3755333
Rred_3392 VDD.$183.Metal1 VDD.P0.nSD 17
Rred_3393 VDD.$189.Metal1 VDD.$193.Metal1 0.0288050295857
Rred_3394 VDD.$189.Metal1 VDD.$512.Metal2 17.6378490009
Rred_3395 VDD.$189.Metal1 VDD.$520.Metal2 8.6620074641
Rred_3396 VDD.$189.Metal1 VDD.$730.Metal3 2199.84258603
Rred_3397 VDD.$189.Metal1 VDD.P0.nSD 17
Rred_3398 VDD.$193.Metal1 VDD.$197.Metal1 0.0287793730468
Rred_3399 VDD.$193.Metal1 VDD.$520.Metal2 5.89354036985
Rred_3400 VDD.$193.Metal1 VDD.$528.Metal2 154.281090943
Rred_3401 VDD.$193.Metal1 VDD.$734.Metal3 19242.3755333
Rred_3402 VDD.$193.Metal1 VDD.P0.nSD 17
Rred_3403 VDD.$197.Metal1 VDD.$203.Metal1 0.0577671356891
Rred_3404 VDD.$197.Metal1 VDD.$520.Metal2 9.64256818393
Rred_3405 VDD.$197.Metal1 VDD.$528.Metal2 5.04788177258
Rred_3406 VDD.$197.Metal1 VDD.$734.Metal3 1202.64847083
Rred_3407 VDD.$197.Metal1 VDD.P0.nSD 11.3452829979
Rred_3408 VDD.$203.Metal1 VDD.$207.Metal1 0.0288110676642
Rred_3409 VDD.$203.Metal1 VDD.$528.Metal2 5.04556141131
Rred_3410 VDD.$203.Metal1 VDD.$536.Metal2 14.0410000127
Rred_3411 VDD.$203.Metal1 VDD.$738.Metal3 1751.23337187
Rred_3412 VDD.$203.Metal1 VDD.P0.nSD 11.348307618
Rred_3413 VDD.$207.Metal1 VDD.$211.Metal1 0.0288145759369
Rred_3414 VDD.$207.Metal1 VDD.$528.Metal2 25.7418333567
Rred_3415 VDD.$207.Metal1 VDD.$536.Metal2 7.31356599054
Rred_3416 VDD.$207.Metal1 VDD.$738.Metal3 3210.59451511
Rred_3417 VDD.$207.Metal1 VDD.P0.nSD 17
Rred_3418 VDD.$211.Metal1 VDD.$215.Metal1 0.0288021931713
Rred_3419 VDD.$211.Metal1 VDD.$536.Metal2 6.67139258545
Rred_3420 VDD.$211.Metal1 VDD.$544.Metal2 38.6008563911
Rred_3421 VDD.$211.Metal1 VDD.$742.Metal3 4814.40836364
Rred_3422 VDD.$211.Metal1 VDD.P0.nSD 17
Rred_3423 VDD.$215.Metal1 VDD.$225.Metal1 0.0871963262325
Rred_3424 VDD.$215.Metal1 VDD.$536.Metal2 11.8771865819
Rred_3425 VDD.$215.Metal1 VDD.$544.Metal2 4.28099630984
Rred_3426 VDD.$215.Metal1 VDD.$548.Metal2 16.5616398851
Rred_3427 VDD.$215.Metal1 VDD.$742.Metal3 1481.35641958
Rred_3428 VDD.$215.Metal1 VDD.P0.nSD 8.53106210171
Rred_3429 VDD.$225.Metal1 VDD.$230.Metal1 0.0458057934037
Rred_3430 VDD.$225.Metal1 VDD.$544.Metal2 14.0523005085
Rred_3431 VDD.$225.Metal1 VDD.$548.Metal2 6.23769563491
Rred_3432 VDD.$225.Metal1 VDD.$552.Metal2 5.93852178009
Rred_3433 VDD.$225.Metal1 VDD.P0.nSD 7.19732773161
Rred_3434 VDD.$230.Metal1 VDD.$238.Metal1 0.0697611346947
Rred_3435 VDD.$230.Metal1 VDD.$552.Metal2 6.11274100194
Rred_3436 VDD.$230.Metal1 VDD.$560.Metal2 4.52958703125
Rred_3437 VDD.$230.Metal1 VDD.$750.Metal3 1131.50554324
Rred_3438 VDD.$230.Metal1 VDD.P0.nSD 9.09368038422
Rred_3439 VDD.$238.Metal1 VDD.$247.Metal1 0.0577633289959
Rred_3440 VDD.$238.Metal1 VDD.$560.Metal2 4.52905892652
Rred_3441 VDD.$238.Metal1 VDD.$568.Metal2 5.04729071348
Rred_3442 VDD.$238.Metal1 VDD.$750.Metal3 2299.30001576
Rred_3443 VDD.$238.Metal1 VDD.$758.Metal3 2299.30001576
Rred_3444 VDD.$238.Metal1 VDD.P0.nSD 7.5504109532
Rred_3445 VDD.$247.Metal1 VDD.$251.Metal1 0.0288136032337
Rred_3446 VDD.$247.Metal1 VDD.$568.Metal2 5.04429784117
Rred_3447 VDD.$247.Metal1 VDD.$576.Metal2 15.4464592875
Rred_3448 VDD.$247.Metal1 VDD.$758.Metal3 1926.52624152
Rred_3449 VDD.$247.Metal1 VDD.P0.nSD 11.3480589919
Rred_3450 VDD.$251.Metal1 VDD.$263.Metal1 0.0871695875975
Rred_3451 VDD.$251.Metal1 VDD.$568.Metal2 22.0663704107
Rred_3452 VDD.$251.Metal1 VDD.$576.Metal2 4.52538279696
Rred_3453 VDD.$251.Metal1 VDD.$580.Metal2 11.5866516695
Rred_3454 VDD.$251.Metal1 VDD.$758.Metal3 2752.18034502
Rred_3455 VDD.$251.Metal1 VDD.P0.nSD 8.53107122987
Rred_3456 VDD.$263.Metal1 VDD.$269.Metal1 0.0577716484036
Rred_3457 VDD.$263.Metal1 VDD.$576.Metal2 22.075415041
Rred_3458 VDD.$263.Metal1 VDD.$580.Metal2 7.45199377725
Rred_3459 VDD.$263.Metal1 VDD.$584.Metal2 4.56819479556
Rred_3460 VDD.$263.Metal1 VDD.$588.Metal2 11.8169280826
Rred_3461 VDD.$263.Metal1 VDD.P0.nSD 6.82126171867
Rred_3462 VDD.$269.Metal1 VDD.$273.Metal1 0.028814395599
Rred_3463 VDD.$269.Metal1 VDD.$584.Metal2 307.240130146
Rred_3464 VDD.$269.Metal1 VDD.$588.Metal2 5.04359852167
Rred_3465 VDD.$269.Metal1 VDD.$596.Metal2 16.2598779584
Rred_3466 VDD.$269.Metal1 VDD.$768.Metal3 2027.97812675
Rred_3467 VDD.$269.Metal1 VDD.P0.nSD 11.3479138426
Rred_3468 VDD.$273.Metal1 VDD.$283.Metal1 0.0871753269277
Rred_3469 VDD.$273.Metal1 VDD.$588.Metal2 20.595845414
Rred_3470 VDD.$273.Metal1 VDD.$596.Metal2 4.5041946951
Rred_3471 VDD.$273.Metal1 VDD.$600.Metal2 11.8849659888
Rred_3472 VDD.$273.Metal1 VDD.$768.Metal3 2568.77229388
Rred_3473 VDD.$273.Metal1 VDD.P0.nSD 8.53126539086
Rred_3474 VDD.$283.Metal1 VDD.$287.Metal1 0.0287794135437
Rred_3475 VDD.$283.Metal1 VDD.$596.Metal2 21.0733744846
Rred_3476 VDD.$283.Metal1 VDD.$600.Metal2 7.33349202498
Rred_3477 VDD.$283.Metal1 VDD.$604.Metal2 4.78294230769
Rred_3478 VDD.$283.Metal1 VDD.P0.nSD 8.52766237648
Rred_3479 VDD.$287.Metal1 VDD.$291.Metal1 0.0288048872138
Rred_3480 VDD.$287.Metal1 VDD.$604.Metal2 10.6364362996
Rred_3481 VDD.$287.Metal1 VDD.$612.Metal2 12.3534294277
Rred_3482 VDD.$287.Metal1 VDD.$776.Metal3 1540.75477895
Rred_3483 VDD.$287.Metal1 VDD.P0.nSD 17
Rred_3484 VDD.$291.Metal1 VDD.$295.Metal1 0.0288150532545
Rred_3485 VDD.$291.Metal1 VDD.$604.Metal2 34.3150817435
Rred_3486 VDD.$291.Metal1 VDD.$612.Metal2 6.82120429833
Rred_3487 VDD.$291.Metal1 VDD.$776.Metal3 4279.87438597
Rred_3488 VDD.$291.Metal1 VDD.P0.nSD 17
Rred_3489 VDD.$295.Metal1 VDD.$299.Metal1 0.0288093244602
Rred_3490 VDD.$295.Metal1 VDD.$612.Metal2 7.14178490216
Rred_3491 VDD.$295.Metal1 VDD.$620.Metal2 28.0803009334
Rred_3492 VDD.$295.Metal1 VDD.$780.Metal3 3502.25482816
Rred_3493 VDD.$295.Metal1 VDD.P0.nSD 17
Rred_3494 VDD.$299.Metal1 VDD.$309.Metal1 0.0871982525799
Rred_3495 VDD.$299.Metal1 VDD.$612.Metal2 13.4297091421
Rred_3496 VDD.$299.Metal1 VDD.$620.Metal2 4.34016680572
Rred_3497 VDD.$299.Metal1 VDD.$624.Metal2 14.9592310144
Rred_3498 VDD.$299.Metal1 VDD.$780.Metal3 1674.99143956
Rred_3499 VDD.$299.Metal1 VDD.P0.nSD 8.53153196007
Rred_3500 VDD.$309.Metal1 VDD.$313.Metal1 0.0288072643101
Rred_3501 VDD.$309.Metal1 VDD.$620.Metal2 15.4578720483
Rred_3502 VDD.$309.Metal1 VDD.$624.Metal2 4.32030884242
Rred_3503 VDD.$309.Metal1 VDD.$632.Metal2 12.8692175863
Rred_3504 VDD.$309.Metal1 VDD.$786.Metal3 1605.08534198
Rred_3505 VDD.$309.Metal1 VDD.P0.nSD 8.53137535834
Rred_3506 VDD.$313.Metal1 VDD.$317.Metal1 0.0288152123603
Rred_3507 VDD.$313.Metal1 VDD.$624.Metal2 30.8861222072
Rred_3508 VDD.$313.Metal1 VDD.$632.Metal2 6.97784081018
Rred_3509 VDD.$313.Metal1 VDD.$786.Metal3 3852.20482074
Rred_3510 VDD.$313.Metal1 VDD.P0.nSD 17
Rred_3511 VDD.$317.Metal1 VDD.$321.Metal1 0.0288072643101
Rred_3512 VDD.$317.Metal1 VDD.$632.Metal2 6.97784081018
Rred_3513 VDD.$317.Metal1 VDD.$640.Metal2 30.8861222072
Rred_3514 VDD.$317.Metal1 VDD.$790.Metal3 3852.20482074
Rred_3515 VDD.$317.Metal1 VDD.P0.nSD 17
Rred_3516 VDD.$321.Metal1 VDD.$332.Metal1 0.0967818976451
Rred_3517 VDD.$321.Metal1 VDD.$632.Metal2 12.8692175863
Rred_3518 VDD.$321.Metal1 VDD.$640.Metal2 4.20355527162
Rred_3519 VDD.$321.Metal1 VDD.$644.Metal2 12.5487222284
Rred_3520 VDD.$321.Metal1 VDD.$790.Metal3 1605.08534198
Rred_3521 VDD.$321.Metal1 VDD.P0.nSD 7.78289393678
Rred_3522 VDD.$332.Metal1 VDD.$340.Metal1 0.0697456849131
Rred_3523 VDD.$332.Metal1 VDD.$640.Metal2 16.6033460769
Rred_3524 VDD.$332.Metal1 VDD.$644.Metal2 2.19566304149
Rred_3525 VDD.$332.Metal1 VDD.$794.Metal3 114.227739692
Rred_3526 VDD.$332.Metal1 VDD.P0.nSD 6.03629704604
Rred_3527 VDD.$340.Metal1 VDD.$388.Metal2 19666788.7587
Rred_3528 VDD.$340.Metal1 VDD.$42.Metal1 418848.164894
Rred_3529 VDD.$340.Metal1 VDD.$644.Metal2 3.27487086488
Rred_3530 VDD.$340.Metal1 VDD.$666.Metal3 446714531.727
Rred_3531 VDD.$340.Metal1 VDD.$794.Metal3 74.3859316747
Rred_3532 VDD.$340.Metal1 VDD.P0.nSD 1.43172679455
Rred_3533 VDD.$388.Metal2 VDD.$392.Metal2 0.0360793953211
Rred_3534 VDD.$388.Metal2 VDD.$42.Metal1 1.35031248509
Rred_3535 VDD.$388.Metal2 VDD.$55.Metal1 12.5487222284
Rred_3536 VDD.$388.Metal2 VDD.$666.Metal3 1.21716087471
Rred_3537 VDD.$388.Metal2 VDD.P0.nSD 68.4122003461
Rred_3538 VDD.$392.Metal2 VDD.$400.Metal2 0.0727381793901
Rred_3539 VDD.$392.Metal2 VDD.$42.Metal1 16.6033460769
Rred_3540 VDD.$392.Metal2 VDD.$55.Metal1 4.20355527162
Rred_3541 VDD.$392.Metal2 VDD.$59.Metal1 30.8861222072
Rred_3542 VDD.$392.Metal2 VDD.$666.Metal3 9.03608
Rred_3543 VDD.$392.Metal2 VDD.$670.Metal3 4.52703011917
Rred_3544 VDD.$392.Metal2 VDD.P0.nSD 2462.6173532
Rred_3545 VDD.$400.Metal2 VDD.$404.Metal2 0.0360790997548
Rred_3546 VDD.$400.Metal2 VDD.$55.Metal1 12.8692175863
Rred_3547 VDD.$400.Metal2 VDD.$59.Metal1 5.03567607018
Rred_3548 VDD.$400.Metal2 VDD.$67.Metal1 18.0873632184
Rred_3549 VDD.$400.Metal2 VDD.$670.Metal3 3.8851010464
Rred_3550 VDD.$400.Metal2 VDD.$676.Metal3 13.6446092814
Rred_3551 VDD.$400.Metal2 VDD.P0.nSD 10673.8199934
Rred_3552 VDD.$404.Metal2 VDD.$412.Metal2 0.0727384141352
Rred_3553 VDD.$404.Metal2 VDD.$59.Metal1 30.7485174712
Rred_3554 VDD.$404.Metal2 VDD.$67.Metal1 5.02748847237
Rred_3555 VDD.$404.Metal2 VDD.$670.Metal3 13.6446092814
Rred_3556 VDD.$404.Metal2 VDD.$676.Metal3 3.88510641584
Rred_3557 VDD.$404.Metal2 VDD.$71.Metal1 9.95520824364
Rred_3558 VDD.$404.Metal2 VDD.P0.nSD 18140.58458
Rred_3559 VDD.$412.Metal2 VDD.$420.Metal2 0.0727381586487
Rred_3560 VDD.$412.Metal2 VDD.$67.Metal1 102.870485184
Rred_3561 VDD.$412.Metal2 VDD.$676.Metal3 4.52703740958
Rred_3562 VDD.$412.Metal2 VDD.$680.Metal3 4.52702947501
Rred_3563 VDD.$412.Metal2 VDD.$71.Metal1 5.04799007623
Rred_3564 VDD.$412.Metal2 VDD.$77.Metal1 5.0461169633
Rred_3565 VDD.$412.Metal2 VDD.$81.Metal1 28.0803009334
Rred_3566 VDD.$412.Metal2 VDD.P0.nSD 6051.37611189
Rred_3567 VDD.$42.Metal1 VDD.$55.Metal1 0.0967818976451
Rred_3568 VDD.$42.Metal1 VDD.$666.Metal3 46.9324256215
Rred_3569 VDD.$42.Metal1 VDD.P0.nSD 1.2227188704
Rred_3570 VDD.$420.Metal2 VDD.$428.Metal2 0.0727382033262
Rred_3571 VDD.$420.Metal2 VDD.$680.Metal3 4.52702947501
Rred_3572 VDD.$420.Metal2 VDD.$684.Metal3 4.52703086255
Rred_3573 VDD.$420.Metal2 VDD.$77.Metal1 13.4297091421
Rred_3574 VDD.$420.Metal2 VDD.$81.Metal1 7.14178490216
Rred_3575 VDD.$420.Metal2 VDD.$85.Metal1 6.82120429833
Rred_3576 VDD.$420.Metal2 VDD.$89.Metal1 12.3534294277
Rred_3577 VDD.$428.Metal2 VDD.$432.Metal2 0.0360795101713
Rred_3578 VDD.$428.Metal2 VDD.$684.Metal3 4.52703086255
Rred_3579 VDD.$428.Metal2 VDD.$688.Metal3 9.03608
Rred_3580 VDD.$428.Metal2 VDD.$85.Metal1 34.3150817435
Rred_3581 VDD.$428.Metal2 VDD.$89.Metal1 4.30058611331
Rred_3582 VDD.$428.Metal2 VDD.$99.Metal1 14.49164833
Rred_3583 VDD.$428.Metal2 VDD.P0.nSD 2846.11396167
Rred_3584 VDD.$432.Metal2 VDD.$436.Metal2 0.03608
Rred_3585 VDD.$432.Metal2 VDD.$688.Metal3 4.5
Rred_3586 VDD.$432.Metal2 VDD.$89.Metal1 15.9907843641
Rred_3587 VDD.$432.Metal2 VDD.$99.Metal1 6.32394034582
Rred_3588 VDD.$432.Metal2 VDD.P0.nSD 3140.88673319
Rred_3589 VDD.$436.Metal2 VDD.$440.Metal2 0.0360790918025
Rred_3590 VDD.$436.Metal2 VDD.$688.Metal3 6.79506398421
Rred_3591 VDD.$436.Metal2 VDD.$694.Metal3 13.6446092814
Rred_3592 VDD.$436.Metal2 VDD.$99.Metal1 5.47615572503
Rred_3593 VDD.$436.Metal2 VDD.P0.nSD 15118.3243465
Rred_3594 VDD.$440.Metal2 VDD.$448.Metal2 0.0727382304586
Rred_3595 VDD.$440.Metal2 VDD.$688.Metal3 13.6446092814
Rred_3596 VDD.$440.Metal2 VDD.$694.Metal3 3.88510221452
Rred_3597 VDD.$440.Metal2 VDD.$99.Metal1 20.5001461139
Rred_3598 VDD.$440.Metal2 VDD.P0.nSD 12096.0620881
Rred_3599 VDD.$448.Metal2 VDD.$452.Metal2 0.0360795122755
Rred_3600 VDD.$448.Metal2 VDD.$694.Metal3 4.52703170519
Rred_3601 VDD.$448.Metal2 VDD.$698.Metal3 9.03608
Rred_3602 VDD.$448.Metal2 VDD.P0.nSD 2759.76636664
Rred_3603 VDD.$452.Metal2 VDD.$456.Metal2 0.03608
Rred_3604 VDD.$452.Metal2 VDD.$698.Metal3 4.5
Rred_3605 VDD.$452.Metal2 VDD.P0.nSD 3253.18111292
Rred_3606 VDD.$456.Metal2 VDD.$460.Metal2 0.0360790902121
Rred_3607 VDD.$456.Metal2 VDD.$698.Metal3 6.79506398421
Rred_3608 VDD.$456.Metal2 VDD.$704.Metal3 13.6446092814
Rred_3609 VDD.$456.Metal2 VDD.P0.nSD 13955.9160792
Rred_3610 VDD.$460.Metal2 VDD.$464.Metal2 0.03608
Rred_3611 VDD.$460.Metal2 VDD.$698.Metal3 13.6446092814
Rred_3612 VDD.$460.Metal2 VDD.$704.Metal3 6.79506398421
Rred_3613 VDD.$460.Metal2 VDD.P0.nSD 12959.5658577
Rred_3614 VDD.$464.Metal2 VDD.$472.Metal2 0.0727374077779
Rred_3615 VDD.$464.Metal2 VDD.$704.Metal3 3.60858803252
Rred_3616 VDD.$464.Metal2 VDD.$708.Metal3 18.2167692814
Rred_3617 VDD.$464.Metal2 VDD.P0.nSD 6723.14228671
Rred_3618 VDD.$472.Metal2 VDD.$476.Metal2 0.03608
Rred_3619 VDD.$472.Metal2 VDD.$704.Metal3 18.2167692814
Rred_3620 VDD.$472.Metal2 VDD.$708.Metal3 3.60858803252
Rred_3621 VDD.$472.Metal2 VDD.P0.nSD 6723.14228671
Rred_3622 VDD.$476.Metal2 VDD.$480.Metal2 0.0360790902121
Rred_3623 VDD.$476.Metal2 VDD.$708.Metal3 6.79506398421
Rred_3624 VDD.$476.Metal2 VDD.$714.Metal3 13.6446092814
Rred_3625 VDD.$476.Metal2 VDD.P0.nSD 12959.5658577
Rred_3626 VDD.$480.Metal2 VDD.$484.Metal2 0.03608
Rred_3627 VDD.$480.Metal2 VDD.$708.Metal3 13.6446092814
Rred_3628 VDD.$480.Metal2 VDD.$714.Metal3 6.79506398421
Rred_3629 VDD.$480.Metal2 VDD.P0.nSD 13955.9160792
Rred_3630 VDD.$484.Metal2 VDD.$488.Metal2 0.0360795122755
Rred_3631 VDD.$484.Metal2 VDD.$714.Metal3 4.5
Rred_3632 VDD.$484.Metal2 VDD.P0.nSD 3253.18111292
Rred_3633 VDD.$488.Metal2 VDD.$496.Metal2 0.0727382304586
Rred_3634 VDD.$488.Metal2 VDD.$714.Metal3 9.03608
Rred_3635 VDD.$488.Metal2 VDD.$718.Metal3 4.52703170519
Rred_3636 VDD.$488.Metal2 VDD.P0.nSD 2759.76636664
Rred_3637 VDD.$496.Metal2 VDD.$504.Metal2 0.0727381411006
Rred_3638 VDD.$496.Metal2 VDD.$718.Metal3 4.52703170519
Rred_3639 VDD.$496.Metal2 VDD.$722.Metal3 4.52702893002
Rred_3640 VDD.$504.Metal2 VDD.$512.Metal2 0.0727384604905
Rred_3641 VDD.$504.Metal2 VDD.$722.Metal3 4.52702893002
Rred_3642 VDD.$504.Metal2 VDD.$726.Metal3 4.52703884922
Rred_3643 VDD.$504.Metal2 VDD.P0.nSD 6259.8898107
Rred_3644 VDD.$512.Metal2 VDD.$520.Metal2 0.0727381151932
Rred_3645 VDD.$512.Metal2 VDD.$726.Metal3 4.52703884922
Rred_3646 VDD.$512.Metal2 VDD.$730.Metal3 4.52702812542
Rred_3647 VDD.$520.Metal2 VDD.$528.Metal2 0.0727384604905
Rred_3648 VDD.$520.Metal2 VDD.$730.Metal3 4.52702812542
Rred_3649 VDD.$520.Metal2 VDD.$734.Metal3 4.52703884922
Rred_3650 VDD.$528.Metal2 VDD.$536.Metal2 0.0727381411006
Rred_3651 VDD.$528.Metal2 VDD.$734.Metal3 4.52703884922
Rred_3652 VDD.$528.Metal2 VDD.$738.Metal3 4.52702893002
Rred_3653 VDD.$528.Metal2 VDD.P0.nSD 6259.8898107
Rred_3654 VDD.$536.Metal2 VDD.$544.Metal2 0.0727382304586
Rred_3655 VDD.$536.Metal2 VDD.$738.Metal3 4.52702893002
Rred_3656 VDD.$536.Metal2 VDD.$742.Metal3 4.52703170519
Rred_3657 VDD.$544.Metal2 VDD.$548.Metal2 0.0360783709843
Rred_3658 VDD.$544.Metal2 VDD.$552.Metal2 2290.22785576
Rred_3659 VDD.$544.Metal2 VDD.$742.Metal3 3.63168870326
Rred_3660 VDD.$544.Metal2 VDD.$750.Metal3 18.3625380079
Rred_3661 VDD.$544.Metal2 VDD.P0.nSD 2759.76636664
Rred_3662 VDD.$548.Metal2 VDD.$552.Metal2 0.036078858678
Rred_3663 VDD.$548.Metal2 VDD.$742.Metal3 9.14460928142
Rred_3664 VDD.$548.Metal2 VDD.$750.Metal3 9.14460928142
Rred_3665 VDD.$548.Metal2 VDD.P0.nSD 3253.18111292
Rred_3666 VDD.$55.Metal1 VDD.$59.Metal1 0.0288072643101
Rred_3667 VDD.$55.Metal1 VDD.$670.Metal3 1605.08534198
Rred_3668 VDD.$55.Metal1 VDD.P0.nSD 7.78289393678
Rred_3669 VDD.$552.Metal2 VDD.$560.Metal2 0.0727385628444
Rred_3670 VDD.$552.Metal2 VDD.$742.Metal3 18.3625380079
Rred_3671 VDD.$552.Metal2 VDD.$750.Metal3 3.63169534661
Rred_3672 VDD.$552.Metal2 VDD.P0.nSD 18823.9097272
Rred_3673 VDD.$560.Metal2 VDD.$568.Metal2 0.0727293596086
Rred_3674 VDD.$560.Metal2 VDD.$750.Metal3 3.03398943114
Rred_3675 VDD.$560.Metal2 VDD.$758.Metal3 9.19927248124
Rred_3676 VDD.$560.Metal2 VDD.P0.nSD 3785.93787355
Rred_3677 VDD.$568.Metal2 VDD.$576.Metal2 0.0727381155799
Rred_3678 VDD.$568.Metal2 VDD.$750.Metal3 9.19927248124
Rred_3679 VDD.$568.Metal2 VDD.$758.Metal3 3.03398319208
Rred_3680 VDD.$568.Metal2 VDD.P0.nSD 6723.14228671
Rred_3681 VDD.$576.Metal2 VDD.$580.Metal2 0.0360795563649
Rred_3682 VDD.$576.Metal2 VDD.$758.Metal3 4.52702813743
Rred_3683 VDD.$576.Metal2 VDD.$762.Metal3 9.03608
Rred_3684 VDD.$576.Metal2 VDD.P0.nSD 4336.78503369
Rred_3685 VDD.$580.Metal2 VDD.$584.Metal2 0.03608
Rred_3686 VDD.$580.Metal2 VDD.$762.Metal3 4.5
Rred_3687 VDD.$580.Metal2 VDD.P0.nSD 2678.29546297
Rred_3688 VDD.$584.Metal2 VDD.$588.Metal2 0.0360792143655
Rred_3689 VDD.$584.Metal2 VDD.$762.Metal3 6.79506398421
Rred_3690 VDD.$584.Metal2 VDD.$768.Metal3 13.6446092814
Rred_3691 VDD.$584.Metal2 VDD.P0.nSD 181342.382993
Rred_3692 VDD.$588.Metal2 VDD.$596.Metal2 0.0727381076056
Rred_3693 VDD.$588.Metal2 VDD.$762.Metal3 13.6446092814
Rred_3694 VDD.$588.Metal2 VDD.$768.Metal3 3.88509940443
Rred_3695 VDD.$588.Metal2 VDD.P0.nSD 6981.45608854
Rred_3696 VDD.$59.Metal1 VDD.$67.Metal1 0.0578177251596
Rred_3697 VDD.$59.Metal1 VDD.$670.Metal3 3852.20482074
Rred_3698 VDD.$59.Metal1 VDD.P0.nSD 11.3466057612
Rred_3699 VDD.$596.Metal2 VDD.$600.Metal2 0.0360784056118
Rred_3700 VDD.$596.Metal2 VDD.$604.Metal2 2290.22785576
Rred_3701 VDD.$596.Metal2 VDD.$768.Metal3 3.63168624781
Rred_3702 VDD.$596.Metal2 VDD.$776.Metal3 18.3625380079
Rred_3703 VDD.$596.Metal2 VDD.P0.nSD 4139.84756814
Rred_3704 VDD.$600.Metal2 VDD.$604.Metal2 0.036078858678
Rred_3705 VDD.$600.Metal2 VDD.$768.Metal3 9.14460928142
Rred_3706 VDD.$600.Metal2 VDD.$776.Metal3 9.14460928142
Rred_3707 VDD.$600.Metal2 VDD.P0.nSD 2678.36036608
Rred_3708 VDD.$604.Metal2 VDD.$612.Metal2 0.0727382033262
Rred_3709 VDD.$604.Metal2 VDD.$768.Metal3 18.3625380079
Rred_3710 VDD.$604.Metal2 VDD.$776.Metal3 3.63168816097
Rred_3711 VDD.$612.Metal2 VDD.$620.Metal2 0.0727381586487
Rred_3712 VDD.$612.Metal2 VDD.$776.Metal3 4.52703086255
Rred_3713 VDD.$612.Metal2 VDD.$780.Metal3 4.52702947501
Rred_3714 VDD.$620.Metal2 VDD.$624.Metal2 0.0360787442188
Rred_3715 VDD.$620.Metal2 VDD.$780.Metal3 3.88510057197
Rred_3716 VDD.$620.Metal2 VDD.$786.Metal3 13.6446092814
Rred_3717 VDD.$620.Metal2 VDD.P0.nSD 3036.0786427
Rred_3718 VDD.$624.Metal2 VDD.$632.Metal2 0.0727381793901
Rred_3719 VDD.$624.Metal2 VDD.$780.Metal3 13.6446092814
Rred_3720 VDD.$624.Metal2 VDD.$786.Metal3 3.8851010464
Rred_3721 VDD.$624.Metal2 VDD.P0.nSD 2938.03235944
Rred_3722 VDD.$632.Metal2 VDD.$640.Metal2 0.0727381793901
Rred_3723 VDD.$632.Metal2 VDD.$786.Metal3 4.52703011917
Rred_3724 VDD.$632.Metal2 VDD.$790.Metal3 4.52703011917
Rred_3725 VDD.$640.Metal2 VDD.$644.Metal2 0.0360793953211
Rred_3726 VDD.$640.Metal2 VDD.$790.Metal3 4.52703011917
Rred_3727 VDD.$640.Metal2 VDD.$794.Metal3 9.03608
Rred_3728 VDD.$640.Metal2 VDD.P0.nSD 2462.6173532
Rred_3729 VDD.$644.Metal2 VDD.$794.Metal3 1.21755706215
Rred_3730 VDD.$644.Metal2 VDD.P0.nSD 1374.49430536
Rred_3731 VDD.$666.Metal3 VDD.$670.Metal3 0.0724492814222
Rred_3732 VDD.$666.Metal3 VDD.P0.nSD 1610.45920632
Rred_3733 VDD.$67.Metal1 VDD.$676.Metal3 12830.2988728
Rred_3734 VDD.$67.Metal1 VDD.$71.Metal1 0.0287839687664
Rred_3735 VDD.$67.Metal1 VDD.P0.nSD 11.3455846685
Rred_3736 VDD.$670.Metal3 VDD.$676.Metal3 0.109399445083
Rred_3737 VDD.$676.Metal3 VDD.$680.Metal3 0.0724492814222
Rred_3738 VDD.$676.Metal3 VDD.$71.Metal1 1241.6418264
Rred_3739 VDD.$680.Metal3 VDD.$684.Metal3 0.0724492814222
Rred_3740 VDD.$680.Metal3 VDD.$77.Metal1 1674.99143956
Rred_3741 VDD.$680.Metal3 VDD.$81.Metal1 3502.25482816
Rred_3742 VDD.$684.Metal3 VDD.$688.Metal3 0.0724492814222
Rred_3743 VDD.$684.Metal3 VDD.$85.Metal1 4279.87438597
Rred_3744 VDD.$684.Metal3 VDD.$89.Metal1 1540.75477895
Rred_3745 VDD.$688.Metal3 VDD.$694.Metal3 0.109399445083
Rred_3746 VDD.$694.Metal3 VDD.$698.Metal3 0.0724492814222
Rred_3747 VDD.$698.Metal3 VDD.$704.Metal3 0.109399445083
Rred_3748 VDD.$704.Metal3 VDD.$708.Metal3 0.0724481309494
Rred_3749 VDD.$708.Metal3 VDD.$714.Metal3 0.109399445083
Rred_3750 VDD.$71.Metal1 VDD.$77.Metal1 0.0577685609103
Rred_3751 VDD.$71.Metal1 VDD.P0.nSD 11.3458974695
Rred_3752 VDD.$714.Metal3 VDD.$718.Metal3 0.0724492814222
Rred_3753 VDD.$718.Metal3 VDD.$722.Metal3 0.0724492814222
Rred_3754 VDD.$722.Metal3 VDD.$726.Metal3 0.0724492814222
Rred_3755 VDD.$726.Metal3 VDD.$730.Metal3 0.0724492814222
Rred_3756 VDD.$730.Metal3 VDD.$734.Metal3 0.0724492814222
Rred_3757 VDD.$734.Metal3 VDD.$738.Metal3 0.0724492814222
Rred_3758 VDD.$738.Metal3 VDD.$742.Metal3 0.0724492814222
Rred_3759 VDD.$742.Metal3 VDD.$750.Metal3 0.147226749184
Rred_3760 VDD.$750.Metal3 VDD.$758.Metal3 0.147222110321
Rred_3761 VDD.$758.Metal3 VDD.$762.Metal3 0.0724492814222
Rred_3762 VDD.$762.Metal3 VDD.$768.Metal3 0.109399445083
Rred_3763 VDD.$768.Metal3 VDD.$776.Metal3 0.147226749184
Rred_3764 VDD.$77.Metal1 VDD.$81.Metal1 0.0288093244602
Rred_3765 VDD.$77.Metal1 VDD.P0.nSD 11.3484006977
Rred_3766 VDD.$776.Metal3 VDD.$780.Metal3 0.0724492814222
Rred_3767 VDD.$780.Metal3 VDD.$786.Metal3 0.109399445083
Rred_3768 VDD.$786.Metal3 VDD.$790.Metal3 0.0724492814222
Rred_3769 VDD.$790.Metal3 VDD.$794.Metal3 0.0724492814222
Rred_3770 VDD.$794.Metal3 VDD.P0.nSD 105936.03634
Rred_3771 VDD.$81.Metal1 VDD.$85.Metal1 0.0288150532545
Rred_3772 VDD.$81.Metal1 VDD.P0.nSD 17
Rred_3773 VDD.$85.Metal1 VDD.$89.Metal1 0.0288048872138
Rred_3774 VDD.$85.Metal1 VDD.P0.nSD 17
Rred_3775 VDD.$89.Metal1 VDD.$99.Metal1 0.0871976104641
Rred_3776 VDD.$89.Metal1 VDD.P0.nSD 8.53121874003
Rred_3777 VDD.$99.Metal1 VDD.P0.nSD 6.82480618198
Rred_3778 VSS VSS.$163.Metal1 0.055201089661
Rred_3779 VSS VSS.$177.Metal1 0.0845530933574
Rred_3780 VSS VSS.$478.Metal2 7.15772747535
Rred_3781 VSS VSS.$482.Metal2 5.45392849319
Rred_3782 VSS VSS.$486.Metal2 10.9636966076
Rred_3783 VSS VSS.P0.pSD 11.5355308439
Rred_3784 VSS.$101.Metal1 VSS.$113.Metal1 0.105531917729
Rred_3785 VSS.$101.Metal1 VSS.$414.Metal2 4.52971199827
Rred_3786 VSS.$101.Metal1 VSS.$422.Metal2 3.88890102677
Rred_3787 VSS.$101.Metal1 VSS.$426.Metal2 13.6824511684
Rred_3788 VSS.$101.Metal1 VSS.$664.Metal3 1131.50554324
Rred_3789 VSS.$101.Metal1 VSS.$91.Metal1 0.069767180001
Rred_3790 VSS.$101.Metal1 VSS.P0.pSD 5.65104000204
Rred_3791 VSS.$113.Metal1 VSS.$123.Metal1 0.0697672942897
Rred_3792 VSS.$113.Metal1 VSS.$422.Metal2 13.6826836115
Rred_3793 VSS.$113.Metal1 VSS.$426.Metal2 3.88891996498
Rred_3794 VSS.$113.Metal1 VSS.$434.Metal2 4.52978727976
Rred_3795 VSS.$113.Metal1 VSS.$670.Metal3 1131.50554324
Rred_3796 VSS.$113.Metal1 VSS.P0.pSD 5.67424095783
Rred_3797 VSS.$123.Metal1 VSS.$135.Metal1 0.105531917729
Rred_3798 VSS.$123.Metal1 VSS.$434.Metal2 4.52978727976
Rred_3799 VSS.$123.Metal1 VSS.$442.Metal2 3.88891996498
Rred_3800 VSS.$123.Metal1 VSS.$446.Metal2 13.6826836115
Rred_3801 VSS.$123.Metal1 VSS.$674.Metal3 1131.50554324
Rred_3802 VSS.$123.Metal1 VSS.P0.pSD 5.67424095783
Rred_3803 VSS.$135.Metal1 VSS.$145.Metal1 0.069767180001
Rred_3804 VSS.$135.Metal1 VSS.$442.Metal2 13.6824511684
Rred_3805 VSS.$135.Metal1 VSS.$446.Metal2 3.88890102677
Rred_3806 VSS.$135.Metal1 VSS.$454.Metal2 4.52971199827
Rred_3807 VSS.$135.Metal1 VSS.$680.Metal3 1131.50554324
Rred_3808 VSS.$135.Metal1 VSS.P0.pSD 5.65104000204
Rred_3809 VSS.$145.Metal1 VSS.$153.Metal1 0.0697692902273
Rred_3810 VSS.$145.Metal1 VSS.$454.Metal2 4.52975050565
Rred_3811 VSS.$145.Metal1 VSS.$462.Metal2 4.52935675254
Rred_3812 VSS.$145.Metal1 VSS.$684.Metal3 1131.50554324
Rred_3813 VSS.$145.Metal1 VSS.P0.pSD 7.06127605553
Rred_3814 VSS.$153.Metal1 VSS.$163.Metal1 0.0697641706687
Rred_3815 VSS.$153.Metal1 VSS.$462.Metal2 4.52929101933
Rred_3816 VSS.$153.Metal1 VSS.$470.Metal2 4.52948783287
Rred_3817 VSS.$153.Metal1 VSS.$684.Metal3 2299.30001576
Rred_3818 VSS.$153.Metal1 VSS.$692.Metal3 2299.30001576
Rred_3819 VSS.$153.Metal1 VSS.P0.pSD 7.20708138041
Rred_3820 VSS.$163.Metal1 VSS.$470.Metal2 4.52938296875
Rred_3821 VSS.$163.Metal1 VSS.$478.Metal2 5.20888368886
Rred_3822 VSS.$163.Metal1 VSS.$692.Metal3 1131.50554324
Rred_3823 VSS.$163.Metal1 VSS.P0.pSD 7.77663131675
Rred_3824 VSS.$17.Metal1 VSS.$301.Metal1 28069.6511472
Rred_3825 VSS.$17.Metal1 VSS.$366.Metal2 1.96972810067
Rred_3826 VSS.$17.Metal1 VSS.$39.Metal1 0.179800037779
Rred_3827 VSS.$17.Metal1 VSS.$606.Metal2 265656.271045
Rred_3828 VSS.$17.Metal1 VSS.$636.Metal3 14.0318061222
Rred_3829 VSS.$17.Metal1 VSS.$760.Metal3 4489813.71839
Rred_3830 VSS.$17.Metal1 VSS.P0.pSD 1.26516951549
Rred_3831 VSS.$177.Metal1 VSS.$191.Metal1 0.105532943036
Rred_3832 VSS.$177.Metal1 VSS.$482.Metal2 26.4511013979
Rred_3833 VSS.$177.Metal1 VSS.$486.Metal2 4.17372556749
Rred_3834 VSS.$177.Metal1 VSS.$494.Metal2 3.88896590119
Rred_3835 VSS.$177.Metal1 VSS.$498.Metal2 13.6819200158
Rred_3836 VSS.$177.Metal1 VSS.$700.Metal3 1131.50554324
Rred_3837 VSS.$177.Metal1 VSS.P0.pSD 5.20146462361
Rred_3838 VSS.$191.Metal1 VSS.$205.Metal1 0.105541703631
Rred_3839 VSS.$191.Metal1 VSS.$494.Metal2 13.6845764657
Rred_3840 VSS.$191.Metal1 VSS.$498.Metal2 3.88907213068
Rred_3841 VSS.$191.Metal1 VSS.$506.Metal2 3.88916072815
Rred_3842 VSS.$191.Metal1 VSS.$510.Metal2 13.685845449
Rred_3843 VSS.$191.Metal1 VSS.$706.Metal3 1131.50554324
Rred_3844 VSS.$191.Metal1 VSS.P0.pSD 4.78701310707
Rred_3845 VSS.$205.Metal1 VSS.$213.Metal1 0.0697682707854
Rred_3846 VSS.$205.Metal1 VSS.$506.Metal2 13.6835206835
Rred_3847 VSS.$205.Metal1 VSS.$510.Metal2 3.88930185557
Rred_3848 VSS.$205.Metal1 VSS.$518.Metal2 4.52931810868
Rred_3849 VSS.$205.Metal1 VSS.$712.Metal3 1131.50554324
Rred_3850 VSS.$205.Metal1 VSS.P0.pSD 5.60635397116
Rred_3851 VSS.$213.Metal1 VSS.$221.Metal1 0.0697611346947
Rred_3852 VSS.$213.Metal1 VSS.$518.Metal2 4.52947222468
Rred_3853 VSS.$213.Metal1 VSS.$526.Metal2 4.52958703125
Rred_3854 VSS.$213.Metal1 VSS.$716.Metal3 1131.50554324
Rred_3855 VSS.$213.Metal1 VSS.P0.pSD 7.28214591173
Rred_3856 VSS.$221.Metal1 VSS.$231.Metal1 0.0697611346947
Rred_3857 VSS.$221.Metal1 VSS.$526.Metal2 4.52905892652
Rred_3858 VSS.$221.Metal1 VSS.$534.Metal2 4.52905892652
Rred_3859 VSS.$221.Metal1 VSS.$716.Metal3 2299.30001576
Rred_3860 VSS.$221.Metal1 VSS.$724.Metal3 2299.30001576
Rred_3861 VSS.$221.Metal1 VSS.P0.pSD 6.78394137185
Rred_3862 VSS.$231.Metal1 VSS.$239.Metal1 0.0697682707854
Rred_3863 VSS.$231.Metal1 VSS.$534.Metal2 4.52958703125
Rred_3864 VSS.$231.Metal1 VSS.$542.Metal2 4.52947222468
Rred_3865 VSS.$231.Metal1 VSS.$724.Metal3 1131.50554324
Rred_3866 VSS.$231.Metal1 VSS.P0.pSD 7.28214591173
Rred_3867 VSS.$239.Metal1 VSS.$253.Metal1 0.105541703631
Rred_3868 VSS.$239.Metal1 VSS.$542.Metal2 4.52931810868
Rred_3869 VSS.$239.Metal1 VSS.$550.Metal2 3.88930185557
Rred_3870 VSS.$239.Metal1 VSS.$554.Metal2 13.6835206835
Rred_3871 VSS.$239.Metal1 VSS.$728.Metal3 1131.50554324
Rred_3872 VSS.$239.Metal1 VSS.P0.pSD 5.60635397116
Rred_3873 VSS.$253.Metal1 VSS.$261.Metal1 0.0697675062039
Rred_3874 VSS.$253.Metal1 VSS.$550.Metal2 13.685845449
Rred_3875 VSS.$253.Metal1 VSS.$554.Metal2 3.88916072815
Rred_3876 VSS.$253.Metal1 VSS.$562.Metal2 4.52949140451
Rred_3877 VSS.$253.Metal1 VSS.$734.Metal3 1131.50554324
Rred_3878 VSS.$253.Metal1 VSS.P0.pSD 5.74534107986
Rred_3879 VSS.$261.Metal1 VSS.$271.Metal1 0.0697668104946
Rred_3880 VSS.$261.Metal1 VSS.$562.Metal2 4.52929875741
Rred_3881 VSS.$261.Metal1 VSS.$570.Metal2 4.52963392708
Rred_3882 VSS.$261.Metal1 VSS.$738.Metal3 1131.50554324
Rred_3883 VSS.$261.Metal1 VSS.P0.pSD 6.95499392273
Rred_3884 VSS.$271.Metal1 VSS.$279.Metal1 0.0697695450878
Rred_3885 VSS.$271.Metal1 VSS.$570.Metal2 4.52957364667
Rred_3886 VSS.$271.Metal1 VSS.$578.Metal2 4.52923325896
Rred_3887 VSS.$271.Metal1 VSS.$738.Metal3 2299.30001576
Rred_3888 VSS.$271.Metal1 VSS.$746.Metal3 2299.30001576
Rred_3889 VSS.$271.Metal1 VSS.P0.pSD 7.09720156148
Rred_3890 VSS.$279.Metal1 VSS.$293.Metal1 0.105545099249
Rred_3891 VSS.$279.Metal1 VSS.$578.Metal2 4.5294145737
Rred_3892 VSS.$279.Metal1 VSS.$586.Metal2 3.88926387732
Rred_3893 VSS.$279.Metal1 VSS.$590.Metal2 13.6852894064
Rred_3894 VSS.$279.Metal1 VSS.$746.Metal3 1131.50554324
Rred_3895 VSS.$279.Metal1 VSS.P0.pSD 5.68306694942
Rred_3896 VSS.$293.Metal1 VSS.$301.Metal1 0.0697696300414
Rred_3897 VSS.$293.Metal1 VSS.$586.Metal2 13.6849572623
Rred_3898 VSS.$293.Metal1 VSS.$590.Metal2 3.88929190205
Rred_3899 VSS.$293.Metal1 VSS.$598.Metal2 4.52939531907
Rred_3900 VSS.$293.Metal1 VSS.$752.Metal3 1131.50554324
Rred_3901 VSS.$293.Metal1 VSS.P0.pSD 5.66763829959
Rred_3902 VSS.$301.Metal1 VSS.$598.Metal2 4.52925253141
Rred_3903 VSS.$301.Metal1 VSS.$606.Metal2 1.01066098621
Rred_3904 VSS.$301.Metal1 VSS.$752.Metal3 2299.30001576
Rred_3905 VSS.$301.Metal1 VSS.$760.Metal3 25.994682718
Rred_3906 VSS.$301.Metal1 VSS.P0.pSD 1.14371512818
Rred_3907 VSS.$366.Metal2 VSS.$370.Metal2 0.0360785013286
Rred_3908 VSS.$366.Metal2 VSS.$39.Metal1 1.41013521912
Rred_3909 VSS.$366.Metal2 VSS.$51.Metal1 13.6817520302
Rred_3910 VSS.$366.Metal2 VSS.$636.Metal3 0.858238258706
Rred_3911 VSS.$366.Metal2 VSS.$642.Metal3 13.6446092814
Rred_3912 VSS.$366.Metal2 VSS.P0.pSD 206.808500506
Rred_3913 VSS.$370.Metal2 VSS.$378.Metal2 0.0727385628444
Rred_3914 VSS.$370.Metal2 VSS.$39.Metal1 13.6833791552
Rred_3915 VSS.$370.Metal2 VSS.$51.Metal1 3.88884402472
Rred_3916 VSS.$370.Metal2 VSS.$636.Metal3 13.6446092814
Rred_3917 VSS.$370.Metal2 VSS.$642.Metal3 3.88510981734
Rred_3918 VSS.$370.Metal2 VSS.P0.pSD 1902.60298298
Rred_3919 VSS.$378.Metal2 VSS.$386.Metal2 0.0727385628444
Rred_3920 VSS.$378.Metal2 VSS.$51.Metal1 4.52946941301
Rred_3921 VSS.$378.Metal2 VSS.$61.Metal1 4.52965651979
Rred_3922 VSS.$378.Metal2 VSS.$642.Metal3 4.52704202798
Rred_3923 VSS.$378.Metal2 VSS.$646.Metal3 4.52704202798
Rred_3924 VSS.$378.Metal2 VSS.P0.pSD 3563.18838066
Rred_3925 VSS.$386.Metal2 VSS.$394.Metal2 0.0727293596086
Rred_3926 VSS.$386.Metal2 VSS.$61.Metal1 4.5294145737
Rred_3927 VSS.$386.Metal2 VSS.$646.Metal3 3.03398943114
Rred_3928 VSS.$386.Metal2 VSS.$654.Metal3 9.19927248124
Rred_3929 VSS.$386.Metal2 VSS.$69.Metal1 4.52923325896
Rred_3930 VSS.$386.Metal2 VSS.P0.pSD 3786.07212424
Rred_3931 VSS.$39.Metal1 VSS.$51.Metal1 0.105530366813
Rred_3932 VSS.$39.Metal1 VSS.$636.Metal3 22.1285326289
Rred_3933 VSS.$39.Metal1 VSS.P0.pSD 3.5906657034
Rred_3934 VSS.$394.Metal2 VSS.$402.Metal2 0.0727385628444
Rred_3935 VSS.$394.Metal2 VSS.$646.Metal3 9.19927248124
Rred_3936 VSS.$394.Metal2 VSS.$654.Metal3 3.03398943114
Rred_3937 VSS.$394.Metal2 VSS.$69.Metal1 4.52957364667
Rred_3938 VSS.$394.Metal2 VSS.$79.Metal1 4.52963392708
Rred_3939 VSS.$394.Metal2 VSS.P0.pSD 3428.7312748
Rred_3940 VSS.$402.Metal2 VSS.$406.Metal2 0.0360785013197
Rred_3941 VSS.$402.Metal2 VSS.$654.Metal3 3.88510981734
Rred_3942 VSS.$402.Metal2 VSS.$660.Metal3 13.6446092814
Rred_3943 VSS.$402.Metal2 VSS.$79.Metal1 3.88888205742
Rred_3944 VSS.$402.Metal2 VSS.$91.Metal1 13.6829157559
Rred_3945 VSS.$402.Metal2 VSS.P0.pSD 1902.60237591
Rred_3946 VSS.$406.Metal2 VSS.$414.Metal2 0.0727385628444
Rred_3947 VSS.$406.Metal2 VSS.$654.Metal3 13.6446092814
Rred_3948 VSS.$406.Metal2 VSS.$660.Metal3 3.88510981734
Rred_3949 VSS.$406.Metal2 VSS.$79.Metal1 13.6822184249
Rred_3950 VSS.$406.Metal2 VSS.$91.Metal1 3.88893887217
Rred_3951 VSS.$406.Metal2 VSS.P0.pSD 1902.59112741
Rred_3952 VSS.$414.Metal2 VSS.$422.Metal2 0.0727385628444
Rred_3953 VSS.$414.Metal2 VSS.$660.Metal3 4.52704202798
Rred_3954 VSS.$414.Metal2 VSS.$664.Metal3 4.52704202798
Rred_3955 VSS.$414.Metal2 VSS.$91.Metal1 4.52975050565
Rred_3956 VSS.$414.Metal2 VSS.P0.pSD 3365.24426629
Rred_3957 VSS.$422.Metal2 VSS.$426.Metal2 0.036078501318
Rred_3958 VSS.$422.Metal2 VSS.$664.Metal3 3.88510981734
Rred_3959 VSS.$422.Metal2 VSS.$670.Metal3 13.6446092814
Rred_3960 VSS.$422.Metal2 VSS.P0.pSD 1902.6000048
Rred_3961 VSS.$426.Metal2 VSS.$434.Metal2 0.0727385628444
Rred_3962 VSS.$426.Metal2 VSS.$664.Metal3 13.6446092814
Rred_3963 VSS.$426.Metal2 VSS.$670.Metal3 3.88510981734
Rred_3964 VSS.$426.Metal2 VSS.P0.pSD 1902.5962553
Rred_3965 VSS.$434.Metal2 VSS.$442.Metal2 0.0727385628444
Rred_3966 VSS.$434.Metal2 VSS.$670.Metal3 4.52704202798
Rred_3967 VSS.$434.Metal2 VSS.$674.Metal3 4.52704202798
Rred_3968 VSS.$434.Metal2 VSS.P0.pSD 3304.06901819
Rred_3969 VSS.$442.Metal2 VSS.$446.Metal2 0.036078501318
Rred_3970 VSS.$442.Metal2 VSS.$674.Metal3 3.88510981734
Rred_3971 VSS.$442.Metal2 VSS.$680.Metal3 13.6446092814
Rred_3972 VSS.$442.Metal2 VSS.P0.pSD 1902.5962553
Rred_3973 VSS.$446.Metal2 VSS.$454.Metal2 0.0727385628444
Rred_3974 VSS.$446.Metal2 VSS.$674.Metal3 13.6446092814
Rred_3975 VSS.$446.Metal2 VSS.$680.Metal3 3.88510981734
Rred_3976 VSS.$446.Metal2 VSS.P0.pSD 1902.6000048
Rred_3977 VSS.$454.Metal2 VSS.$462.Metal2 0.0727385628444
Rred_3978 VSS.$454.Metal2 VSS.$680.Metal3 4.52704202798
Rred_3979 VSS.$454.Metal2 VSS.$684.Metal3 4.52704202798
Rred_3980 VSS.$454.Metal2 VSS.P0.pSD 3365.24426629
Rred_3981 VSS.$462.Metal2 VSS.$470.Metal2 0.0727293596086
Rred_3982 VSS.$462.Metal2 VSS.$684.Metal3 3.03398943114
Rred_3983 VSS.$462.Metal2 VSS.$692.Metal3 9.19927248124
Rred_3984 VSS.$462.Metal2 VSS.P0.pSD 3786.06805636
Rred_3985 VSS.$470.Metal2 VSS.$478.Metal2 0.0727385628444
Rred_3986 VSS.$470.Metal2 VSS.$684.Metal3 9.19927248124
Rred_3987 VSS.$470.Metal2 VSS.$692.Metal3 3.03398943114
Rred_3988 VSS.$470.Metal2 VSS.P0.pSD 3634.45996974
Rred_3989 VSS.$478.Metal2 VSS.$482.Metal2 0.036078858678
Rred_3990 VSS.$478.Metal2 VSS.$486.Metal2 2290.22785576
Rred_3991 VSS.$478.Metal2 VSS.$692.Metal3 3.63169534661
Rred_3992 VSS.$478.Metal2 VSS.$700.Metal3 18.3625380079
Rred_3993 VSS.$478.Metal2 VSS.P0.pSD 7679.78744493
Rred_3994 VSS.$482.Metal2 VSS.$486.Metal2 0.0360784791623
Rred_3995 VSS.$482.Metal2 VSS.$692.Metal3 9.14460928142
Rred_3996 VSS.$482.Metal2 VSS.$700.Metal3 9.14460928142
Rred_3997 VSS.$482.Metal2 VSS.P0.pSD 5409.09045623
Rred_3998 VSS.$486.Metal2 VSS.$494.Metal2 0.0727385628444
Rred_3999 VSS.$486.Metal2 VSS.$692.Metal3 18.3625380079
Rred_4000 VSS.$486.Metal2 VSS.$700.Metal3 3.63169534661
Rred_4001 VSS.$486.Metal2 VSS.P0.pSD 2808.2147266
Rred_4002 VSS.$494.Metal2 VSS.$498.Metal2 0.0360785013839
Rred_4003 VSS.$494.Metal2 VSS.$700.Metal3 3.88510981734
Rred_4004 VSS.$494.Metal2 VSS.$706.Metal3 13.6446092814
Rred_4005 VSS.$494.Metal2 VSS.P0.pSD 1851.08167695
Rred_4006 VSS.$498.Metal2 VSS.$506.Metal2 0.0727385628444
Rred_4007 VSS.$498.Metal2 VSS.$700.Metal3 13.6446092814
Rred_4008 VSS.$498.Metal2 VSS.$706.Metal3 3.88510981734
Rred_4009 VSS.$498.Metal2 VSS.P0.pSD 1876.54404608
Rred_4010 VSS.$506.Metal2 VSS.$510.Metal2 0.0360785014768
Rred_4011 VSS.$506.Metal2 VSS.$706.Metal3 3.88510981734
Rred_4012 VSS.$506.Metal2 VSS.$712.Metal3 13.6446092814
Rred_4013 VSS.$506.Metal2 VSS.P0.pSD 1826.62751185
Rred_4014 VSS.$51.Metal1 VSS.$61.Metal1 0.0697653058286
Rred_4015 VSS.$51.Metal1 VSS.$642.Metal3 1131.50554324
Rred_4016 VSS.$51.Metal1 VSS.P0.pSD 5.58245669815
Rred_4017 VSS.$510.Metal2 VSS.$518.Metal2 0.0727385628444
Rred_4018 VSS.$510.Metal2 VSS.$706.Metal3 13.6446092814
Rred_4019 VSS.$510.Metal2 VSS.$712.Metal3 3.88510981734
Rred_4020 VSS.$510.Metal2 VSS.P0.pSD 1756.03296012
Rred_4021 VSS.$518.Metal2 VSS.$526.Metal2 0.0727385628444
Rred_4022 VSS.$518.Metal2 VSS.$712.Metal3 4.52704202798
Rred_4023 VSS.$518.Metal2 VSS.$716.Metal3 4.52704202798
Rred_4024 VSS.$518.Metal2 VSS.P0.pSD 3786.05178466
Rred_4025 VSS.$526.Metal2 VSS.$534.Metal2 0.0727293596086
Rred_4026 VSS.$526.Metal2 VSS.$716.Metal3 3.03398943114
Rred_4027 VSS.$526.Metal2 VSS.$724.Metal3 9.19927248124
Rred_4028 VSS.$526.Metal2 VSS.P0.pSD 3785.93787355
Rred_4029 VSS.$534.Metal2 VSS.$542.Metal2 0.0727385628444
Rred_4030 VSS.$534.Metal2 VSS.$716.Metal3 9.19927248124
Rred_4031 VSS.$534.Metal2 VSS.$724.Metal3 3.03398943114
Rred_4032 VSS.$534.Metal2 VSS.P0.pSD 3785.93787355
Rred_4033 VSS.$542.Metal2 VSS.$550.Metal2 0.0727385628444
Rred_4034 VSS.$542.Metal2 VSS.$724.Metal3 4.52704202798
Rred_4035 VSS.$542.Metal2 VSS.$728.Metal3 4.52704202798
Rred_4036 VSS.$542.Metal2 VSS.P0.pSD 3786.05178466
Rred_4037 VSS.$550.Metal2 VSS.$554.Metal2 0.0360785014768
Rred_4038 VSS.$550.Metal2 VSS.$728.Metal3 3.88510981734
Rred_4039 VSS.$550.Metal2 VSS.$734.Metal3 13.6446092814
Rred_4040 VSS.$550.Metal2 VSS.P0.pSD 1756.03296012
Rred_4041 VSS.$554.Metal2 VSS.$562.Metal2 0.0727385628444
Rred_4042 VSS.$554.Metal2 VSS.$728.Metal3 13.6446092814
Rred_4043 VSS.$554.Metal2 VSS.$734.Metal3 3.88510981734
Rred_4044 VSS.$554.Metal2 VSS.P0.pSD 1826.62751185
Rred_4045 VSS.$562.Metal2 VSS.$570.Metal2 0.0727385628444
Rred_4046 VSS.$562.Metal2 VSS.$734.Metal3 4.52704202798
Rred_4047 VSS.$562.Metal2 VSS.$738.Metal3 4.52704202798
Rred_4048 VSS.$562.Metal2 VSS.P0.pSD 3786.03958067
Rred_4049 VSS.$570.Metal2 VSS.$578.Metal2 0.0727293596086
Rred_4050 VSS.$570.Metal2 VSS.$738.Metal3 3.03398943114
Rred_4051 VSS.$570.Metal2 VSS.$746.Metal3 9.19927248124
Rred_4052 VSS.$570.Metal2 VSS.P0.pSD 3428.7312748
Rred_4053 VSS.$578.Metal2 VSS.$586.Metal2 0.0727385628444
Rred_4054 VSS.$578.Metal2 VSS.$738.Metal3 9.19927248124
Rred_4055 VSS.$578.Metal2 VSS.$746.Metal3 3.03398943114
Rred_4056 VSS.$578.Metal2 VSS.P0.pSD 3786.07212424
Rred_4057 VSS.$586.Metal2 VSS.$590.Metal2 0.0360785015004
Rred_4058 VSS.$586.Metal2 VSS.$746.Metal3 3.88510981734
Rred_4059 VSS.$586.Metal2 VSS.$752.Metal3 13.6446092814
Rred_4060 VSS.$586.Metal2 VSS.P0.pSD 1779.03911022
Rred_4061 VSS.$590.Metal2 VSS.$598.Metal2 0.0727385628444
Rred_4062 VSS.$590.Metal2 VSS.$746.Metal3 13.6446092814
Rred_4063 VSS.$590.Metal2 VSS.$752.Metal3 3.88510981734
Rred_4064 VSS.$590.Metal2 VSS.P0.pSD 1767.50532552
Rred_4065 VSS.$598.Metal2 VSS.$606.Metal2 0.0727293596086
Rred_4066 VSS.$598.Metal2 VSS.$752.Metal3 3.03398943114
Rred_4067 VSS.$598.Metal2 VSS.$760.Metal3 9.19927248124
Rred_4068 VSS.$598.Metal2 VSS.P0.pSD 3786.07348019
Rred_4069 VSS.$606.Metal2 VSS.$752.Metal3 9.19927248124
Rred_4070 VSS.$606.Metal2 VSS.$760.Metal3 1.00242276135
Rred_4071 VSS.$606.Metal2 VSS.P0.pSD 13.97920883
Rred_4072 VSS.$61.Metal1 VSS.$646.Metal3 1131.50554324
Rred_4073 VSS.$61.Metal1 VSS.$69.Metal1 0.0697695450878
Rred_4074 VSS.$61.Metal1 VSS.P0.pSD 7.17009846302
Rred_4075 VSS.$636.Metal3 VSS.$642.Metal3 0.109399445083
Rred_4076 VSS.$636.Metal3 VSS.P0.pSD 1980.02680701
Rred_4077 VSS.$642.Metal3 VSS.$646.Metal3 0.0724492814222
Rred_4078 VSS.$646.Metal3 VSS.$654.Metal3 0.147222110321
Rred_4079 VSS.$646.Metal3 VSS.$69.Metal1 2299.30001576
Rred_4080 VSS.$654.Metal3 VSS.$660.Metal3 0.109399445083
Rred_4081 VSS.$654.Metal3 VSS.$69.Metal1 2299.30001576
Rred_4082 VSS.$654.Metal3 VSS.$79.Metal1 1131.50554324
Rred_4083 VSS.$660.Metal3 VSS.$664.Metal3 0.0724492814222
Rred_4084 VSS.$660.Metal3 VSS.$91.Metal1 1131.50554324
Rred_4085 VSS.$664.Metal3 VSS.$670.Metal3 0.109399445083
Rred_4086 VSS.$670.Metal3 VSS.$674.Metal3 0.0724492814222
Rred_4087 VSS.$674.Metal3 VSS.$680.Metal3 0.109399445083
Rred_4088 VSS.$680.Metal3 VSS.$684.Metal3 0.0724492814222
Rred_4089 VSS.$684.Metal3 VSS.$692.Metal3 0.147222110321
Rred_4090 VSS.$69.Metal1 VSS.$79.Metal1 0.0697668104946
Rred_4091 VSS.$69.Metal1 VSS.P0.pSD 7.09720156148
Rred_4092 VSS.$692.Metal3 VSS.$700.Metal3 0.147226749184
Rred_4093 VSS.$700.Metal3 VSS.$706.Metal3 0.109399445083
Rred_4094 VSS.$706.Metal3 VSS.$712.Metal3 0.109399445083
Rred_4095 VSS.$712.Metal3 VSS.$716.Metal3 0.0724492814222
Rred_4096 VSS.$716.Metal3 VSS.$724.Metal3 0.147222110321
Rred_4097 VSS.$724.Metal3 VSS.$728.Metal3 0.0724492814222
Rred_4098 VSS.$728.Metal3 VSS.$734.Metal3 0.109399445083
Rred_4099 VSS.$734.Metal3 VSS.$738.Metal3 0.0724492814222
Rred_4100 VSS.$738.Metal3 VSS.$746.Metal3 0.147222110321
Rred_4101 VSS.$746.Metal3 VSS.$752.Metal3 0.109399445083
Rred_4102 VSS.$752.Metal3 VSS.$760.Metal3 0.147222110321
Rred_4103 VSS.$760.Metal3 VSS.P0.pSD 242.391965018
Rred_4104 VSS.$79.Metal1 VSS.$91.Metal1 0.105531659243
Rred_4105 VSS.$79.Metal1 VSS.P0.pSD 5.62801049173
Rred_4106 VSS.$91.Metal1 VSS.P0.pSD 5.69743757492
.ENDS iqmod_mixer_tg_pex
