* PEX produced on Sat Mar 28 08:15:50 PM CET 2026 using /foss/tools/sak/sak-pex.sh with m=1 and s=1
* NGSPICE file created from iqmod_mfb_lpf_ota_core_hybrid_bm_pex.ext - technology: ihp-sg13g2

.subckt iqmod_mfb_lpf_ota_core_hybrid_bm_pex VSS VDD vinp vinn voutn voutp
+ di_ota_en
X0 iqmod_mfb_lpf_ota_core_hybrid_bm_pex_half_1.iqmod_mfb_lpf_ota_core_inv_NF6_2.vin iqmod_mfb_lpf_ota_core_hybrid_bm_pex_half_0.iqmod_mfb_lpf_ota_core_spdt_switch_0.do_spdt_ctrl_n iqmod_mfb_lpf_ota_core_hybrid_bm_pex_half_1.iqmod_mfb_lpf_ota_core_tg_1.v_a VDD sg13_lv_pmos ad=1.14p pd=6.38u as=1.14p ps=6.38u w=6u l=0.13u
X1 VSS VSS VSS VSS sg13_lv_nmos ad=0.34p pd=2.68u as=1.04613n ps=1.5458m w=1u l=0.13u
X2 iqmod_mfb_lpf_ota_core_hybrid_bm_pex_half_1.iqmod_mfb_lpf_ota_core_inv_NF10_0.vout iqmod_mfb_lpf_ota_core_hybrid_bm_pex_half_0.iqmod_mfb_lpf_ota_core_inv_NF10_0.vin VSS VSS sg13_lv_nmos ad=0.19p pd=1.38u as=0.19p ps=1.38u w=1u l=1u
X3 iqmod_mfb_lpf_ota_core_hybrid_bm_pex_half_1.iqmod_mfb_lpf_ota_core_tg_1.v_a voutp VSS VSS sg13_lv_nmos ad=0.19p pd=1.38u as=0.19p ps=1.38u w=1u l=1u
X4 VSS iqmod_mfb_lpf_ota_core_hybrid_bm_pex_half_0.iqmod_mfb_lpf_ota_core_inv_NF10_0.vin voutp VSS sg13_lv_nmos ad=0.19p pd=1.38u as=0.19p ps=1.38u w=1u l=1u
X5 iqmod_mfb_lpf_ota_core_hybrid_bm_pex_half_1.iqmod_mfb_lpf_ota_core_inv_NF6_2.vin di_ota_en iqmod_mfb_lpf_ota_core_hybrid_bm_pex_half_1.iqmod_mfb_lpf_ota_core_tg_1.v_a VSS sg13_lv_nmos ad=0.19p pd=1.38u as=0.19p ps=1.38u w=1u l=0.13u
X6 VDD VDD VDD VDD sg13_lv_pmos ad=1.14p pd=6.38u as=1.62466n ps=3.23532m w=6u l=1u
X7 iqmod_mfb_lpf_ota_core_hybrid_bm_pex_half_1.iqmod_mfb_lpf_ota_core_tg_1.v_a voutn VSS VSS sg13_lv_nmos ad=0.19p pd=1.38u as=0.19p ps=1.38u w=1u l=1u
X8 VSS voutp iqmod_mfb_lpf_ota_core_hybrid_bm_pex_half_1.iqmod_mfb_lpf_ota_core_tg_1.v_a VSS sg13_lv_nmos ad=0.19p pd=1.38u as=0.19p ps=1.38u w=1u l=1u
X9 voutp iqmod_mfb_lpf_ota_core_hybrid_bm_pex_half_0.iqmod_mfb_lpf_ota_core_inv_NF10_0.vin VSS VSS sg13_lv_nmos ad=0.19p pd=1.38u as=0.19p ps=1.38u w=1u l=1u
X10 VSS iqmod_mfb_lpf_ota_core_hybrid_bm_pex_half_0.iqmod_mfb_lpf_ota_core_inv_NF10_0.vin iqmod_mfb_lpf_ota_core_hybrid_bm_pex_half_1.iqmod_mfb_lpf_ota_core_inv_NF10_0.vout VSS sg13_lv_nmos ad=0.19p pd=1.38u as=0.19p ps=1.38u w=1u l=1u
X11 iqmod_mfb_lpf_ota_core_hybrid_bm_pex_half_1.iqmod_mfb_lpf_ota_core_inv_NF10_0.vout iqmod_mfb_lpf_ota_core_hybrid_bm_pex_half_0.iqmod_mfb_lpf_ota_core_inv_NF10_0.vin VSS VSS sg13_lv_nmos ad=0.19p pd=1.38u as=0.19p ps=1.38u w=1u l=1u
X12 VDD iqmod_mfb_lpf_ota_core_hybrid_bm_pex_half_0.iqmod_mfb_lpf_ota_core_inv_NF10_0.vin voutp VDD sg13_lv_pmos ad=1.14p pd=6.38u as=1.14p ps=6.38u w=6u l=1u
X13 VSS VSS VSS VSS sg13_lv_nmos ad=0.34p pd=2.68u as=0 ps=0 w=1u l=1u
X14 voutn iqmod_mfb_lpf_ota_core_hybrid_bm_pex_half_1.iqmod_mfb_lpf_ota_core_inv_NF10_0.vin VDD VDD sg13_lv_pmos ad=1.14p pd=6.38u as=1.14p ps=6.38u w=6u l=1u
X15 VDD iqmod_mfb_lpf_ota_core_hybrid_bm_pex_half_0.iqmod_mfb_lpf_ota_core_inv_NF10_0.vin iqmod_mfb_lpf_ota_core_hybrid_bm_pex_half_1.iqmod_mfb_lpf_ota_core_inv_NF10_0.vout VDD sg13_lv_pmos ad=1.14p pd=6.38u as=1.14p ps=6.38u w=6u l=1u
X16 VDD VDD VDD VDD sg13_lv_pmos ad=1.14p pd=6.38u as=0 ps=0 w=6u l=1u
X17 iqmod_mfb_lpf_ota_core_hybrid_bm_pex_half_1.iqmod_mfb_lpf_ota_core_inv_NF10_0.vout iqmod_mfb_lpf_ota_core_hybrid_bm_pex_half_1.iqmod_mfb_lpf_ota_core_inv_NF10_0.vin VDD VDD sg13_lv_pmos ad=1.14p pd=6.38u as=1.14p ps=6.38u w=6u l=1u
X18 VDD iqmod_mfb_lpf_ota_core_hybrid_bm_pex_half_1.iqmod_mfb_lpf_ota_core_inv_NF10_0.vin voutn VDD sg13_lv_pmos ad=1.14p pd=6.38u as=1.14p ps=6.38u w=6u l=1u
X19 voutp iqmod_mfb_lpf_ota_core_hybrid_bm_pex_half_0.iqmod_mfb_lpf_ota_core_inv_NF10_0.vin VDD VDD sg13_lv_pmos ad=1.14p pd=6.38u as=1.14p ps=6.38u w=6u l=1u
X20 VDD VDD VDD VDD sg13_lv_pmos ad=1.14p pd=6.38u as=0 ps=0 w=6u l=0.13u
X21 iqmod_mfb_lpf_ota_core_hybrid_bm_pex_half_1.iqmod_mfb_lpf_ota_core_inv_NF10_0.vout iqmod_mfb_lpf_ota_core_hybrid_bm_pex_half_0.iqmod_mfb_lpf_ota_core_inv_NF10_0.vin VDD VDD sg13_lv_pmos ad=1.14p pd=6.38u as=1.14p ps=6.38u w=6u l=1u
X22 VDD VDD VDD VDD sg13_lv_pmos ad=1.14p pd=6.38u as=0 ps=0 w=6u l=1u
X23 VSS iqmod_mfb_lpf_ota_core_hybrid_bm_pex_half_1.iqmod_mfb_lpf_ota_core_inv_NF6_0.vout voutn VSS sg13_lv_nmos ad=0.19p pd=1.38u as=0.19p ps=1.38u w=1u l=1u
X24 VSS VSS VSS VSS sg13_lv_nmos ad=0.19p pd=1.38u as=0 ps=0 w=1u l=1u
X25 iqmod_mfb_lpf_ota_core_hybrid_bm_pex_half_1.iqmod_mfb_lpf_ota_core_spdt_switch_0.iqmod_mfb_lpf_ota_core_spdt_switch_inv$1_0.vout iqmod_mfb_lpf_ota_core_hybrid_bm_pex_half_1.iqmod_mfb_lpf_ota_core_spdt_switch_0.do_spdt_ctrl_n VDD VDD sg13_lv_pmos ad=1.14p pd=6.38u as=1.14p ps=6.38u w=6u l=0.13u
X26 iqmod_mfb_lpf_ota_core_hybrid_bm_pex_half_1.iqmod_mfb_lpf_ota_core_inv_NF10_0.vin iqmod_mfb_lpf_ota_core_hybrid_bm_pex_half_1.iqmod_mfb_lpf_ota_core_spdt_switch_0.do_spdt_ctrl_n vinp VDD sg13_lv_pmos ad=1.14p pd=6.38u as=2.04p ps=12.68u w=6u l=0.13u
X27 VDD iqmod_mfb_lpf_ota_core_hybrid_bm_pex_half_1.iqmod_mfb_lpf_ota_core_spdt_switch_0.do_spdt_ctrl_n iqmod_mfb_lpf_ota_core_hybrid_bm_pex_half_1.iqmod_mfb_lpf_ota_core_inv_NF10_0.vin VSS sg13_lv_nmos ad=0.19p pd=1.38u as=0.19p ps=1.38u w=1u l=0.13u
X28 VSS VSS VSS VSS sg13_lv_nmos ad=0.19p pd=1.38u as=0 ps=0 w=1u l=0.13u
X29 iqmod_mfb_lpf_ota_core_hybrid_bm_pex_half_1.iqmod_mfb_lpf_ota_core_spdt_switch_0.iqmod_mfb_lpf_ota_core_spdt_switch_inv$1_0.vout iqmod_mfb_lpf_ota_core_hybrid_bm_pex_half_1.iqmod_mfb_lpf_ota_core_spdt_switch_0.do_spdt_ctrl_n VSS VSS sg13_lv_nmos ad=0.19p pd=1.38u as=0.19p ps=1.38u w=1u l=0.13u
X30 iqmod_mfb_lpf_ota_core_hybrid_bm_pex_half_1.iqmod_mfb_lpf_ota_core_inv_NF6_2.vin iqmod_mfb_lpf_ota_core_hybrid_bm_pex_half_0.iqmod_mfb_lpf_ota_core_spdt_switch_0.do_spdt_ctrl_n iqmod_mfb_lpf_ota_core_hybrid_bm_pex_half_1.iqmod_mfb_lpf_ota_core_tg_1.v_a VDD sg13_lv_pmos ad=1.14p pd=6.38u as=2.04p ps=12.68u w=6u l=0.13u
X31 iqmod_mfb_lpf_ota_core_hybrid_bm_pex_half_1.iqmod_mfb_lpf_ota_core_inv_NF6_2.vin iqmod_mfb_lpf_ota_core_hybrid_bm_pex_half_1.iqmod_mfb_lpf_ota_core_tg_1.v_a VSS VSS sg13_lv_nmos ad=0.19p pd=1.38u as=0.19p ps=1.38u w=1u l=1u
X32 iqmod_mfb_lpf_ota_core_hybrid_bm_pex_half_1.iqmod_mfb_lpf_ota_core_tg_1.v_a di_ota_en iqmod_mfb_lpf_ota_core_hybrid_bm_pex_half_1.iqmod_mfb_lpf_ota_core_inv_NF6_2.vin VSS sg13_lv_nmos ad=0.19p pd=1.38u as=0.19p ps=1.38u w=1u l=0.13u
X33 VSS VSS VSS VSS sg13_lv_nmos ad=0.19p pd=1.38u as=0 ps=0 w=1u l=1u
X34 iqmod_mfb_lpf_ota_core_hybrid_bm_pex_half_1.iqmod_mfb_lpf_ota_core_inv_NF6_0.vout iqmod_mfb_lpf_ota_core_hybrid_bm_pex_half_1.iqmod_mfb_lpf_ota_core_inv_NF10_0.vout VDD VDD sg13_lv_pmos ad=1.14p pd=6.38u as=1.14p ps=6.38u w=6u l=1u
X35 VSS voutn iqmod_mfb_lpf_ota_core_hybrid_bm_pex_half_1.iqmod_mfb_lpf_ota_core_tg_1.v_a VSS sg13_lv_nmos ad=0.19p pd=1.38u as=0.19p ps=1.38u w=1u l=1u
X36 iqmod_mfb_lpf_ota_core_hybrid_bm_pex_half_1.iqmod_mfb_lpf_ota_core_inv_NF6_0.vout iqmod_mfb_lpf_ota_core_hybrid_bm_pex_half_1.iqmod_mfb_lpf_ota_core_inv_NF10_0.vout VDD VDD sg13_lv_pmos ad=1.14p pd=6.38u as=1.14p ps=6.38u w=6u l=1u
X37 VSS iqmod_mfb_lpf_ota_core_hybrid_bm_pex_half_1.iqmod_mfb_lpf_ota_core_tg_1.v_a iqmod_mfb_lpf_ota_core_hybrid_bm_pex_half_1.iqmod_mfb_lpf_ota_core_inv_NF6_2.vin VSS sg13_lv_nmos ad=0.19p pd=1.38u as=0.19p ps=1.38u w=1u l=1u
X38 VSS iqmod_mfb_lpf_ota_core_hybrid_bm_pex_half_1.iqmod_mfb_lpf_ota_core_inv_NF6_0.vout voutn VSS sg13_lv_nmos ad=0.19p pd=1.38u as=0.19p ps=1.38u w=1u l=1u
X39 VDD di_ota_en iqmod_mfb_lpf_ota_core_hybrid_bm_pex_half_1.iqmod_mfb_lpf_ota_core_spdt_switch_0.do_spdt_ctrl_n VDD sg13_lv_pmos ad=1.14p pd=6.38u as=1.14p ps=6.38u w=6u l=0.13u
X40 iqmod_mfb_lpf_ota_core_hybrid_bm_pex_half_1.iqmod_mfb_lpf_ota_core_inv_NF6_0.vout iqmod_mfb_lpf_ota_core_hybrid_bm_pex_half_0.iqmod_mfb_lpf_ota_core_spdt_switch_0.do_spdt_ctrl_n iqmod_mfb_lpf_ota_core_hybrid_bm_pex_half_1.iqmod_mfb_lpf_ota_core_inv_NF10_0.vout VDD sg13_lv_pmos ad=1.14p pd=6.38u as=1.14p ps=6.38u w=6u l=0.13u
X41 VDD VDD VDD VDD sg13_lv_pmos ad=2.04p pd=12.68u as=0 ps=0 w=6u l=1u
X42 VSS VSS VSS VSS sg13_lv_nmos ad=0.19p pd=1.38u as=0 ps=0 w=1u l=1u
X43 VDD iqmod_mfb_lpf_ota_core_hybrid_bm_pex_half_1.iqmod_mfb_lpf_ota_core_tg_1.v_a iqmod_mfb_lpf_ota_core_hybrid_bm_pex_half_1.iqmod_mfb_lpf_ota_core_inv_NF6_2.vin VDD sg13_lv_pmos ad=1.14p pd=6.38u as=1.14p ps=6.38u w=6u l=1u
X44 iqmod_mfb_lpf_ota_core_hybrid_bm_pex_half_1.iqmod_mfb_lpf_ota_core_inv_NF6_0.vout iqmod_mfb_lpf_ota_core_hybrid_bm_pex_half_0.iqmod_mfb_lpf_ota_core_spdt_switch_0.do_spdt_ctrl_n iqmod_mfb_lpf_ota_core_hybrid_bm_pex_half_1.iqmod_mfb_lpf_ota_core_inv_NF10_0.vout VDD sg13_lv_pmos ad=1.14p pd=6.38u as=2.04p ps=12.68u w=6u l=0.13u
X45 iqmod_mfb_lpf_ota_core_hybrid_bm_pex_half_1.iqmod_mfb_lpf_ota_core_inv_NF6_2.vin iqmod_mfb_lpf_ota_core_hybrid_bm_pex_half_1.iqmod_mfb_lpf_ota_core_tg_1.v_a VSS VSS sg13_lv_nmos ad=0.19p pd=1.38u as=0.19p ps=1.38u w=1u l=1u
X46 VSS VSS VSS VSS sg13_lv_nmos ad=0.34p pd=2.68u as=0 ps=0 w=1u l=0.13u
X47 iqmod_mfb_lpf_ota_core_hybrid_bm_pex_half_1.iqmod_mfb_lpf_ota_core_inv_NF10_0.vin iqmod_mfb_lpf_ota_core_hybrid_bm_pex_half_1.iqmod_mfb_lpf_ota_core_spdt_switch_0.do_spdt_ctrl_n VDD VSS sg13_lv_nmos ad=0.19p pd=1.38u as=0.19p ps=1.38u w=1u l=0.13u
X48 VDD VDD VDD VDD sg13_lv_pmos ad=2.04p pd=12.68u as=0 ps=0 w=6u l=0.13u
X49 voutp iqmod_mfb_lpf_ota_core_hybrid_bm_pex_half_0.iqmod_mfb_lpf_ota_core_inv_NF10_0.vin VSS VSS sg13_lv_nmos ad=0.19p pd=1.38u as=0.19p ps=1.38u w=1u l=1u
X50 voutn iqmod_mfb_lpf_ota_core_hybrid_bm_pex_half_1.iqmod_mfb_lpf_ota_core_inv_NF6_0.vout VDD VDD sg13_lv_pmos ad=1.14p pd=6.38u as=1.14p ps=6.38u w=6u l=1u
X51 VSS iqmod_mfb_lpf_ota_core_hybrid_bm_pex_half_1.iqmod_mfb_lpf_ota_core_inv_NF10_0.vin voutn VSS sg13_lv_nmos ad=0.19p pd=1.38u as=0.19p ps=1.38u w=1u l=1u
X52 VSS iqmod_mfb_lpf_ota_core_hybrid_bm_pex_half_1.iqmod_mfb_lpf_ota_core_spdt_switch_0.do_spdt_ctrl_n iqmod_mfb_lpf_ota_core_hybrid_bm_pex_half_1.iqmod_mfb_lpf_ota_core_spdt_switch_0.iqmod_mfb_lpf_ota_core_spdt_switch_inv$1_0.vout VSS sg13_lv_nmos ad=0.19p pd=1.38u as=0.19p ps=1.38u w=1u l=0.13u
X53 voutn iqmod_mfb_lpf_ota_core_hybrid_bm_pex_half_1.iqmod_mfb_lpf_ota_core_inv_NF6_0.vout VSS VSS sg13_lv_nmos ad=0.19p pd=1.38u as=0.19p ps=1.38u w=1u l=1u
X54 iqmod_mfb_lpf_ota_core_hybrid_bm_pex_half_1.iqmod_mfb_lpf_ota_core_inv_NF10_0.vout iqmod_mfb_lpf_ota_core_hybrid_bm_pex_half_0.iqmod_mfb_lpf_ota_core_inv_NF10_0.vin VSS VSS sg13_lv_nmos ad=0.19p pd=1.38u as=0.19p ps=1.38u w=1u l=1u
X55 iqmod_mfb_lpf_ota_core_hybrid_bm_pex_half_1.iqmod_mfb_lpf_ota_core_inv_NF6_2.vin di_ota_en iqmod_mfb_lpf_ota_core_hybrid_bm_pex_half_1.iqmod_mfb_lpf_ota_core_tg_1.v_a VSS sg13_lv_nmos ad=0.19p pd=1.38u as=0.19p ps=1.38u w=1u l=0.13u
X56 iqmod_mfb_lpf_ota_core_hybrid_bm_pex_half_1.iqmod_mfb_lpf_ota_core_tg_1.v_a voutp VSS VSS sg13_lv_nmos ad=0.19p pd=1.38u as=0.19p ps=1.38u w=1u l=1u
X57 voutn iqmod_mfb_lpf_ota_core_hybrid_bm_pex_half_1.iqmod_mfb_lpf_ota_core_inv_NF10_0.vin VSS VSS sg13_lv_nmos ad=0.19p pd=1.38u as=0.19p ps=1.38u w=1u l=1u
X58 VDD iqmod_mfb_lpf_ota_core_hybrid_bm_pex_half_1.iqmod_mfb_lpf_ota_core_inv_NF10_0.vin voutn VDD sg13_lv_pmos ad=1.14p pd=6.38u as=1.14p ps=6.38u w=6u l=1u
X59 voutp iqmod_mfb_lpf_ota_core_hybrid_bm_pex_half_1.iqmod_mfb_lpf_ota_core_inv_NF6_0.vout VDD VDD sg13_lv_pmos ad=1.14p pd=6.38u as=1.14p ps=6.38u w=6u l=1u
X60 iqmod_mfb_lpf_ota_core_hybrid_bm_pex_half_1.iqmod_mfb_lpf_ota_core_inv_NF6_0.vout iqmod_mfb_lpf_ota_core_hybrid_bm_pex_half_1.iqmod_mfb_lpf_ota_core_spdt_switch_0.do_spdt_ctrl_n iqmod_mfb_lpf_ota_core_hybrid_bm_pex_half_1.iqmod_mfb_lpf_ota_core_inv_NF10_0.vout VDD sg13_lv_pmos ad=1.14p pd=6.38u as=1.14p ps=6.38u w=6u l=0.13u
X61 VDD voutp iqmod_mfb_lpf_ota_core_hybrid_bm_pex_half_1.iqmod_mfb_lpf_ota_core_tg_1.v_a VDD sg13_lv_pmos ad=1.14p pd=6.38u as=1.14p ps=6.38u w=6u l=1u
X62 VSS iqmod_mfb_lpf_ota_core_hybrid_bm_pex_half_0.iqmod_mfb_lpf_ota_core_inv_NF10_0.vin voutp VSS sg13_lv_nmos ad=0.19p pd=1.38u as=0.19p ps=1.38u w=1u l=1u
X63 iqmod_mfb_lpf_ota_core_hybrid_bm_pex_half_1.iqmod_mfb_lpf_ota_core_tg_1.v_a di_ota_en iqmod_mfb_lpf_ota_core_hybrid_bm_pex_half_1.iqmod_mfb_lpf_ota_core_inv_NF6_2.vin VSS sg13_lv_nmos ad=0.34p pd=2.68u as=0.19p ps=1.38u w=1u l=0.13u
X64 VDD iqmod_mfb_lpf_ota_core_hybrid_bm_pex_half_1.iqmod_mfb_lpf_ota_core_inv_NF10_0.vin iqmod_mfb_lpf_ota_core_hybrid_bm_pex_half_1.iqmod_mfb_lpf_ota_core_inv_NF10_0.vout VDD sg13_lv_pmos ad=1.14p pd=6.38u as=1.14p ps=6.38u w=6u l=1u
X65 iqmod_mfb_lpf_ota_core_hybrid_bm_pex_half_1.iqmod_mfb_lpf_ota_core_inv_NF6_0.vout iqmod_mfb_lpf_ota_core_hybrid_bm_pex_half_1.iqmod_mfb_lpf_ota_core_inv_NF10_0.vout VDD VDD sg13_lv_pmos ad=1.14p pd=6.38u as=1.14p ps=6.38u w=6u l=1u
X66 iqmod_mfb_lpf_ota_core_hybrid_bm_pex_half_1.iqmod_mfb_lpf_ota_core_inv_NF6_0.vout di_ota_en iqmod_mfb_lpf_ota_core_hybrid_bm_pex_half_1.iqmod_mfb_lpf_ota_core_inv_NF10_0.vout VSS sg13_lv_nmos ad=0.19p pd=1.38u as=0.19p ps=1.38u w=1u l=0.13u
X67 iqmod_mfb_lpf_ota_core_hybrid_bm_pex_half_0.iqmod_mfb_lpf_ota_core_inv_NF10_0.vin iqmod_mfb_lpf_ota_core_hybrid_bm_pex_half_0.iqmod_mfb_lpf_ota_core_spdt_switch_0.iqmod_mfb_lpf_ota_core_spdt_switch_inv$1_0.vout vinn VSS sg13_lv_nmos ad=0.19p pd=1.38u as=0.19p ps=1.38u w=1u l=0.13u
X68 VSS VSS VSS VSS sg13_lv_nmos ad=0.19p pd=1.38u as=0 ps=0 w=1u l=1u
X69 voutn iqmod_mfb_lpf_ota_core_hybrid_bm_pex_half_1.iqmod_mfb_lpf_ota_core_inv_NF10_0.vin VDD VDD sg13_lv_pmos ad=1.14p pd=6.38u as=1.14p ps=6.38u w=6u l=1u
X70 iqmod_mfb_lpf_ota_core_hybrid_bm_pex_half_1.iqmod_mfb_lpf_ota_core_inv_NF10_0.vout di_ota_en iqmod_mfb_lpf_ota_core_hybrid_bm_pex_half_1.iqmod_mfb_lpf_ota_core_inv_NF6_0.vout VSS sg13_lv_nmos ad=0.19p pd=1.38u as=0.19p ps=1.38u w=1u l=0.13u
X71 voutn iqmod_mfb_lpf_ota_core_hybrid_bm_pex_half_1.iqmod_mfb_lpf_ota_core_inv_NF6_0.vout VSS VSS sg13_lv_nmos ad=0.19p pd=1.38u as=0.19p ps=1.38u w=1u l=1u
X72 VDD iqmod_mfb_lpf_ota_core_hybrid_bm_pex_half_1.iqmod_mfb_lpf_ota_core_inv_NF6_0.vout voutp VDD sg13_lv_pmos ad=1.14p pd=6.38u as=1.14p ps=6.38u w=6u l=1u
X73 VSS iqmod_mfb_lpf_ota_core_hybrid_bm_pex_half_0.iqmod_mfb_lpf_ota_core_inv_NF10_0.vin iqmod_mfb_lpf_ota_core_hybrid_bm_pex_half_1.iqmod_mfb_lpf_ota_core_inv_NF10_0.vout VSS sg13_lv_nmos ad=0.19p pd=1.38u as=0.19p ps=1.38u w=1u l=1u
X74 vinn iqmod_mfb_lpf_ota_core_hybrid_bm_pex_half_0.iqmod_mfb_lpf_ota_core_spdt_switch_0.iqmod_mfb_lpf_ota_core_spdt_switch_inv$1_0.vout iqmod_mfb_lpf_ota_core_hybrid_bm_pex_half_0.iqmod_mfb_lpf_ota_core_inv_NF10_0.vin VSS sg13_lv_nmos ad=0.19p pd=1.38u as=0.19p ps=1.38u w=1u l=0.13u
X75 VSS VSS VSS VSS sg13_lv_nmos ad=0.19p pd=1.38u as=0 ps=0 w=1u l=1u
X76 VDD VDD VDD VDD sg13_lv_pmos ad=1.14p pd=6.38u as=0 ps=0 w=6u l=1u
X77 VSS iqmod_mfb_lpf_ota_core_hybrid_bm_pex_half_1.iqmod_mfb_lpf_ota_core_tg_1.v_a iqmod_mfb_lpf_ota_core_hybrid_bm_pex_half_1.iqmod_mfb_lpf_ota_core_inv_NF6_2.vin VSS sg13_lv_nmos ad=0.19p pd=1.38u as=0.19p ps=1.38u w=1u l=1u
X78 iqmod_mfb_lpf_ota_core_hybrid_bm_pex_half_1.iqmod_mfb_lpf_ota_core_inv_NF6_2.vin iqmod_mfb_lpf_ota_core_hybrid_bm_pex_half_1.iqmod_mfb_lpf_ota_core_tg_1.v_a VDD VDD sg13_lv_pmos ad=1.14p pd=6.38u as=1.14p ps=6.38u w=6u l=1u
X79 iqmod_mfb_lpf_ota_core_hybrid_bm_pex_half_1.iqmod_mfb_lpf_ota_core_inv_NF6_0.vout iqmod_mfb_lpf_ota_core_hybrid_bm_pex_half_1.iqmod_mfb_lpf_ota_core_inv_NF6_2.vin VSS VSS sg13_lv_nmos ad=0.19p pd=1.38u as=0.19p ps=1.38u w=1u l=1u
X80 VSS iqmod_mfb_lpf_ota_core_hybrid_bm_pex_half_1.iqmod_mfb_lpf_ota_core_inv_NF10_0.vin iqmod_mfb_lpf_ota_core_hybrid_bm_pex_half_1.iqmod_mfb_lpf_ota_core_inv_NF10_0.vout VSS sg13_lv_nmos ad=0.19p pd=1.38u as=0.19p ps=1.38u w=1u l=1u
X81 VDD iqmod_mfb_lpf_ota_core_hybrid_bm_pex_half_1.iqmod_mfb_lpf_ota_core_spdt_switch_0.do_spdt_ctrl_n iqmod_mfb_lpf_ota_core_hybrid_bm_pex_half_1.iqmod_mfb_lpf_ota_core_inv_NF10_0.vin VSS sg13_lv_nmos ad=0.19p pd=1.38u as=0.19p ps=1.38u w=1u l=0.13u
X82 VSS VSS VSS VSS sg13_lv_nmos ad=0.34p pd=2.68u as=0 ps=0 w=1u l=1u
X83 voutn iqmod_mfb_lpf_ota_core_hybrid_bm_pex_half_1.iqmod_mfb_lpf_ota_core_inv_NF6_0.vout VSS VSS sg13_lv_nmos ad=0.19p pd=1.38u as=0.19p ps=1.38u w=1u l=1u
X84 VDD iqmod_mfb_lpf_ota_core_hybrid_bm_pex_half_1.iqmod_mfb_lpf_ota_core_inv_NF10_0.vout iqmod_mfb_lpf_ota_core_hybrid_bm_pex_half_1.iqmod_mfb_lpf_ota_core_inv_NF6_0.vout VDD sg13_lv_pmos ad=1.14p pd=6.38u as=1.14p ps=6.38u w=6u l=1u
X85 iqmod_mfb_lpf_ota_core_hybrid_bm_pex_half_1.iqmod_mfb_lpf_ota_core_tg_1.v_a voutp VSS VSS sg13_lv_nmos ad=0.19p pd=1.38u as=0.19p ps=1.38u w=1u l=1u
X86 VSS VSS VSS VSS sg13_lv_nmos ad=0.19p pd=1.38u as=0 ps=0 w=1u l=0.13u
X87 iqmod_mfb_lpf_ota_core_hybrid_bm_pex_half_1.iqmod_mfb_lpf_ota_core_inv_NF6_0.vout iqmod_mfb_lpf_ota_core_hybrid_bm_pex_half_1.iqmod_mfb_lpf_ota_core_inv_NF6_2.vin VSS VSS sg13_lv_nmos ad=0.19p pd=1.38u as=0.19p ps=1.38u w=1u l=1u
X88 iqmod_mfb_lpf_ota_core_hybrid_bm_pex_half_1.iqmod_mfb_lpf_ota_core_tg_1.v_a iqmod_mfb_lpf_ota_core_hybrid_bm_pex_half_1.iqmod_mfb_lpf_ota_core_spdt_switch_0.do_spdt_ctrl_n iqmod_mfb_lpf_ota_core_hybrid_bm_pex_half_1.iqmod_mfb_lpf_ota_core_inv_NF6_2.vin VDD sg13_lv_pmos ad=2.04p pd=12.68u as=1.14p ps=6.38u w=6u l=0.13u
X89 voutp iqmod_mfb_lpf_ota_core_hybrid_bm_pex_half_1.iqmod_mfb_lpf_ota_core_inv_NF6_0.vout VDD VDD sg13_lv_pmos ad=1.14p pd=6.38u as=1.14p ps=6.38u w=6u l=1u
X90 iqmod_mfb_lpf_ota_core_hybrid_bm_pex_half_1.iqmod_mfb_lpf_ota_core_inv_NF6_2.vin iqmod_mfb_lpf_ota_core_hybrid_bm_pex_half_1.iqmod_mfb_lpf_ota_core_tg_1.v_a VSS VSS sg13_lv_nmos ad=0.19p pd=1.38u as=0.19p ps=1.38u w=1u l=1u
X91 voutp iqmod_mfb_lpf_ota_core_hybrid_bm_pex_half_0.iqmod_mfb_lpf_ota_core_inv_NF10_0.vin VSS VSS sg13_lv_nmos ad=0.19p pd=1.38u as=0.19p ps=1.38u w=1u l=1u
X92 iqmod_mfb_lpf_ota_core_hybrid_bm_pex_half_1.iqmod_mfb_lpf_ota_core_inv_NF6_2.vin iqmod_mfb_lpf_ota_core_hybrid_bm_pex_half_1.iqmod_mfb_lpf_ota_core_spdt_switch_0.do_spdt_ctrl_n iqmod_mfb_lpf_ota_core_hybrid_bm_pex_half_1.iqmod_mfb_lpf_ota_core_tg_1.v_a VDD sg13_lv_pmos ad=1.14p pd=6.38u as=1.14p ps=6.38u w=6u l=0.13u
X93 VSS iqmod_mfb_lpf_ota_core_hybrid_bm_pex_half_1.iqmod_mfb_lpf_ota_core_inv_NF6_2.vin iqmod_mfb_lpf_ota_core_hybrid_bm_pex_half_1.iqmod_mfb_lpf_ota_core_inv_NF6_0.vout VSS sg13_lv_nmos ad=0.19p pd=1.38u as=0.19p ps=1.38u w=1u l=1u
X94 VDD iqmod_mfb_lpf_ota_core_hybrid_bm_pex_half_1.iqmod_mfb_lpf_ota_core_tg_1.v_a iqmod_mfb_lpf_ota_core_hybrid_bm_pex_half_1.iqmod_mfb_lpf_ota_core_inv_NF6_2.vin VDD sg13_lv_pmos ad=1.14p pd=6.38u as=1.14p ps=6.38u w=6u l=1u
X95 iqmod_mfb_lpf_ota_core_hybrid_bm_pex_half_1.iqmod_mfb_lpf_ota_core_tg_1.v_a voutn VDD VDD sg13_lv_pmos ad=1.14p pd=6.38u as=1.14p ps=6.38u w=6u l=1u
X96 iqmod_mfb_lpf_ota_core_hybrid_bm_pex_half_1.iqmod_mfb_lpf_ota_core_inv_NF6_2.vin di_ota_en iqmod_mfb_lpf_ota_core_hybrid_bm_pex_half_1.iqmod_mfb_lpf_ota_core_tg_1.v_a VSS sg13_lv_nmos ad=0.19p pd=1.38u as=0.19p ps=1.38u w=1u l=0.13u
X97 iqmod_mfb_lpf_ota_core_hybrid_bm_pex_half_1.iqmod_mfb_lpf_ota_core_inv_NF6_2.vin iqmod_mfb_lpf_ota_core_hybrid_bm_pex_half_1.iqmod_mfb_lpf_ota_core_tg_1.v_a VDD VDD sg13_lv_pmos ad=1.14p pd=6.38u as=1.14p ps=6.38u w=6u l=1u
X98 VDD voutn iqmod_mfb_lpf_ota_core_hybrid_bm_pex_half_1.iqmod_mfb_lpf_ota_core_tg_1.v_a VDD sg13_lv_pmos ad=1.14p pd=6.38u as=1.14p ps=6.38u w=6u l=1u
X99 iqmod_mfb_lpf_ota_core_hybrid_bm_pex_half_1.iqmod_mfb_lpf_ota_core_tg_1.v_a voutn VSS VSS sg13_lv_nmos ad=0.19p pd=1.38u as=0.19p ps=1.38u w=1u l=1u
X100 iqmod_mfb_lpf_ota_core_hybrid_bm_pex_half_1.iqmod_mfb_lpf_ota_core_tg_1.v_a voutn VDD VDD sg13_lv_pmos ad=1.14p pd=6.38u as=1.14p ps=6.38u w=6u l=1u
X101 voutp iqmod_mfb_lpf_ota_core_hybrid_bm_pex_half_1.iqmod_mfb_lpf_ota_core_inv_NF6_0.vout VSS VSS sg13_lv_nmos ad=0.19p pd=1.38u as=0.19p ps=1.38u w=1u l=1u
X102 VDD iqmod_mfb_lpf_ota_core_hybrid_bm_pex_half_1.iqmod_mfb_lpf_ota_core_spdt_switch_0.iqmod_mfb_lpf_ota_core_spdt_switch_inv$1_0.vout iqmod_mfb_lpf_ota_core_hybrid_bm_pex_half_1.iqmod_mfb_lpf_ota_core_inv_NF10_0.vin VDD sg13_lv_pmos ad=2.04p pd=12.68u as=1.14p ps=6.38u w=6u l=0.13u
X103 VSS VSS VSS VSS sg13_lv_nmos ad=0.34p pd=2.68u as=0 ps=0 w=1u l=0.13u
X104 VDD iqmod_mfb_lpf_ota_core_hybrid_bm_pex_half_1.iqmod_mfb_lpf_ota_core_inv_NF6_0.vout voutp VDD sg13_lv_pmos ad=1.14p pd=6.38u as=1.14p ps=6.38u w=6u l=1u
X105 iqmod_mfb_lpf_ota_core_hybrid_bm_pex_half_1.iqmod_mfb_lpf_ota_core_inv_NF10_0.vin iqmod_mfb_lpf_ota_core_hybrid_bm_pex_half_1.iqmod_mfb_lpf_ota_core_spdt_switch_0.iqmod_mfb_lpf_ota_core_spdt_switch_inv$1_0.vout VDD VDD sg13_lv_pmos ad=1.14p pd=6.38u as=1.14p ps=6.38u w=6u l=0.13u
X106 VSS iqmod_mfb_lpf_ota_core_hybrid_bm_pex_half_1.iqmod_mfb_lpf_ota_core_inv_NF10_0.vout iqmod_mfb_lpf_ota_core_hybrid_bm_pex_half_1.iqmod_mfb_lpf_ota_core_inv_NF6_0.vout VSS sg13_lv_nmos ad=0.19p pd=1.38u as=0.19p ps=1.38u w=1u l=1u
X107 voutp iqmod_mfb_lpf_ota_core_hybrid_bm_pex_half_0.iqmod_mfb_lpf_ota_core_inv_NF10_0.vin VDD VDD sg13_lv_pmos ad=1.14p pd=6.38u as=1.14p ps=6.38u w=6u l=1u
X108 VDD VDD VDD VDD sg13_lv_pmos ad=1.14p pd=6.38u as=0 ps=0 w=6u l=1u
X109 iqmod_mfb_lpf_ota_core_hybrid_bm_pex_half_0.iqmod_mfb_lpf_ota_core_inv_NF10_0.vin iqmod_mfb_lpf_ota_core_hybrid_bm_pex_half_0.iqmod_mfb_lpf_ota_core_spdt_switch_0.do_spdt_ctrl_n VDD VSS sg13_lv_nmos ad=0.19p pd=1.38u as=0.19p ps=1.38u w=1u l=0.13u
X110 VSS iqmod_mfb_lpf_ota_core_hybrid_bm_pex_half_1.iqmod_mfb_lpf_ota_core_inv_NF6_0.vout voutn VSS sg13_lv_nmos ad=0.19p pd=1.38u as=0.19p ps=1.38u w=1u l=1u
X111 VDD iqmod_mfb_lpf_ota_core_hybrid_bm_pex_half_1.iqmod_mfb_lpf_ota_core_inv_NF6_0.vout voutn VDD sg13_lv_pmos ad=1.14p pd=6.38u as=1.14p ps=6.38u w=6u l=1u
X112 iqmod_mfb_lpf_ota_core_hybrid_bm_pex_half_1.iqmod_mfb_lpf_ota_core_inv_NF10_0.vout iqmod_mfb_lpf_ota_core_hybrid_bm_pex_half_0.iqmod_mfb_lpf_ota_core_inv_NF10_0.vin VDD VDD sg13_lv_pmos ad=1.14p pd=6.38u as=1.14p ps=6.38u w=6u l=1u
X113 iqmod_mfb_lpf_ota_core_hybrid_bm_pex_half_1.iqmod_mfb_lpf_ota_core_inv_NF10_0.vin iqmod_mfb_lpf_ota_core_hybrid_bm_pex_half_1.iqmod_mfb_lpf_ota_core_spdt_switch_0.do_spdt_ctrl_n VDD VSS sg13_lv_nmos ad=0.19p pd=1.38u as=0.19p ps=1.38u w=1u l=0.13u
X114 iqmod_mfb_lpf_ota_core_hybrid_bm_pex_half_1.iqmod_mfb_lpf_ota_core_tg_1.v_a di_ota_en iqmod_mfb_lpf_ota_core_hybrid_bm_pex_half_1.iqmod_mfb_lpf_ota_core_inv_NF6_2.vin VSS sg13_lv_nmos ad=0.19p pd=1.38u as=0.19p ps=1.38u w=1u l=0.13u
X115 iqmod_mfb_lpf_ota_core_hybrid_bm_pex_half_1.iqmod_mfb_lpf_ota_core_tg_1.v_a voutp VSS VSS sg13_lv_nmos ad=0.19p pd=1.38u as=0.19p ps=1.38u w=1u l=1u
X116 VDD iqmod_mfb_lpf_ota_core_hybrid_bm_pex_half_0.iqmod_mfb_lpf_ota_core_inv_NF10_0.vin voutp VDD sg13_lv_pmos ad=1.14p pd=6.38u as=1.14p ps=6.38u w=6u l=1u
X117 VSS iqmod_mfb_lpf_ota_core_hybrid_bm_pex_half_1.iqmod_mfb_lpf_ota_core_inv_NF10_0.vin voutn VSS sg13_lv_nmos ad=0.19p pd=1.38u as=0.19p ps=1.38u w=1u l=1u
X118 VSS VSS VSS VSS sg13_lv_nmos ad=0.34p pd=2.68u as=0 ps=0 w=1u l=1u
X119 VSS VSS VSS VSS sg13_lv_nmos ad=0.34p pd=2.68u as=0 ps=0 w=1u l=1u
X120 iqmod_mfb_lpf_ota_core_hybrid_bm_pex_half_1.iqmod_mfb_lpf_ota_core_tg_1.v_a voutp VDD VDD sg13_lv_pmos ad=1.14p pd=6.38u as=1.14p ps=6.38u w=6u l=1u
X121 VSS iqmod_mfb_lpf_ota_core_hybrid_bm_pex_half_0.iqmod_mfb_lpf_ota_core_inv_NF10_0.vin voutp VSS sg13_lv_nmos ad=0.19p pd=1.38u as=0.19p ps=1.38u w=1u l=1u
X122 VDD iqmod_mfb_lpf_ota_core_hybrid_bm_pex_half_1.iqmod_mfb_lpf_ota_core_inv_NF6_0.vout voutn VDD sg13_lv_pmos ad=1.14p pd=6.38u as=1.14p ps=6.38u w=6u l=1u
X123 VDD iqmod_mfb_lpf_ota_core_hybrid_bm_pex_half_1.iqmod_mfb_lpf_ota_core_spdt_switch_0.do_spdt_ctrl_n iqmod_mfb_lpf_ota_core_hybrid_bm_pex_half_1.iqmod_mfb_lpf_ota_core_inv_NF10_0.vin VSS sg13_lv_nmos ad=0.34p pd=2.68u as=0.19p ps=1.38u w=1u l=0.13u
X124 VSS voutn iqmod_mfb_lpf_ota_core_hybrid_bm_pex_half_1.iqmod_mfb_lpf_ota_core_tg_1.v_a VSS sg13_lv_nmos ad=0.19p pd=1.38u as=0.19p ps=1.38u w=1u l=1u
X125 iqmod_mfb_lpf_ota_core_hybrid_bm_pex_half_1.iqmod_mfb_lpf_ota_core_inv_NF10_0.vin iqmod_mfb_lpf_ota_core_hybrid_bm_pex_half_1.iqmod_mfb_lpf_ota_core_spdt_switch_0.do_spdt_ctrl_n VDD VSS sg13_lv_nmos ad=0.19p pd=1.38u as=0.34p ps=2.68u w=1u l=0.13u
X126 iqmod_mfb_lpf_ota_core_hybrid_bm_pex_half_1.iqmod_mfb_lpf_ota_core_tg_1.v_a voutp VSS VSS sg13_lv_nmos ad=0.19p pd=1.38u as=0.19p ps=1.38u w=1u l=1u
X127 VSS iqmod_mfb_lpf_ota_core_hybrid_bm_pex_half_1.iqmod_mfb_lpf_ota_core_inv_NF6_0.vout voutn VSS sg13_lv_nmos ad=0.19p pd=1.38u as=0.19p ps=1.38u w=1u l=1u
X128 VDD iqmod_mfb_lpf_ota_core_hybrid_bm_pex_half_1.iqmod_mfb_lpf_ota_core_inv_NF10_0.vout iqmod_mfb_lpf_ota_core_hybrid_bm_pex_half_1.iqmod_mfb_lpf_ota_core_inv_NF6_0.vout VDD sg13_lv_pmos ad=1.14p pd=6.38u as=1.14p ps=6.38u w=6u l=1u
X129 VSS iqmod_mfb_lpf_ota_core_hybrid_bm_pex_half_1.iqmod_mfb_lpf_ota_core_inv_NF10_0.vin voutn VSS sg13_lv_nmos ad=0.19p pd=1.38u as=0.19p ps=1.38u w=1u l=1u
X130 VSS voutp iqmod_mfb_lpf_ota_core_hybrid_bm_pex_half_1.iqmod_mfb_lpf_ota_core_tg_1.v_a VSS sg13_lv_nmos ad=0.19p pd=1.38u as=0.19p ps=1.38u w=1u l=1u
X131 iqmod_mfb_lpf_ota_core_hybrid_bm_pex_half_1.iqmod_mfb_lpf_ota_core_inv_NF6_2.vin iqmod_mfb_lpf_ota_core_hybrid_bm_pex_half_1.iqmod_mfb_lpf_ota_core_tg_1.v_a VSS VSS sg13_lv_nmos ad=0.19p pd=1.38u as=0.19p ps=1.38u w=1u l=1u
X132 iqmod_mfb_lpf_ota_core_hybrid_bm_pex_half_1.iqmod_mfb_lpf_ota_core_inv_NF6_0.vout iqmod_mfb_lpf_ota_core_hybrid_bm_pex_half_1.iqmod_mfb_lpf_ota_core_inv_NF10_0.vout VDD VDD sg13_lv_pmos ad=1.14p pd=6.38u as=1.14p ps=6.38u w=6u l=1u
X133 VDD iqmod_mfb_lpf_ota_core_hybrid_bm_pex_half_1.iqmod_mfb_lpf_ota_core_tg_1.v_a iqmod_mfb_lpf_ota_core_hybrid_bm_pex_half_1.iqmod_mfb_lpf_ota_core_inv_NF6_2.vin VDD sg13_lv_pmos ad=1.14p pd=6.38u as=1.14p ps=6.38u w=6u l=1u
X134 VDD iqmod_mfb_lpf_ota_core_hybrid_bm_pex_half_1.iqmod_mfb_lpf_ota_core_inv_NF10_0.vin voutn VDD sg13_lv_pmos ad=1.14p pd=6.38u as=1.14p ps=6.38u w=6u l=1u
X135 VDD iqmod_mfb_lpf_ota_core_hybrid_bm_pex_half_1.iqmod_mfb_lpf_ota_core_inv_NF10_0.vin iqmod_mfb_lpf_ota_core_hybrid_bm_pex_half_1.iqmod_mfb_lpf_ota_core_inv_NF10_0.vout VDD sg13_lv_pmos ad=1.14p pd=6.38u as=1.14p ps=6.38u w=6u l=1u
X136 VDD voutp iqmod_mfb_lpf_ota_core_hybrid_bm_pex_half_1.iqmod_mfb_lpf_ota_core_tg_1.v_a VDD sg13_lv_pmos ad=1.14p pd=6.38u as=1.14p ps=6.38u w=6u l=1u
X137 VDD iqmod_mfb_lpf_ota_core_hybrid_bm_pex_half_1.iqmod_mfb_lpf_ota_core_inv_NF10_0.vin voutn VDD sg13_lv_pmos ad=1.14p pd=6.38u as=1.14p ps=6.38u w=6u l=1u
X138 iqmod_mfb_lpf_ota_core_hybrid_bm_pex_half_1.iqmod_mfb_lpf_ota_core_spdt_switch_0.do_spdt_ctrl_n di_ota_en VSS VSS sg13_lv_nmos ad=0.19p pd=1.38u as=0.19p ps=1.38u w=1u l=0.13u
X139 voutp iqmod_mfb_lpf_ota_core_hybrid_bm_pex_half_1.iqmod_mfb_lpf_ota_core_inv_NF6_0.vout VSS VSS sg13_lv_nmos ad=0.19p pd=1.38u as=0.19p ps=1.38u w=1u l=1u
X140 VDD iqmod_mfb_lpf_ota_core_hybrid_bm_pex_half_1.iqmod_mfb_lpf_ota_core_inv_NF10_0.vin iqmod_mfb_lpf_ota_core_hybrid_bm_pex_half_1.iqmod_mfb_lpf_ota_core_inv_NF10_0.vout VDD sg13_lv_pmos ad=1.14p pd=6.38u as=1.14p ps=6.38u w=6u l=1u
X141 iqmod_mfb_lpf_ota_core_hybrid_bm_pex_half_1.iqmod_mfb_lpf_ota_core_inv_NF6_0.vout iqmod_mfb_lpf_ota_core_hybrid_bm_pex_half_1.iqmod_mfb_lpf_ota_core_inv_NF6_2.vin VSS VSS sg13_lv_nmos ad=0.19p pd=1.38u as=0.19p ps=1.38u w=1u l=1u
X142 VDD iqmod_mfb_lpf_ota_core_hybrid_bm_pex_half_1.iqmod_mfb_lpf_ota_core_inv_NF6_0.vout voutp VDD sg13_lv_pmos ad=1.14p pd=6.38u as=1.14p ps=6.38u w=6u l=1u
X143 iqmod_mfb_lpf_ota_core_hybrid_bm_pex_half_1.iqmod_mfb_lpf_ota_core_inv_NF6_0.vout iqmod_mfb_lpf_ota_core_hybrid_bm_pex_half_1.iqmod_mfb_lpf_ota_core_inv_NF6_2.vin VDD VDD sg13_lv_pmos ad=1.14p pd=6.38u as=1.14p ps=6.38u w=6u l=1u
X144 VDD VDD VDD VDD sg13_lv_pmos ad=2.04p pd=12.68u as=0 ps=0 w=6u l=1u
X145 VDD VDD VDD VDD sg13_lv_pmos ad=1.14p pd=6.38u as=0 ps=0 w=6u l=0.13u
X146 VSS VSS VSS VSS sg13_lv_nmos ad=0.34p pd=2.68u as=0 ps=0 w=1u l=1u
X147 VDD iqmod_mfb_lpf_ota_core_hybrid_bm_pex_half_0.iqmod_mfb_lpf_ota_core_spdt_switch_0.iqmod_mfb_lpf_ota_core_spdt_switch_inv$1_0.vout iqmod_mfb_lpf_ota_core_hybrid_bm_pex_half_0.iqmod_mfb_lpf_ota_core_inv_NF10_0.vin VDD sg13_lv_pmos ad=1.14p pd=6.38u as=1.14p ps=6.38u w=6u l=0.13u
X148 iqmod_mfb_lpf_ota_core_hybrid_bm_pex_half_0.iqmod_mfb_lpf_ota_core_inv_NF10_0.vin iqmod_mfb_lpf_ota_core_hybrid_bm_pex_half_0.iqmod_mfb_lpf_ota_core_spdt_switch_0.do_spdt_ctrl_n vinn VDD sg13_lv_pmos ad=1.14p pd=6.38u as=1.14p ps=6.38u w=6u l=0.13u
X149 VSS VSS VSS VSS sg13_lv_nmos ad=0.19p pd=1.38u as=0 ps=0 w=1u l=1u
X150 VDD VDD VDD VDD sg13_lv_pmos ad=2.04p pd=12.68u as=0 ps=0 w=6u l=1u
X151 iqmod_mfb_lpf_ota_core_hybrid_bm_pex_half_1.iqmod_mfb_lpf_ota_core_inv_NF6_0.vout iqmod_mfb_lpf_ota_core_hybrid_bm_pex_half_1.iqmod_mfb_lpf_ota_core_inv_NF6_2.vin VSS VSS sg13_lv_nmos ad=0.19p pd=1.38u as=0.19p ps=1.38u w=1u l=1u
X152 VDD voutn iqmod_mfb_lpf_ota_core_hybrid_bm_pex_half_1.iqmod_mfb_lpf_ota_core_tg_1.v_a VDD sg13_lv_pmos ad=1.14p pd=6.38u as=1.14p ps=6.38u w=6u l=1u
X153 VDD iqmod_mfb_lpf_ota_core_hybrid_bm_pex_half_1.iqmod_mfb_lpf_ota_core_spdt_switch_0.do_spdt_ctrl_n iqmod_mfb_lpf_ota_core_hybrid_bm_pex_half_1.iqmod_mfb_lpf_ota_core_spdt_switch_0.iqmod_mfb_lpf_ota_core_spdt_switch_inv$1_0.vout VDD sg13_lv_pmos ad=1.14p pd=6.38u as=1.14p ps=6.38u w=6u l=0.13u
X154 VSS iqmod_mfb_lpf_ota_core_hybrid_bm_pex_half_1.iqmod_mfb_lpf_ota_core_inv_NF6_2.vin iqmod_mfb_lpf_ota_core_hybrid_bm_pex_half_1.iqmod_mfb_lpf_ota_core_inv_NF6_0.vout VSS sg13_lv_nmos ad=0.19p pd=1.38u as=0.19p ps=1.38u w=1u l=1u
X155 voutn iqmod_mfb_lpf_ota_core_hybrid_bm_pex_half_1.iqmod_mfb_lpf_ota_core_inv_NF10_0.vin VSS VSS sg13_lv_nmos ad=0.19p pd=1.38u as=0.19p ps=1.38u w=1u l=1u
X156 iqmod_mfb_lpf_ota_core_hybrid_bm_pex_half_1.iqmod_mfb_lpf_ota_core_tg_1.v_a voutn VDD VDD sg13_lv_pmos ad=1.14p pd=6.38u as=1.14p ps=6.38u w=6u l=1u
X157 VSS voutn iqmod_mfb_lpf_ota_core_hybrid_bm_pex_half_1.iqmod_mfb_lpf_ota_core_tg_1.v_a VSS sg13_lv_nmos ad=0.19p pd=1.38u as=0.19p ps=1.38u w=1u l=1u
X158 voutn iqmod_mfb_lpf_ota_core_hybrid_bm_pex_half_1.iqmod_mfb_lpf_ota_core_inv_NF6_0.vout VSS VSS sg13_lv_nmos ad=0.19p pd=1.38u as=0.19p ps=1.38u w=1u l=1u
X159 iqmod_mfb_lpf_ota_core_hybrid_bm_pex_half_1.iqmod_mfb_lpf_ota_core_tg_1.v_a iqmod_mfb_lpf_ota_core_hybrid_bm_pex_half_0.iqmod_mfb_lpf_ota_core_spdt_switch_0.do_spdt_ctrl_n iqmod_mfb_lpf_ota_core_hybrid_bm_pex_half_1.iqmod_mfb_lpf_ota_core_inv_NF6_2.vin VDD sg13_lv_pmos ad=1.14p pd=6.38u as=1.14p ps=6.38u w=6u l=0.13u
X160 VDD voutn iqmod_mfb_lpf_ota_core_hybrid_bm_pex_half_1.iqmod_mfb_lpf_ota_core_tg_1.v_a VDD sg13_lv_pmos ad=1.14p pd=6.38u as=1.14p ps=6.38u w=6u l=1u
X161 VDD iqmod_mfb_lpf_ota_core_hybrid_bm_pex_half_0.iqmod_mfb_lpf_ota_core_inv_NF10_0.vin voutp VDD sg13_lv_pmos ad=1.14p pd=6.38u as=1.14p ps=6.38u w=6u l=1u
X162 iqmod_mfb_lpf_ota_core_hybrid_bm_pex_half_1.iqmod_mfb_lpf_ota_core_inv_NF6_0.vout di_ota_en iqmod_mfb_lpf_ota_core_hybrid_bm_pex_half_1.iqmod_mfb_lpf_ota_core_inv_NF10_0.vout VSS sg13_lv_nmos ad=0.19p pd=1.38u as=0.34p ps=2.68u w=1u l=0.13u
X163 VSS VSS VSS VSS sg13_lv_nmos ad=0.34p pd=2.68u as=0 ps=0 w=1u l=0.13u
X164 iqmod_mfb_lpf_ota_core_hybrid_bm_pex_half_1.iqmod_mfb_lpf_ota_core_inv_NF6_0.vout iqmod_mfb_lpf_ota_core_hybrid_bm_pex_half_1.iqmod_mfb_lpf_ota_core_inv_NF6_2.vin VDD VDD sg13_lv_pmos ad=1.14p pd=6.38u as=1.14p ps=6.38u w=6u l=1u
X165 VDD iqmod_mfb_lpf_ota_core_hybrid_bm_pex_half_0.iqmod_mfb_lpf_ota_core_inv_NF10_0.vin iqmod_mfb_lpf_ota_core_hybrid_bm_pex_half_1.iqmod_mfb_lpf_ota_core_inv_NF10_0.vout VDD sg13_lv_pmos ad=1.14p pd=6.38u as=1.14p ps=6.38u w=6u l=1u
X166 VSS iqmod_mfb_lpf_ota_core_hybrid_bm_pex_half_1.iqmod_mfb_lpf_ota_core_inv_NF6_0.vout voutp VSS sg13_lv_nmos ad=0.19p pd=1.38u as=0.19p ps=1.38u w=1u l=1u
X167 VDD VDD VDD VDD sg13_lv_pmos ad=1.14p pd=6.38u as=0 ps=0 w=6u l=0.13u
X168 VSS di_ota_en iqmod_mfb_lpf_ota_core_hybrid_bm_pex_half_1.iqmod_mfb_lpf_ota_core_spdt_switch_0.do_spdt_ctrl_n VSS sg13_lv_nmos ad=0.19p pd=1.38u as=0.19p ps=1.38u w=1u l=0.13u
X169 VDD iqmod_mfb_lpf_ota_core_hybrid_bm_pex_half_1.iqmod_mfb_lpf_ota_core_inv_NF6_0.vout voutp VDD sg13_lv_pmos ad=1.14p pd=6.38u as=1.14p ps=6.38u w=6u l=1u
X170 VSS iqmod_mfb_lpf_ota_core_hybrid_bm_pex_half_1.iqmod_mfb_lpf_ota_core_inv_NF10_0.vin iqmod_mfb_lpf_ota_core_hybrid_bm_pex_half_1.iqmod_mfb_lpf_ota_core_inv_NF10_0.vout VSS sg13_lv_nmos ad=0.19p pd=1.38u as=0.19p ps=1.38u w=1u l=1u
X171 VDD voutn iqmod_mfb_lpf_ota_core_hybrid_bm_pex_half_1.iqmod_mfb_lpf_ota_core_tg_1.v_a VDD sg13_lv_pmos ad=1.14p pd=6.38u as=1.14p ps=6.38u w=6u l=1u
X172 voutp iqmod_mfb_lpf_ota_core_hybrid_bm_pex_half_1.iqmod_mfb_lpf_ota_core_inv_NF6_0.vout VSS VSS sg13_lv_nmos ad=0.19p pd=1.38u as=0.19p ps=1.38u w=1u l=1u
X173 voutp iqmod_mfb_lpf_ota_core_hybrid_bm_pex_half_1.iqmod_mfb_lpf_ota_core_inv_NF6_0.vout VSS VSS sg13_lv_nmos ad=0.19p pd=1.38u as=0.19p ps=1.38u w=1u l=1u
X174 iqmod_mfb_lpf_ota_core_hybrid_bm_pex_half_1.iqmod_mfb_lpf_ota_core_tg_1.v_a voutp VSS VSS sg13_lv_nmos ad=0.19p pd=1.38u as=0.19p ps=1.38u w=1u l=1u
X175 voutp iqmod_mfb_lpf_ota_core_hybrid_bm_pex_half_0.iqmod_mfb_lpf_ota_core_inv_NF10_0.vin VDD VDD sg13_lv_pmos ad=1.14p pd=6.38u as=1.14p ps=6.38u w=6u l=1u
X176 iqmod_mfb_lpf_ota_core_hybrid_bm_pex_half_0.iqmod_mfb_lpf_ota_core_spdt_switch_0.do_spdt_ctrl_n di_ota_en VSS VSS sg13_lv_nmos ad=0.19p pd=1.38u as=0.19p ps=1.38u w=1u l=0.13u
X177 voutn iqmod_mfb_lpf_ota_core_hybrid_bm_pex_half_1.iqmod_mfb_lpf_ota_core_inv_NF6_0.vout VDD VDD sg13_lv_pmos ad=1.14p pd=6.38u as=1.14p ps=6.38u w=6u l=1u
X178 vinn iqmod_mfb_lpf_ota_core_hybrid_bm_pex_half_0.iqmod_mfb_lpf_ota_core_spdt_switch_0.do_spdt_ctrl_n iqmod_mfb_lpf_ota_core_hybrid_bm_pex_half_0.iqmod_mfb_lpf_ota_core_inv_NF10_0.vin VDD sg13_lv_pmos ad=1.14p pd=6.38u as=1.14p ps=6.38u w=6u l=0.13u
X179 VSS iqmod_mfb_lpf_ota_core_hybrid_bm_pex_half_1.iqmod_mfb_lpf_ota_core_inv_NF6_0.vout voutn VSS sg13_lv_nmos ad=0.19p pd=1.38u as=0.19p ps=1.38u w=1u l=1u
X180 VDD iqmod_mfb_lpf_ota_core_hybrid_bm_pex_half_1.iqmod_mfb_lpf_ota_core_inv_NF6_2.vin iqmod_mfb_lpf_ota_core_hybrid_bm_pex_half_1.iqmod_mfb_lpf_ota_core_inv_NF6_0.vout VDD sg13_lv_pmos ad=1.14p pd=6.38u as=1.14p ps=6.38u w=6u l=1u
X181 VDD VDD VDD VDD sg13_lv_pmos ad=1.14p pd=6.38u as=0 ps=0 w=6u l=1u
X182 VDD VDD VDD VDD sg13_lv_pmos ad=2.04p pd=12.68u as=0 ps=0 w=6u l=0.13u
X183 VSS voutp iqmod_mfb_lpf_ota_core_hybrid_bm_pex_half_1.iqmod_mfb_lpf_ota_core_tg_1.v_a VSS sg13_lv_nmos ad=0.19p pd=1.38u as=0.19p ps=1.38u w=1u l=1u
X184 voutp iqmod_mfb_lpf_ota_core_hybrid_bm_pex_half_0.iqmod_mfb_lpf_ota_core_inv_NF10_0.vin VSS VSS sg13_lv_nmos ad=0.19p pd=1.38u as=0.19p ps=1.38u w=1u l=1u
X185 iqmod_mfb_lpf_ota_core_hybrid_bm_pex_half_1.iqmod_mfb_lpf_ota_core_inv_NF6_0.vout iqmod_mfb_lpf_ota_core_hybrid_bm_pex_half_1.iqmod_mfb_lpf_ota_core_inv_NF10_0.vout VDD VDD sg13_lv_pmos ad=1.14p pd=6.38u as=1.14p ps=6.38u w=6u l=1u
X186 VDD iqmod_mfb_lpf_ota_core_hybrid_bm_pex_half_1.iqmod_mfb_lpf_ota_core_inv_NF6_0.vout voutn VDD sg13_lv_pmos ad=1.14p pd=6.38u as=1.14p ps=6.38u w=6u l=1u
X187 voutp iqmod_mfb_lpf_ota_core_hybrid_bm_pex_half_1.iqmod_mfb_lpf_ota_core_inv_NF6_0.vout VDD VDD sg13_lv_pmos ad=1.14p pd=6.38u as=1.14p ps=6.38u w=6u l=1u
X188 iqmod_mfb_lpf_ota_core_hybrid_bm_pex_half_1.iqmod_mfb_lpf_ota_core_inv_NF6_0.vout iqmod_mfb_lpf_ota_core_hybrid_bm_pex_half_1.iqmod_mfb_lpf_ota_core_inv_NF6_2.vin VSS VSS sg13_lv_nmos ad=0.19p pd=1.38u as=0.19p ps=1.38u w=1u l=1u
X189 VDD iqmod_mfb_lpf_ota_core_hybrid_bm_pex_half_0.iqmod_mfb_lpf_ota_core_inv_NF10_0.vin voutp VDD sg13_lv_pmos ad=1.14p pd=6.38u as=1.14p ps=6.38u w=6u l=1u
X190 iqmod_mfb_lpf_ota_core_hybrid_bm_pex_half_1.iqmod_mfb_lpf_ota_core_tg_1.v_a voutp VSS VSS sg13_lv_nmos ad=0.19p pd=1.38u as=0.19p ps=1.38u w=1u l=1u
X191 VSS iqmod_mfb_lpf_ota_core_hybrid_bm_pex_half_1.iqmod_mfb_lpf_ota_core_inv_NF10_0.vin voutn VSS sg13_lv_nmos ad=0.19p pd=1.38u as=0.19p ps=1.38u w=1u l=1u
X192 VSS iqmod_mfb_lpf_ota_core_hybrid_bm_pex_half_0.iqmod_mfb_lpf_ota_core_inv_NF10_0.vin voutp VSS sg13_lv_nmos ad=0.19p pd=1.38u as=0.19p ps=1.38u w=1u l=1u
X193 VDD iqmod_mfb_lpf_ota_core_hybrid_bm_pex_half_0.iqmod_mfb_lpf_ota_core_inv_NF10_0.vin iqmod_mfb_lpf_ota_core_hybrid_bm_pex_half_1.iqmod_mfb_lpf_ota_core_inv_NF10_0.vout VDD sg13_lv_pmos ad=1.14p pd=6.38u as=1.14p ps=6.38u w=6u l=1u
X194 iqmod_mfb_lpf_ota_core_hybrid_bm_pex_half_1.iqmod_mfb_lpf_ota_core_tg_1.v_a voutn VSS VSS sg13_lv_nmos ad=0.19p pd=1.38u as=0.19p ps=1.38u w=1u l=1u
X195 VSS voutp iqmod_mfb_lpf_ota_core_hybrid_bm_pex_half_1.iqmod_mfb_lpf_ota_core_tg_1.v_a VSS sg13_lv_nmos ad=0.19p pd=1.38u as=0.19p ps=1.38u w=1u l=1u
X196 VSS VSS VSS VSS sg13_lv_nmos ad=0.34p pd=2.68u as=0 ps=0 w=1u l=1u
X197 iqmod_mfb_lpf_ota_core_hybrid_bm_pex_half_1.iqmod_mfb_lpf_ota_core_inv_NF10_0.vout di_ota_en iqmod_mfb_lpf_ota_core_hybrid_bm_pex_half_1.iqmod_mfb_lpf_ota_core_inv_NF6_0.vout VSS sg13_lv_nmos ad=0.19p pd=1.38u as=0.19p ps=1.38u w=1u l=0.13u
X198 iqmod_mfb_lpf_ota_core_hybrid_bm_pex_half_1.iqmod_mfb_lpf_ota_core_tg_1.v_a iqmod_mfb_lpf_ota_core_hybrid_bm_pex_half_0.iqmod_mfb_lpf_ota_core_spdt_switch_0.do_spdt_ctrl_n iqmod_mfb_lpf_ota_core_hybrid_bm_pex_half_1.iqmod_mfb_lpf_ota_core_inv_NF6_2.vin VDD sg13_lv_pmos ad=1.14p pd=6.38u as=1.14p ps=6.38u w=6u l=0.13u
X199 iqmod_mfb_lpf_ota_core_hybrid_bm_pex_half_1.iqmod_mfb_lpf_ota_core_tg_1.v_a voutn VSS VSS sg13_lv_nmos ad=0.19p pd=1.38u as=0.19p ps=1.38u w=1u l=1u
X200 VSS iqmod_mfb_lpf_ota_core_hybrid_bm_pex_half_1.iqmod_mfb_lpf_ota_core_inv_NF6_0.vout voutp VSS sg13_lv_nmos ad=0.19p pd=1.38u as=0.19p ps=1.38u w=1u l=1u
X201 vinp iqmod_mfb_lpf_ota_core_hybrid_bm_pex_half_1.iqmod_mfb_lpf_ota_core_spdt_switch_0.do_spdt_ctrl_n iqmod_mfb_lpf_ota_core_hybrid_bm_pex_half_1.iqmod_mfb_lpf_ota_core_inv_NF10_0.vin VDD sg13_lv_pmos ad=1.14p pd=6.38u as=1.14p ps=6.38u w=6u l=0.13u
X202 iqmod_mfb_lpf_ota_core_hybrid_bm_pex_half_1.iqmod_mfb_lpf_ota_core_inv_NF10_0.vin iqmod_mfb_lpf_ota_core_hybrid_bm_pex_half_1.iqmod_mfb_lpf_ota_core_spdt_switch_0.iqmod_mfb_lpf_ota_core_spdt_switch_inv$1_0.vout VDD VDD sg13_lv_pmos ad=1.14p pd=6.38u as=2.04p ps=12.68u w=6u l=0.13u
X203 iqmod_mfb_lpf_ota_core_hybrid_bm_pex_half_1.iqmod_mfb_lpf_ota_core_inv_NF10_0.vout iqmod_mfb_lpf_ota_core_hybrid_bm_pex_half_1.iqmod_mfb_lpf_ota_core_spdt_switch_0.do_spdt_ctrl_n iqmod_mfb_lpf_ota_core_hybrid_bm_pex_half_1.iqmod_mfb_lpf_ota_core_inv_NF6_0.vout VDD sg13_lv_pmos ad=1.14p pd=6.38u as=1.14p ps=6.38u w=6u l=0.13u
X204 voutn iqmod_mfb_lpf_ota_core_hybrid_bm_pex_half_1.iqmod_mfb_lpf_ota_core_inv_NF10_0.vin VDD VDD sg13_lv_pmos ad=1.14p pd=6.38u as=1.14p ps=6.38u w=6u l=1u
X205 VDD voutn iqmod_mfb_lpf_ota_core_hybrid_bm_pex_half_1.iqmod_mfb_lpf_ota_core_tg_1.v_a VDD sg13_lv_pmos ad=1.14p pd=6.38u as=1.14p ps=6.38u w=6u l=1u
X206 VSS VSS VSS VSS sg13_lv_nmos ad=0.19p pd=1.38u as=0 ps=0 w=1u l=0.13u
X207 iqmod_mfb_lpf_ota_core_hybrid_bm_pex_half_1.iqmod_mfb_lpf_ota_core_inv_NF10_0.vout di_ota_en iqmod_mfb_lpf_ota_core_hybrid_bm_pex_half_1.iqmod_mfb_lpf_ota_core_inv_NF6_0.vout VSS sg13_lv_nmos ad=0.34p pd=2.68u as=0.19p ps=1.38u w=1u l=0.13u
X208 iqmod_mfb_lpf_ota_core_hybrid_bm_pex_half_1.iqmod_mfb_lpf_ota_core_inv_NF6_0.vout iqmod_mfb_lpf_ota_core_hybrid_bm_pex_half_1.iqmod_mfb_lpf_ota_core_spdt_switch_0.do_spdt_ctrl_n iqmod_mfb_lpf_ota_core_hybrid_bm_pex_half_1.iqmod_mfb_lpf_ota_core_inv_NF10_0.vout VDD sg13_lv_pmos ad=1.14p pd=6.38u as=2.04p ps=12.68u w=6u l=0.13u
X209 vinn iqmod_mfb_lpf_ota_core_hybrid_bm_pex_half_0.iqmod_mfb_lpf_ota_core_spdt_switch_0.iqmod_mfb_lpf_ota_core_spdt_switch_inv$1_0.vout iqmod_mfb_lpf_ota_core_hybrid_bm_pex_half_0.iqmod_mfb_lpf_ota_core_inv_NF10_0.vin VSS sg13_lv_nmos ad=0.34p pd=2.68u as=0.19p ps=1.38u w=1u l=0.13u
X210 VSS VSS VSS VSS sg13_lv_nmos ad=0.19p pd=1.38u as=0 ps=0 w=1u l=1u
X211 VDD voutp iqmod_mfb_lpf_ota_core_hybrid_bm_pex_half_1.iqmod_mfb_lpf_ota_core_tg_1.v_a VDD sg13_lv_pmos ad=1.14p pd=6.38u as=1.14p ps=6.38u w=6u l=1u
X212 iqmod_mfb_lpf_ota_core_hybrid_bm_pex_half_1.iqmod_mfb_lpf_ota_core_inv_NF10_0.vout iqmod_mfb_lpf_ota_core_hybrid_bm_pex_half_0.iqmod_mfb_lpf_ota_core_spdt_switch_0.do_spdt_ctrl_n iqmod_mfb_lpf_ota_core_hybrid_bm_pex_half_1.iqmod_mfb_lpf_ota_core_inv_NF6_0.vout VDD sg13_lv_pmos ad=2.04p pd=12.68u as=1.14p ps=6.38u w=6u l=0.13u
X213 iqmod_mfb_lpf_ota_core_hybrid_bm_pex_half_1.iqmod_mfb_lpf_ota_core_inv_NF6_0.vout di_ota_en iqmod_mfb_lpf_ota_core_hybrid_bm_pex_half_1.iqmod_mfb_lpf_ota_core_inv_NF10_0.vout VSS sg13_lv_nmos ad=0.19p pd=1.38u as=0.19p ps=1.38u w=1u l=0.13u
X214 iqmod_mfb_lpf_ota_core_hybrid_bm_pex_half_1.iqmod_mfb_lpf_ota_core_inv_NF10_0.vout iqmod_mfb_lpf_ota_core_hybrid_bm_pex_half_1.iqmod_mfb_lpf_ota_core_inv_NF10_0.vin VDD VDD sg13_lv_pmos ad=1.14p pd=6.38u as=1.14p ps=6.38u w=6u l=1u
X215 iqmod_mfb_lpf_ota_core_hybrid_bm_pex_half_0.iqmod_mfb_lpf_ota_core_inv_NF10_0.vin iqmod_mfb_lpf_ota_core_hybrid_bm_pex_half_0.iqmod_mfb_lpf_ota_core_spdt_switch_0.iqmod_mfb_lpf_ota_core_spdt_switch_inv$1_0.vout vinn VSS sg13_lv_nmos ad=0.19p pd=1.38u as=0.19p ps=1.38u w=1u l=0.13u
X216 VDD VDD VDD VDD sg13_lv_pmos ad=1.14p pd=6.38u as=0 ps=0 w=6u l=1u
X217 iqmod_mfb_lpf_ota_core_hybrid_bm_pex_half_1.iqmod_mfb_lpf_ota_core_inv_NF10_0.vout iqmod_mfb_lpf_ota_core_hybrid_bm_pex_half_0.iqmod_mfb_lpf_ota_core_spdt_switch_0.do_spdt_ctrl_n iqmod_mfb_lpf_ota_core_hybrid_bm_pex_half_1.iqmod_mfb_lpf_ota_core_inv_NF6_0.vout VDD sg13_lv_pmos ad=1.14p pd=6.38u as=1.14p ps=6.38u w=6u l=0.13u
X218 VSS iqmod_mfb_lpf_ota_core_hybrid_bm_pex_half_1.iqmod_mfb_lpf_ota_core_inv_NF6_2.vin iqmod_mfb_lpf_ota_core_hybrid_bm_pex_half_1.iqmod_mfb_lpf_ota_core_inv_NF6_0.vout VSS sg13_lv_nmos ad=0.19p pd=1.38u as=0.19p ps=1.38u w=1u l=1u
X219 VSS iqmod_mfb_lpf_ota_core_hybrid_bm_pex_half_1.iqmod_mfb_lpf_ota_core_inv_NF6_0.vout voutn VSS sg13_lv_nmos ad=0.19p pd=1.38u as=0.19p ps=1.38u w=1u l=1u
X220 voutp iqmod_mfb_lpf_ota_core_hybrid_bm_pex_half_1.iqmod_mfb_lpf_ota_core_inv_NF6_0.vout VSS VSS sg13_lv_nmos ad=0.19p pd=1.38u as=0.19p ps=1.38u w=1u l=1u
X221 VSS iqmod_mfb_lpf_ota_core_hybrid_bm_pex_half_1.iqmod_mfb_lpf_ota_core_inv_NF6_0.vout voutp VSS sg13_lv_nmos ad=0.19p pd=1.38u as=0.19p ps=1.38u w=1u l=1u
X222 VDD iqmod_mfb_lpf_ota_core_hybrid_bm_pex_half_1.iqmod_mfb_lpf_ota_core_inv_NF6_0.vout voutp VDD sg13_lv_pmos ad=1.14p pd=6.38u as=1.14p ps=6.38u w=6u l=1u
X223 VSS iqmod_mfb_lpf_ota_core_hybrid_bm_pex_half_0.iqmod_mfb_lpf_ota_core_inv_NF10_0.vin voutp VSS sg13_lv_nmos ad=0.19p pd=1.38u as=0.19p ps=1.38u w=1u l=1u
X224 voutp iqmod_mfb_lpf_ota_core_hybrid_bm_pex_half_0.iqmod_mfb_lpf_ota_core_inv_NF10_0.vin VDD VDD sg13_lv_pmos ad=1.14p pd=6.38u as=1.14p ps=6.38u w=6u l=1u
X225 iqmod_mfb_lpf_ota_core_hybrid_bm_pex_half_1.iqmod_mfb_lpf_ota_core_tg_1.v_a voutp VDD VDD sg13_lv_pmos ad=1.14p pd=6.38u as=1.14p ps=6.38u w=6u l=1u
X226 iqmod_mfb_lpf_ota_core_hybrid_bm_pex_half_0.iqmod_mfb_lpf_ota_core_spdt_switch_0.do_spdt_ctrl_n di_ota_en VDD VDD sg13_lv_pmos ad=1.14p pd=6.38u as=1.14p ps=6.38u w=6u l=0.13u
X227 VDD VDD VDD VDD sg13_lv_pmos ad=1.14p pd=6.38u as=0 ps=0 w=6u l=1u
X228 VSS iqmod_mfb_lpf_ota_core_hybrid_bm_pex_half_1.iqmod_mfb_lpf_ota_core_inv_NF10_0.vin voutn VSS sg13_lv_nmos ad=0.19p pd=1.38u as=0.19p ps=1.38u w=1u l=1u
X229 voutp iqmod_mfb_lpf_ota_core_hybrid_bm_pex_half_1.iqmod_mfb_lpf_ota_core_inv_NF6_0.vout VDD VDD sg13_lv_pmos ad=1.14p pd=6.38u as=1.14p ps=6.38u w=6u l=1u
X230 iqmod_mfb_lpf_ota_core_hybrid_bm_pex_half_1.iqmod_mfb_lpf_ota_core_tg_1.v_a iqmod_mfb_lpf_ota_core_hybrid_bm_pex_half_1.iqmod_mfb_lpf_ota_core_spdt_switch_0.do_spdt_ctrl_n iqmod_mfb_lpf_ota_core_hybrid_bm_pex_half_1.iqmod_mfb_lpf_ota_core_inv_NF6_2.vin VDD sg13_lv_pmos ad=1.14p pd=6.38u as=1.14p ps=6.38u w=6u l=0.13u
X231 VDD VDD VDD VDD sg13_lv_pmos ad=2.04p pd=12.68u as=0 ps=0 w=6u l=1u
X232 voutp iqmod_mfb_lpf_ota_core_hybrid_bm_pex_half_1.iqmod_mfb_lpf_ota_core_inv_NF6_0.vout VSS VSS sg13_lv_nmos ad=0.19p pd=1.38u as=0.19p ps=1.38u w=1u l=1u
X233 iqmod_mfb_lpf_ota_core_hybrid_bm_pex_half_1.iqmod_mfb_lpf_ota_core_tg_1.v_a voutn VSS VSS sg13_lv_nmos ad=0.19p pd=1.38u as=0.19p ps=1.38u w=1u l=1u
X234 VDD VDD VDD VDD sg13_lv_pmos ad=2.04p pd=12.68u as=0 ps=0 w=6u l=1u
X235 voutn iqmod_mfb_lpf_ota_core_hybrid_bm_pex_half_1.iqmod_mfb_lpf_ota_core_inv_NF10_0.vin VSS VSS sg13_lv_nmos ad=0.19p pd=1.38u as=0.19p ps=1.38u w=1u l=1u
X236 iqmod_mfb_lpf_ota_core_hybrid_bm_pex_half_1.iqmod_mfb_lpf_ota_core_inv_NF6_0.vout iqmod_mfb_lpf_ota_core_hybrid_bm_pex_half_1.iqmod_mfb_lpf_ota_core_inv_NF10_0.vout VDD VDD sg13_lv_pmos ad=1.14p pd=6.38u as=1.14p ps=6.38u w=6u l=1u
X237 VSS iqmod_mfb_lpf_ota_core_hybrid_bm_pex_half_1.iqmod_mfb_lpf_ota_core_inv_NF6_0.vout voutp VSS sg13_lv_nmos ad=0.19p pd=1.38u as=0.19p ps=1.38u w=1u l=1u
X238 VSS voutn iqmod_mfb_lpf_ota_core_hybrid_bm_pex_half_1.iqmod_mfb_lpf_ota_core_tg_1.v_a VSS sg13_lv_nmos ad=0.19p pd=1.38u as=0.19p ps=1.38u w=1u l=1u
X239 VDD iqmod_mfb_lpf_ota_core_hybrid_bm_pex_half_1.iqmod_mfb_lpf_ota_core_tg_1.v_a iqmod_mfb_lpf_ota_core_hybrid_bm_pex_half_1.iqmod_mfb_lpf_ota_core_inv_NF6_2.vin VDD sg13_lv_pmos ad=1.14p pd=6.38u as=1.14p ps=6.38u w=6u l=1u
X240 VSS VSS VSS VSS sg13_lv_nmos ad=0.19p pd=1.38u as=0 ps=0 w=1u l=1u
X241 VDD voutp iqmod_mfb_lpf_ota_core_hybrid_bm_pex_half_1.iqmod_mfb_lpf_ota_core_tg_1.v_a VDD sg13_lv_pmos ad=1.14p pd=6.38u as=1.14p ps=6.38u w=6u l=1u
X242 iqmod_mfb_lpf_ota_core_hybrid_bm_pex_half_1.iqmod_mfb_lpf_ota_core_inv_NF10_0.vout di_ota_en iqmod_mfb_lpf_ota_core_hybrid_bm_pex_half_1.iqmod_mfb_lpf_ota_core_inv_NF6_0.vout VSS sg13_lv_nmos ad=0.19p pd=1.38u as=0.19p ps=1.38u w=1u l=0.13u
X243 VDD iqmod_mfb_lpf_ota_core_hybrid_bm_pex_half_1.iqmod_mfb_lpf_ota_core_inv_NF6_0.vout voutn VDD sg13_lv_pmos ad=1.14p pd=6.38u as=1.14p ps=6.38u w=6u l=1u
X244 VDD iqmod_mfb_lpf_ota_core_hybrid_bm_pex_half_1.iqmod_mfb_lpf_ota_core_inv_NF6_0.vout voutn VDD sg13_lv_pmos ad=1.14p pd=6.38u as=1.14p ps=6.38u w=6u l=1u
X245 VDD iqmod_mfb_lpf_ota_core_hybrid_bm_pex_half_1.iqmod_mfb_lpf_ota_core_inv_NF6_0.vout voutp VDD sg13_lv_pmos ad=1.14p pd=6.38u as=1.14p ps=6.38u w=6u l=1u
X246 VSS VSS VSS VSS sg13_lv_nmos ad=0.34p pd=2.68u as=0 ps=0 w=1u l=1u
X247 VDD iqmod_mfb_lpf_ota_core_hybrid_bm_pex_half_1.iqmod_mfb_lpf_ota_core_spdt_switch_0.iqmod_mfb_lpf_ota_core_spdt_switch_inv$1_0.vout iqmod_mfb_lpf_ota_core_hybrid_bm_pex_half_1.iqmod_mfb_lpf_ota_core_inv_NF10_0.vin VDD sg13_lv_pmos ad=1.14p pd=6.38u as=1.14p ps=6.38u w=6u l=0.13u
X248 iqmod_mfb_lpf_ota_core_hybrid_bm_pex_half_1.iqmod_mfb_lpf_ota_core_inv_NF6_0.vout iqmod_mfb_lpf_ota_core_hybrid_bm_pex_half_0.iqmod_mfb_lpf_ota_core_spdt_switch_0.do_spdt_ctrl_n iqmod_mfb_lpf_ota_core_hybrid_bm_pex_half_1.iqmod_mfb_lpf_ota_core_inv_NF10_0.vout VDD sg13_lv_pmos ad=1.14p pd=6.38u as=1.14p ps=6.38u w=6u l=0.13u
X249 VSS iqmod_mfb_lpf_ota_core_hybrid_bm_pex_half_0.iqmod_mfb_lpf_ota_core_inv_NF10_0.vin voutp VSS sg13_lv_nmos ad=0.19p pd=1.38u as=0.19p ps=1.38u w=1u l=1u
X250 voutn iqmod_mfb_lpf_ota_core_hybrid_bm_pex_half_1.iqmod_mfb_lpf_ota_core_inv_NF10_0.vin VSS VSS sg13_lv_nmos ad=0.19p pd=1.38u as=0.19p ps=1.38u w=1u l=1u
X251 voutn iqmod_mfb_lpf_ota_core_hybrid_bm_pex_half_1.iqmod_mfb_lpf_ota_core_inv_NF6_0.vout VDD VDD sg13_lv_pmos ad=1.14p pd=6.38u as=1.14p ps=6.38u w=6u l=1u
X252 iqmod_mfb_lpf_ota_core_hybrid_bm_pex_half_1.iqmod_mfb_lpf_ota_core_inv_NF6_2.vin iqmod_mfb_lpf_ota_core_hybrid_bm_pex_half_1.iqmod_mfb_lpf_ota_core_spdt_switch_0.do_spdt_ctrl_n iqmod_mfb_lpf_ota_core_hybrid_bm_pex_half_1.iqmod_mfb_lpf_ota_core_tg_1.v_a VDD sg13_lv_pmos ad=1.14p pd=6.38u as=2.04p ps=12.68u w=6u l=0.13u
X253 VSS voutp iqmod_mfb_lpf_ota_core_hybrid_bm_pex_half_1.iqmod_mfb_lpf_ota_core_tg_1.v_a VSS sg13_lv_nmos ad=0.19p pd=1.38u as=0.19p ps=1.38u w=1u l=1u
X254 VSS iqmod_mfb_lpf_ota_core_hybrid_bm_pex_half_1.iqmod_mfb_lpf_ota_core_inv_NF10_0.vin iqmod_mfb_lpf_ota_core_hybrid_bm_pex_half_1.iqmod_mfb_lpf_ota_core_inv_NF10_0.vout VSS sg13_lv_nmos ad=0.19p pd=1.38u as=0.19p ps=1.38u w=1u l=1u
X255 iqmod_mfb_lpf_ota_core_hybrid_bm_pex_half_0.iqmod_mfb_lpf_ota_core_inv_NF10_0.vin iqmod_mfb_lpf_ota_core_hybrid_bm_pex_half_0.iqmod_mfb_lpf_ota_core_spdt_switch_0.iqmod_mfb_lpf_ota_core_spdt_switch_inv$1_0.vout VDD VDD sg13_lv_pmos ad=1.14p pd=6.38u as=2.04p ps=12.68u w=6u l=0.13u
X256 voutp iqmod_mfb_lpf_ota_core_hybrid_bm_pex_half_0.iqmod_mfb_lpf_ota_core_inv_NF10_0.vin VSS VSS sg13_lv_nmos ad=0.19p pd=1.38u as=0.19p ps=1.38u w=1u l=1u
X257 VDD iqmod_mfb_lpf_ota_core_hybrid_bm_pex_half_0.iqmod_mfb_lpf_ota_core_spdt_switch_0.do_spdt_ctrl_n iqmod_mfb_lpf_ota_core_hybrid_bm_pex_half_0.iqmod_mfb_lpf_ota_core_inv_NF10_0.vin VSS sg13_lv_nmos ad=0.19p pd=1.38u as=0.19p ps=1.38u w=1u l=0.13u
X258 VSS VSS VSS VSS sg13_lv_nmos ad=0.19p pd=1.38u as=0 ps=0 w=1u l=1u
X259 voutn iqmod_mfb_lpf_ota_core_hybrid_bm_pex_half_1.iqmod_mfb_lpf_ota_core_inv_NF10_0.vin VDD VDD sg13_lv_pmos ad=1.14p pd=6.38u as=1.14p ps=6.38u w=6u l=1u
X260 voutp iqmod_mfb_lpf_ota_core_hybrid_bm_pex_half_0.iqmod_mfb_lpf_ota_core_inv_NF10_0.vin VSS VSS sg13_lv_nmos ad=0.19p pd=1.38u as=0.19p ps=1.38u w=1u l=1u
X261 iqmod_mfb_lpf_ota_core_hybrid_bm_pex_half_1.iqmod_mfb_lpf_ota_core_tg_1.v_a voutp VDD VDD sg13_lv_pmos ad=1.14p pd=6.38u as=1.14p ps=6.38u w=6u l=1u
X262 iqmod_mfb_lpf_ota_core_hybrid_bm_pex_half_1.iqmod_mfb_lpf_ota_core_inv_NF10_0.vout iqmod_mfb_lpf_ota_core_hybrid_bm_pex_half_1.iqmod_mfb_lpf_ota_core_inv_NF10_0.vin VDD VDD sg13_lv_pmos ad=1.14p pd=6.38u as=1.14p ps=6.38u w=6u l=1u
X263 VDD iqmod_mfb_lpf_ota_core_hybrid_bm_pex_half_1.iqmod_mfb_lpf_ota_core_inv_NF10_0.vin voutn VDD sg13_lv_pmos ad=1.14p pd=6.38u as=1.14p ps=6.38u w=6u l=1u
X264 iqmod_mfb_lpf_ota_core_hybrid_bm_pex_half_1.iqmod_mfb_lpf_ota_core_tg_1.v_a voutn VDD VDD sg13_lv_pmos ad=1.14p pd=6.38u as=1.14p ps=6.38u w=6u l=1u
X265 VDD iqmod_mfb_lpf_ota_core_hybrid_bm_pex_half_0.iqmod_mfb_lpf_ota_core_inv_NF10_0.vin voutp VDD sg13_lv_pmos ad=1.14p pd=6.38u as=1.14p ps=6.38u w=6u l=1u
X266 VDD iqmod_mfb_lpf_ota_core_hybrid_bm_pex_half_1.iqmod_mfb_lpf_ota_core_inv_NF10_0.vin iqmod_mfb_lpf_ota_core_hybrid_bm_pex_half_1.iqmod_mfb_lpf_ota_core_inv_NF10_0.vout VDD sg13_lv_pmos ad=1.14p pd=6.38u as=1.14p ps=6.38u w=6u l=1u
X267 voutn iqmod_mfb_lpf_ota_core_hybrid_bm_pex_half_1.iqmod_mfb_lpf_ota_core_inv_NF10_0.vin VDD VDD sg13_lv_pmos ad=1.14p pd=6.38u as=1.14p ps=6.38u w=6u l=1u
X268 VDD voutn iqmod_mfb_lpf_ota_core_hybrid_bm_pex_half_1.iqmod_mfb_lpf_ota_core_tg_1.v_a VDD sg13_lv_pmos ad=1.14p pd=6.38u as=1.14p ps=6.38u w=6u l=1u
X269 voutp iqmod_mfb_lpf_ota_core_hybrid_bm_pex_half_1.iqmod_mfb_lpf_ota_core_inv_NF6_0.vout VSS VSS sg13_lv_nmos ad=0.19p pd=1.38u as=0.19p ps=1.38u w=1u l=1u
X270 iqmod_mfb_lpf_ota_core_hybrid_bm_pex_half_1.iqmod_mfb_lpf_ota_core_tg_1.v_a voutp VDD VDD sg13_lv_pmos ad=1.14p pd=6.38u as=1.14p ps=6.38u w=6u l=1u
X271 iqmod_mfb_lpf_ota_core_hybrid_bm_pex_half_1.iqmod_mfb_lpf_ota_core_inv_NF6_0.vout di_ota_en iqmod_mfb_lpf_ota_core_hybrid_bm_pex_half_1.iqmod_mfb_lpf_ota_core_inv_NF10_0.vout VSS sg13_lv_nmos ad=0.19p pd=1.38u as=0.19p ps=1.38u w=1u l=0.13u
X272 iqmod_mfb_lpf_ota_core_hybrid_bm_pex_half_1.iqmod_mfb_lpf_ota_core_inv_NF10_0.vout iqmod_mfb_lpf_ota_core_hybrid_bm_pex_half_1.iqmod_mfb_lpf_ota_core_inv_NF10_0.vin VDD VDD sg13_lv_pmos ad=1.14p pd=6.38u as=1.14p ps=6.38u w=6u l=1u
X273 iqmod_mfb_lpf_ota_core_hybrid_bm_pex_half_1.iqmod_mfb_lpf_ota_core_tg_1.v_a voutn VSS VSS sg13_lv_nmos ad=0.19p pd=1.38u as=0.19p ps=1.38u w=1u l=1u
X274 VSS iqmod_mfb_lpf_ota_core_hybrid_bm_pex_half_1.iqmod_mfb_lpf_ota_core_inv_NF6_0.vout voutp VSS sg13_lv_nmos ad=0.19p pd=1.38u as=0.19p ps=1.38u w=1u l=1u
X275 iqmod_mfb_lpf_ota_core_hybrid_bm_pex_half_1.iqmod_mfb_lpf_ota_core_inv_NF10_0.vout iqmod_mfb_lpf_ota_core_hybrid_bm_pex_half_1.iqmod_mfb_lpf_ota_core_inv_NF10_0.vin VSS VSS sg13_lv_nmos ad=0.19p pd=1.38u as=0.19p ps=1.38u w=1u l=1u
X276 vinp iqmod_mfb_lpf_ota_core_hybrid_bm_pex_half_1.iqmod_mfb_lpf_ota_core_spdt_switch_0.iqmod_mfb_lpf_ota_core_spdt_switch_inv$1_0.vout iqmod_mfb_lpf_ota_core_hybrid_bm_pex_half_1.iqmod_mfb_lpf_ota_core_inv_NF10_0.vin VSS sg13_lv_nmos ad=0.19p pd=1.38u as=0.19p ps=1.38u w=1u l=0.13u
X277 VDD voutp iqmod_mfb_lpf_ota_core_hybrid_bm_pex_half_1.iqmod_mfb_lpf_ota_core_tg_1.v_a VDD sg13_lv_pmos ad=1.14p pd=6.38u as=1.14p ps=6.38u w=6u l=1u
X278 VDD VDD VDD VDD sg13_lv_pmos ad=2.04p pd=12.68u as=0 ps=0 w=6u l=1u
X279 voutp iqmod_mfb_lpf_ota_core_hybrid_bm_pex_half_0.iqmod_mfb_lpf_ota_core_inv_NF10_0.vin VDD VDD sg13_lv_pmos ad=1.14p pd=6.38u as=1.14p ps=6.38u w=6u l=1u
X280 VSS iqmod_mfb_lpf_ota_core_hybrid_bm_pex_half_1.iqmod_mfb_lpf_ota_core_inv_NF10_0.vin voutn VSS sg13_lv_nmos ad=0.19p pd=1.38u as=0.19p ps=1.38u w=1u l=1u
X281 VDD VDD VDD VDD sg13_lv_pmos ad=1.14p pd=6.38u as=0 ps=0 w=6u l=1u
X282 iqmod_mfb_lpf_ota_core_hybrid_bm_pex_half_1.iqmod_mfb_lpf_ota_core_tg_1.v_a voutn VSS VSS sg13_lv_nmos ad=0.19p pd=1.38u as=0.19p ps=1.38u w=1u l=1u
X283 voutn iqmod_mfb_lpf_ota_core_hybrid_bm_pex_half_1.iqmod_mfb_lpf_ota_core_inv_NF6_0.vout VSS VSS sg13_lv_nmos ad=0.19p pd=1.38u as=0.19p ps=1.38u w=1u l=1u
X284 VDD VDD VDD VDD sg13_lv_pmos ad=1.14p pd=6.38u as=0 ps=0 w=6u l=0.13u
X285 VDD VDD VDD VDD sg13_lv_pmos ad=2.04p pd=12.68u as=0 ps=0 w=6u l=1u
X286 voutp iqmod_mfb_lpf_ota_core_hybrid_bm_pex_half_0.iqmod_mfb_lpf_ota_core_inv_NF10_0.vin VSS VSS sg13_lv_nmos ad=0.19p pd=1.38u as=0.19p ps=1.38u w=1u l=1u
X287 voutn iqmod_mfb_lpf_ota_core_hybrid_bm_pex_half_1.iqmod_mfb_lpf_ota_core_inv_NF10_0.vin VSS VSS sg13_lv_nmos ad=0.19p pd=1.38u as=0.19p ps=1.38u w=1u l=1u
X288 iqmod_mfb_lpf_ota_core_hybrid_bm_pex_half_1.iqmod_mfb_lpf_ota_core_tg_1.v_a voutp VDD VDD sg13_lv_pmos ad=1.14p pd=6.38u as=1.14p ps=6.38u w=6u l=1u
X289 iqmod_mfb_lpf_ota_core_hybrid_bm_pex_half_1.iqmod_mfb_lpf_ota_core_inv_NF10_0.vout iqmod_mfb_lpf_ota_core_hybrid_bm_pex_half_0.iqmod_mfb_lpf_ota_core_inv_NF10_0.vin VSS VSS sg13_lv_nmos ad=0.19p pd=1.38u as=0.19p ps=1.38u w=1u l=1u
X290 VSS iqmod_mfb_lpf_ota_core_hybrid_bm_pex_half_0.iqmod_mfb_lpf_ota_core_inv_NF10_0.vin voutp VSS sg13_lv_nmos ad=0.19p pd=1.38u as=0.19p ps=1.38u w=1u l=1u
X291 iqmod_mfb_lpf_ota_core_hybrid_bm_pex_half_1.iqmod_mfb_lpf_ota_core_inv_NF6_2.vin iqmod_mfb_lpf_ota_core_hybrid_bm_pex_half_1.iqmod_mfb_lpf_ota_core_tg_1.v_a VDD VDD sg13_lv_pmos ad=1.14p pd=6.38u as=1.14p ps=6.38u w=6u l=1u
X292 VDD VDD VDD VDD sg13_lv_pmos ad=1.14p pd=6.38u as=0 ps=0 w=6u l=1u
X293 VSS VSS VSS VSS sg13_lv_nmos ad=0.19p pd=1.38u as=0 ps=0 w=1u l=1u
X294 iqmod_mfb_lpf_ota_core_hybrid_bm_pex_half_1.iqmod_mfb_lpf_ota_core_tg_1.v_a voutn VSS VSS sg13_lv_nmos ad=0.19p pd=1.38u as=0.19p ps=1.38u w=1u l=1u
X295 VDD iqmod_mfb_lpf_ota_core_hybrid_bm_pex_half_1.iqmod_mfb_lpf_ota_core_tg_1.v_a iqmod_mfb_lpf_ota_core_hybrid_bm_pex_half_1.iqmod_mfb_lpf_ota_core_inv_NF6_2.vin VDD sg13_lv_pmos ad=1.14p pd=6.38u as=1.14p ps=6.38u w=6u l=1u
X296 iqmod_mfb_lpf_ota_core_hybrid_bm_pex_half_0.iqmod_mfb_lpf_ota_core_inv_NF10_0.vin iqmod_mfb_lpf_ota_core_hybrid_bm_pex_half_0.iqmod_mfb_lpf_ota_core_spdt_switch_0.iqmod_mfb_lpf_ota_core_spdt_switch_inv$1_0.vout vinn VSS sg13_lv_nmos ad=0.19p pd=1.38u as=0.34p ps=2.68u w=1u l=0.13u
X297 iqmod_mfb_lpf_ota_core_hybrid_bm_pex_half_0.iqmod_mfb_lpf_ota_core_spdt_switch_0.iqmod_mfb_lpf_ota_core_spdt_switch_inv$1_0.vout iqmod_mfb_lpf_ota_core_hybrid_bm_pex_half_0.iqmod_mfb_lpf_ota_core_spdt_switch_0.do_spdt_ctrl_n VSS VSS sg13_lv_nmos ad=0.19p pd=1.38u as=0.19p ps=1.38u w=1u l=0.13u
X298 iqmod_mfb_lpf_ota_core_hybrid_bm_pex_half_1.iqmod_mfb_lpf_ota_core_inv_NF10_0.vout di_ota_en iqmod_mfb_lpf_ota_core_hybrid_bm_pex_half_1.iqmod_mfb_lpf_ota_core_inv_NF6_0.vout VSS sg13_lv_nmos ad=0.34p pd=2.68u as=0.19p ps=1.38u w=1u l=0.13u
X299 VDD iqmod_mfb_lpf_ota_core_hybrid_bm_pex_half_1.iqmod_mfb_lpf_ota_core_tg_1.v_a iqmod_mfb_lpf_ota_core_hybrid_bm_pex_half_1.iqmod_mfb_lpf_ota_core_inv_NF6_2.vin VDD sg13_lv_pmos ad=1.14p pd=6.38u as=1.14p ps=6.38u w=6u l=1u
X300 VDD VDD VDD VDD sg13_lv_pmos ad=1.14p pd=6.38u as=0 ps=0 w=6u l=1u
X301 iqmod_mfb_lpf_ota_core_hybrid_bm_pex_half_1.iqmod_mfb_lpf_ota_core_inv_NF10_0.vin iqmod_mfb_lpf_ota_core_hybrid_bm_pex_half_1.iqmod_mfb_lpf_ota_core_spdt_switch_0.iqmod_mfb_lpf_ota_core_spdt_switch_inv$1_0.vout vinp VSS sg13_lv_nmos ad=0.19p pd=1.38u as=0.19p ps=1.38u w=1u l=0.13u
X302 VSS VSS VSS VSS sg13_lv_nmos ad=0.34p pd=2.68u as=0 ps=0 w=1u l=1u
X303 VDD voutp iqmod_mfb_lpf_ota_core_hybrid_bm_pex_half_1.iqmod_mfb_lpf_ota_core_tg_1.v_a VDD sg13_lv_pmos ad=1.14p pd=6.38u as=1.14p ps=6.38u w=6u l=1u
X304 iqmod_mfb_lpf_ota_core_hybrid_bm_pex_half_1.iqmod_mfb_lpf_ota_core_inv_NF6_0.vout iqmod_mfb_lpf_ota_core_hybrid_bm_pex_half_1.iqmod_mfb_lpf_ota_core_inv_NF10_0.vout VSS VSS sg13_lv_nmos ad=0.19p pd=1.38u as=0.19p ps=1.38u w=1u l=1u
X305 VDD VDD VDD VDD sg13_lv_pmos ad=2.04p pd=12.68u as=0 ps=0 w=6u l=0.13u
X306 VSS iqmod_mfb_lpf_ota_core_hybrid_bm_pex_half_1.iqmod_mfb_lpf_ota_core_inv_NF6_2.vin iqmod_mfb_lpf_ota_core_hybrid_bm_pex_half_1.iqmod_mfb_lpf_ota_core_inv_NF6_0.vout VSS sg13_lv_nmos ad=0.19p pd=1.38u as=0.19p ps=1.38u w=1u l=1u
X307 iqmod_mfb_lpf_ota_core_hybrid_bm_pex_half_1.iqmod_mfb_lpf_ota_core_inv_NF6_0.vout iqmod_mfb_lpf_ota_core_hybrid_bm_pex_half_1.iqmod_mfb_lpf_ota_core_inv_NF10_0.vout VSS VSS sg13_lv_nmos ad=0.19p pd=1.38u as=0.19p ps=1.38u w=1u l=1u
X308 VDD iqmod_mfb_lpf_ota_core_hybrid_bm_pex_half_1.iqmod_mfb_lpf_ota_core_inv_NF6_0.vout voutp VDD sg13_lv_pmos ad=1.14p pd=6.38u as=1.14p ps=6.38u w=6u l=1u
X309 VSS di_ota_en iqmod_mfb_lpf_ota_core_hybrid_bm_pex_half_0.iqmod_mfb_lpf_ota_core_spdt_switch_0.do_spdt_ctrl_n VSS sg13_lv_nmos ad=0.19p pd=1.38u as=0.19p ps=1.38u w=1u l=0.13u
X310 vinp iqmod_mfb_lpf_ota_core_hybrid_bm_pex_half_1.iqmod_mfb_lpf_ota_core_spdt_switch_0.iqmod_mfb_lpf_ota_core_spdt_switch_inv$1_0.vout iqmod_mfb_lpf_ota_core_hybrid_bm_pex_half_1.iqmod_mfb_lpf_ota_core_inv_NF10_0.vin VSS sg13_lv_nmos ad=0.19p pd=1.38u as=0.19p ps=1.38u w=1u l=0.13u
X311 VSS VSS VSS VSS sg13_lv_nmos ad=0.34p pd=2.68u as=0 ps=0 w=1u l=1u
X312 voutp iqmod_mfb_lpf_ota_core_hybrid_bm_pex_half_0.iqmod_mfb_lpf_ota_core_inv_NF10_0.vin VDD VDD sg13_lv_pmos ad=1.14p pd=6.38u as=1.14p ps=6.38u w=6u l=1u
X313 voutn iqmod_mfb_lpf_ota_core_hybrid_bm_pex_half_1.iqmod_mfb_lpf_ota_core_inv_NF10_0.vin VDD VDD sg13_lv_pmos ad=1.14p pd=6.38u as=1.14p ps=6.38u w=6u l=1u
X314 iqmod_mfb_lpf_ota_core_hybrid_bm_pex_half_0.iqmod_mfb_lpf_ota_core_inv_NF10_0.vin iqmod_mfb_lpf_ota_core_hybrid_bm_pex_half_0.iqmod_mfb_lpf_ota_core_spdt_switch_0.iqmod_mfb_lpf_ota_core_spdt_switch_inv$1_0.vout VDD VDD sg13_lv_pmos ad=1.14p pd=6.38u as=1.14p ps=6.38u w=6u l=0.13u
X315 VSS iqmod_mfb_lpf_ota_core_hybrid_bm_pex_half_1.iqmod_mfb_lpf_ota_core_tg_1.v_a iqmod_mfb_lpf_ota_core_hybrid_bm_pex_half_1.iqmod_mfb_lpf_ota_core_inv_NF6_2.vin VSS sg13_lv_nmos ad=0.19p pd=1.38u as=0.19p ps=1.38u w=1u l=1u
X316 iqmod_mfb_lpf_ota_core_hybrid_bm_pex_half_1.iqmod_mfb_lpf_ota_core_inv_NF10_0.vout iqmod_mfb_lpf_ota_core_hybrid_bm_pex_half_0.iqmod_mfb_lpf_ota_core_inv_NF10_0.vin VDD VDD sg13_lv_pmos ad=1.14p pd=6.38u as=1.14p ps=6.38u w=6u l=1u
X317 voutn iqmod_mfb_lpf_ota_core_hybrid_bm_pex_half_1.iqmod_mfb_lpf_ota_core_inv_NF10_0.vin VSS VSS sg13_lv_nmos ad=0.19p pd=1.38u as=0.19p ps=1.38u w=1u l=1u
X318 iqmod_mfb_lpf_ota_core_hybrid_bm_pex_half_1.iqmod_mfb_lpf_ota_core_inv_NF10_0.vout iqmod_mfb_lpf_ota_core_hybrid_bm_pex_half_1.iqmod_mfb_lpf_ota_core_inv_NF10_0.vin VDD VDD sg13_lv_pmos ad=1.14p pd=6.38u as=1.14p ps=6.38u w=6u l=1u
X319 VSS voutn iqmod_mfb_lpf_ota_core_hybrid_bm_pex_half_1.iqmod_mfb_lpf_ota_core_tg_1.v_a VSS sg13_lv_nmos ad=0.19p pd=1.38u as=0.19p ps=1.38u w=1u l=1u
X320 iqmod_mfb_lpf_ota_core_hybrid_bm_pex_half_1.iqmod_mfb_lpf_ota_core_tg_1.v_a voutn VDD VDD sg13_lv_pmos ad=1.14p pd=6.38u as=1.14p ps=6.38u w=6u l=1u
X321 voutp iqmod_mfb_lpf_ota_core_hybrid_bm_pex_half_1.iqmod_mfb_lpf_ota_core_inv_NF6_0.vout VDD VDD sg13_lv_pmos ad=1.14p pd=6.38u as=1.14p ps=6.38u w=6u l=1u
X322 iqmod_mfb_lpf_ota_core_hybrid_bm_pex_half_1.iqmod_mfb_lpf_ota_core_inv_NF6_2.vin iqmod_mfb_lpf_ota_core_hybrid_bm_pex_half_0.iqmod_mfb_lpf_ota_core_spdt_switch_0.do_spdt_ctrl_n iqmod_mfb_lpf_ota_core_hybrid_bm_pex_half_1.iqmod_mfb_lpf_ota_core_tg_1.v_a VDD sg13_lv_pmos ad=1.14p pd=6.38u as=1.14p ps=6.38u w=6u l=0.13u
X323 VDD iqmod_mfb_lpf_ota_core_hybrid_bm_pex_half_1.iqmod_mfb_lpf_ota_core_inv_NF10_0.vin voutn VDD sg13_lv_pmos ad=1.14p pd=6.38u as=1.14p ps=6.38u w=6u l=1u
X324 VDD iqmod_mfb_lpf_ota_core_hybrid_bm_pex_half_0.iqmod_mfb_lpf_ota_core_inv_NF10_0.vin voutp VDD sg13_lv_pmos ad=1.14p pd=6.38u as=1.14p ps=6.38u w=6u l=1u
X325 iqmod_mfb_lpf_ota_core_hybrid_bm_pex_half_1.iqmod_mfb_lpf_ota_core_inv_NF6_0.vout iqmod_mfb_lpf_ota_core_hybrid_bm_pex_half_1.iqmod_mfb_lpf_ota_core_spdt_switch_0.do_spdt_ctrl_n iqmod_mfb_lpf_ota_core_hybrid_bm_pex_half_1.iqmod_mfb_lpf_ota_core_inv_NF10_0.vout VDD sg13_lv_pmos ad=1.14p pd=6.38u as=1.14p ps=6.38u w=6u l=0.13u
X326 voutp iqmod_mfb_lpf_ota_core_hybrid_bm_pex_half_1.iqmod_mfb_lpf_ota_core_inv_NF6_0.vout VSS VSS sg13_lv_nmos ad=0.19p pd=1.38u as=0.19p ps=1.38u w=1u l=1u
X327 iqmod_mfb_lpf_ota_core_hybrid_bm_pex_half_1.iqmod_mfb_lpf_ota_core_inv_NF10_0.vin iqmod_mfb_lpf_ota_core_hybrid_bm_pex_half_1.iqmod_mfb_lpf_ota_core_spdt_switch_0.do_spdt_ctrl_n vinp VDD sg13_lv_pmos ad=1.14p pd=6.38u as=1.14p ps=6.38u w=6u l=0.13u
X328 VDD iqmod_mfb_lpf_ota_core_hybrid_bm_pex_half_0.iqmod_mfb_lpf_ota_core_inv_NF10_0.vin iqmod_mfb_lpf_ota_core_hybrid_bm_pex_half_1.iqmod_mfb_lpf_ota_core_inv_NF10_0.vout VDD sg13_lv_pmos ad=1.14p pd=6.38u as=1.14p ps=6.38u w=6u l=1u
X329 voutn iqmod_mfb_lpf_ota_core_hybrid_bm_pex_half_1.iqmod_mfb_lpf_ota_core_inv_NF10_0.vin VSS VSS sg13_lv_nmos ad=0.19p pd=1.38u as=0.19p ps=1.38u w=1u l=1u
X330 vinp iqmod_mfb_lpf_ota_core_hybrid_bm_pex_half_1.iqmod_mfb_lpf_ota_core_spdt_switch_0.do_spdt_ctrl_n iqmod_mfb_lpf_ota_core_hybrid_bm_pex_half_1.iqmod_mfb_lpf_ota_core_inv_NF10_0.vin VDD sg13_lv_pmos ad=1.14p pd=6.38u as=1.14p ps=6.38u w=6u l=0.13u
X331 VDD iqmod_mfb_lpf_ota_core_hybrid_bm_pex_half_1.iqmod_mfb_lpf_ota_core_inv_NF10_0.vin iqmod_mfb_lpf_ota_core_hybrid_bm_pex_half_1.iqmod_mfb_lpf_ota_core_inv_NF10_0.vout VDD sg13_lv_pmos ad=1.14p pd=6.38u as=1.14p ps=6.38u w=6u l=1u
X332 iqmod_mfb_lpf_ota_core_hybrid_bm_pex_half_1.iqmod_mfb_lpf_ota_core_inv_NF10_0.vout iqmod_mfb_lpf_ota_core_hybrid_bm_pex_half_1.iqmod_mfb_lpf_ota_core_spdt_switch_0.do_spdt_ctrl_n iqmod_mfb_lpf_ota_core_hybrid_bm_pex_half_1.iqmod_mfb_lpf_ota_core_inv_NF6_0.vout VDD sg13_lv_pmos ad=1.14p pd=6.38u as=1.14p ps=6.38u w=6u l=0.13u
X333 VSS iqmod_mfb_lpf_ota_core_hybrid_bm_pex_half_1.iqmod_mfb_lpf_ota_core_inv_NF6_0.vout voutn VSS sg13_lv_nmos ad=0.19p pd=1.38u as=0.19p ps=1.38u w=1u l=1u
X334 VSS VSS VSS VSS sg13_lv_nmos ad=0.34p pd=2.68u as=0 ps=0 w=1u l=1u
X335 iqmod_mfb_lpf_ota_core_hybrid_bm_pex_half_1.iqmod_mfb_lpf_ota_core_inv_NF6_0.vout iqmod_mfb_lpf_ota_core_hybrid_bm_pex_half_1.iqmod_mfb_lpf_ota_core_inv_NF6_2.vin VDD VDD sg13_lv_pmos ad=1.14p pd=6.38u as=1.14p ps=6.38u w=6u l=1u
X336 VDD voutp iqmod_mfb_lpf_ota_core_hybrid_bm_pex_half_1.iqmod_mfb_lpf_ota_core_tg_1.v_a VDD sg13_lv_pmos ad=1.14p pd=6.38u as=1.14p ps=6.38u w=6u l=1u
X337 VSS iqmod_mfb_lpf_ota_core_hybrid_bm_pex_half_0.iqmod_mfb_lpf_ota_core_inv_NF10_0.vin voutp VSS sg13_lv_nmos ad=0.19p pd=1.38u as=0.19p ps=1.38u w=1u l=1u
X338 iqmod_mfb_lpf_ota_core_hybrid_bm_pex_half_1.iqmod_mfb_lpf_ota_core_inv_NF10_0.vout iqmod_mfb_lpf_ota_core_hybrid_bm_pex_half_1.iqmod_mfb_lpf_ota_core_inv_NF10_0.vin VSS VSS sg13_lv_nmos ad=0.19p pd=1.38u as=0.19p ps=1.38u w=1u l=1u
X339 iqmod_mfb_lpf_ota_core_hybrid_bm_pex_half_1.iqmod_mfb_lpf_ota_core_inv_NF10_0.vin iqmod_mfb_lpf_ota_core_hybrid_bm_pex_half_1.iqmod_mfb_lpf_ota_core_spdt_switch_0.iqmod_mfb_lpf_ota_core_spdt_switch_inv$1_0.vout vinp VSS sg13_lv_nmos ad=0.19p pd=1.38u as=0.19p ps=1.38u w=1u l=0.13u
X340 iqmod_mfb_lpf_ota_core_hybrid_bm_pex_half_1.iqmod_mfb_lpf_ota_core_inv_NF6_0.vout di_ota_en iqmod_mfb_lpf_ota_core_hybrid_bm_pex_half_1.iqmod_mfb_lpf_ota_core_inv_NF10_0.vout VSS sg13_lv_nmos ad=0.19p pd=1.38u as=0.19p ps=1.38u w=1u l=0.13u
X341 iqmod_mfb_lpf_ota_core_hybrid_bm_pex_half_1.iqmod_mfb_lpf_ota_core_inv_NF6_0.vout iqmod_mfb_lpf_ota_core_hybrid_bm_pex_half_1.iqmod_mfb_lpf_ota_core_inv_NF10_0.vout VSS VSS sg13_lv_nmos ad=0.19p pd=1.38u as=0.19p ps=1.38u w=1u l=1u
X342 voutp iqmod_mfb_lpf_ota_core_hybrid_bm_pex_half_0.iqmod_mfb_lpf_ota_core_inv_NF10_0.vin VDD VDD sg13_lv_pmos ad=1.14p pd=6.38u as=1.14p ps=6.38u w=6u l=1u
X343 VSS iqmod_mfb_lpf_ota_core_hybrid_bm_pex_half_0.iqmod_mfb_lpf_ota_core_inv_NF10_0.vin iqmod_mfb_lpf_ota_core_hybrid_bm_pex_half_1.iqmod_mfb_lpf_ota_core_inv_NF10_0.vout VSS sg13_lv_nmos ad=0.19p pd=1.38u as=0.19p ps=1.38u w=1u l=1u
X344 voutp iqmod_mfb_lpf_ota_core_hybrid_bm_pex_half_0.iqmod_mfb_lpf_ota_core_inv_NF10_0.vin VSS VSS sg13_lv_nmos ad=0.19p pd=1.38u as=0.19p ps=1.38u w=1u l=1u
X345 VDD VDD VDD VDD sg13_lv_pmos ad=2.04p pd=12.68u as=0 ps=0 w=6u l=1u
X346 VDD iqmod_mfb_lpf_ota_core_hybrid_bm_pex_half_0.iqmod_mfb_lpf_ota_core_spdt_switch_0.iqmod_mfb_lpf_ota_core_spdt_switch_inv$1_0.vout iqmod_mfb_lpf_ota_core_hybrid_bm_pex_half_0.iqmod_mfb_lpf_ota_core_inv_NF10_0.vin VDD sg13_lv_pmos ad=2.04p pd=12.68u as=1.14p ps=6.38u w=6u l=0.13u
X347 iqmod_mfb_lpf_ota_core_hybrid_bm_pex_half_0.iqmod_mfb_lpf_ota_core_inv_NF10_0.vin iqmod_mfb_lpf_ota_core_hybrid_bm_pex_half_0.iqmod_mfb_lpf_ota_core_spdt_switch_0.do_spdt_ctrl_n vinn VDD sg13_lv_pmos ad=1.14p pd=6.38u as=1.14p ps=6.38u w=6u l=0.13u
X348 iqmod_mfb_lpf_ota_core_hybrid_bm_pex_half_1.iqmod_mfb_lpf_ota_core_tg_1.v_a voutn VDD VDD sg13_lv_pmos ad=1.14p pd=6.38u as=1.14p ps=6.38u w=6u l=1u
X349 VDD iqmod_mfb_lpf_ota_core_hybrid_bm_pex_half_1.iqmod_mfb_lpf_ota_core_inv_NF10_0.vout iqmod_mfb_lpf_ota_core_hybrid_bm_pex_half_1.iqmod_mfb_lpf_ota_core_inv_NF6_0.vout VDD sg13_lv_pmos ad=1.14p pd=6.38u as=1.14p ps=6.38u w=6u l=1u
X350 iqmod_mfb_lpf_ota_core_hybrid_bm_pex_half_1.iqmod_mfb_lpf_ota_core_inv_NF10_0.vout iqmod_mfb_lpf_ota_core_hybrid_bm_pex_half_0.iqmod_mfb_lpf_ota_core_inv_NF10_0.vin VDD VDD sg13_lv_pmos ad=1.14p pd=6.38u as=1.14p ps=6.38u w=6u l=1u
X351 iqmod_mfb_lpf_ota_core_hybrid_bm_pex_half_0.iqmod_mfb_lpf_ota_core_spdt_switch_0.iqmod_mfb_lpf_ota_core_spdt_switch_inv$1_0.vout iqmod_mfb_lpf_ota_core_hybrid_bm_pex_half_0.iqmod_mfb_lpf_ota_core_spdt_switch_0.do_spdt_ctrl_n VDD VDD sg13_lv_pmos ad=1.14p pd=6.38u as=1.14p ps=6.38u w=6u l=0.13u
X352 iqmod_mfb_lpf_ota_core_hybrid_bm_pex_half_1.iqmod_mfb_lpf_ota_core_inv_NF6_0.vout iqmod_mfb_lpf_ota_core_hybrid_bm_pex_half_1.iqmod_mfb_lpf_ota_core_inv_NF6_2.vin VDD VDD sg13_lv_pmos ad=1.14p pd=6.38u as=1.14p ps=6.38u w=6u l=1u
X353 VSS VSS VSS VSS sg13_lv_nmos ad=0.19p pd=1.38u as=0 ps=0 w=1u l=1u
X354 voutp iqmod_mfb_lpf_ota_core_hybrid_bm_pex_half_1.iqmod_mfb_lpf_ota_core_inv_NF6_0.vout VDD VDD sg13_lv_pmos ad=1.14p pd=6.38u as=1.14p ps=6.38u w=6u l=1u
X355 VDD iqmod_mfb_lpf_ota_core_hybrid_bm_pex_half_0.iqmod_mfb_lpf_ota_core_spdt_switch_0.iqmod_mfb_lpf_ota_core_spdt_switch_inv$1_0.vout iqmod_mfb_lpf_ota_core_hybrid_bm_pex_half_0.iqmod_mfb_lpf_ota_core_inv_NF10_0.vin VDD sg13_lv_pmos ad=1.14p pd=6.38u as=1.14p ps=6.38u w=6u l=0.13u
X356 iqmod_mfb_lpf_ota_core_hybrid_bm_pex_half_1.iqmod_mfb_lpf_ota_core_tg_1.v_a voutn VSS VSS sg13_lv_nmos ad=0.19p pd=1.38u as=0.19p ps=1.38u w=1u l=1u
X357 voutn iqmod_mfb_lpf_ota_core_hybrid_bm_pex_half_1.iqmod_mfb_lpf_ota_core_inv_NF10_0.vin VDD VDD sg13_lv_pmos ad=1.14p pd=6.38u as=1.14p ps=6.38u w=6u l=1u
X358 iqmod_mfb_lpf_ota_core_hybrid_bm_pex_half_1.iqmod_mfb_lpf_ota_core_inv_NF6_2.vin iqmod_mfb_lpf_ota_core_hybrid_bm_pex_half_1.iqmod_mfb_lpf_ota_core_tg_1.v_a VDD VDD sg13_lv_pmos ad=1.14p pd=6.38u as=1.14p ps=6.38u w=6u l=1u
X359 VDD iqmod_mfb_lpf_ota_core_hybrid_bm_pex_half_0.iqmod_mfb_lpf_ota_core_inv_NF10_0.vin voutp VDD sg13_lv_pmos ad=1.14p pd=6.38u as=1.14p ps=6.38u w=6u l=1u
X360 VDD iqmod_mfb_lpf_ota_core_hybrid_bm_pex_half_1.iqmod_mfb_lpf_ota_core_inv_NF6_2.vin iqmod_mfb_lpf_ota_core_hybrid_bm_pex_half_1.iqmod_mfb_lpf_ota_core_inv_NF6_0.vout VDD sg13_lv_pmos ad=1.14p pd=6.38u as=1.14p ps=6.38u w=6u l=1u
X361 iqmod_mfb_lpf_ota_core_hybrid_bm_pex_half_1.iqmod_mfb_lpf_ota_core_inv_NF6_2.vin iqmod_mfb_lpf_ota_core_hybrid_bm_pex_half_1.iqmod_mfb_lpf_ota_core_spdt_switch_0.do_spdt_ctrl_n iqmod_mfb_lpf_ota_core_hybrid_bm_pex_half_1.iqmod_mfb_lpf_ota_core_tg_1.v_a VDD sg13_lv_pmos ad=1.14p pd=6.38u as=1.14p ps=6.38u w=6u l=0.13u
X362 VDD iqmod_mfb_lpf_ota_core_hybrid_bm_pex_half_0.iqmod_mfb_lpf_ota_core_inv_NF10_0.vin iqmod_mfb_lpf_ota_core_hybrid_bm_pex_half_1.iqmod_mfb_lpf_ota_core_inv_NF10_0.vout VDD sg13_lv_pmos ad=1.14p pd=6.38u as=1.14p ps=6.38u w=6u l=1u
X363 VDD VDD VDD VDD sg13_lv_pmos ad=1.14p pd=6.38u as=0 ps=0 w=6u l=1u
X364 iqmod_mfb_lpf_ota_core_hybrid_bm_pex_half_1.iqmod_mfb_lpf_ota_core_tg_1.v_a iqmod_mfb_lpf_ota_core_hybrid_bm_pex_half_0.iqmod_mfb_lpf_ota_core_spdt_switch_0.do_spdt_ctrl_n iqmod_mfb_lpf_ota_core_hybrid_bm_pex_half_1.iqmod_mfb_lpf_ota_core_inv_NF6_2.vin VDD sg13_lv_pmos ad=2.04p pd=12.68u as=1.14p ps=6.38u w=6u l=0.13u
X365 iqmod_mfb_lpf_ota_core_hybrid_bm_pex_half_1.iqmod_mfb_lpf_ota_core_inv_NF6_0.vout iqmod_mfb_lpf_ota_core_hybrid_bm_pex_half_1.iqmod_mfb_lpf_ota_core_inv_NF6_2.vin VSS VSS sg13_lv_nmos ad=0.19p pd=1.38u as=0.19p ps=1.38u w=1u l=1u
X366 VSS iqmod_mfb_lpf_ota_core_hybrid_bm_pex_half_1.iqmod_mfb_lpf_ota_core_inv_NF10_0.vout iqmod_mfb_lpf_ota_core_hybrid_bm_pex_half_1.iqmod_mfb_lpf_ota_core_inv_NF6_0.vout VSS sg13_lv_nmos ad=0.19p pd=1.38u as=0.19p ps=1.38u w=1u l=1u
X367 VSS iqmod_mfb_lpf_ota_core_hybrid_bm_pex_half_1.iqmod_mfb_lpf_ota_core_inv_NF10_0.vout iqmod_mfb_lpf_ota_core_hybrid_bm_pex_half_1.iqmod_mfb_lpf_ota_core_inv_NF6_0.vout VSS sg13_lv_nmos ad=0.19p pd=1.38u as=0.19p ps=1.38u w=1u l=1u
X368 voutn iqmod_mfb_lpf_ota_core_hybrid_bm_pex_half_1.iqmod_mfb_lpf_ota_core_inv_NF6_0.vout VDD VDD sg13_lv_pmos ad=1.14p pd=6.38u as=1.14p ps=6.38u w=6u l=1u
X369 iqmod_mfb_lpf_ota_core_hybrid_bm_pex_half_1.iqmod_mfb_lpf_ota_core_tg_1.v_a di_ota_en iqmod_mfb_lpf_ota_core_hybrid_bm_pex_half_1.iqmod_mfb_lpf_ota_core_inv_NF6_2.vin VSS sg13_lv_nmos ad=0.34p pd=2.68u as=0.19p ps=1.38u w=1u l=0.13u
X370 iqmod_mfb_lpf_ota_core_hybrid_bm_pex_half_1.iqmod_mfb_lpf_ota_core_inv_NF6_2.vin di_ota_en iqmod_mfb_lpf_ota_core_hybrid_bm_pex_half_1.iqmod_mfb_lpf_ota_core_tg_1.v_a VSS sg13_lv_nmos ad=0.19p pd=1.38u as=0.19p ps=1.38u w=1u l=0.13u
X371 iqmod_mfb_lpf_ota_core_hybrid_bm_pex_half_1.iqmod_mfb_lpf_ota_core_tg_1.v_a voutp VSS VSS sg13_lv_nmos ad=0.19p pd=1.38u as=0.19p ps=1.38u w=1u l=1u
X372 VDD iqmod_mfb_lpf_ota_core_hybrid_bm_pex_half_1.iqmod_mfb_lpf_ota_core_inv_NF10_0.vout iqmod_mfb_lpf_ota_core_hybrid_bm_pex_half_1.iqmod_mfb_lpf_ota_core_inv_NF6_0.vout VDD sg13_lv_pmos ad=1.14p pd=6.38u as=1.14p ps=6.38u w=6u l=1u
X373 iqmod_mfb_lpf_ota_core_hybrid_bm_pex_half_1.iqmod_mfb_lpf_ota_core_inv_NF6_0.vout iqmod_mfb_lpf_ota_core_hybrid_bm_pex_half_1.iqmod_mfb_lpf_ota_core_inv_NF6_2.vin VDD VDD sg13_lv_pmos ad=1.14p pd=6.38u as=1.14p ps=6.38u w=6u l=1u
X374 iqmod_mfb_lpf_ota_core_hybrid_bm_pex_half_1.iqmod_mfb_lpf_ota_core_inv_NF10_0.vin iqmod_mfb_lpf_ota_core_hybrid_bm_pex_half_1.iqmod_mfb_lpf_ota_core_spdt_switch_0.iqmod_mfb_lpf_ota_core_spdt_switch_inv$1_0.vout VDD VDD sg13_lv_pmos ad=1.14p pd=6.38u as=1.14p ps=6.38u w=6u l=0.13u
X375 VSS iqmod_mfb_lpf_ota_core_hybrid_bm_pex_half_1.iqmod_mfb_lpf_ota_core_inv_NF10_0.vin voutn VSS sg13_lv_nmos ad=0.19p pd=1.38u as=0.19p ps=1.38u w=1u l=1u
X376 vinp iqmod_mfb_lpf_ota_core_hybrid_bm_pex_half_1.iqmod_mfb_lpf_ota_core_spdt_switch_0.iqmod_mfb_lpf_ota_core_spdt_switch_inv$1_0.vout iqmod_mfb_lpf_ota_core_hybrid_bm_pex_half_1.iqmod_mfb_lpf_ota_core_inv_NF10_0.vin VSS sg13_lv_nmos ad=0.34p pd=2.68u as=0.19p ps=1.38u w=1u l=0.13u
X377 iqmod_mfb_lpf_ota_core_hybrid_bm_pex_half_1.iqmod_mfb_lpf_ota_core_inv_NF6_2.vin iqmod_mfb_lpf_ota_core_hybrid_bm_pex_half_1.iqmod_mfb_lpf_ota_core_tg_1.v_a VSS VSS sg13_lv_nmos ad=0.19p pd=1.38u as=0.19p ps=1.38u w=1u l=1u
X378 voutn iqmod_mfb_lpf_ota_core_hybrid_bm_pex_half_1.iqmod_mfb_lpf_ota_core_inv_NF6_0.vout VSS VSS sg13_lv_nmos ad=0.19p pd=1.38u as=0.19p ps=1.38u w=1u l=1u
X379 iqmod_mfb_lpf_ota_core_hybrid_bm_pex_half_1.iqmod_mfb_lpf_ota_core_inv_NF10_0.vin iqmod_mfb_lpf_ota_core_hybrid_bm_pex_half_1.iqmod_mfb_lpf_ota_core_spdt_switch_0.iqmod_mfb_lpf_ota_core_spdt_switch_inv$1_0.vout vinp VSS sg13_lv_nmos ad=0.19p pd=1.38u as=0.34p ps=2.68u w=1u l=0.13u
X380 VSS voutp iqmod_mfb_lpf_ota_core_hybrid_bm_pex_half_1.iqmod_mfb_lpf_ota_core_tg_1.v_a VSS sg13_lv_nmos ad=0.19p pd=1.38u as=0.19p ps=1.38u w=1u l=1u
X381 iqmod_mfb_lpf_ota_core_hybrid_bm_pex_half_1.iqmod_mfb_lpf_ota_core_tg_1.v_a iqmod_mfb_lpf_ota_core_hybrid_bm_pex_half_1.iqmod_mfb_lpf_ota_core_spdt_switch_0.do_spdt_ctrl_n iqmod_mfb_lpf_ota_core_hybrid_bm_pex_half_1.iqmod_mfb_lpf_ota_core_inv_NF6_2.vin VDD sg13_lv_pmos ad=1.14p pd=6.38u as=1.14p ps=6.38u w=6u l=0.13u
X382 iqmod_mfb_lpf_ota_core_hybrid_bm_pex_half_1.iqmod_mfb_lpf_ota_core_tg_1.v_a voutn VDD VDD sg13_lv_pmos ad=1.14p pd=6.38u as=1.14p ps=6.38u w=6u l=1u
X383 VDD iqmod_mfb_lpf_ota_core_hybrid_bm_pex_half_0.iqmod_mfb_lpf_ota_core_inv_NF10_0.vin voutp VDD sg13_lv_pmos ad=1.14p pd=6.38u as=1.14p ps=6.38u w=6u l=1u
X384 VSS VSS VSS VSS sg13_lv_nmos ad=0.34p pd=2.68u as=0 ps=0 w=1u l=1u
X385 VSS iqmod_mfb_lpf_ota_core_hybrid_bm_pex_half_1.iqmod_mfb_lpf_ota_core_inv_NF6_0.vout voutn VSS sg13_lv_nmos ad=0.19p pd=1.38u as=0.19p ps=1.38u w=1u l=1u
X386 iqmod_mfb_lpf_ota_core_hybrid_bm_pex_half_1.iqmod_mfb_lpf_ota_core_tg_1.v_a voutp VSS VSS sg13_lv_nmos ad=0.19p pd=1.38u as=0.19p ps=1.38u w=1u l=1u
X387 VDD VDD VDD VDD sg13_lv_pmos ad=2.04p pd=12.68u as=0 ps=0 w=6u l=1u
X388 VDD iqmod_mfb_lpf_ota_core_hybrid_bm_pex_half_0.iqmod_mfb_lpf_ota_core_spdt_switch_0.do_spdt_ctrl_n iqmod_mfb_lpf_ota_core_hybrid_bm_pex_half_0.iqmod_mfb_lpf_ota_core_inv_NF10_0.vin VSS sg13_lv_nmos ad=0.34p pd=2.68u as=0.19p ps=1.38u w=1u l=0.13u
X389 VDD iqmod_mfb_lpf_ota_core_hybrid_bm_pex_half_1.iqmod_mfb_lpf_ota_core_inv_NF10_0.vin voutn VDD sg13_lv_pmos ad=1.14p pd=6.38u as=1.14p ps=6.38u w=6u l=1u
X390 voutp iqmod_mfb_lpf_ota_core_hybrid_bm_pex_half_0.iqmod_mfb_lpf_ota_core_inv_NF10_0.vin VDD VDD sg13_lv_pmos ad=1.14p pd=6.38u as=1.14p ps=6.38u w=6u l=1u
X391 VDD iqmod_mfb_lpf_ota_core_hybrid_bm_pex_half_1.iqmod_mfb_lpf_ota_core_inv_NF6_0.vout voutp VDD sg13_lv_pmos ad=1.14p pd=6.38u as=1.14p ps=6.38u w=6u l=1u
X392 iqmod_mfb_lpf_ota_core_hybrid_bm_pex_half_0.iqmod_mfb_lpf_ota_core_inv_NF10_0.vin iqmod_mfb_lpf_ota_core_hybrid_bm_pex_half_0.iqmod_mfb_lpf_ota_core_spdt_switch_0.do_spdt_ctrl_n VDD VSS sg13_lv_nmos ad=0.19p pd=1.38u as=0.19p ps=1.38u w=1u l=0.13u
X393 iqmod_mfb_lpf_ota_core_hybrid_bm_pex_half_1.iqmod_mfb_lpf_ota_core_tg_1.v_a voutp VDD VDD sg13_lv_pmos ad=1.14p pd=6.38u as=1.14p ps=6.38u w=6u l=1u
X394 VDD di_ota_en iqmod_mfb_lpf_ota_core_hybrid_bm_pex_half_0.iqmod_mfb_lpf_ota_core_spdt_switch_0.do_spdt_ctrl_n VDD sg13_lv_pmos ad=1.14p pd=6.38u as=1.14p ps=6.38u w=6u l=0.13u
X395 iqmod_mfb_lpf_ota_core_hybrid_bm_pex_half_1.iqmod_mfb_lpf_ota_core_tg_1.v_a voutn VDD VDD sg13_lv_pmos ad=1.14p pd=6.38u as=1.14p ps=6.38u w=6u l=1u
X396 VDD iqmod_mfb_lpf_ota_core_hybrid_bm_pex_half_1.iqmod_mfb_lpf_ota_core_inv_NF6_2.vin iqmod_mfb_lpf_ota_core_hybrid_bm_pex_half_1.iqmod_mfb_lpf_ota_core_inv_NF6_0.vout VDD sg13_lv_pmos ad=1.14p pd=6.38u as=1.14p ps=6.38u w=6u l=1u
X397 iqmod_mfb_lpf_ota_core_hybrid_bm_pex_half_1.iqmod_mfb_lpf_ota_core_inv_NF10_0.vout iqmod_mfb_lpf_ota_core_hybrid_bm_pex_half_0.iqmod_mfb_lpf_ota_core_inv_NF10_0.vin VDD VDD sg13_lv_pmos ad=1.14p pd=6.38u as=1.14p ps=6.38u w=6u l=1u
X398 VDD iqmod_mfb_lpf_ota_core_hybrid_bm_pex_half_1.iqmod_mfb_lpf_ota_core_inv_NF10_0.vout iqmod_mfb_lpf_ota_core_hybrid_bm_pex_half_1.iqmod_mfb_lpf_ota_core_inv_NF6_0.vout VDD sg13_lv_pmos ad=1.14p pd=6.38u as=1.14p ps=6.38u w=6u l=1u
X399 VSS iqmod_mfb_lpf_ota_core_hybrid_bm_pex_half_1.iqmod_mfb_lpf_ota_core_inv_NF6_0.vout voutp VSS sg13_lv_nmos ad=0.19p pd=1.38u as=0.19p ps=1.38u w=1u l=1u
X400 voutp iqmod_mfb_lpf_ota_core_hybrid_bm_pex_half_1.iqmod_mfb_lpf_ota_core_inv_NF6_0.vout VDD VDD sg13_lv_pmos ad=1.14p pd=6.38u as=1.14p ps=6.38u w=6u l=1u
X401 VSS voutn iqmod_mfb_lpf_ota_core_hybrid_bm_pex_half_1.iqmod_mfb_lpf_ota_core_tg_1.v_a VSS sg13_lv_nmos ad=0.19p pd=1.38u as=0.19p ps=1.38u w=1u l=1u
X402 VDD voutn iqmod_mfb_lpf_ota_core_hybrid_bm_pex_half_1.iqmod_mfb_lpf_ota_core_tg_1.v_a VDD sg13_lv_pmos ad=1.14p pd=6.38u as=1.14p ps=6.38u w=6u l=1u
X403 VDD VDD VDD VDD sg13_lv_pmos ad=2.04p pd=12.68u as=0 ps=0 w=6u l=1u
X404 VSS iqmod_mfb_lpf_ota_core_hybrid_bm_pex_half_1.iqmod_mfb_lpf_ota_core_inv_NF10_0.vin iqmod_mfb_lpf_ota_core_hybrid_bm_pex_half_1.iqmod_mfb_lpf_ota_core_inv_NF10_0.vout VSS sg13_lv_nmos ad=0.19p pd=1.38u as=0.19p ps=1.38u w=1u l=1u
X405 VSS iqmod_mfb_lpf_ota_core_hybrid_bm_pex_half_1.iqmod_mfb_lpf_ota_core_inv_NF6_0.vout voutp VSS sg13_lv_nmos ad=0.19p pd=1.38u as=0.19p ps=1.38u w=1u l=1u
X406 VDD iqmod_mfb_lpf_ota_core_hybrid_bm_pex_half_0.iqmod_mfb_lpf_ota_core_inv_NF10_0.vin voutp VDD sg13_lv_pmos ad=1.14p pd=6.38u as=1.14p ps=6.38u w=6u l=1u
X407 voutn iqmod_mfb_lpf_ota_core_hybrid_bm_pex_half_1.iqmod_mfb_lpf_ota_core_inv_NF6_0.vout VSS VSS sg13_lv_nmos ad=0.19p pd=1.38u as=0.19p ps=1.38u w=1u l=1u
X408 voutn iqmod_mfb_lpf_ota_core_hybrid_bm_pex_half_1.iqmod_mfb_lpf_ota_core_inv_NF6_0.vout VDD VDD sg13_lv_pmos ad=1.14p pd=6.38u as=1.14p ps=6.38u w=6u l=1u
X409 VSS iqmod_mfb_lpf_ota_core_hybrid_bm_pex_half_1.iqmod_mfb_lpf_ota_core_inv_NF10_0.vout iqmod_mfb_lpf_ota_core_hybrid_bm_pex_half_1.iqmod_mfb_lpf_ota_core_inv_NF6_0.vout VSS sg13_lv_nmos ad=0.19p pd=1.38u as=0.19p ps=1.38u w=1u l=1u
X410 voutn iqmod_mfb_lpf_ota_core_hybrid_bm_pex_half_1.iqmod_mfb_lpf_ota_core_inv_NF10_0.vin VSS VSS sg13_lv_nmos ad=0.19p pd=1.38u as=0.19p ps=1.38u w=1u l=1u
X411 VDD iqmod_mfb_lpf_ota_core_hybrid_bm_pex_half_1.iqmod_mfb_lpf_ota_core_inv_NF6_0.vout voutp VDD sg13_lv_pmos ad=1.14p pd=6.38u as=1.14p ps=6.38u w=6u l=1u
X412 VSS voutn iqmod_mfb_lpf_ota_core_hybrid_bm_pex_half_1.iqmod_mfb_lpf_ota_core_tg_1.v_a VSS sg13_lv_nmos ad=0.19p pd=1.38u as=0.19p ps=1.38u w=1u l=1u
X413 iqmod_mfb_lpf_ota_core_hybrid_bm_pex_half_1.iqmod_mfb_lpf_ota_core_inv_NF10_0.vout iqmod_mfb_lpf_ota_core_hybrid_bm_pex_half_0.iqmod_mfb_lpf_ota_core_spdt_switch_0.do_spdt_ctrl_n iqmod_mfb_lpf_ota_core_hybrid_bm_pex_half_1.iqmod_mfb_lpf_ota_core_inv_NF6_0.vout VDD sg13_lv_pmos ad=1.14p pd=6.38u as=1.14p ps=6.38u w=6u l=0.13u
X414 VDD VDD VDD VDD sg13_lv_pmos ad=2.04p pd=12.68u as=0 ps=0 w=6u l=1u
X415 VSS iqmod_mfb_lpf_ota_core_hybrid_bm_pex_half_0.iqmod_mfb_lpf_ota_core_inv_NF10_0.vin voutp VSS sg13_lv_nmos ad=0.19p pd=1.38u as=0.19p ps=1.38u w=1u l=1u
X416 VDD VDD VDD VDD sg13_lv_pmos ad=2.04p pd=12.68u as=0 ps=0 w=6u l=1u
X417 iqmod_mfb_lpf_ota_core_hybrid_bm_pex_half_1.iqmod_mfb_lpf_ota_core_inv_NF6_2.vin iqmod_mfb_lpf_ota_core_hybrid_bm_pex_half_1.iqmod_mfb_lpf_ota_core_tg_1.v_a VDD VDD sg13_lv_pmos ad=1.14p pd=6.38u as=1.14p ps=6.38u w=6u l=1u
X418 voutn iqmod_mfb_lpf_ota_core_hybrid_bm_pex_half_1.iqmod_mfb_lpf_ota_core_inv_NF10_0.vin VSS VSS sg13_lv_nmos ad=0.19p pd=1.38u as=0.19p ps=1.38u w=1u l=1u
X419 iqmod_mfb_lpf_ota_core_hybrid_bm_pex_half_1.iqmod_mfb_lpf_ota_core_inv_NF6_0.vout iqmod_mfb_lpf_ota_core_hybrid_bm_pex_half_1.iqmod_mfb_lpf_ota_core_inv_NF6_2.vin VDD VDD sg13_lv_pmos ad=1.14p pd=6.38u as=1.14p ps=6.38u w=6u l=1u
X420 VSS iqmod_mfb_lpf_ota_core_hybrid_bm_pex_half_0.iqmod_mfb_lpf_ota_core_inv_NF10_0.vin iqmod_mfb_lpf_ota_core_hybrid_bm_pex_half_1.iqmod_mfb_lpf_ota_core_inv_NF10_0.vout VSS sg13_lv_nmos ad=0.19p pd=1.38u as=0.19p ps=1.38u w=1u l=1u
X421 iqmod_mfb_lpf_ota_core_hybrid_bm_pex_half_0.iqmod_mfb_lpf_ota_core_inv_NF10_0.vin iqmod_mfb_lpf_ota_core_hybrid_bm_pex_half_0.iqmod_mfb_lpf_ota_core_spdt_switch_0.do_spdt_ctrl_n vinn VDD sg13_lv_pmos ad=1.14p pd=6.38u as=2.04p ps=12.68u w=6u l=0.13u
X422 VSS iqmod_mfb_lpf_ota_core_hybrid_bm_pex_half_0.iqmod_mfb_lpf_ota_core_inv_NF10_0.vin voutp VSS sg13_lv_nmos ad=0.19p pd=1.38u as=0.19p ps=1.38u w=1u l=1u
X423 VDD VDD VDD VDD sg13_lv_pmos ad=1.14p pd=6.38u as=0 ps=0 w=6u l=1u
X424 VSS iqmod_mfb_lpf_ota_core_hybrid_bm_pex_half_1.iqmod_mfb_lpf_ota_core_inv_NF6_2.vin iqmod_mfb_lpf_ota_core_hybrid_bm_pex_half_1.iqmod_mfb_lpf_ota_core_inv_NF6_0.vout VSS sg13_lv_nmos ad=0.19p pd=1.38u as=0.19p ps=1.38u w=1u l=1u
X425 iqmod_mfb_lpf_ota_core_hybrid_bm_pex_half_1.iqmod_mfb_lpf_ota_core_inv_NF6_0.vout iqmod_mfb_lpf_ota_core_hybrid_bm_pex_half_1.iqmod_mfb_lpf_ota_core_inv_NF10_0.vout VSS VSS sg13_lv_nmos ad=0.19p pd=1.38u as=0.19p ps=1.38u w=1u l=1u
X426 VDD iqmod_mfb_lpf_ota_core_hybrid_bm_pex_half_1.iqmod_mfb_lpf_ota_core_inv_NF6_2.vin iqmod_mfb_lpf_ota_core_hybrid_bm_pex_half_1.iqmod_mfb_lpf_ota_core_inv_NF6_0.vout VDD sg13_lv_pmos ad=1.14p pd=6.38u as=1.14p ps=6.38u w=6u l=1u
X427 VSS iqmod_mfb_lpf_ota_core_hybrid_bm_pex_half_0.iqmod_mfb_lpf_ota_core_inv_NF10_0.vin iqmod_mfb_lpf_ota_core_hybrid_bm_pex_half_1.iqmod_mfb_lpf_ota_core_inv_NF10_0.vout VSS sg13_lv_nmos ad=0.19p pd=1.38u as=0.19p ps=1.38u w=1u l=1u
X428 VSS VSS VSS VSS sg13_lv_nmos ad=0.34p pd=2.68u as=0 ps=0 w=1u l=1u
X429 iqmod_mfb_lpf_ota_core_hybrid_bm_pex_half_1.iqmod_mfb_lpf_ota_core_tg_1.v_a voutp VDD VDD sg13_lv_pmos ad=1.14p pd=6.38u as=1.14p ps=6.38u w=6u l=1u
X430 iqmod_mfb_lpf_ota_core_hybrid_bm_pex_half_1.iqmod_mfb_lpf_ota_core_inv_NF6_2.vin di_ota_en iqmod_mfb_lpf_ota_core_hybrid_bm_pex_half_1.iqmod_mfb_lpf_ota_core_tg_1.v_a VSS sg13_lv_nmos ad=0.19p pd=1.38u as=0.34p ps=2.68u w=1u l=0.13u
X431 VDD VDD VDD VDD sg13_lv_pmos ad=2.04p pd=12.68u as=0 ps=0 w=6u l=0.13u
X432 VDD iqmod_mfb_lpf_ota_core_hybrid_bm_pex_half_1.iqmod_mfb_lpf_ota_core_inv_NF6_0.vout voutn VDD sg13_lv_pmos ad=1.14p pd=6.38u as=1.14p ps=6.38u w=6u l=1u
X433 VSS voutp iqmod_mfb_lpf_ota_core_hybrid_bm_pex_half_1.iqmod_mfb_lpf_ota_core_tg_1.v_a VSS sg13_lv_nmos ad=0.19p pd=1.38u as=0.19p ps=1.38u w=1u l=1u
X434 VSS iqmod_mfb_lpf_ota_core_hybrid_bm_pex_half_0.iqmod_mfb_lpf_ota_core_spdt_switch_0.do_spdt_ctrl_n iqmod_mfb_lpf_ota_core_hybrid_bm_pex_half_0.iqmod_mfb_lpf_ota_core_spdt_switch_0.iqmod_mfb_lpf_ota_core_spdt_switch_inv$1_0.vout VSS sg13_lv_nmos ad=0.19p pd=1.38u as=0.19p ps=1.38u w=1u l=0.13u
X435 VSS iqmod_mfb_lpf_ota_core_hybrid_bm_pex_half_1.iqmod_mfb_lpf_ota_core_inv_NF6_0.vout voutn VSS sg13_lv_nmos ad=0.19p pd=1.38u as=0.19p ps=1.38u w=1u l=1u
X436 VSS iqmod_mfb_lpf_ota_core_hybrid_bm_pex_half_1.iqmod_mfb_lpf_ota_core_inv_NF10_0.vin voutn VSS sg13_lv_nmos ad=0.19p pd=1.38u as=0.19p ps=1.38u w=1u l=1u
X437 voutn iqmod_mfb_lpf_ota_core_hybrid_bm_pex_half_1.iqmod_mfb_lpf_ota_core_inv_NF6_0.vout VSS VSS sg13_lv_nmos ad=0.19p pd=1.38u as=0.19p ps=1.38u w=1u l=1u
X438 voutn iqmod_mfb_lpf_ota_core_hybrid_bm_pex_half_1.iqmod_mfb_lpf_ota_core_inv_NF6_0.vout VDD VDD sg13_lv_pmos ad=1.14p pd=6.38u as=1.14p ps=6.38u w=6u l=1u
X439 iqmod_mfb_lpf_ota_core_hybrid_bm_pex_half_1.iqmod_mfb_lpf_ota_core_tg_1.v_a voutp VSS VSS sg13_lv_nmos ad=0.19p pd=1.38u as=0.19p ps=1.38u w=1u l=1u
X440 iqmod_mfb_lpf_ota_core_hybrid_bm_pex_half_1.iqmod_mfb_lpf_ota_core_inv_NF10_0.vout iqmod_mfb_lpf_ota_core_hybrid_bm_pex_half_1.iqmod_mfb_lpf_ota_core_inv_NF10_0.vin VSS VSS sg13_lv_nmos ad=0.19p pd=1.38u as=0.19p ps=1.38u w=1u l=1u
X441 voutn iqmod_mfb_lpf_ota_core_hybrid_bm_pex_half_1.iqmod_mfb_lpf_ota_core_inv_NF6_0.vout VDD VDD sg13_lv_pmos ad=1.14p pd=6.38u as=1.14p ps=6.38u w=6u l=1u
X442 voutp iqmod_mfb_lpf_ota_core_hybrid_bm_pex_half_1.iqmod_mfb_lpf_ota_core_inv_NF6_0.vout VDD VDD sg13_lv_pmos ad=1.14p pd=6.38u as=1.14p ps=6.38u w=6u l=1u
X443 VSS voutp iqmod_mfb_lpf_ota_core_hybrid_bm_pex_half_1.iqmod_mfb_lpf_ota_core_tg_1.v_a VSS sg13_lv_nmos ad=0.19p pd=1.38u as=0.19p ps=1.38u w=1u l=1u
X444 VSS iqmod_mfb_lpf_ota_core_hybrid_bm_pex_half_1.iqmod_mfb_lpf_ota_core_tg_1.v_a iqmod_mfb_lpf_ota_core_hybrid_bm_pex_half_1.iqmod_mfb_lpf_ota_core_inv_NF6_2.vin VSS sg13_lv_nmos ad=0.19p pd=1.38u as=0.19p ps=1.38u w=1u l=1u
X445 VDD voutp iqmod_mfb_lpf_ota_core_hybrid_bm_pex_half_1.iqmod_mfb_lpf_ota_core_tg_1.v_a VDD sg13_lv_pmos ad=1.14p pd=6.38u as=1.14p ps=6.38u w=6u l=1u
X446 iqmod_mfb_lpf_ota_core_hybrid_bm_pex_half_1.iqmod_mfb_lpf_ota_core_tg_1.v_a voutn VDD VDD sg13_lv_pmos ad=1.14p pd=6.38u as=1.14p ps=6.38u w=6u l=1u
X447 VSS iqmod_mfb_lpf_ota_core_hybrid_bm_pex_half_1.iqmod_mfb_lpf_ota_core_inv_NF10_0.vout iqmod_mfb_lpf_ota_core_hybrid_bm_pex_half_1.iqmod_mfb_lpf_ota_core_inv_NF6_0.vout VSS sg13_lv_nmos ad=0.19p pd=1.38u as=0.19p ps=1.38u w=1u l=1u
X448 iqmod_mfb_lpf_ota_core_hybrid_bm_pex_half_1.iqmod_mfb_lpf_ota_core_spdt_switch_0.do_spdt_ctrl_n di_ota_en VDD VDD sg13_lv_pmos ad=1.14p pd=6.38u as=1.14p ps=6.38u w=6u l=0.13u
X449 VSS VSS VSS VSS sg13_lv_nmos ad=0.19p pd=1.38u as=0 ps=0 w=1u l=0.13u
X450 VSS iqmod_mfb_lpf_ota_core_hybrid_bm_pex_half_1.iqmod_mfb_lpf_ota_core_inv_NF10_0.vin voutn VSS sg13_lv_nmos ad=0.19p pd=1.38u as=0.19p ps=1.38u w=1u l=1u
X451 VDD voutn iqmod_mfb_lpf_ota_core_hybrid_bm_pex_half_1.iqmod_mfb_lpf_ota_core_tg_1.v_a VDD sg13_lv_pmos ad=1.14p pd=6.38u as=1.14p ps=6.38u w=6u l=1u
X452 iqmod_mfb_lpf_ota_core_hybrid_bm_pex_half_1.iqmod_mfb_lpf_ota_core_tg_1.v_a voutn VSS VSS sg13_lv_nmos ad=0.19p pd=1.38u as=0.19p ps=1.38u w=1u l=1u
X453 voutn iqmod_mfb_lpf_ota_core_hybrid_bm_pex_half_1.iqmod_mfb_lpf_ota_core_inv_NF10_0.vin VDD VDD sg13_lv_pmos ad=1.14p pd=6.38u as=1.14p ps=6.38u w=6u l=1u
X454 VSS voutp iqmod_mfb_lpf_ota_core_hybrid_bm_pex_half_1.iqmod_mfb_lpf_ota_core_tg_1.v_a VSS sg13_lv_nmos ad=0.19p pd=1.38u as=0.19p ps=1.38u w=1u l=1u
X455 VDD iqmod_mfb_lpf_ota_core_hybrid_bm_pex_half_1.iqmod_mfb_lpf_ota_core_inv_NF10_0.vout iqmod_mfb_lpf_ota_core_hybrid_bm_pex_half_1.iqmod_mfb_lpf_ota_core_inv_NF6_0.vout VDD sg13_lv_pmos ad=1.14p pd=6.38u as=1.14p ps=6.38u w=6u l=1u
X456 iqmod_mfb_lpf_ota_core_hybrid_bm_pex_half_1.iqmod_mfb_lpf_ota_core_inv_NF6_2.vin iqmod_mfb_lpf_ota_core_hybrid_bm_pex_half_1.iqmod_mfb_lpf_ota_core_tg_1.v_a VDD VDD sg13_lv_pmos ad=1.14p pd=6.38u as=1.14p ps=6.38u w=6u l=1u
X457 VSS voutn iqmod_mfb_lpf_ota_core_hybrid_bm_pex_half_1.iqmod_mfb_lpf_ota_core_tg_1.v_a VSS sg13_lv_nmos ad=0.19p pd=1.38u as=0.19p ps=1.38u w=1u l=1u
X458 VSS VSS VSS VSS sg13_lv_nmos ad=0.34p pd=2.68u as=0 ps=0 w=1u l=1u
X459 iqmod_mfb_lpf_ota_core_hybrid_bm_pex_half_1.iqmod_mfb_lpf_ota_core_inv_NF10_0.vout iqmod_mfb_lpf_ota_core_hybrid_bm_pex_half_1.iqmod_mfb_lpf_ota_core_inv_NF10_0.vin VSS VSS sg13_lv_nmos ad=0.19p pd=1.38u as=0.19p ps=1.38u w=1u l=1u
X460 VDD iqmod_mfb_lpf_ota_core_hybrid_bm_pex_half_1.iqmod_mfb_lpf_ota_core_inv_NF10_0.vin voutn VDD sg13_lv_pmos ad=1.14p pd=6.38u as=1.14p ps=6.38u w=6u l=1u
X461 iqmod_mfb_lpf_ota_core_hybrid_bm_pex_half_1.iqmod_mfb_lpf_ota_core_tg_1.v_a voutn VDD VDD sg13_lv_pmos ad=1.14p pd=6.38u as=1.14p ps=6.38u w=6u l=1u
X462 VDD VDD VDD VDD sg13_lv_pmos ad=2.04p pd=12.68u as=0 ps=0 w=6u l=1u
X463 VDD voutn iqmod_mfb_lpf_ota_core_hybrid_bm_pex_half_1.iqmod_mfb_lpf_ota_core_tg_1.v_a VDD sg13_lv_pmos ad=1.14p pd=6.38u as=1.14p ps=6.38u w=6u l=1u
X464 iqmod_mfb_lpf_ota_core_hybrid_bm_pex_half_1.iqmod_mfb_lpf_ota_core_tg_1.v_a voutp VDD VDD sg13_lv_pmos ad=1.14p pd=6.38u as=1.14p ps=6.38u w=6u l=1u
X465 VSS VSS VSS VSS sg13_lv_nmos ad=0.19p pd=1.38u as=0 ps=0 w=1u l=1u
X466 voutp iqmod_mfb_lpf_ota_core_hybrid_bm_pex_half_1.iqmod_mfb_lpf_ota_core_inv_NF6_0.vout VSS VSS sg13_lv_nmos ad=0.19p pd=1.38u as=0.19p ps=1.38u w=1u l=1u
X467 iqmod_mfb_lpf_ota_core_hybrid_bm_pex_half_1.iqmod_mfb_lpf_ota_core_tg_1.v_a di_ota_en iqmod_mfb_lpf_ota_core_hybrid_bm_pex_half_1.iqmod_mfb_lpf_ota_core_inv_NF6_2.vin VSS sg13_lv_nmos ad=0.19p pd=1.38u as=0.19p ps=1.38u w=1u l=0.13u
X468 VDD iqmod_mfb_lpf_ota_core_hybrid_bm_pex_half_1.iqmod_mfb_lpf_ota_core_inv_NF6_0.vout voutn VDD sg13_lv_pmos ad=1.14p pd=6.38u as=1.14p ps=6.38u w=6u l=1u
X469 voutp iqmod_mfb_lpf_ota_core_hybrid_bm_pex_half_1.iqmod_mfb_lpf_ota_core_inv_NF6_0.vout VDD VDD sg13_lv_pmos ad=1.14p pd=6.38u as=1.14p ps=6.38u w=6u l=1u
X470 VSS iqmod_mfb_lpf_ota_core_hybrid_bm_pex_half_1.iqmod_mfb_lpf_ota_core_inv_NF6_0.vout voutp VSS sg13_lv_nmos ad=0.19p pd=1.38u as=0.19p ps=1.38u w=1u l=1u
X471 iqmod_mfb_lpf_ota_core_hybrid_bm_pex_half_1.iqmod_mfb_lpf_ota_core_inv_NF6_0.vout iqmod_mfb_lpf_ota_core_hybrid_bm_pex_half_1.iqmod_mfb_lpf_ota_core_inv_NF10_0.vout VSS VSS sg13_lv_nmos ad=0.19p pd=1.38u as=0.19p ps=1.38u w=1u l=1u
X472 VDD voutp iqmod_mfb_lpf_ota_core_hybrid_bm_pex_half_1.iqmod_mfb_lpf_ota_core_tg_1.v_a VDD sg13_lv_pmos ad=1.14p pd=6.38u as=1.14p ps=6.38u w=6u l=1u
X473 vinp iqmod_mfb_lpf_ota_core_hybrid_bm_pex_half_1.iqmod_mfb_lpf_ota_core_spdt_switch_0.do_spdt_ctrl_n iqmod_mfb_lpf_ota_core_hybrid_bm_pex_half_1.iqmod_mfb_lpf_ota_core_inv_NF10_0.vin VDD sg13_lv_pmos ad=2.04p pd=12.68u as=1.14p ps=6.38u w=6u l=0.13u
X474 iqmod_mfb_lpf_ota_core_hybrid_bm_pex_half_1.iqmod_mfb_lpf_ota_core_inv_NF10_0.vout iqmod_mfb_lpf_ota_core_hybrid_bm_pex_half_1.iqmod_mfb_lpf_ota_core_spdt_switch_0.do_spdt_ctrl_n iqmod_mfb_lpf_ota_core_hybrid_bm_pex_half_1.iqmod_mfb_lpf_ota_core_inv_NF6_0.vout VDD sg13_lv_pmos ad=2.04p pd=12.68u as=1.14p ps=6.38u w=6u l=0.13u
X475 iqmod_mfb_lpf_ota_core_hybrid_bm_pex_half_1.iqmod_mfb_lpf_ota_core_inv_NF10_0.vin iqmod_mfb_lpf_ota_core_hybrid_bm_pex_half_1.iqmod_mfb_lpf_ota_core_spdt_switch_0.do_spdt_ctrl_n vinp VDD sg13_lv_pmos ad=1.14p pd=6.38u as=1.14p ps=6.38u w=6u l=0.13u
X476 VDD iqmod_mfb_lpf_ota_core_hybrid_bm_pex_half_1.iqmod_mfb_lpf_ota_core_inv_NF6_2.vin iqmod_mfb_lpf_ota_core_hybrid_bm_pex_half_1.iqmod_mfb_lpf_ota_core_inv_NF6_0.vout VDD sg13_lv_pmos ad=1.14p pd=6.38u as=1.14p ps=6.38u w=6u l=1u
X477 voutn iqmod_mfb_lpf_ota_core_hybrid_bm_pex_half_1.iqmod_mfb_lpf_ota_core_inv_NF6_0.vout VDD VDD sg13_lv_pmos ad=1.14p pd=6.38u as=1.14p ps=6.38u w=6u l=1u
X478 iqmod_mfb_lpf_ota_core_hybrid_bm_pex_half_1.iqmod_mfb_lpf_ota_core_inv_NF6_0.vout iqmod_mfb_lpf_ota_core_hybrid_bm_pex_half_1.iqmod_mfb_lpf_ota_core_inv_NF10_0.vout VSS VSS sg13_lv_nmos ad=0.19p pd=1.38u as=0.19p ps=1.38u w=1u l=1u
X479 VDD iqmod_mfb_lpf_ota_core_hybrid_bm_pex_half_1.iqmod_mfb_lpf_ota_core_inv_NF6_0.vout voutp VDD sg13_lv_pmos ad=1.14p pd=6.38u as=1.14p ps=6.38u w=6u l=1u
X480 iqmod_mfb_lpf_ota_core_hybrid_bm_pex_half_1.iqmod_mfb_lpf_ota_core_inv_NF10_0.vout di_ota_en iqmod_mfb_lpf_ota_core_hybrid_bm_pex_half_1.iqmod_mfb_lpf_ota_core_inv_NF6_0.vout VSS sg13_lv_nmos ad=0.19p pd=1.38u as=0.19p ps=1.38u w=1u l=0.13u
X481 VSS voutp iqmod_mfb_lpf_ota_core_hybrid_bm_pex_half_1.iqmod_mfb_lpf_ota_core_tg_1.v_a VSS sg13_lv_nmos ad=0.19p pd=1.38u as=0.19p ps=1.38u w=1u l=1u
X482 voutp iqmod_mfb_lpf_ota_core_hybrid_bm_pex_half_0.iqmod_mfb_lpf_ota_core_inv_NF10_0.vin VSS VSS sg13_lv_nmos ad=0.19p pd=1.38u as=0.19p ps=1.38u w=1u l=1u
X483 iqmod_mfb_lpf_ota_core_hybrid_bm_pex_half_0.iqmod_mfb_lpf_ota_core_inv_NF10_0.vin iqmod_mfb_lpf_ota_core_hybrid_bm_pex_half_0.iqmod_mfb_lpf_ota_core_spdt_switch_0.do_spdt_ctrl_n VDD VSS sg13_lv_nmos ad=0.19p pd=1.38u as=0.34p ps=2.68u w=1u l=0.13u
X484 vinn iqmod_mfb_lpf_ota_core_hybrid_bm_pex_half_0.iqmod_mfb_lpf_ota_core_spdt_switch_0.iqmod_mfb_lpf_ota_core_spdt_switch_inv$1_0.vout iqmod_mfb_lpf_ota_core_hybrid_bm_pex_half_0.iqmod_mfb_lpf_ota_core_inv_NF10_0.vin VSS sg13_lv_nmos ad=0.19p pd=1.38u as=0.19p ps=1.38u w=1u l=0.13u
X485 iqmod_mfb_lpf_ota_core_hybrid_bm_pex_half_1.iqmod_mfb_lpf_ota_core_inv_NF6_0.vout di_ota_en iqmod_mfb_lpf_ota_core_hybrid_bm_pex_half_1.iqmod_mfb_lpf_ota_core_inv_NF10_0.vout VSS sg13_lv_nmos ad=0.19p pd=1.38u as=0.34p ps=2.68u w=1u l=0.13u
X486 VDD iqmod_mfb_lpf_ota_core_hybrid_bm_pex_half_1.iqmod_mfb_lpf_ota_core_inv_NF10_0.vin voutn VDD sg13_lv_pmos ad=1.14p pd=6.38u as=1.14p ps=6.38u w=6u l=1u
X487 VDD iqmod_mfb_lpf_ota_core_hybrid_bm_pex_half_1.iqmod_mfb_lpf_ota_core_inv_NF6_0.vout voutn VDD sg13_lv_pmos ad=1.14p pd=6.38u as=1.14p ps=6.38u w=6u l=1u
X488 VSS VSS VSS VSS sg13_lv_nmos ad=0.19p pd=1.38u as=0 ps=0 w=1u l=1u
X489 iqmod_mfb_lpf_ota_core_hybrid_bm_pex_half_1.iqmod_mfb_lpf_ota_core_inv_NF10_0.vout iqmod_mfb_lpf_ota_core_hybrid_bm_pex_half_0.iqmod_mfb_lpf_ota_core_inv_NF10_0.vin VSS VSS sg13_lv_nmos ad=0.19p pd=1.38u as=0.19p ps=1.38u w=1u l=1u
X490 voutp iqmod_mfb_lpf_ota_core_hybrid_bm_pex_half_0.iqmod_mfb_lpf_ota_core_inv_NF10_0.vin VDD VDD sg13_lv_pmos ad=1.14p pd=6.38u as=1.14p ps=6.38u w=6u l=1u
X491 VDD iqmod_mfb_lpf_ota_core_hybrid_bm_pex_half_1.iqmod_mfb_lpf_ota_core_inv_NF6_2.vin iqmod_mfb_lpf_ota_core_hybrid_bm_pex_half_1.iqmod_mfb_lpf_ota_core_inv_NF6_0.vout VDD sg13_lv_pmos ad=1.14p pd=6.38u as=1.14p ps=6.38u w=6u l=1u
X492 VSS voutn iqmod_mfb_lpf_ota_core_hybrid_bm_pex_half_1.iqmod_mfb_lpf_ota_core_tg_1.v_a VSS sg13_lv_nmos ad=0.19p pd=1.38u as=0.19p ps=1.38u w=1u l=1u
X493 voutp iqmod_mfb_lpf_ota_core_hybrid_bm_pex_half_1.iqmod_mfb_lpf_ota_core_inv_NF6_0.vout VDD VDD sg13_lv_pmos ad=1.14p pd=6.38u as=1.14p ps=6.38u w=6u l=1u
X494 voutn iqmod_mfb_lpf_ota_core_hybrid_bm_pex_half_1.iqmod_mfb_lpf_ota_core_inv_NF6_0.vout VDD VDD sg13_lv_pmos ad=1.14p pd=6.38u as=1.14p ps=6.38u w=6u l=1u
X495 VSS iqmod_mfb_lpf_ota_core_hybrid_bm_pex_half_1.iqmod_mfb_lpf_ota_core_inv_NF6_0.vout voutn VSS sg13_lv_nmos ad=0.19p pd=1.38u as=0.19p ps=1.38u w=1u l=1u
X496 VSS iqmod_mfb_lpf_ota_core_hybrid_bm_pex_half_1.iqmod_mfb_lpf_ota_core_inv_NF6_2.vin iqmod_mfb_lpf_ota_core_hybrid_bm_pex_half_1.iqmod_mfb_lpf_ota_core_inv_NF6_0.vout VSS sg13_lv_nmos ad=0.19p pd=1.38u as=0.19p ps=1.38u w=1u l=1u
X497 VSS iqmod_mfb_lpf_ota_core_hybrid_bm_pex_half_1.iqmod_mfb_lpf_ota_core_inv_NF10_0.vin iqmod_mfb_lpf_ota_core_hybrid_bm_pex_half_1.iqmod_mfb_lpf_ota_core_inv_NF10_0.vout VSS sg13_lv_nmos ad=0.19p pd=1.38u as=0.19p ps=1.38u w=1u l=1u
X498 VDD iqmod_mfb_lpf_ota_core_hybrid_bm_pex_half_1.iqmod_mfb_lpf_ota_core_inv_NF6_0.vout voutn VDD sg13_lv_pmos ad=1.14p pd=6.38u as=1.14p ps=6.38u w=6u l=1u
X499 iqmod_mfb_lpf_ota_core_hybrid_bm_pex_half_1.iqmod_mfb_lpf_ota_core_inv_NF6_2.vin iqmod_mfb_lpf_ota_core_hybrid_bm_pex_half_1.iqmod_mfb_lpf_ota_core_tg_1.v_a VSS VSS sg13_lv_nmos ad=0.19p pd=1.38u as=0.19p ps=1.38u w=1u l=1u
X500 iqmod_mfb_lpf_ota_core_hybrid_bm_pex_half_1.iqmod_mfb_lpf_ota_core_tg_1.v_a voutp VDD VDD sg13_lv_pmos ad=1.14p pd=6.38u as=1.14p ps=6.38u w=6u l=1u
X501 VDD VDD VDD VDD sg13_lv_pmos ad=1.14p pd=6.38u as=0 ps=0 w=6u l=1u
X502 VSS VSS VSS VSS sg13_lv_nmos ad=0.19p pd=1.38u as=0 ps=0 w=1u l=1u
X503 voutn iqmod_mfb_lpf_ota_core_hybrid_bm_pex_half_1.iqmod_mfb_lpf_ota_core_inv_NF10_0.vin VSS VSS sg13_lv_nmos ad=0.19p pd=1.38u as=0.19p ps=1.38u w=1u l=1u
X504 VDD iqmod_mfb_lpf_ota_core_hybrid_bm_pex_half_0.iqmod_mfb_lpf_ota_core_inv_NF10_0.vin voutp VDD sg13_lv_pmos ad=1.14p pd=6.38u as=1.14p ps=6.38u w=6u l=1u
X505 VSS voutn iqmod_mfb_lpf_ota_core_hybrid_bm_pex_half_1.iqmod_mfb_lpf_ota_core_tg_1.v_a VSS sg13_lv_nmos ad=0.19p pd=1.38u as=0.19p ps=1.38u w=1u l=1u
X506 VDD VDD VDD VDD sg13_lv_pmos ad=2.04p pd=12.68u as=0 ps=0 w=6u l=1u
X507 VSS VSS VSS VSS sg13_lv_nmos ad=0.34p pd=2.68u as=0 ps=0 w=1u l=1u
X508 iqmod_mfb_lpf_ota_core_hybrid_bm_pex_half_1.iqmod_mfb_lpf_ota_core_tg_1.v_a di_ota_en iqmod_mfb_lpf_ota_core_hybrid_bm_pex_half_1.iqmod_mfb_lpf_ota_core_inv_NF6_2.vin VSS sg13_lv_nmos ad=0.19p pd=1.38u as=0.19p ps=1.38u w=1u l=0.13u
X509 VSS iqmod_mfb_lpf_ota_core_hybrid_bm_pex_half_1.iqmod_mfb_lpf_ota_core_inv_NF10_0.vin voutn VSS sg13_lv_nmos ad=0.19p pd=1.38u as=0.19p ps=1.38u w=1u l=1u
X510 iqmod_mfb_lpf_ota_core_hybrid_bm_pex_half_1.iqmod_mfb_lpf_ota_core_tg_1.v_a voutp VDD VDD sg13_lv_pmos ad=1.14p pd=6.38u as=1.14p ps=6.38u w=6u l=1u
X511 VDD iqmod_mfb_lpf_ota_core_hybrid_bm_pex_half_1.iqmod_mfb_lpf_ota_core_inv_NF10_0.vin voutn VDD sg13_lv_pmos ad=1.14p pd=6.38u as=1.14p ps=6.38u w=6u l=1u
X512 voutp iqmod_mfb_lpf_ota_core_hybrid_bm_pex_half_0.iqmod_mfb_lpf_ota_core_inv_NF10_0.vin VDD VDD sg13_lv_pmos ad=1.14p pd=6.38u as=1.14p ps=6.38u w=6u l=1u
X513 voutn iqmod_mfb_lpf_ota_core_hybrid_bm_pex_half_1.iqmod_mfb_lpf_ota_core_inv_NF10_0.vin VDD VDD sg13_lv_pmos ad=1.14p pd=6.38u as=1.14p ps=6.38u w=6u l=1u
X514 VDD voutn iqmod_mfb_lpf_ota_core_hybrid_bm_pex_half_1.iqmod_mfb_lpf_ota_core_tg_1.v_a VDD sg13_lv_pmos ad=1.14p pd=6.38u as=1.14p ps=6.38u w=6u l=1u
X515 VDD voutp iqmod_mfb_lpf_ota_core_hybrid_bm_pex_half_1.iqmod_mfb_lpf_ota_core_tg_1.v_a VDD sg13_lv_pmos ad=1.14p pd=6.38u as=1.14p ps=6.38u w=6u l=1u
X516 VSS iqmod_mfb_lpf_ota_core_hybrid_bm_pex_half_1.iqmod_mfb_lpf_ota_core_tg_1.v_a iqmod_mfb_lpf_ota_core_hybrid_bm_pex_half_1.iqmod_mfb_lpf_ota_core_inv_NF6_2.vin VSS sg13_lv_nmos ad=0.19p pd=1.38u as=0.19p ps=1.38u w=1u l=1u
X517 VSS iqmod_mfb_lpf_ota_core_hybrid_bm_pex_half_1.iqmod_mfb_lpf_ota_core_inv_NF6_0.vout voutp VSS sg13_lv_nmos ad=0.19p pd=1.38u as=0.19p ps=1.38u w=1u l=1u
X518 VDD iqmod_mfb_lpf_ota_core_hybrid_bm_pex_half_1.iqmod_mfb_lpf_ota_core_spdt_switch_0.iqmod_mfb_lpf_ota_core_spdt_switch_inv$1_0.vout iqmod_mfb_lpf_ota_core_hybrid_bm_pex_half_1.iqmod_mfb_lpf_ota_core_inv_NF10_0.vin VDD sg13_lv_pmos ad=1.14p pd=6.38u as=1.14p ps=6.38u w=6u l=0.13u
X519 VSS iqmod_mfb_lpf_ota_core_hybrid_bm_pex_half_1.iqmod_mfb_lpf_ota_core_inv_NF6_0.vout voutp VSS sg13_lv_nmos ad=0.19p pd=1.38u as=0.19p ps=1.38u w=1u l=1u
X520 vinn iqmod_mfb_lpf_ota_core_hybrid_bm_pex_half_0.iqmod_mfb_lpf_ota_core_spdt_switch_0.do_spdt_ctrl_n iqmod_mfb_lpf_ota_core_hybrid_bm_pex_half_0.iqmod_mfb_lpf_ota_core_inv_NF10_0.vin VDD sg13_lv_pmos ad=2.04p pd=12.68u as=1.14p ps=6.38u w=6u l=0.13u
X521 VDD iqmod_mfb_lpf_ota_core_hybrid_bm_pex_half_0.iqmod_mfb_lpf_ota_core_spdt_switch_0.do_spdt_ctrl_n iqmod_mfb_lpf_ota_core_hybrid_bm_pex_half_0.iqmod_mfb_lpf_ota_core_spdt_switch_0.iqmod_mfb_lpf_ota_core_spdt_switch_inv$1_0.vout VDD sg13_lv_pmos ad=1.14p pd=6.38u as=1.14p ps=6.38u w=6u l=0.13u
X522 VDD iqmod_mfb_lpf_ota_core_hybrid_bm_pex_half_0.iqmod_mfb_lpf_ota_core_spdt_switch_0.do_spdt_ctrl_n iqmod_mfb_lpf_ota_core_hybrid_bm_pex_half_0.iqmod_mfb_lpf_ota_core_inv_NF10_0.vin VSS sg13_lv_nmos ad=0.19p pd=1.38u as=0.19p ps=1.38u w=1u l=0.13u
X523 voutn iqmod_mfb_lpf_ota_core_hybrid_bm_pex_half_1.iqmod_mfb_lpf_ota_core_inv_NF6_0.vout VSS VSS sg13_lv_nmos ad=0.19p pd=1.38u as=0.19p ps=1.38u w=1u l=1u
X524 voutn iqmod_mfb_lpf_ota_core_hybrid_bm_pex_half_1.iqmod_mfb_lpf_ota_core_inv_NF10_0.vin VDD VDD sg13_lv_pmos ad=1.14p pd=6.38u as=1.14p ps=6.38u w=6u l=1u
X525 voutp iqmod_mfb_lpf_ota_core_hybrid_bm_pex_half_1.iqmod_mfb_lpf_ota_core_inv_NF6_0.vout VSS VSS sg13_lv_nmos ad=0.19p pd=1.38u as=0.19p ps=1.38u w=1u l=1u
X526 iqmod_mfb_lpf_ota_core_hybrid_bm_pex_half_0.iqmod_mfb_lpf_ota_core_inv_NF10_0.vin iqmod_mfb_lpf_ota_core_hybrid_bm_pex_half_0.iqmod_mfb_lpf_ota_core_spdt_switch_0.iqmod_mfb_lpf_ota_core_spdt_switch_inv$1_0.vout VDD VDD sg13_lv_pmos ad=1.14p pd=6.38u as=1.14p ps=6.38u w=6u l=0.13u
X527 iqmod_mfb_lpf_ota_core_hybrid_bm_pex_half_1.iqmod_mfb_lpf_ota_core_inv_NF10_0.vout iqmod_mfb_lpf_ota_core_hybrid_bm_pex_half_1.iqmod_mfb_lpf_ota_core_inv_NF10_0.vin VSS VSS sg13_lv_nmos ad=0.19p pd=1.38u as=0.19p ps=1.38u w=1u l=1u
X528 vinn iqmod_mfb_lpf_ota_core_hybrid_bm_pex_half_0.iqmod_mfb_lpf_ota_core_spdt_switch_0.do_spdt_ctrl_n iqmod_mfb_lpf_ota_core_hybrid_bm_pex_half_0.iqmod_mfb_lpf_ota_core_inv_NF10_0.vin VDD sg13_lv_pmos ad=1.14p pd=6.38u as=1.14p ps=6.38u w=6u l=0.13u
X529 iqmod_mfb_lpf_ota_core_hybrid_bm_pex_half_1.iqmod_mfb_lpf_ota_core_inv_NF6_2.vin di_ota_en iqmod_mfb_lpf_ota_core_hybrid_bm_pex_half_1.iqmod_mfb_lpf_ota_core_tg_1.v_a VSS sg13_lv_nmos ad=0.19p pd=1.38u as=0.34p ps=2.68u w=1u l=0.13u
X530 voutn iqmod_mfb_lpf_ota_core_hybrid_bm_pex_half_1.iqmod_mfb_lpf_ota_core_inv_NF6_0.vout VSS VSS sg13_lv_nmos ad=0.19p pd=1.38u as=0.19p ps=1.38u w=1u l=1u
X531 voutn iqmod_mfb_lpf_ota_core_hybrid_bm_pex_half_1.iqmod_mfb_lpf_ota_core_inv_NF6_0.vout VDD VDD sg13_lv_pmos ad=1.14p pd=6.38u as=1.14p ps=6.38u w=6u l=1u
X532 VSS iqmod_mfb_lpf_ota_core_hybrid_bm_pex_half_1.iqmod_mfb_lpf_ota_core_inv_NF10_0.vout iqmod_mfb_lpf_ota_core_hybrid_bm_pex_half_1.iqmod_mfb_lpf_ota_core_inv_NF6_0.vout VSS sg13_lv_nmos ad=0.19p pd=1.38u as=0.19p ps=1.38u w=1u l=1u
X533 voutp iqmod_mfb_lpf_ota_core_hybrid_bm_pex_half_0.iqmod_mfb_lpf_ota_core_inv_NF10_0.vin VSS VSS sg13_lv_nmos ad=0.19p pd=1.38u as=0.19p ps=1.38u w=1u l=1u
X534 VSS iqmod_mfb_lpf_ota_core_hybrid_bm_pex_half_1.iqmod_mfb_lpf_ota_core_tg_1.v_a iqmod_mfb_lpf_ota_core_hybrid_bm_pex_half_1.iqmod_mfb_lpf_ota_core_inv_NF6_2.vin VSS sg13_lv_nmos ad=0.19p pd=1.38u as=0.19p ps=1.38u w=1u l=1u
X535 VDD iqmod_mfb_lpf_ota_core_hybrid_bm_pex_half_1.iqmod_mfb_lpf_ota_core_inv_NF6_0.vout voutn VDD sg13_lv_pmos ad=1.14p pd=6.38u as=1.14p ps=6.38u w=6u l=1u
C0 voutp VSS 87.8351f
C1 vinn VSS 6.42739f
C2 voutn VSS 87.8351f
C3 vinp VSS 6.42739f
C4 di_ota_en VSS 27.7356f
C5 VDD VSS 0.35052p
C6 iqmod_mfb_lpf_ota_core_hybrid_bm_pex_half_0.iqmod_mfb_lpf_ota_core_inv_NF10_0.vin VSS 64.66669f
C7 iqmod_mfb_lpf_ota_core_hybrid_bm_pex_half_0.iqmod_mfb_lpf_ota_core_spdt_switch_0.iqmod_mfb_lpf_ota_core_spdt_switch_inv$1_0.vout VSS 6.53049f
C8 iqmod_mfb_lpf_ota_core_hybrid_bm_pex_half_0.iqmod_mfb_lpf_ota_core_spdt_switch_0.do_spdt_ctrl_n VSS 21.0166f
C9 iqmod_mfb_lpf_ota_core_hybrid_bm_pex_half_1.iqmod_mfb_lpf_ota_core_tg_1.v_a VSS 79.156f
C10 iqmod_mfb_lpf_ota_core_hybrid_bm_pex_half_1.iqmod_mfb_lpf_ota_core_inv_NF6_2.vin VSS 46.9298f
C11 iqmod_mfb_lpf_ota_core_hybrid_bm_pex_half_1.iqmod_mfb_lpf_ota_core_inv_NF6_0.vout VSS 0.11764p
C12 iqmod_mfb_lpf_ota_core_hybrid_bm_pex_half_1.iqmod_mfb_lpf_ota_core_inv_NF10_0.vout VSS 55.791f
C13 iqmod_mfb_lpf_ota_core_hybrid_bm_pex_half_1.iqmod_mfb_lpf_ota_core_inv_NF10_0.vin VSS 64.66669f
C14 iqmod_mfb_lpf_ota_core_hybrid_bm_pex_half_1.iqmod_mfb_lpf_ota_core_spdt_switch_0.iqmod_mfb_lpf_ota_core_spdt_switch_inv$1_0.vout VSS 6.53049f
C15 iqmod_mfb_lpf_ota_core_hybrid_bm_pex_half_1.iqmod_mfb_lpf_ota_core_spdt_switch_0.do_spdt_ctrl_n VSS 21.0166f
.ends
