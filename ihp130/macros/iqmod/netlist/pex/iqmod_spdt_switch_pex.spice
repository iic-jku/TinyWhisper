* PEX produced on Sun Mar 29 03:00:31 AM CEST 2026 using /foss/tools/sak/sak-pex.sh with m=2 and s=1
* NGSPICE file created from iqmod_spdt_switch_pex.ext - technology: ihp-sg13g2

.subckt iqmod_spdt_switch_pex VDD di_spdt_ctrl VSS v_c v_b v_a
X0 v_c spdt_switch_inv_0.vout v_b VDD sg13_lv_pmos ad=1.14p pd=6.38u as=1.14p ps=6.38u w=6u l=0.13u
X1 v_c spdt_switch_inv_0.vout v_a VSS sg13_lv_nmos ad=0.19p pd=1.38u as=0.34p ps=2.68u w=1u l=0.13u
X2 v_a spdt_switch_inv_0.vout v_c VSS sg13_lv_nmos ad=0.34p pd=2.68u as=0.19p ps=1.38u w=1u l=0.13u
X3 VDD VDD VDD VDD sg13_lv_pmos ad=2.04p pd=12.68u as=51.853p ps=0.25399m w=6u l=0.13u
X4 spdt_switch_inv_1.vout di_spdt_ctrl VDD VDD sg13_lv_pmos ad=1.14p pd=6.38u as=1.14p ps=6.38u w=6u l=0.13u
X5 v_a spdt_switch_inv_1.vout v_c VDD sg13_lv_pmos ad=2.04p pd=12.68u as=1.14p ps=6.38u w=6u l=0.13u
X6 v_c spdt_switch_inv_1.vout v_a VDD sg13_lv_pmos ad=1.14p pd=6.38u as=1.14p ps=6.38u w=6u l=0.13u
X7 v_b spdt_switch_inv_0.vout v_c VDD sg13_lv_pmos ad=1.14p pd=6.38u as=1.14p ps=6.38u w=6u l=0.13u
X8 VSS VSS VSS VSS sg13_lv_nmos ad=0.34p pd=2.68u as=45.604p ps=0.10343m w=1u l=0.13u
X9 spdt_switch_inv_0.vout spdt_switch_inv_1.vout VDD VDD sg13_lv_pmos ad=1.14p pd=6.38u as=1.14p ps=6.38u w=6u l=0.13u
X10 v_c spdt_switch_inv_1.vout v_a VDD sg13_lv_pmos ad=1.14p pd=6.38u as=2.04p ps=12.68u w=6u l=0.13u
X11 spdt_switch_inv_0.vout spdt_switch_inv_1.vout VSS VSS sg13_lv_nmos ad=0.19p pd=1.38u as=0.19p ps=1.38u w=1u l=0.13u
X12 v_b spdt_switch_inv_1.vout v_c VSS sg13_lv_nmos ad=0.19p pd=1.38u as=0.19p ps=1.38u w=1u l=0.13u
X13 VDD di_spdt_ctrl spdt_switch_inv_1.vout VDD sg13_lv_pmos ad=1.14p pd=6.38u as=1.14p ps=6.38u w=6u l=0.13u
X14 VSS spdt_switch_inv_1.vout spdt_switch_inv_0.vout VSS sg13_lv_nmos ad=0.19p pd=1.38u as=0.19p ps=1.38u w=1u l=0.13u
X15 v_c spdt_switch_inv_1.vout v_b VSS sg13_lv_nmos ad=0.19p pd=1.38u as=0.19p ps=1.38u w=1u l=0.13u
X16 VSS VSS VSS VSS sg13_lv_nmos ad=0.19p pd=1.38u as=0 ps=0 w=1u l=0.13u
X17 v_b spdt_switch_inv_1.vout v_c VSS sg13_lv_nmos ad=0.19p pd=1.38u as=0.19p ps=1.38u w=1u l=0.13u
X18 v_c spdt_switch_inv_0.vout v_b VDD sg13_lv_pmos ad=1.14p pd=6.38u as=1.14p ps=6.38u w=6u l=0.13u
X19 v_b spdt_switch_inv_0.vout v_c VDD sg13_lv_pmos ad=2.04p pd=12.68u as=1.14p ps=6.38u w=6u l=0.13u
X20 VSS VSS VSS VSS sg13_lv_nmos ad=0.34p pd=2.68u as=0 ps=0 w=1u l=0.13u
X21 v_c spdt_switch_inv_1.vout v_b VSS sg13_lv_nmos ad=0.19p pd=1.38u as=0.19p ps=1.38u w=1u l=0.13u
X22 v_c spdt_switch_inv_1.vout v_b VSS sg13_lv_nmos ad=0.19p pd=1.38u as=0.34p ps=2.68u w=1u l=0.13u
X23 v_b spdt_switch_inv_1.vout v_c VSS sg13_lv_nmos ad=0.34p pd=2.68u as=0.19p ps=1.38u w=1u l=0.13u
X24 spdt_switch_inv_1.vout di_spdt_ctrl VSS VSS sg13_lv_nmos ad=0.19p pd=1.38u as=0.19p ps=1.38u w=1u l=0.13u
X25 VDD spdt_switch_inv_1.vout spdt_switch_inv_0.vout VDD sg13_lv_pmos ad=1.14p pd=6.38u as=1.14p ps=6.38u w=6u l=0.13u
X26 VDD VDD VDD VDD sg13_lv_pmos ad=1.14p pd=6.38u as=0 ps=0 w=6u l=0.13u
X27 VSS di_spdt_ctrl spdt_switch_inv_1.vout VSS sg13_lv_nmos ad=0.19p pd=1.38u as=0.19p ps=1.38u w=1u l=0.13u
X28 v_a spdt_switch_inv_1.vout v_c VDD sg13_lv_pmos ad=1.14p pd=6.38u as=1.14p ps=6.38u w=6u l=0.13u
X29 v_c spdt_switch_inv_0.vout v_b VDD sg13_lv_pmos ad=1.14p pd=6.38u as=2.04p ps=12.68u w=6u l=0.13u
X30 VSS VSS VSS VSS sg13_lv_nmos ad=0.19p pd=1.38u as=0 ps=0 w=1u l=0.13u
X31 v_b spdt_switch_inv_0.vout v_c VDD sg13_lv_pmos ad=1.14p pd=6.38u as=1.14p ps=6.38u w=6u l=0.13u
X32 v_a spdt_switch_inv_0.vout v_c VSS sg13_lv_nmos ad=0.19p pd=1.38u as=0.19p ps=1.38u w=1u l=0.13u
X33 VDD VDD VDD VDD sg13_lv_pmos ad=1.14p pd=6.38u as=0 ps=0 w=6u l=0.13u
X34 VDD VDD VDD VDD sg13_lv_pmos ad=2.04p pd=12.68u as=0 ps=0 w=6u l=0.13u
X35 v_c spdt_switch_inv_0.vout v_a VSS sg13_lv_nmos ad=0.19p pd=1.38u as=0.19p ps=1.38u w=1u l=0.13u
X36 v_a spdt_switch_inv_0.vout v_c VSS sg13_lv_nmos ad=0.19p pd=1.38u as=0.19p ps=1.38u w=1u l=0.13u
X37 v_a spdt_switch_inv_1.vout v_c VDD sg13_lv_pmos ad=1.14p pd=6.38u as=1.14p ps=6.38u w=6u l=0.13u
X38 v_c spdt_switch_inv_1.vout v_a VDD sg13_lv_pmos ad=1.14p pd=6.38u as=1.14p ps=6.38u w=6u l=0.13u
X39 v_c spdt_switch_inv_0.vout v_a VSS sg13_lv_nmos ad=0.19p pd=1.38u as=0.19p ps=1.38u w=1u l=0.13u
C0 v_c v_a 12.9673f
C1 spdt_switch_inv_0.vout v_a 1.09149f
C2 spdt_switch_inv_0.vout v_c 2.05095f
C3 spdt_switch_inv_1.vout v_b 0.81049f
C4 di_spdt_ctrl VDD 0.75555f
C5 v_a VDD 1.56401f
C6 v_c VDD 0.52959f
C7 spdt_switch_inv_1.vout di_spdt_ctrl 0.54132f
C8 spdt_switch_inv_0.vout VDD 6.54983f
C9 spdt_switch_inv_1.vout v_a 1.17306f
C10 spdt_switch_inv_1.vout v_c 1.77589f
C11 v_b v_a 0.75939f
C12 v_b v_c 13.8546f
C13 spdt_switch_inv_1.vout spdt_switch_inv_0.vout 1.10866f
C14 spdt_switch_inv_0.vout v_b 1.07601f
C15 di_spdt_ctrl v_a 0.04863f
C16 spdt_switch_inv_1.vout VDD 7.88626f
C17 v_b VDD 1.8999f
C18 v_b VSS 1.13537f
C19 v_c VSS 0.62301f
C20 v_a VSS 0.83529f
C21 di_spdt_ctrl VSS 0.63773f
C22 VDD VSS 3.44404f
C23 spdt_switch_inv_0.vout VSS 2.70911f
C24 spdt_switch_inv_1.vout VSS 3.95475f
.ends
