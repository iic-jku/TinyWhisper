* PEX produced on 2026-11-14 using kpex 0.9.0 with --2.5D --mode RC --blackbox y --reduce ticer
*********************************************************
*** NGSPICE file created by KLayout-PEX 0.9.0
*** -----------------------------------------------------
***     Extraction Engine: KPEX/2.5D
***     Technology: ihp_sg13g2
***     Date: 2026-11-14 14:53:52
*********************************************************

.SUBCKT iqmod_spdt_switch_pex VDD di_spdt_ctrl VSS v_c v_b v_a
X$1 v_c.P0.nSD di_tg_ctrl|di_tg_ctrl_n|vin|vout v_b.P0.nSD \$5 sg13_lv_nmos
+ w=1e-06 l=1.3e-07 as=3.4e-13 ad=1.9e-13 ps=2.68e-06 pd=1.38e-06
X$2 v_b.P1.nSD di_tg_ctrl|di_tg_ctrl_n|vin|vout.P1.GatPoly v_c.P0.nSD \$5
+ sg13_lv_nmos w=1e-06 l=1.3e-07 as=1.9e-13 ad=1.9e-13 ps=1.38e-06 pd=1.38e-06
X$3 v_c.P2.nSD di_tg_ctrl|di_tg_ctrl_n|vin|vout.P2.GatPoly v_b.P1.nSD \$5
+ sg13_lv_nmos w=1e-06 l=1.3e-07 as=1.9e-13 ad=1.9e-13 ps=1.38e-06 pd=1.38e-06
X$4 v_b.P3.nSD di_tg_ctrl|di_tg_ctrl_n|vin|vout.P3.GatPoly v_c.P2.nSD \$5
+ sg13_lv_nmos w=1e-06 l=1.3e-07 as=1.9e-13 ad=1.9e-13 ps=1.38e-06 pd=1.38e-06
X$5 v_c.P4.nSD di_tg_ctrl|di_tg_ctrl_n|vin|vout.P4.GatPoly v_b.P3.nSD \$5
+ sg13_lv_nmos w=1e-06 l=1.3e-07 as=1.9e-13 ad=1.9e-13 ps=1.38e-06 pd=1.38e-06
X$6 v_b.P5.nSD di_tg_ctrl|di_tg_ctrl_n|vin|vout.P5.GatPoly v_c.P4.nSD \$5
+ sg13_lv_nmos w=1e-06 l=1.3e-07 as=1.9e-13 ad=3.4e-13 ps=1.38e-06 pd=2.68e-06
X$7 VSS.P0.pSD \$5 ptap1
X$8 v_c.P6.nSD di_tg_ctrl|di_tg_ctrl_n|vout v_a.P0.nSD \$5 sg13_lv_nmos w=1e-06
+ l=1.3e-07 as=3.4e-13 ad=1.9e-13 ps=2.68e-06 pd=1.38e-06
X$9 v_a.P1.nSD di_tg_ctrl|di_tg_ctrl_n|vout.P1.GatPoly v_c.P6.nSD \$5
+ sg13_lv_nmos w=1e-06 l=1.3e-07 as=1.9e-13 ad=1.9e-13 ps=1.38e-06 pd=1.38e-06
X$10 v_c.P8.nSD di_tg_ctrl|di_tg_ctrl_n|vout.P2.GatPoly v_a.P1.nSD \$5
+ sg13_lv_nmos w=1e-06 l=1.3e-07 as=1.9e-13 ad=1.9e-13 ps=1.38e-06 pd=1.38e-06
X$11 v_a.P3.nSD di_tg_ctrl|di_tg_ctrl_n|vout.P3.GatPoly v_c.P8.nSD \$5
+ sg13_lv_nmos w=1e-06 l=1.3e-07 as=1.9e-13 ad=1.9e-13 ps=1.38e-06 pd=1.38e-06
X$12 v_c.P10.nSD di_tg_ctrl|di_tg_ctrl_n|vout.P4.GatPoly v_a.P3.nSD \$5
+ sg13_lv_nmos w=1e-06 l=1.3e-07 as=1.9e-13 ad=1.9e-13 ps=1.38e-06 pd=1.38e-06
X$13 v_a.P5.nSD di_tg_ctrl|di_tg_ctrl_n|vout.P5.GatPoly v_c.P10.nSD \$5
+ sg13_lv_nmos w=1e-06 l=1.3e-07 as=1.9e-13 ad=3.4e-13 ps=1.38e-06 pd=2.68e-06
X$14 VSS.P0.pSD \$5 ptap1
X$15 v_c.P0.pSD di_tg_ctrl|di_tg_ctrl_n|vout.P6.GatPoly v_b.P0.pSD \$I14
+ sg13_lv_pmos w=6e-06 l=1.3e-07 as=2.04e-12 ad=1.14e-12 ps=1.268e-05
+ pd=6.38e-06
X$16 v_b.P1.pSD di_tg_ctrl|di_tg_ctrl_n|vout.P7.GatPoly v_c.P0.pSD \$I14
+ sg13_lv_pmos w=6e-06 l=1.3e-07 as=1.14e-12 ad=1.14e-12 ps=6.38e-06 pd=6.38e-06
X$17 v_c.P2.pSD di_tg_ctrl|di_tg_ctrl_n|vout.P8.GatPoly v_b.P1.pSD \$I14
+ sg13_lv_pmos w=6e-06 l=1.3e-07 as=1.14e-12 ad=1.14e-12 ps=6.38e-06 pd=6.38e-06
X$18 v_b.P3.pSD di_tg_ctrl|di_tg_ctrl_n|vout.P9.GatPoly v_c.P2.pSD \$I14
+ sg13_lv_pmos w=6e-06 l=1.3e-07 as=1.14e-12 ad=1.14e-12 ps=6.38e-06 pd=6.38e-06
X$19 v_c.P4.pSD di_tg_ctrl|di_tg_ctrl_n|vout.P10.GatPoly v_b.P3.pSD \$I14
+ sg13_lv_pmos w=6e-06 l=1.3e-07 as=1.14e-12 ad=1.14e-12 ps=6.38e-06 pd=6.38e-06
X$20 v_b.P5.pSD di_tg_ctrl|di_tg_ctrl_n|vout.P11.GatPoly v_c.P4.pSD \$I14
+ sg13_lv_pmos w=6e-06 l=1.3e-07 as=1.14e-12 ad=2.04e-12 ps=6.38e-06
+ pd=1.268e-05
X$21 VDD.P0.nSD \$I14 ntap1
X$22 v_c.P6.pSD di_tg_ctrl|di_tg_ctrl_n|vin|vout.P6.GatPoly v_a.P0.pSD \$I14
+ sg13_lv_pmos w=6e-06 l=1.3e-07 as=2.04e-12 ad=1.14e-12 ps=1.268e-05
+ pd=6.38e-06
X$23 v_a.P1.pSD di_tg_ctrl|di_tg_ctrl_n|vin|vout.P7.GatPoly v_c.P6.pSD \$I14
+ sg13_lv_pmos w=6e-06 l=1.3e-07 as=1.14e-12 ad=1.14e-12 ps=6.38e-06 pd=6.38e-06
X$24 v_c.P8.pSD di_tg_ctrl|di_tg_ctrl_n|vin|vout.P8.GatPoly v_a.P1.pSD \$I14
+ sg13_lv_pmos w=6e-06 l=1.3e-07 as=1.14e-12 ad=1.14e-12 ps=6.38e-06 pd=6.38e-06
X$25 v_a.P3.pSD di_tg_ctrl|di_tg_ctrl_n|vin|vout.P9.GatPoly v_c.P8.pSD \$I14
+ sg13_lv_pmos w=6e-06 l=1.3e-07 as=1.14e-12 ad=1.14e-12 ps=6.38e-06 pd=6.38e-06
X$26 v_c.P10.pSD di_tg_ctrl|di_tg_ctrl_n|vin|vout.P10.GatPoly v_a.P3.pSD \$I14
+ sg13_lv_pmos w=6e-06 l=1.3e-07 as=1.14e-12 ad=1.14e-12 ps=6.38e-06 pd=6.38e-06
X$27 v_a.P5.pSD di_tg_ctrl|di_tg_ctrl_n|vin|vout.P11.GatPoly v_c.P10.pSD \$I14
+ sg13_lv_pmos w=6e-06 l=1.3e-07 as=1.14e-12 ad=2.04e-12 ps=6.38e-06
+ pd=1.268e-05
X$28 VDD.P0.nSD \$I14 ntap1
X$29 VDD.P1.pSD VDD.P0.GatPoly VDD.P0.pSD \$I14 sg13_lv_pmos w=6e-06 l=1.3e-07
+ as=2.04e-12 ad=1.14e-12 ps=1.268e-05 pd=6.38e-06
X$30 di_tg_ctrl|di_tg_ctrl_n|vin|vout.P0.pSD di_spdt_ctrl.P0.GatPoly VDD.P1.pSD
+ \$I14 sg13_lv_pmos w=6e-06 l=1.3e-07 as=1.14e-12 ad=1.14e-12 ps=6.38e-06
+ pd=6.38e-06
X$31 VDD.P3.pSD di_spdt_ctrl.P1.GatPoly di_tg_ctrl|di_tg_ctrl_n|vin|vout.P0.pSD
+ \$I14 sg13_lv_pmos w=6e-06 l=1.3e-07 as=1.14e-12 ad=1.14e-12 ps=6.38e-06
+ pd=6.38e-06
X$32 VDD.P5.pSD VDD.P1.GatPoly VDD.P3.pSD \$I14 sg13_lv_pmos w=6e-06 l=1.3e-07
+ as=1.14e-12 ad=2.04e-12 ps=6.38e-06 pd=1.268e-05
X$33 VDD.P0.nSD \$I14 ntap1
X$34 VDD.P7.pSD VDD.P2.GatPoly VDD.P6.pSD \$I14 sg13_lv_pmos w=6e-06 l=1.3e-07
+ as=2.04e-12 ad=1.14e-12 ps=1.268e-05 pd=6.38e-06
X$35 di_tg_ctrl|di_tg_ctrl_n|vout.P0.pSD
+ di_tg_ctrl|di_tg_ctrl_n|vin|vout.P12.GatPoly VDD.P7.pSD \$I14 sg13_lv_pmos
+ w=6e-06 l=1.3e-07 as=1.14e-12 ad=1.14e-12 ps=6.38e-06 pd=6.38e-06
X$36 VDD.P10.pSD di_tg_ctrl|di_tg_ctrl_n|vin|vout.P13.GatPoly
+ di_tg_ctrl|di_tg_ctrl_n|vout.P0.pSD \$I14 sg13_lv_pmos w=6e-06 l=1.3e-07
+ as=1.14e-12 ad=1.14e-12 ps=6.38e-06 pd=6.38e-06
X$37 VDD.P11.pSD VDD.P3.GatPoly VDD.P10.pSD \$I14 sg13_lv_pmos w=6e-06
+ l=1.3e-07 as=1.14e-12 ad=2.04e-12 ps=6.38e-06 pd=1.268e-05
X$38 VDD.P0.nSD \$I14 ntap1
X$39 VSS.P1.nSD VSS.P0.GatPoly VSS.P0.nSD \$5 sg13_lv_nmos w=1e-06 l=1.3e-07
+ as=3.4e-13 ad=1.9e-13 ps=2.68e-06 pd=1.38e-06
X$40 di_tg_ctrl|di_tg_ctrl_n|vin|vout.P0.nSD di_spdt_ctrl.P2.GatPoly VSS.P1.nSD
+ \$5 sg13_lv_nmos w=1e-06 l=1.3e-07 as=1.9e-13 ad=1.9e-13 ps=1.38e-06
+ pd=1.38e-06
X$41 VSS.P3.nSD di_spdt_ctrl.P3.GatPoly di_tg_ctrl|di_tg_ctrl_n|vin|vout.P0.nSD
+ \$5 sg13_lv_nmos w=1e-06 l=1.3e-07 as=1.9e-13 ad=1.9e-13 ps=1.38e-06
+ pd=1.38e-06
X$42 VSS.P5.nSD VSS.P1.GatPoly VSS.P3.nSD \$5 sg13_lv_nmos w=1e-06 l=1.3e-07
+ as=1.9e-13 ad=3.4e-13 ps=1.38e-06 pd=2.68e-06
X$43 VSS.P0.pSD \$5 ptap1
X$44 VSS.P7.nSD VSS.P2.GatPoly VSS.P6.nSD \$5 sg13_lv_nmos w=1e-06 l=1.3e-07
+ as=3.4e-13 ad=1.9e-13 ps=2.68e-06 pd=1.38e-06
X$45 di_tg_ctrl|di_tg_ctrl_n|vout.P0.nSD
+ di_tg_ctrl|di_tg_ctrl_n|vin|vout.P14.GatPoly VSS.P7.nSD \$5 sg13_lv_nmos
+ w=1e-06 l=1.3e-07 as=1.9e-13 ad=1.9e-13 ps=1.38e-06 pd=1.38e-06
X$46 VSS.P10.nSD di_tg_ctrl|di_tg_ctrl_n|vin|vout.P15.GatPoly
+ di_tg_ctrl|di_tg_ctrl_n|vout.P0.nSD \$5 sg13_lv_nmos w=1e-06 l=1.3e-07
+ as=1.9e-13 ad=1.9e-13 ps=1.38e-06 pd=1.38e-06
X$47 VSS.P11.nSD VSS.P3.GatPoly VSS.P10.nSD \$5 sg13_lv_nmos w=1e-06 l=1.3e-07
+ as=1.9e-13 ad=3.4e-13 ps=1.38e-06 pd=2.68e-06
X$48 VSS.P0.pSD \$5 ptap1
* netlist reduce (TICER tau=0.1ps max degree 5, floating max degree 64): 3775 R, 6857 C, 2272 nodes -> 1604 R, 6067 C, 472 nodes
Cred_1 \$I14 di_spdt_ctrl 0.133696f
Cred_2 \$I14 di_spdt_ctrl.P0.GatPoly 0.0165609f
Cred_3 \$I14 di_spdt_ctrl.P1.GatPoly 0.0166199f
Cred_4 \$I14 di_spdt_ctrl.P2.GatPoly 0.000274128f
Cred_5 \$I14 di_spdt_ctrl.P3.GatPoly 0.000274128f
Cred_6 \$I14 di_tg_ctrl|di_tg_ctrl_n|vin|vout.$13.GatPoly 0.0597756f
Cred_7 \$I14 di_tg_ctrl|di_tg_ctrl_n|vin|vout.$136.Metal2 0.165711f
Cred_8 \$I14 di_tg_ctrl|di_tg_ctrl_n|vin|vout.$149.Metal2 0.00611702f
Cred_9 \$I14 di_tg_ctrl|di_tg_ctrl_n|vin|vout.$151.Metal2 0.00148607f
Cred_10 \$I14 di_tg_ctrl|di_tg_ctrl_n|vin|vout.$153.Metal2 0.00149493f
Cred_11 \$I14 di_tg_ctrl|di_tg_ctrl_n|vin|vout.$155.Metal2 0.00893573f
Cred_12 \$I14 di_tg_ctrl|di_tg_ctrl_n|vin|vout.$199.Metal3 0.0435834f
Cred_13 \$I14 di_tg_ctrl|di_tg_ctrl_n|vin|vout.$202.Metal3 0.00335343f
Cred_14 \$I14 di_tg_ctrl|di_tg_ctrl_n|vin|vout.$205.Metal3 0.00576599f
Cred_15 \$I14 di_tg_ctrl|di_tg_ctrl_n|vin|vout.$225.Metal4 0.0125044f
Cred_16 \$I14 di_tg_ctrl|di_tg_ctrl_n|vin|vout.$4.GatPoly 0.0466672f
Cred_17 \$I14 di_tg_ctrl|di_tg_ctrl_n|vin|vout.$6.GatPoly 0.0315436f
Cred_18 \$I14 di_tg_ctrl|di_tg_ctrl_n|vin|vout.$75.Metal1 0.0126575f
Cred_19 \$I14 di_tg_ctrl|di_tg_ctrl_n|vin|vout.$77.Metal1 0.00671426f
Cred_20 \$I14 di_tg_ctrl|di_tg_ctrl_n|vin|vout.$80.Metal1 0.00944278f
Cred_21 \$I14 di_tg_ctrl|di_tg_ctrl_n|vin|vout.$82.Metal1 0.0374362f
Cred_22 \$I14 di_tg_ctrl|di_tg_ctrl_n|vin|vout.$9.GatPoly 0.0436641f
Cred_23 \$I14 di_tg_ctrl|di_tg_ctrl_n|vin|vout.P0.nSD 0.00401882f
Cred_24 \$I14 di_tg_ctrl|di_tg_ctrl_n|vin|vout.P0.pSD 0.0270329f
Cred_25 \$I14 di_tg_ctrl|di_tg_ctrl_n|vin|vout.P10.GatPoly 0.0117542f
Cred_26 \$I14 di_tg_ctrl|di_tg_ctrl_n|vin|vout.P11.GatPoly 0.016516f
Cred_27 \$I14 di_tg_ctrl|di_tg_ctrl_n|vin|vout.P12.GatPoly 0.0174493f
Cred_28 \$I14 di_tg_ctrl|di_tg_ctrl_n|vin|vout.P13.GatPoly 0.0121854f
Cred_29 \$I14 di_tg_ctrl|di_tg_ctrl_n|vin|vout.P14.GatPoly 0.000324992f
Cred_30 \$I14 di_tg_ctrl|di_tg_ctrl_n|vin|vout.P15.GatPoly 0.000324992f
Cred_31 \$I14 di_tg_ctrl|di_tg_ctrl_n|vin|vout.P6.GatPoly 0.00753628f
Cred_32 \$I14 di_tg_ctrl|di_tg_ctrl_n|vin|vout.P7.GatPoly 0.0117542f
Cred_33 \$I14 di_tg_ctrl|di_tg_ctrl_n|vin|vout.P8.GatPoly 0.0119367f
Cred_34 \$I14 di_tg_ctrl|di_tg_ctrl_n|vin|vout.P9.GatPoly 0.012459f
Cred_35 \$I14 di_tg_ctrl|di_tg_ctrl_n|vout.$14.GatPoly 0.052899f
Cred_36 \$I14 di_tg_ctrl|di_tg_ctrl_n|vout.$144.Metal2 0.00690051f
Cred_37 \$I14 di_tg_ctrl|di_tg_ctrl_n|vout.$148.Metal2 0.0029526f
Cred_38 \$I14 di_tg_ctrl|di_tg_ctrl_n|vout.$152.Metal2 0.00757119f
Cred_39 \$I14 di_tg_ctrl|di_tg_ctrl_n|vout.$17.GatPoly 0.0436641f
Cred_40 \$I14 di_tg_ctrl|di_tg_ctrl_n|vout.$180.Metal3 0.0498007f
Cred_41 \$I14 di_tg_ctrl|di_tg_ctrl_n|vout.$192.Metal3 0.00568067f
Cred_42 \$I14 di_tg_ctrl|di_tg_ctrl_n|vout.$196.Metal3 0.00635837f
Cred_43 \$I14 di_tg_ctrl|di_tg_ctrl_n|vout.$206.Metal4 0.0923389f
Cred_44 \$I14 di_tg_ctrl|di_tg_ctrl_n|vout.$209.Metal4 0.00212233f
Cred_45 \$I14 di_tg_ctrl|di_tg_ctrl_n|vout.$21.GatPoly 0.0585148f
Cred_46 \$I14 di_tg_ctrl|di_tg_ctrl_n|vout.$77.Metal1 0.0247664f
Cred_47 \$I14 di_tg_ctrl|di_tg_ctrl_n|vout.$79.Metal1 0.00654752f
Cred_48 \$I14 di_tg_ctrl|di_tg_ctrl_n|vout.$81.Metal1 0.00672438f
Cred_49 \$I14 di_tg_ctrl|di_tg_ctrl_n|vout.$84.Metal1 0.00945573f
Cred_50 \$I14 di_tg_ctrl|di_tg_ctrl_n|vout.$86.Metal1 0.00846029f
Cred_51 \$I14 di_tg_ctrl|di_tg_ctrl_n|vout.$88.Metal1 0.00650726f
Cred_52 \$I14 di_tg_ctrl|di_tg_ctrl_n|vout.$90.Metal1 0.0245743f
Cred_53 \$I14 di_tg_ctrl|di_tg_ctrl_n|vout.P0.nSD 0.00564542f
Cred_54 \$I14 di_tg_ctrl|di_tg_ctrl_n|vout.P0.pSD 0.0333123f
Cred_55 \$I14 di_tg_ctrl|di_tg_ctrl_n|vout.P10.GatPoly 0.0117542f
Cred_56 \$I14 di_tg_ctrl|di_tg_ctrl_n|vout.P11.GatPoly 0.0159736f
Cred_57 \$I14 di_tg_ctrl|di_tg_ctrl_n|vout.P6.GatPoly 0.0164949f
Cred_58 \$I14 di_tg_ctrl|di_tg_ctrl_n|vout.P7.GatPoly 0.0117542f
Cred_59 \$I14 di_tg_ctrl|di_tg_ctrl_n|vout.P8.GatPoly 0.0119367f
Cred_60 \$I14 di_tg_ctrl|di_tg_ctrl_n|vout.P9.GatPoly 0.012459f
Cred_61 \$I14 v_a 0.0331485f
Cred_62 \$I14 v_a.$148.Metal2 0.127242f
Cred_63 \$I14 v_a.$182.Metal2 0.128716f
Cred_64 \$I14 v_a.P0.pSD 0.0739793f
Cred_65 \$I14 v_a.P1.nSD 9.61115e-05f
Cred_66 \$I14 v_a.P1.pSD 0.00428944f
Cred_67 \$I14 v_a.P3.pSD 0.0039217f
Cred_68 \$I14 v_a.P5.nSD 0.00068984f
Cred_69 \$I14 v_a.P5.pSD 0.0969646f
Cred_70 \$I14 v_b 0.129588f
Cred_71 \$I14 v_b.$161.Metal2 0.127148f
Cred_72 \$I14 v_b.$195.Metal2 0.192536f
Cred_73 \$I14 v_b.P0.nSD 0.000677664f
Cred_74 \$I14 v_b.P0.pSD 0.0963183f
Cred_75 \$I14 v_b.P1.pSD 0.00393814f
Cred_76 \$I14 v_b.P3.nSD 9.63727e-05f
Cred_77 \$I14 v_b.P3.pSD 0.00430689f
Cred_78 \$I14 v_b.P5.pSD 0.0788066f
Cred_79 \$I14 v_c 0.00528687f
Cred_80 \$I14 v_c.$129.Metal1 0.002655f
Cred_81 \$I14 v_c.$165.Metal1 0.0026514f
Cred_82 \$I14 v_c.$201.Metal1 0.00265252f
Cred_83 \$I14 v_c.$21.Metal1 0.00256942f
Cred_84 \$I14 v_c.$220.Metal2 0.00163681f
Cred_85 \$I14 v_c.$224.Metal2 8.43766e-06f
Cred_86 \$I14 v_c.$284.Metal2 0.0016878f
Cred_87 \$I14 v_c.$288.Metal2 8.43766e-06f
Cred_88 \$I14 v_c.$320.Metal2 0.00157515f
Cred_89 \$I14 v_c.$352.Metal2 0.00150122f
Cred_90 \$I14 v_c.$384.Metal2 0.00152422f
Cred_91 \$I14 v_c.$411.Metal3 0.00728092f
Cred_92 \$I14 v_c.$425.Metal3 0.0313015f
Cred_93 \$I14 v_c.$446.Metal3 0.0136412f
Cred_94 \$I14 v_c.$459.Metal3 0.0482334f
Cred_95 \$I14 v_c.$464.Metal3 0.00686799f
Cred_96 \$I14 v_c.$476.Metal3 0.00467829f
Cred_97 \$I14 v_c.$481.Metal3 0.0034936f
Cred_98 \$I14 v_c.$493.Metal3 0.0154092f
Cred_99 \$I14 v_c.$498.Metal3 0.00454329f
Cred_100 \$I14 v_c.$93.Metal1 0.00256942f
Cred_101 \$I14 v_c.P0.pSD 8.72454e-05f
Cred_102 \$I14 v_c.P10.nSD 0.000113113f
Cred_103 \$I14 v_c.P10.pSD 8.55145e-05f
Cred_104 \$I14 v_c.P2.pSD 8.71757e-05f
Cred_105 \$I14 v_c.P4.pSD 8.71974e-05f
Cred_106 \$I14 v_c.P6.nSD 1.44005e-05f
Cred_107 \$I14 v_c.P6.pSD 8.55145e-05f
Cred_108 \$I14 v_c.P8.pSD 0.00282611f
Cred_109 \$I14 VDD.$102.Metal1 0.00256745f
Cred_110 \$I14 VDD.$105.Metal1 0.0189955f
Cred_111 \$I14 VDD.$113.Metal1 0.0189953f
Cred_112 \$I14 VDD.$125.Metal1 0.0021812f
Cred_113 \$I14 VDD.$131.Metal1 0.00256927f
Cred_114 \$I14 VDD.$170.Metal1 0.0177387f
Cred_115 \$I14 VDD.$172.Metal1 0.00913536f
Cred_116 \$I14 VDD.$174.Metal1 0.00912007f
Cred_117 \$I14 VDD.$176.Metal1 0.00686119f
Cred_118 \$I14 VDD.$177.Metal1 0.00683002f
Cred_119 \$I14 VDD.$179.Metal1 0.0113231f
Cred_120 \$I14 VDD.$182.Metal1 0.0199829f
Cred_121 \$I14 VDD.$185.Metal1 0.0312182f
Cred_122 \$I14 VDD.$215.Metal1 0.136233f
Cred_123 \$I14 VDD.$218.Metal1 0.0298364f
Cred_124 \$I14 VDD.$240.Metal1 0.0177387f
Cred_125 \$I14 VDD.$242.Metal1 0.00913536f
Cred_126 \$I14 VDD.$244.Metal1 0.00912007f
Cred_127 \$I14 VDD.$246.Metal1 0.00686119f
Cred_128 \$I14 VDD.$247.Metal1 0.00683002f
Cred_129 \$I14 VDD.$249.Metal1 0.0113231f
Cred_130 \$I14 VDD.$252.Metal1 0.0199829f
Cred_131 \$I14 VDD.$257.Metal1 0.0223608f
Cred_132 \$I14 VDD.$279.Metal1 0.00256927f
Cred_133 \$I14 VDD.$29.Metal1 0.10281f
Cred_134 \$I14 VDD.$291.Metal1 0.00256745f
Cred_135 \$I14 VDD.$298.Metal1 0.0182568f
Cred_136 \$I14 VDD.$320.Metal1 0.00276499f
Cred_137 \$I14 VDD.$33.Metal1 0.0206861f
Cred_138 \$I14 VDD.$332.Metal1 0.00256745f
Cred_139 \$I14 VDD.$339.Metal1 0.0223608f
Cred_140 \$I14 VDD.$359.Metal1 0.0179344f
Cred_141 \$I14 VDD.$361.Metal1 0.00913536f
Cred_142 \$I14 VDD.$363.Metal1 0.00912007f
Cred_143 \$I14 VDD.$365.Metal1 0.00686119f
Cred_144 \$I14 VDD.$366.Metal1 0.00683002f
Cred_145 \$I14 VDD.$368.Metal1 0.0113231f
Cred_146 \$I14 VDD.$371.Metal1 0.0199829f
Cred_147 \$I14 VDD.$378.Metal1 0.0710957f
Cred_148 \$I14 VDD.$382.Metal1 0.326134f
Cred_149 \$I14 VDD.$405.Metal1 0.0831877f
Cred_150 \$I14 VDD.$414.Metal1 0.0176436f
Cred_151 \$I14 VDD.$418.Metal1 0.00559205f
Cred_152 \$I14 VDD.$422.Metal1 0.00558547f
Cred_153 \$I14 VDD.$426.Metal1 0.0113037f
Cred_154 \$I14 VDD.$434.Metal1 0.0112988f
Cred_155 \$I14 VDD.$438.Metal1 0.00558547f
Cred_156 \$I14 VDD.$442.Metal1 0.00559205f
Cred_157 \$I14 VDD.$446.Metal1 0.0176436f
Cred_158 \$I14 VDD.$453.Metal1 0.0259972f
Cred_159 \$I14 VDD.$477.Metal1 0.134586f
Cred_160 \$I14 VDD.$484.Metal1 0.0331138f
Cred_161 \$I14 VDD.$495.Metal1 0.0114386f
Cred_162 \$I14 VDD.$499.Metal1 0.0113037f
Cred_163 \$I14 VDD.$507.Metal1 0.0112988f
Cred_164 \$I14 VDD.$51.Metal1 0.0178894f
Cred_165 \$I14 VDD.$511.Metal1 0.00837087f
Cred_166 \$I14 VDD.$519.Metal1 0.0205692f
Cred_167 \$I14 VDD.$526.Metal1 0.137661f
Cred_168 \$I14 VDD.$53.Metal1 0.00913536f
Cred_169 \$I14 VDD.$55.Metal1 0.00912007f
Cred_170 \$I14 VDD.$552.Metal2 0.0336099f
Cred_171 \$I14 VDD.$562.Metal2 0.032351f
Cred_172 \$I14 VDD.$563.Metal2 0.00675312f
Cred_173 \$I14 VDD.$564.Metal2 0.0067964f
Cred_174 \$I14 VDD.$565.Metal2 0.00677335f
Cred_175 \$I14 VDD.$566.Metal2 0.00678927f
Cred_176 \$I14 VDD.$567.Metal2 0.00676199f
Cred_177 \$I14 VDD.$568.Metal2 0.00679385f
Cred_178 \$I14 VDD.$569.Metal2 0.00676047f
Cred_179 \$I14 VDD.$57.Metal1 0.00686119f
Cred_180 \$I14 VDD.$570.Metal2 0.00684499f
Cred_181 \$I14 VDD.$571.Metal2 0.0068331f
Cred_182 \$I14 VDD.$572.Metal2 0.00685531f
Cred_183 \$I14 VDD.$573.Metal2 0.0552483f
Cred_184 \$I14 VDD.$574.Metal2 0.000578952f
Cred_185 \$I14 VDD.$58.Metal1 0.00683002f
Cred_186 \$I14 VDD.$597.Metal2 0.00401103f
Cred_187 \$I14 VDD.$60.Metal1 0.0113231f
Cred_188 \$I14 VDD.$606.Metal2 0.0381953f
Cred_189 \$I14 VDD.$607.Metal2 0.010785f
Cred_190 \$I14 VDD.$608.Metal2 0.0106762f
Cred_191 \$I14 VDD.$609.Metal2 0.0105897f
Cred_192 \$I14 VDD.$610.Metal2 0.0106762f
Cred_193 \$I14 VDD.$611.Metal2 0.0106301f
Cred_194 \$I14 VDD.$612.Metal2 0.010662f
Cred_195 \$I14 VDD.$613.Metal2 0.0106074f
Cred_196 \$I14 VDD.$614.Metal2 0.0106711f
Cred_197 \$I14 VDD.$615.Metal2 0.0106044f
Cred_198 \$I14 VDD.$616.Metal2 0.0107734f
Cred_199 \$I14 VDD.$617.Metal2 0.0108018f
Cred_200 \$I14 VDD.$618.Metal2 0.0108824f
Cred_201 \$I14 VDD.$619.Metal2 0.0213148f
Cred_202 \$I14 VDD.$620.Metal2 0.141757f
Cred_203 \$I14 VDD.$621.Metal2 0.000633624f
Cred_204 \$I14 VDD.$63.Metal1 0.0199829f
Cred_205 \$I14 VDD.$643.Metal2 0.00214509f
Cred_206 \$I14 VDD.$651.Metal2 0.00106092f
Cred_207 \$I14 VDD.$688.Metal2 0.00258492f
Cred_208 \$I14 VDD.$696.Metal2 0.00258492f
Cred_209 \$I14 VDD.$703.Metal2 0.0412418f
Cred_210 \$I14 VDD.$704.Metal2 0.00820543f
Cred_211 \$I14 VDD.$705.Metal2 0.00824871f
Cred_212 \$I14 VDD.$706.Metal2 0.00822566f
Cred_213 \$I14 VDD.$707.Metal2 0.00824158f
Cred_214 \$I14 VDD.$708.Metal2 0.0082143f
Cred_215 \$I14 VDD.$709.Metal2 0.00824616f
Cred_216 \$I14 VDD.$710.Metal2 0.00821278f
Cred_217 \$I14 VDD.$711.Metal2 0.0082973f
Cred_218 \$I14 VDD.$712.Metal2 0.00828541f
Cred_219 \$I14 VDD.$713.Metal2 0.00830762f
Cred_220 \$I14 VDD.$714.Metal2 0.0666787f
Cred_221 \$I14 VDD.$734.Metal2 0.0406683f
Cred_222 \$I14 VDD.$738.Metal2 0.0159788f
Cred_223 \$I14 VDD.$746.Metal2 0.0274866f
Cred_224 \$I14 VDD.$754.Metal2 0.000665988f
Cred_225 \$I14 VDD.$762.Metal2 3.29236e-05f
Cred_226 \$I14 VDD.$766.Metal2 3.74062e-05f
Cred_227 \$I14 VDD.$774.Metal2 0.000665988f
Cred_228 \$I14 VDD.$782.Metal2 0.0188494f
Cred_229 \$I14 VDD.$790.Metal2 0.021246f
Cred_230 \$I14 VDD.$798.Metal2 0.00732089f
Cred_231 \$I14 VDD.$802.Metal2 2.92792e-05f
Cred_232 \$I14 VDD.$810.Metal2 3.29236e-05f
Cred_233 \$I14 VDD.$814.Metal2 3.74062e-05f
Cred_234 \$I14 VDD.$822.Metal2 1.86077e-05f
Cred_235 \$I14 VDD.$826.Metal2 0.0334688f
Cred_236 \$I14 VDD.$844.Metal3 0.0030327f
Cred_237 \$I14 VDD.$852.Metal3 0.00100011f
Cred_238 \$I14 VDD.$856.Metal3 8.00438e-06f
Cred_239 \$I14 VDD.$864.Metal3 1.09501e-05f
Cred_240 \$I14 VDD.$874.Metal3 0.000119035f
Cred_241 \$I14 VDD.$878.Metal3 5.26824e-06f
Cred_242 \$I14 VDD.$882.Metal3 2.21419e-08f
Cred_243 \$I14 VDD.$888.Metal3 2.21419e-08f
Cred_244 \$I14 VDD.$892.Metal3 0.00542952f
Cred_245 \$I14 VDD.$896.Metal3 0.0242483f
Cred_246 \$I14 VDD.$90.Metal1 0.00271998f
Cred_247 \$I14 VDD.$902.Metal3 0.0116386f
Cred_248 \$I14 VDD.$906.Metal3 2.21419e-08f
Cred_249 \$I14 VDD.$912.Metal3 2.21419e-08f
Cred_250 \$I14 VDD.$918.Metal3 0.0302428f
Cred_251 \$I14 VDD.P0.GatPoly 0.0209983f
Cred_252 \$I14 VDD.P0.nSD 0.726918f
Cred_253 \$I14 VDD.P0.pSD 0.000827031f
Cred_254 \$I14 VDD.P1.GatPoly 0.0216294f
Cred_255 \$I14 VDD.P1.pSD 0.000174335f
Cred_256 \$I14 VDD.P10.pSD 0.000175224f
Cred_257 \$I14 VDD.P11.pSD 0.00082792f
Cred_258 \$I14 VDD.P2.GatPoly 0.0216306f
Cred_259 \$I14 VDD.P3.GatPoly 0.025129f
Cred_260 \$I14 VDD.P3.pSD 0.000332441f
Cred_261 \$I14 VDD.P5.pSD 0.000824083f
Cred_262 \$I14 VDD.P6.pSD 0.000824083f
Cred_263 \$I14 VDD.P7.pSD 0.000171387f
Cred_264 \$I14 VSS.$129.Metal1 0.0141929f
Cred_265 \$I14 VSS.$156.Metal1 6.47359e-05f
Cred_266 \$I14 VSS.$209.Metal1 1.18838e-05f
Cred_267 \$I14 VSS.$220.Metal1 0.0308778f
Cred_268 \$I14 VSS.$255.Metal1 0.00643383f
Cred_269 \$I14 VSS.$284.Metal2 1.28624e-06f
Cred_270 \$I14 VSS.$311.Metal2 0.00813397f
Cred_271 \$I14 VSS.$33.Metal1 0.00366114f
Cred_272 \$I14 VSS.$359.Metal2 0.0168073f
Cred_273 \$I14 VSS.$416.Metal2 0.00409903f
Cred_274 \$I14 VSS.$424.Metal2 0.00363822f
Cred_275 \$I14 VSS.$428.Metal2 0.00261684f
Cred_276 \$I14 VSS.$452.Metal2 0.000261706f
Cred_277 \$I14 VSS.$5.Metal1 0.000823594f
Cred_278 \$I14 VSS.$530.Metal3 1.18838e-05f
Cred_279 \$I14 VSS.$548.Metal3 1.88278e-05f
Cred_280 \$I14 VSS.$78.Metal1 0.000181811f
Cred_281 \$I14 VSS.$87.Metal1 0.027671f
Cred_282 \$I14 VSS.P0.pSD 0.0216643f
Cred_283 \$I14 VSS.P1.GatPoly 2.39468e-07f
Cred_284 \$I14 VSS.P3.nSD 2.37956e-06f
Cred_285 \$I14 VSS.P5.nSD 1.88602e-06f
Cred_286 di_spdt_ctrl di_tg_ctrl|di_tg_ctrl_n|vin|vout.$136.Metal2 0.0975335f
Cred_287 di_spdt_ctrl di_tg_ctrl|di_tg_ctrl_n|vin|vout.$199.Metal3 0.0481226f
Cred_288 di_spdt_ctrl di_tg_ctrl|di_tg_ctrl_n|vin|vout.$225.Metal4 0.0271793f
Cred_289 di_spdt_ctrl di_tg_ctrl|di_tg_ctrl_n|vin|vout.P0.nSD 0.0486891f
Cred_290 di_spdt_ctrl di_tg_ctrl|di_tg_ctrl_n|vin|vout.P0.pSD 0.170617f
Cred_291 di_spdt_ctrl di_tg_ctrl|di_tg_ctrl_n|vin|vout.P12.GatPoly 2.65492e-05f
Cred_292 di_spdt_ctrl di_tg_ctrl|di_tg_ctrl_n|vin|vout.P13.GatPoly 2.6547e-05f
Cred_293 di_spdt_ctrl di_tg_ctrl|di_tg_ctrl_n|vin|vout.P14.GatPoly 8.82793e-05f
Cred_294 di_spdt_ctrl di_tg_ctrl|di_tg_ctrl_n|vin|vout.P15.GatPoly 8.82717e-05f
Cred_295 di_spdt_ctrl VSS 0.21597f
Cred_296 di_spdt_ctrl v_a 0.0465282f
Cred_297 di_spdt_ctrl VDD.$131.Metal1 0.0111612f
Cred_298 di_spdt_ctrl VDD.$133.Metal1 0.00141172f
Cred_299 di_spdt_ctrl VDD.$215.Metal1 0.010583f
Cred_300 di_spdt_ctrl VDD.$29.Metal1 0.0135673f
Cred_301 di_spdt_ctrl VDD.$382.Metal1 0.0273384f
Cred_302 di_spdt_ctrl VDD.$51.Metal1 0.000419098f
Cred_303 di_spdt_ctrl VDD.$562.Metal2 0.064859f
Cred_304 di_spdt_ctrl VDD.$563.Metal2 8.21634e-07f
Cred_305 di_spdt_ctrl VDD.$606.Metal2 0.00120285f
Cred_306 di_spdt_ctrl VDD.$607.Metal2 4.98034e-05f
Cred_307 di_spdt_ctrl VDD.$608.Metal2 2.95333e-05f
Cred_308 di_spdt_ctrl VDD.$609.Metal2 8.21634e-07f
Cred_309 di_spdt_ctrl VDD.$90.Metal1 0.0115803f
Cred_310 di_spdt_ctrl VDD.$92.Metal1 0.00141172f
Cred_311 di_spdt_ctrl VDD.P0.GatPoly 0.0557501f
Cred_312 di_spdt_ctrl VDD.P0.nSD 0.132847f
Cred_313 di_spdt_ctrl VDD.P0.pSD 8.47767e-06f
Cred_314 di_spdt_ctrl VDD.P1.GatPoly 0.0551978f
Cred_315 di_spdt_ctrl VDD.P1.pSD 0.00251239f
Cred_316 di_spdt_ctrl VDD.P3.pSD 0.00122545f
Cred_317 di_spdt_ctrl VSS 0.000645437f
Cred_318 di_spdt_ctrl VSS.$284.Metal2 0.06126f
Cred_319 di_spdt_ctrl VSS.$286.Metal2 1.08905e-06f
Cred_320 di_spdt_ctrl VSS.$292.Metal2 0.00198878f
Cred_321 di_spdt_ctrl VSS.$303.Metal2 0.0061323f
Cred_322 di_spdt_ctrl VSS.$307.Metal2 0.00325671f
Cred_323 di_spdt_ctrl VSS.$33.Metal1 0.035013f
Cred_324 di_spdt_ctrl VSS.$42.Metal1 0.00356418f
Cred_325 di_spdt_ctrl VSS.$474.Metal3 0.000456529f
Cred_326 di_spdt_ctrl VSS.$478.Metal3 1.81898e-05f
Cred_327 di_spdt_ctrl VSS.$5.Metal1 0.00718656f
Cred_328 di_spdt_ctrl VSS.$61.Metal1 0.00176398f
Cred_329 di_spdt_ctrl VSS.$78.Metal1 0.00200227f
Cred_330 di_spdt_ctrl VSS.$87.Metal1 0.0823852f
Cred_331 di_spdt_ctrl VSS.P0.GatPoly 0.00805706f
Cred_332 di_spdt_ctrl VSS.P0.nSD 2.27355e-05f
Cred_333 di_spdt_ctrl VSS.P0.pSD 0.0387536f
Cred_334 di_spdt_ctrl VSS.P1.GatPoly 0.00739034f
Cred_335 di_spdt_ctrl VSS.P1.nSD 2.27355e-05f
Cred_336 di_spdt_ctrl.P0.GatPoly di_tg_ctrl|di_tg_ctrl_n|vin|vout.$136.Metal2 0.00608907f
Cred_337 di_spdt_ctrl.P0.GatPoly di_tg_ctrl|di_tg_ctrl_n|vin|vout.$199.Metal3 0.00477456f
Cred_338 di_spdt_ctrl.P0.GatPoly di_tg_ctrl|di_tg_ctrl_n|vin|vout.$225.Metal4 0.00269663f
Cred_339 di_spdt_ctrl.P0.GatPoly di_tg_ctrl|di_tg_ctrl_n|vin|vout.P0.nSD 0.00200746f
Cred_340 di_spdt_ctrl.P0.GatPoly di_tg_ctrl|di_tg_ctrl_n|vin|vout.P0.pSD 0.0568553f
Cred_341 di_spdt_ctrl.P0.GatPoly di_tg_ctrl|di_tg_ctrl_n|vin|vout.P12.GatPoly 5.33826e-08f
Cred_342 di_spdt_ctrl.P0.GatPoly di_tg_ctrl|di_tg_ctrl_n|vin|vout.P13.GatPoly 5.33768e-08f
Cred_343 di_spdt_ctrl.P0.GatPoly di_tg_ctrl|di_tg_ctrl_n|vin|vout.P14.GatPoly 1.03161e-07f
Cred_344 di_spdt_ctrl.P0.GatPoly di_tg_ctrl|di_tg_ctrl_n|vin|vout.P15.GatPoly 1.03154e-07f
Cred_345 di_spdt_ctrl.P0.GatPoly VSS 0.00200268f
Cred_346 di_spdt_ctrl.P0.GatPoly v_a 1.33927e-05f
Cred_347 di_spdt_ctrl.P0.GatPoly v_b 0.00583208f
Cred_348 di_spdt_ctrl.P0.GatPoly VDD.$100.Metal1 0.00787427f
Cred_349 di_spdt_ctrl.P0.GatPoly VDD.$102.Metal1 0.0130966f
Cred_350 di_spdt_ctrl.P0.GatPoly VDD.$105.Metal1 0.00305933f
Cred_351 di_spdt_ctrl.P0.GatPoly VDD.$113.Metal1 0.000328131f
Cred_352 di_spdt_ctrl.P0.GatPoly VDD.$131.Metal1 0.00065462f
Cred_353 di_spdt_ctrl.P0.GatPoly VDD.$133.Metal1 8.2799e-05f
Cred_354 di_spdt_ctrl.P0.GatPoly VDD.$215.Metal1 0.000132304f
Cred_355 di_spdt_ctrl.P0.GatPoly VDD.$29.Metal1 0.000137468f
Cred_356 di_spdt_ctrl.P0.GatPoly VDD.$382.Metal1 0.000338235f
Cred_357 di_spdt_ctrl.P0.GatPoly VDD.$51.Metal1 8.73029e-07f
Cred_358 di_spdt_ctrl.P0.GatPoly VDD.$552.Metal2 0.0174698f
Cred_359 di_spdt_ctrl.P0.GatPoly VDD.$562.Metal2 0.000139051f
Cred_360 di_spdt_ctrl.P0.GatPoly VDD.$563.Metal2 1.21287e-06f
Cred_361 di_spdt_ctrl.P0.GatPoly VDD.$564.Metal2 3.95746e-05f
Cred_362 di_spdt_ctrl.P0.GatPoly VDD.$565.Metal2 1.97047e-05f
Cred_363 di_spdt_ctrl.P0.GatPoly VDD.$566.Metal2 3.34227e-05f
Cred_364 di_spdt_ctrl.P0.GatPoly VDD.$567.Metal2 3.30981e-05f
Cred_365 di_spdt_ctrl.P0.GatPoly VDD.$568.Metal2 1.87248e-05f
Cred_366 di_spdt_ctrl.P0.GatPoly VDD.$569.Metal2 4.02052e-05f
Cred_367 di_spdt_ctrl.P0.GatPoly VDD.$570.Metal2 2.25087e-06f
Cred_368 di_spdt_ctrl.P0.GatPoly VDD.$571.Metal2 3.88876e-05f
Cred_369 di_spdt_ctrl.P0.GatPoly VDD.$572.Metal2 5.94388e-05f
Cred_370 di_spdt_ctrl.P0.GatPoly VDD.$573.Metal2 0.0286463f
Cred_371 di_spdt_ctrl.P0.GatPoly VDD.$574.Metal2 0.00137831f
Cred_372 di_spdt_ctrl.P0.GatPoly VDD.$597.Metal2 0.00157479f
Cred_373 di_spdt_ctrl.P0.GatPoly VDD.$606.Metal2 7.05485e-05f
Cred_374 di_spdt_ctrl.P0.GatPoly VDD.$607.Metal2 2.92103e-06f
Cred_375 di_spdt_ctrl.P0.GatPoly VDD.$608.Metal2 1.73216e-06f
Cred_376 di_spdt_ctrl.P0.GatPoly VDD.$609.Metal2 4.81899e-08f
Cred_377 di_spdt_ctrl.P0.GatPoly VDD.$620.Metal2 0.00893557f
Cred_378 di_spdt_ctrl.P0.GatPoly VDD.$844.Metal3 0.00177786f
Cred_379 di_spdt_ctrl.P0.GatPoly VDD.$90.Metal1 0.000895668f
Cred_380 di_spdt_ctrl.P0.GatPoly VDD.$92.Metal1 0.00606347f
Cred_381 di_spdt_ctrl.P0.GatPoly VDD.$94.Metal1 0.00786109f
Cred_382 di_spdt_ctrl.P0.GatPoly VDD.$96.Metal1 0.0078574f
Cred_383 di_spdt_ctrl.P0.GatPoly VDD.$98.Metal1 0.00786165f
Cred_384 di_spdt_ctrl.P0.GatPoly VDD.P0.GatPoly 0.134853f
Cred_385 di_spdt_ctrl.P0.GatPoly VDD.P0.nSD 0.00152663f
Cred_386 di_spdt_ctrl.P0.GatPoly VDD.P0.pSD 1.76042e-08f
Cred_387 di_spdt_ctrl.P0.GatPoly VDD.P1.GatPoly 0.0270496f
Cred_388 di_spdt_ctrl.P0.GatPoly VDD.P1.pSD 0.000346336f
Cred_389 di_spdt_ctrl.P0.GatPoly VDD.P3.pSD 3.72139e-05f
Cred_390 di_spdt_ctrl.P0.GatPoly VSS.$284.Metal2 1.63121e-05f
Cred_391 di_spdt_ctrl.P0.GatPoly VSS.$292.Metal2 1.64413e-06f
Cred_392 di_spdt_ctrl.P0.GatPoly VSS.$303.Metal2 5.06958e-06f
Cred_393 di_spdt_ctrl.P0.GatPoly VSS.$307.Metal2 2.69232e-06f
Cred_394 di_spdt_ctrl.P0.GatPoly VSS.$33.Metal1 1.44492e-05f
Cred_395 di_spdt_ctrl.P0.GatPoly VSS.$42.Metal1 2.94651e-06f
Cred_396 di_spdt_ctrl.P0.GatPoly VSS.$478.Metal3 1.50375e-08f
Cred_397 di_spdt_ctrl.P0.GatPoly VSS.$5.Metal1 3.06675e-06f
Cred_398 di_spdt_ctrl.P0.GatPoly VSS.$61.Metal1 1.45829e-06f
Cred_399 di_spdt_ctrl.P0.GatPoly VSS.$78.Metal1 1.65528e-06f
Cred_400 di_spdt_ctrl.P0.GatPoly VSS.$87.Metal1 5.36862e-05f
Cred_401 di_spdt_ctrl.P0.GatPoly VSS.P0.GatPoly 6.66077e-06f
Cred_402 di_spdt_ctrl.P0.GatPoly VSS.P0.nSD 6.0535e-09f
Cred_403 di_spdt_ctrl.P0.GatPoly VSS.P0.pSD 1.98767e-05f
Cred_404 di_spdt_ctrl.P0.GatPoly VSS.P1.GatPoly 6.1096e-06f
Cred_405 di_spdt_ctrl.P0.GatPoly VSS.P1.nSD 6.0535e-09f
Cred_406 di_spdt_ctrl.P1.GatPoly di_tg_ctrl|di_tg_ctrl_n|vin|vout.$136.Metal2 0.00669335f
Cred_407 di_spdt_ctrl.P1.GatPoly di_tg_ctrl|di_tg_ctrl_n|vin|vout.$199.Metal3 0.00525174f
Cred_408 di_spdt_ctrl.P1.GatPoly di_tg_ctrl|di_tg_ctrl_n|vin|vout.$225.Metal4 0.00296614f
Cred_409 di_spdt_ctrl.P1.GatPoly di_tg_ctrl|di_tg_ctrl_n|vin|vout.P0.nSD 0.00220572f
Cred_410 di_spdt_ctrl.P1.GatPoly di_tg_ctrl|di_tg_ctrl_n|vin|vout.P0.pSD 0.0591374f
Cred_411 di_spdt_ctrl.P1.GatPoly di_tg_ctrl|di_tg_ctrl_n|vin|vout.P12.GatPoly 5.33884e-08f
Cred_412 di_spdt_ctrl.P1.GatPoly di_tg_ctrl|di_tg_ctrl_n|vin|vout.P13.GatPoly 5.33827e-08f
Cred_413 di_spdt_ctrl.P1.GatPoly di_tg_ctrl|di_tg_ctrl_n|vin|vout.P14.GatPoly 1.03166e-07f
Cred_414 di_spdt_ctrl.P1.GatPoly di_tg_ctrl|di_tg_ctrl_n|vin|vout.P15.GatPoly 1.0316e-07f
Cred_415 di_spdt_ctrl.P1.GatPoly di_tg_ctrl|di_tg_ctrl_n|vout.$180.Metal3 0.000280861f
Cred_416 di_spdt_ctrl.P1.GatPoly di_tg_ctrl|di_tg_ctrl_n|vout.$206.Metal4 0.000828125f
Cred_417 di_spdt_ctrl.P1.GatPoly di_tg_ctrl|di_tg_ctrl_n|vout.P0.nSD 3.22689e-05f
Cred_418 di_spdt_ctrl.P1.GatPoly di_tg_ctrl|di_tg_ctrl_n|vout.P0.pSD 0.000167506f
Cred_419 di_spdt_ctrl.P1.GatPoly VSS 0.00197662f
Cred_420 di_spdt_ctrl.P1.GatPoly v_a 1.33927e-05f
Cred_421 di_spdt_ctrl.P1.GatPoly v_b 0.00168405f
Cred_422 di_spdt_ctrl.P1.GatPoly VDD.$105.Metal1 0.000328131f
Cred_423 di_spdt_ctrl.P1.GatPoly VDD.$113.Metal1 0.00306171f
Cred_424 di_spdt_ctrl.P1.GatPoly VDD.$125.Metal1 0.0189554f
Cred_425 di_spdt_ctrl.P1.GatPoly VDD.$131.Metal1 0.000894795f
Cred_426 di_spdt_ctrl.P1.GatPoly VDD.$133.Metal1 0.00606347f
Cred_427 di_spdt_ctrl.P1.GatPoly VDD.$135.Metal1 0.00786109f
Cred_428 di_spdt_ctrl.P1.GatPoly VDD.$137.Metal1 0.0078574f
Cred_429 di_spdt_ctrl.P1.GatPoly VDD.$139.Metal1 0.00791603f
Cred_430 di_spdt_ctrl.P1.GatPoly VDD.$215.Metal1 0.000132752f
Cred_431 di_spdt_ctrl.P1.GatPoly VDD.$29.Metal1 0.000136847f
Cred_432 di_spdt_ctrl.P1.GatPoly VDD.$382.Metal1 0.000339377f
Cred_433 di_spdt_ctrl.P1.GatPoly VDD.$51.Metal1 7.22663e-07f
Cred_434 di_spdt_ctrl.P1.GatPoly VDD.$552.Metal2 0.00350625f
Cred_435 di_spdt_ctrl.P1.GatPoly VDD.$562.Metal2 0.00011445f
Cred_436 di_spdt_ctrl.P1.GatPoly VDD.$563.Metal2 4.81899e-08f
Cred_437 di_spdt_ctrl.P1.GatPoly VDD.$573.Metal2 0.0054284f
Cred_438 di_spdt_ctrl.P1.GatPoly VDD.$597.Metal2 0.00187812f
Cred_439 di_spdt_ctrl.P1.GatPoly VDD.$606.Metal2 9.34602e-05f
Cred_440 di_spdt_ctrl.P1.GatPoly VDD.$607.Metal2 3.86968e-06f
Cred_441 di_spdt_ctrl.P1.GatPoly VDD.$608.Metal2 2.7682e-06f
Cred_442 di_spdt_ctrl.P1.GatPoly VDD.$609.Metal2 1.21287e-06f
Cred_443 di_spdt_ctrl.P1.GatPoly VDD.$610.Metal2 3.95746e-05f
Cred_444 di_spdt_ctrl.P1.GatPoly VDD.$611.Metal2 1.97047e-05f
Cred_445 di_spdt_ctrl.P1.GatPoly VDD.$612.Metal2 3.34227e-05f
Cred_446 di_spdt_ctrl.P1.GatPoly VDD.$613.Metal2 3.30981e-05f
Cred_447 di_spdt_ctrl.P1.GatPoly VDD.$614.Metal2 1.87248e-05f
Cred_448 di_spdt_ctrl.P1.GatPoly VDD.$615.Metal2 4.12022e-05f
Cred_449 di_spdt_ctrl.P1.GatPoly VDD.$617.Metal2 0.000302813f
Cred_450 di_spdt_ctrl.P1.GatPoly VDD.$618.Metal2 0.000508417f
Cred_451 di_spdt_ctrl.P1.GatPoly VDD.$619.Metal2 0.00202959f
Cred_452 di_spdt_ctrl.P1.GatPoly VDD.$620.Metal2 0.0445212f
Cred_453 di_spdt_ctrl.P1.GatPoly VDD.$621.Metal2 0.00187559f
Cred_454 di_spdt_ctrl.P1.GatPoly VDD.$844.Metal3 0.00087604f
Cred_455 di_spdt_ctrl.P1.GatPoly VDD.$852.Metal3 0.00087604f
Cred_456 di_spdt_ctrl.P1.GatPoly VDD.$90.Metal1 0.000655343f
Cred_457 di_spdt_ctrl.P1.GatPoly VDD.$92.Metal1 8.2799e-05f
Cred_458 di_spdt_ctrl.P1.GatPoly VDD.P0.GatPoly 0.0270829f
Cred_459 di_spdt_ctrl.P1.GatPoly VDD.P0.nSD 0.00152569f
Cred_460 di_spdt_ctrl.P1.GatPoly VDD.P0.pSD 1.45763e-08f
Cred_461 di_spdt_ctrl.P1.GatPoly VDD.P1.GatPoly 0.134202f
Cred_462 di_spdt_ctrl.P1.GatPoly VDD.P1.pSD 3.82854e-05f
Cred_463 di_spdt_ctrl.P1.GatPoly VDD.P3.pSD 0.0011646f
Cred_464 di_spdt_ctrl.P1.GatPoly VSS.$284.Metal2 1.63121e-05f
Cred_465 di_spdt_ctrl.P1.GatPoly VSS.$292.Metal2 1.64413e-06f
Cred_466 di_spdt_ctrl.P1.GatPoly VSS.$303.Metal2 5.06958e-06f
Cred_467 di_spdt_ctrl.P1.GatPoly VSS.$307.Metal2 2.69232e-06f
Cred_468 di_spdt_ctrl.P1.GatPoly VSS.$33.Metal1 1.44492e-05f
Cred_469 di_spdt_ctrl.P1.GatPoly VSS.$42.Metal1 2.94651e-06f
Cred_470 di_spdt_ctrl.P1.GatPoly VSS.$478.Metal3 1.50375e-08f
Cred_471 di_spdt_ctrl.P1.GatPoly VSS.$5.Metal1 3.06675e-06f
Cred_472 di_spdt_ctrl.P1.GatPoly VSS.$61.Metal1 1.45829e-06f
Cred_473 di_spdt_ctrl.P1.GatPoly VSS.$78.Metal1 1.65528e-06f
Cred_474 di_spdt_ctrl.P1.GatPoly VSS.$87.Metal1 5.36862e-05f
Cred_475 di_spdt_ctrl.P1.GatPoly VSS.P0.GatPoly 6.66077e-06f
Cred_476 di_spdt_ctrl.P1.GatPoly VSS.P0.nSD 6.0535e-09f
Cred_477 di_spdt_ctrl.P1.GatPoly VSS.P0.pSD 1.98767e-05f
Cred_478 di_spdt_ctrl.P1.GatPoly VSS.P1.GatPoly 6.1096e-06f
Cred_479 di_spdt_ctrl.P1.GatPoly VSS.P1.nSD 6.0535e-09f
Cred_480 di_spdt_ctrl.P2.GatPoly di_tg_ctrl|di_tg_ctrl_n|vin|vout.$136.Metal2 0.00168364f
Cred_481 di_spdt_ctrl.P2.GatPoly di_tg_ctrl|di_tg_ctrl_n|vin|vout.$199.Metal3 0.00122424f
Cred_482 di_spdt_ctrl.P2.GatPoly di_tg_ctrl|di_tg_ctrl_n|vin|vout.$225.Metal4 0.00069144f
Cred_483 di_spdt_ctrl.P2.GatPoly di_tg_ctrl|di_tg_ctrl_n|vin|vout.P0.nSD 0.0102583f
Cred_484 di_spdt_ctrl.P2.GatPoly di_tg_ctrl|di_tg_ctrl_n|vin|vout.P0.pSD 0.00279398f
Cred_485 di_spdt_ctrl.P2.GatPoly di_tg_ctrl|di_tg_ctrl_n|vin|vout.P12.GatPoly 1.03762e-07f
Cred_486 di_spdt_ctrl.P2.GatPoly di_tg_ctrl|di_tg_ctrl_n|vin|vout.P13.GatPoly 1.03757e-07f
Cred_487 di_spdt_ctrl.P2.GatPoly di_tg_ctrl|di_tg_ctrl_n|vin|vout.P14.GatPoly 6.46445e-07f
Cred_488 di_spdt_ctrl.P2.GatPoly di_tg_ctrl|di_tg_ctrl_n|vin|vout.P15.GatPoly 6.46375e-07f
Cred_489 di_spdt_ctrl.P2.GatPoly VSS 0.0289902f
Cred_490 di_spdt_ctrl.P2.GatPoly v_a 3.72391e-05f
Cred_491 di_spdt_ctrl.P2.GatPoly VDD.$131.Metal1 2.56562e-05f
Cred_492 di_spdt_ctrl.P2.GatPoly VDD.$133.Metal1 3.2451e-06f
Cred_493 di_spdt_ctrl.P2.GatPoly VDD.$215.Metal1 2.05019e-05f
Cred_494 di_spdt_ctrl.P2.GatPoly VDD.$29.Metal1 2.09731e-05f
Cred_495 di_spdt_ctrl.P2.GatPoly VDD.$382.Metal1 5.28612e-05f
Cred_496 di_spdt_ctrl.P2.GatPoly VDD.$51.Metal1 3.56527e-07f
Cred_497 di_spdt_ctrl.P2.GatPoly VDD.$562.Metal2 5.52421e-05f
Cred_498 di_spdt_ctrl.P2.GatPoly VDD.$563.Metal2 1.88868e-09f
Cred_499 di_spdt_ctrl.P2.GatPoly VDD.$606.Metal2 2.76497e-06f
Cred_500 di_spdt_ctrl.P2.GatPoly VDD.$607.Metal2 1.14482e-07f
Cred_501 di_spdt_ctrl.P2.GatPoly VDD.$608.Metal2 6.78878e-08f
Cred_502 di_spdt_ctrl.P2.GatPoly VDD.$609.Metal2 1.88868e-09f
Cred_503 di_spdt_ctrl.P2.GatPoly VDD.$90.Metal1 2.60127e-05f
Cred_504 di_spdt_ctrl.P2.GatPoly VDD.$92.Metal1 3.2451e-06f
Cred_505 di_spdt_ctrl.P2.GatPoly VDD.P0.GatPoly 0.000128152f
Cred_506 di_spdt_ctrl.P2.GatPoly VDD.P0.nSD 0.000232673f
Cred_507 di_spdt_ctrl.P2.GatPoly VDD.P0.pSD 7.2109e-09f
Cred_508 di_spdt_ctrl.P2.GatPoly VDD.P1.GatPoly 0.000126883f
Cred_509 di_spdt_ctrl.P2.GatPoly VDD.P1.pSD 5.76292e-06f
Cred_510 di_spdt_ctrl.P2.GatPoly VDD.P3.pSD 2.81693e-06f
Cred_511 di_spdt_ctrl.P2.GatPoly VSS.$284.Metal2 0.00147251f
Cred_512 di_spdt_ctrl.P2.GatPoly VSS.$292.Metal2 0.000642715f
Cred_513 di_spdt_ctrl.P2.GatPoly VSS.$303.Metal2 0.000771806f
Cred_514 di_spdt_ctrl.P2.GatPoly VSS.$307.Metal2 3.2239e-05f
Cred_515 di_spdt_ctrl.P2.GatPoly VSS.$311.Metal2 4.36829e-05f
Cred_516 di_spdt_ctrl.P2.GatPoly VSS.$33.Metal1 0.0203162f
Cred_517 di_spdt_ctrl.P2.GatPoly VSS.$42.Metal1 0.00205095f
Cred_518 di_spdt_ctrl.P2.GatPoly VSS.$478.Metal3 5.8784e-06f
Cred_519 di_spdt_ctrl.P2.GatPoly VSS.$5.Metal1 0.000141174f
Cred_520 di_spdt_ctrl.P2.GatPoly VSS.$61.Metal1 0.000261331f
Cred_521 di_spdt_ctrl.P2.GatPoly VSS.$78.Metal1 0.00134981f
Cred_522 di_spdt_ctrl.P2.GatPoly VSS.$87.Metal1 0.00234412f
Cred_523 di_spdt_ctrl.P2.GatPoly VSS.P0.GatPoly 0.0366196f
Cred_524 di_spdt_ctrl.P2.GatPoly VSS.P0.nSD 0.000105071f
Cred_525 di_spdt_ctrl.P2.GatPoly VSS.P0.pSD 0.000913744f
Cred_526 di_spdt_ctrl.P2.GatPoly VSS.P1.GatPoly 0.00773065f
Cred_527 di_spdt_ctrl.P2.GatPoly VSS.P1.nSD 0.000105071f
Cred_528 di_spdt_ctrl.P2.GatPoly VSS.P3.nSD 1.54557e-05f
Cred_529 di_spdt_ctrl.P2.GatPoly VSS.P5.nSD 1.23545e-05f
Cred_530 di_spdt_ctrl.P3.GatPoly di_tg_ctrl|di_tg_ctrl_n|vin|vout.$136.Metal2 0.00173076f
Cred_531 di_spdt_ctrl.P3.GatPoly di_tg_ctrl|di_tg_ctrl_n|vin|vout.$199.Metal3 0.00126144f
Cred_532 di_spdt_ctrl.P3.GatPoly di_tg_ctrl|di_tg_ctrl_n|vin|vout.$225.Metal4 0.000712451f
Cred_533 di_spdt_ctrl.P3.GatPoly di_tg_ctrl|di_tg_ctrl_n|vin|vout.P0.nSD 0.0106061f
Cred_534 di_spdt_ctrl.P3.GatPoly di_tg_ctrl|di_tg_ctrl_n|vin|vout.P0.pSD 0.00287422f
Cred_535 di_spdt_ctrl.P3.GatPoly di_tg_ctrl|di_tg_ctrl_n|vin|vout.P12.GatPoly 1.03769e-07f
Cred_536 di_spdt_ctrl.P3.GatPoly di_tg_ctrl|di_tg_ctrl_n|vin|vout.P13.GatPoly 1.03764e-07f
Cred_537 di_spdt_ctrl.P3.GatPoly di_tg_ctrl|di_tg_ctrl_n|vin|vout.P14.GatPoly 6.46517e-07f
Cred_538 di_spdt_ctrl.P3.GatPoly di_tg_ctrl|di_tg_ctrl_n|vin|vout.P15.GatPoly 6.46446e-07f
Cred_539 di_spdt_ctrl.P3.GatPoly VSS 0.0289426f
Cred_540 di_spdt_ctrl.P3.GatPoly v_a 3.72391e-05f
Cred_541 di_spdt_ctrl.P3.GatPoly VDD.$131.Metal1 2.56562e-05f
Cred_542 di_spdt_ctrl.P3.GatPoly VDD.$133.Metal1 3.2451e-06f
Cred_543 di_spdt_ctrl.P3.GatPoly VDD.$215.Metal1 2.05019e-05f
Cred_544 di_spdt_ctrl.P3.GatPoly VDD.$29.Metal1 2.09731e-05f
Cred_545 di_spdt_ctrl.P3.GatPoly VDD.$382.Metal1 5.28612e-05f
Cred_546 di_spdt_ctrl.P3.GatPoly VDD.$51.Metal1 3.56527e-07f
Cred_547 di_spdt_ctrl.P3.GatPoly VDD.$562.Metal2 5.52421e-05f
Cred_548 di_spdt_ctrl.P3.GatPoly VDD.$563.Metal2 1.88868e-09f
Cred_549 di_spdt_ctrl.P3.GatPoly VDD.$606.Metal2 2.76497e-06f
Cred_550 di_spdt_ctrl.P3.GatPoly VDD.$607.Metal2 1.14482e-07f
Cred_551 di_spdt_ctrl.P3.GatPoly VDD.$608.Metal2 6.78878e-08f
Cred_552 di_spdt_ctrl.P3.GatPoly VDD.$609.Metal2 1.88868e-09f
Cred_553 di_spdt_ctrl.P3.GatPoly VDD.$90.Metal1 2.60127e-05f
Cred_554 di_spdt_ctrl.P3.GatPoly VDD.$92.Metal1 3.2451e-06f
Cred_555 di_spdt_ctrl.P3.GatPoly VDD.P0.GatPoly 0.000128152f
Cred_556 di_spdt_ctrl.P3.GatPoly VDD.P0.nSD 0.000232673f
Cred_557 di_spdt_ctrl.P3.GatPoly VDD.P0.pSD 7.2109e-09f
Cred_558 di_spdt_ctrl.P3.GatPoly VDD.P1.GatPoly 0.000126883f
Cred_559 di_spdt_ctrl.P3.GatPoly VDD.P1.pSD 5.76292e-06f
Cred_560 di_spdt_ctrl.P3.GatPoly VDD.P3.pSD 2.81693e-06f
Cred_561 di_spdt_ctrl.P3.GatPoly VSS.$284.Metal2 0.000110588f
Cred_562 di_spdt_ctrl.P3.GatPoly VSS.$292.Metal2 1.36549e-05f
Cred_563 di_spdt_ctrl.P3.GatPoly VSS.$303.Metal2 5.80855e-05f
Cred_564 di_spdt_ctrl.P3.GatPoly VSS.$307.Metal2 0.00139814f
Cred_565 di_spdt_ctrl.P3.GatPoly VSS.$311.Metal2 0.00266651f
Cred_566 di_spdt_ctrl.P3.GatPoly VSS.$33.Metal1 0.00189128f
Cred_567 di_spdt_ctrl.P3.GatPoly VSS.$42.Metal1 0.00102586f
Cred_568 di_spdt_ctrl.P3.GatPoly VSS.$478.Metal3 1.2489e-07f
Cred_569 di_spdt_ctrl.P3.GatPoly VSS.$5.Metal1 0.000139829f
Cred_570 di_spdt_ctrl.P3.GatPoly VSS.$61.Metal1 0.00126627f
Cred_571 di_spdt_ctrl.P3.GatPoly VSS.$78.Metal1 0.0199961f
Cred_572 di_spdt_ctrl.P3.GatPoly VSS.$87.Metal1 0.0023563f
Cred_573 di_spdt_ctrl.P3.GatPoly VSS.P0.GatPoly 0.00786783f
Cred_574 di_spdt_ctrl.P3.GatPoly VSS.P0.nSD 4.09707e-08f
Cred_575 di_spdt_ctrl.P3.GatPoly VSS.P0.pSD 0.000911233f
Cred_576 di_spdt_ctrl.P3.GatPoly VSS.P1.GatPoly 0.0358684f
Cred_577 di_spdt_ctrl.P3.GatPoly VSS.P1.nSD 4.09707e-08f
Cred_578 di_spdt_ctrl.P3.GatPoly VSS.P3.nSD 0.000295954f
Cred_579 di_spdt_ctrl.P3.GatPoly VSS.P5.nSD 0.000205773f
Cred_580 di_tg_ctrl|di_tg_ctrl_n|vin|vout di_tg_ctrl|di_tg_ctrl_n|vout 0.00127455f
Cred_581 di_tg_ctrl|di_tg_ctrl_n|vin|vout di_tg_ctrl|di_tg_ctrl_n|vout.$10.GatPoly 0.000365272f
Cred_582 di_tg_ctrl|di_tg_ctrl_n|vin|vout di_tg_ctrl|di_tg_ctrl_n|vout.$136.Metal2 1.20599e-05f
Cred_583 di_tg_ctrl|di_tg_ctrl_n|vin|vout di_tg_ctrl|di_tg_ctrl_n|vout.$186.Metal3 5.58606e-07f
Cred_584 di_tg_ctrl|di_tg_ctrl_n|vin|vout di_tg_ctrl|di_tg_ctrl_n|vout.$70.Metal1 0.000173224f
Cred_585 di_tg_ctrl|di_tg_ctrl_n|vin|vout di_tg_ctrl|di_tg_ctrl_n|vout.P1.GatPoly 0.0013276f
Cred_586 di_tg_ctrl|di_tg_ctrl_n|vin|vout di_tg_ctrl|di_tg_ctrl_n|vout.P2.GatPoly 0.0015818f
Cred_587 di_tg_ctrl|di_tg_ctrl_n|vin|vout di_tg_ctrl|di_tg_ctrl_n|vout.P3.GatPoly 0.00179962f
Cred_588 di_tg_ctrl|di_tg_ctrl_n|vin|vout di_tg_ctrl|di_tg_ctrl_n|vout.P4.GatPoly 0.00210047f
Cred_589 di_tg_ctrl|di_tg_ctrl_n|vin|vout di_tg_ctrl|di_tg_ctrl_n|vout.P5.GatPoly 0.00662457f
Cred_590 di_tg_ctrl|di_tg_ctrl_n|vin|vout VSS 0.0200571f
Cred_591 di_tg_ctrl|di_tg_ctrl_n|vin|vout v_b.$161.Metal2 0.00830934f
Cred_592 di_tg_ctrl|di_tg_ctrl_n|vin|vout v_b.P0.nSD 0.00513104f
Cred_593 di_tg_ctrl|di_tg_ctrl_n|vin|vout v_b.P0.pSD 0.000220821f
Cred_594 di_tg_ctrl|di_tg_ctrl_n|vin|vout v_c.$459.Metal3 0.00584362f
Cred_595 di_tg_ctrl|di_tg_ctrl_n|vin|vout v_c.P0.nSD 0.00750867f
Cred_596 di_tg_ctrl|di_tg_ctrl_n|vin|vout VSS.$220.Metal1 0.00248555f
Cred_597 di_tg_ctrl|di_tg_ctrl_n|vin|vout VSS.$231.Metal1 0.000250964f
Cred_598 di_tg_ctrl|di_tg_ctrl_n|vin|vout VSS.$241.Metal1 0.000114996f
Cred_599 di_tg_ctrl|di_tg_ctrl_n|vin|vout VSS.$255.Metal1 0.000275208f
Cred_600 di_tg_ctrl|di_tg_ctrl_n|vin|vout VSS.$436.Metal2 1.13781e-06f
Cred_601 di_tg_ctrl|di_tg_ctrl_n|vin|vout VSS.$440.Metal2 2.48667e-07f
Cred_602 di_tg_ctrl|di_tg_ctrl_n|vin|vout VSS.$452.Metal2 1.11945e-05f
Cred_603 di_tg_ctrl|di_tg_ctrl_n|vin|vout VSS.$548.Metal3 8.05361e-07f
Cred_604 di_tg_ctrl|di_tg_ctrl_n|vin|vout VSS.P0.pSD 0.000728693f
Cred_605 di_tg_ctrl|di_tg_ctrl_n|vin|vout.$102.Metal1 VSS 0.0306766f
Cred_606 di_tg_ctrl|di_tg_ctrl_n|vin|vout.$102.Metal1 v_b 4.07286e-07f
Cred_607 di_tg_ctrl|di_tg_ctrl_n|vin|vout.$102.Metal1 v_b.$161.Metal2 0.000217236f
Cred_608 di_tg_ctrl|di_tg_ctrl_n|vin|vout.$102.Metal1 v_b.$195.Metal2 0.00962484f
Cred_609 di_tg_ctrl|di_tg_ctrl_n|vin|vout.$102.Metal1 v_b.P3.nSD 0.00090516f
Cred_610 di_tg_ctrl|di_tg_ctrl_n|vin|vout.$102.Metal1 v_b.P3.pSD 6.91362e-06f
Cred_611 di_tg_ctrl|di_tg_ctrl_n|vin|vout.$102.Metal1 v_b.P5.nSD 0.00996368f
Cred_612 di_tg_ctrl|di_tg_ctrl_n|vin|vout.$102.Metal1 v_c.$493.Metal3 0.00883253f
Cred_613 di_tg_ctrl|di_tg_ctrl_n|vin|vout.$102.Metal1 v_c.P4.nSD 0.0140629f
Cred_614 di_tg_ctrl|di_tg_ctrl_n|vin|vout.$102.Metal1 VSS.$220.Metal1 0.00208115f
Cred_615 di_tg_ctrl|di_tg_ctrl_n|vin|vout.$102.Metal1 VSS.$245.Metal1 0.00277375f
Cred_616 di_tg_ctrl|di_tg_ctrl_n|vin|vout.$102.Metal1 VSS.$255.Metal1 0.0484965f
Cred_617 di_tg_ctrl|di_tg_ctrl_n|vin|vout.$102.Metal1 VSS.$444.Metal2 1.88703e-10f
Cred_618 di_tg_ctrl|di_tg_ctrl_n|vin|vout.$102.Metal1 VSS.$448.Metal2 2.3474e-06f
Cred_619 di_tg_ctrl|di_tg_ctrl_n|vin|vout.$102.Metal1 VSS.$452.Metal2 0.00104276f
Cred_620 di_tg_ctrl|di_tg_ctrl_n|vin|vout.$102.Metal1 VSS.$540.Metal3 2.35355e-08f
Cred_621 di_tg_ctrl|di_tg_ctrl_n|vin|vout.$102.Metal1 VSS.$548.Metal3 8.81114e-05f
Cred_622 di_tg_ctrl|di_tg_ctrl_n|vin|vout.$102.Metal1 VSS.P0.pSD 0.00347364f
Cred_623 di_tg_ctrl|di_tg_ctrl_n|vin|vout.$13.GatPoly di_tg_ctrl|di_tg_ctrl_n|vout.$14.GatPoly 0.0132661f
Cred_624 di_tg_ctrl|di_tg_ctrl_n|vin|vout.$13.GatPoly di_tg_ctrl|di_tg_ctrl_n|vout.$144.Metal2 3.95245e-06f
Cred_625 di_tg_ctrl|di_tg_ctrl_n|vin|vout.$13.GatPoly di_tg_ctrl|di_tg_ctrl_n|vout.$17.GatPoly 0.000985437f
Cred_626 di_tg_ctrl|di_tg_ctrl_n|vin|vout.$13.GatPoly di_tg_ctrl|di_tg_ctrl_n|vout.$192.Metal3 1.53428e-07f
Cred_627 di_tg_ctrl|di_tg_ctrl_n|vin|vout.$13.GatPoly di_tg_ctrl|di_tg_ctrl_n|vout.$206.Metal4 2.89676e-06f
Cred_628 di_tg_ctrl|di_tg_ctrl_n|vin|vout.$13.GatPoly di_tg_ctrl|di_tg_ctrl_n|vout.$209.Metal4 9.98181e-10f
Cred_629 di_tg_ctrl|di_tg_ctrl_n|vin|vout.$13.GatPoly di_tg_ctrl|di_tg_ctrl_n|vout.$21.GatPoly 0.00254413f
Cred_630 di_tg_ctrl|di_tg_ctrl_n|vin|vout.$13.GatPoly di_tg_ctrl|di_tg_ctrl_n|vout.$77.Metal1 0.00238492f
Cred_631 di_tg_ctrl|di_tg_ctrl_n|vin|vout.$13.GatPoly di_tg_ctrl|di_tg_ctrl_n|vout.$79.Metal1 0.000431343f
Cred_632 di_tg_ctrl|di_tg_ctrl_n|vin|vout.$13.GatPoly di_tg_ctrl|di_tg_ctrl_n|vout.$81.Metal1 3.90308e-05f
Cred_633 di_tg_ctrl|di_tg_ctrl_n|vin|vout.$13.GatPoly di_tg_ctrl|di_tg_ctrl_n|vout.$84.Metal1 0.000147012f
Cred_634 di_tg_ctrl|di_tg_ctrl_n|vin|vout.$13.GatPoly di_tg_ctrl|di_tg_ctrl_n|vout.$86.Metal1 8.47855e-05f
Cred_635 di_tg_ctrl|di_tg_ctrl_n|vin|vout.$13.GatPoly di_tg_ctrl|di_tg_ctrl_n|vout.P6.GatPoly 0.000193369f
Cred_636 di_tg_ctrl|di_tg_ctrl_n|vin|vout.$13.GatPoly di_tg_ctrl|di_tg_ctrl_n|vout.P8.GatPoly 8.19453e-06f
Cred_637 di_tg_ctrl|di_tg_ctrl_n|vin|vout.$13.GatPoly di_tg_ctrl|di_tg_ctrl_n|vout.P9.GatPoly 1.78008e-05f
Cred_638 di_tg_ctrl|di_tg_ctrl_n|vin|vout.$13.GatPoly VSS 0.0104897f
Cred_639 di_tg_ctrl|di_tg_ctrl_n|vin|vout.$13.GatPoly v_a.$182.Metal2 0.0128088f
Cred_640 di_tg_ctrl|di_tg_ctrl_n|vin|vout.$13.GatPoly v_a.P3.pSD 0.0184278f
Cred_641 di_tg_ctrl|di_tg_ctrl_n|vin|vout.$13.GatPoly v_a.P5.nSD 2.6914e-05f
Cred_642 di_tg_ctrl|di_tg_ctrl_n|vin|vout.$13.GatPoly v_a.P5.pSD 0.00874365f
Cred_643 di_tg_ctrl|di_tg_ctrl_n|vin|vout.$13.GatPoly v_c.$284.Metal2 5.59311e-11f
Cred_644 di_tg_ctrl|di_tg_ctrl_n|vin|vout.$13.GatPoly v_c.$292.Metal2 0.00986826f
Cred_645 di_tg_ctrl|di_tg_ctrl_n|vin|vout.$13.GatPoly v_c.$425.Metal3 0.00258501f
Cred_646 di_tg_ctrl|di_tg_ctrl_n|vin|vout.$13.GatPoly v_c.$446.Metal3 6.97589e-09f
Cred_647 di_tg_ctrl|di_tg_ctrl_n|vin|vout.$13.GatPoly v_c.$450.Metal3 0.00970481f
Cred_648 di_tg_ctrl|di_tg_ctrl_n|vin|vout.$13.GatPoly v_c.$459.Metal3 8.24267e-09f
Cred_649 di_tg_ctrl|di_tg_ctrl_n|vin|vout.$13.GatPoly v_c.$95.Metal1 0.0119856f
Cred_650 di_tg_ctrl|di_tg_ctrl_n|vin|vout.$13.GatPoly v_c.P10.nSD 1.47572e-10f
Cred_651 di_tg_ctrl|di_tg_ctrl_n|vin|vout.$13.GatPoly v_c.P10.pSD 0.0116682f
Cred_652 di_tg_ctrl|di_tg_ctrl_n|vin|vout.$13.GatPoly v_c.P8.pSD 0.00422193f
Cred_653 di_tg_ctrl|di_tg_ctrl_n|vin|vout.$13.GatPoly VDD.$382.Metal1 9.67247e-07f
Cred_654 di_tg_ctrl|di_tg_ctrl_n|vin|vout.$13.GatPoly VDD.$426.Metal1 0.000325518f
Cred_655 di_tg_ctrl|di_tg_ctrl_n|vin|vout.$13.GatPoly VDD.$434.Metal1 0.00306301f
Cred_656 di_tg_ctrl|di_tg_ctrl_n|vin|vout.$13.GatPoly VDD.$438.Metal1 0.00354842f
Cred_657 di_tg_ctrl|di_tg_ctrl_n|vin|vout.$13.GatPoly VDD.$442.Metal1 0.00316597f
Cred_658 di_tg_ctrl|di_tg_ctrl_n|vin|vout.$13.GatPoly VDD.$446.Metal1 0.000988537f
Cred_659 di_tg_ctrl|di_tg_ctrl_n|vin|vout.$13.GatPoly VDD.$477.Metal1 0.000133281f
Cred_660 di_tg_ctrl|di_tg_ctrl_n|vin|vout.$13.GatPoly VDD.$526.Metal1 1.26015e-07f
Cred_661 di_tg_ctrl|di_tg_ctrl_n|vin|vout.$13.GatPoly VDD.$714.Metal2 0.00220615f
Cred_662 di_tg_ctrl|di_tg_ctrl_n|vin|vout.$13.GatPoly VDD.$734.Metal2 0.00162455f
Cred_663 di_tg_ctrl|di_tg_ctrl_n|vin|vout.$13.GatPoly VDD.$738.Metal2 0.000278495f
Cred_664 di_tg_ctrl|di_tg_ctrl_n|vin|vout.$13.GatPoly VDD.$762.Metal2 1.80565e-06f
Cred_665 di_tg_ctrl|di_tg_ctrl_n|vin|vout.$13.GatPoly VDD.$766.Metal2 6.72911e-06f
Cred_666 di_tg_ctrl|di_tg_ctrl_n|vin|vout.$13.GatPoly VDD.$774.Metal2 3.76469e-05f
Cred_667 di_tg_ctrl|di_tg_ctrl_n|vin|vout.$13.GatPoly VDD.$782.Metal2 1.17013e-05f
Cred_668 di_tg_ctrl|di_tg_ctrl_n|vin|vout.$13.GatPoly VDD.$888.Metal3 1.92353e-08f
Cred_669 di_tg_ctrl|di_tg_ctrl_n|vin|vout.$13.GatPoly VDD.$892.Metal3 6.00958e-07f
Cred_670 di_tg_ctrl|di_tg_ctrl_n|vin|vout.$13.GatPoly VDD.P0.nSD 1.46737e-05f
Cred_671 di_tg_ctrl|di_tg_ctrl_n|vin|vout.$13.GatPoly VDD.P3.GatPoly 0.000576377f
Cred_672 di_tg_ctrl|di_tg_ctrl_n|vin|vout.$136.Metal2 di_tg_ctrl|di_tg_ctrl_n|vout.$180.Metal3 0.178462f
Cred_673 di_tg_ctrl|di_tg_ctrl_n|vin|vout.$136.Metal2 di_tg_ctrl|di_tg_ctrl_n|vout.$206.Metal4 0.0302169f
Cred_674 di_tg_ctrl|di_tg_ctrl_n|vin|vout.$136.Metal2 di_tg_ctrl|di_tg_ctrl_n|vout.P0.nSD 0.0503837f
Cred_675 di_tg_ctrl|di_tg_ctrl_n|vin|vout.$136.Metal2 di_tg_ctrl|di_tg_ctrl_n|vout.P0.pSD 0.190528f
Cred_676 di_tg_ctrl|di_tg_ctrl_n|vin|vout.$136.Metal2 VSS 0.214099f
Cred_677 di_tg_ctrl|di_tg_ctrl_n|vin|vout.$136.Metal2 v_a 0.111999f
Cred_678 di_tg_ctrl|di_tg_ctrl_n|vin|vout.$136.Metal2 v_a.$148.Metal2 0.0386462f
Cred_679 di_tg_ctrl|di_tg_ctrl_n|vin|vout.$136.Metal2 v_a.$182.Metal2 0.00795294f
Cred_680 di_tg_ctrl|di_tg_ctrl_n|vin|vout.$136.Metal2 v_a.P0.nSD 0.000228762f
Cred_681 di_tg_ctrl|di_tg_ctrl_n|vin|vout.$136.Metal2 v_a.P0.pSD 0.00099022f
Cred_682 di_tg_ctrl|di_tg_ctrl_n|vin|vout.$136.Metal2 v_a.P1.nSD 7.64202e-05f
Cred_683 di_tg_ctrl|di_tg_ctrl_n|vin|vout.$136.Metal2 v_a.P1.pSD 0.000300802f
Cred_684 di_tg_ctrl|di_tg_ctrl_n|vin|vout.$136.Metal2 v_a.P5.nSD 1.72183e-05f
Cred_685 di_tg_ctrl|di_tg_ctrl_n|vin|vout.$136.Metal2 v_a.P5.pSD 6.25161e-05f
Cred_686 di_tg_ctrl|di_tg_ctrl_n|vin|vout.$136.Metal2 v_b 0.0536926f
Cred_687 di_tg_ctrl|di_tg_ctrl_n|vin|vout.$136.Metal2 VDD.$100.Metal1 0.00496699f
Cred_688 di_tg_ctrl|di_tg_ctrl_n|vin|vout.$136.Metal2 VDD.$102.Metal1 0.00828902f
Cred_689 di_tg_ctrl|di_tg_ctrl_n|vin|vout.$136.Metal2 VDD.$105.Metal1 0.000645416f
Cred_690 di_tg_ctrl|di_tg_ctrl_n|vin|vout.$136.Metal2 VDD.$113.Metal1 0.000645471f
Cred_691 di_tg_ctrl|di_tg_ctrl_n|vin|vout.$136.Metal2 VDD.$125.Metal1 0.0119365f
Cred_692 di_tg_ctrl|di_tg_ctrl_n|vin|vout.$136.Metal2 VDD.$131.Metal1 0.008652f
Cred_693 di_tg_ctrl|di_tg_ctrl_n|vin|vout.$136.Metal2 VDD.$133.Metal1 0.00523661f
Cred_694 di_tg_ctrl|di_tg_ctrl_n|vin|vout.$136.Metal2 VDD.$135.Metal1 0.00522171f
Cred_695 di_tg_ctrl|di_tg_ctrl_n|vin|vout.$136.Metal2 VDD.$137.Metal1 0.00520192f
Cred_696 di_tg_ctrl|di_tg_ctrl_n|vin|vout.$136.Metal2 VDD.$139.Metal1 0.00521543f
Cred_697 di_tg_ctrl|di_tg_ctrl_n|vin|vout.$136.Metal2 VDD.$215.Metal1 0.011541f
Cred_698 di_tg_ctrl|di_tg_ctrl_n|vin|vout.$136.Metal2 VDD.$218.Metal1 6.07396e-06f
Cred_699 di_tg_ctrl|di_tg_ctrl_n|vin|vout.$136.Metal2 VDD.$257.Metal1 2.37061e-07f
Cred_700 di_tg_ctrl|di_tg_ctrl_n|vin|vout.$136.Metal2 VDD.$279.Metal1 0.0111577f
Cred_701 di_tg_ctrl|di_tg_ctrl_n|vin|vout.$136.Metal2 VDD.$281.Metal1 0.00141127f
Cred_702 di_tg_ctrl|di_tg_ctrl_n|vin|vout.$136.Metal2 VDD.$29.Metal1 0.00337191f
Cred_703 di_tg_ctrl|di_tg_ctrl_n|vin|vout.$136.Metal2 VDD.$320.Metal1 0.0111656f
Cred_704 di_tg_ctrl|di_tg_ctrl_n|vin|vout.$136.Metal2 VDD.$322.Metal1 0.00141127f
Cred_705 di_tg_ctrl|di_tg_ctrl_n|vin|vout.$136.Metal2 VDD.$359.Metal1 7.88772e-06f
Cred_706 di_tg_ctrl|di_tg_ctrl_n|vin|vout.$136.Metal2 VDD.$378.Metal1 4.52496e-05f
Cred_707 di_tg_ctrl|di_tg_ctrl_n|vin|vout.$136.Metal2 VDD.$382.Metal1 0.0919421f
Cred_708 di_tg_ctrl|di_tg_ctrl_n|vin|vout.$136.Metal2 VDD.$405.Metal1 6.19339e-05f
Cred_709 di_tg_ctrl|di_tg_ctrl_n|vin|vout.$136.Metal2 VDD.$51.Metal1 0.00012105f
Cred_710 di_tg_ctrl|di_tg_ctrl_n|vin|vout.$136.Metal2 VDD.$552.Metal2 8.26062e-05f
Cred_711 di_tg_ctrl|di_tg_ctrl_n|vin|vout.$136.Metal2 VDD.$562.Metal2 0.0306592f
Cred_712 di_tg_ctrl|di_tg_ctrl_n|vin|vout.$136.Metal2 VDD.$563.Metal2 0.00884701f
Cred_713 di_tg_ctrl|di_tg_ctrl_n|vin|vout.$136.Metal2 VDD.$564.Metal2 0.0087806f
Cred_714 di_tg_ctrl|di_tg_ctrl_n|vin|vout.$136.Metal2 VDD.$565.Metal2 0.00868383f
Cred_715 di_tg_ctrl|di_tg_ctrl_n|vin|vout.$136.Metal2 VDD.$566.Metal2 0.00861455f
Cred_716 di_tg_ctrl|di_tg_ctrl_n|vin|vout.$136.Metal2 VDD.$567.Metal2 0.00854403f
Cred_717 di_tg_ctrl|di_tg_ctrl_n|vin|vout.$136.Metal2 VDD.$568.Metal2 0.00847328f
Cred_718 di_tg_ctrl|di_tg_ctrl_n|vin|vout.$136.Metal2 VDD.$569.Metal2 0.00843375f
Cred_719 di_tg_ctrl|di_tg_ctrl_n|vin|vout.$136.Metal2 VDD.$570.Metal2 0.00836736f
Cred_720 di_tg_ctrl|di_tg_ctrl_n|vin|vout.$136.Metal2 VDD.$571.Metal2 0.00835774f
Cred_721 di_tg_ctrl|di_tg_ctrl_n|vin|vout.$136.Metal2 VDD.$572.Metal2 0.00834833f
Cred_722 di_tg_ctrl|di_tg_ctrl_n|vin|vout.$136.Metal2 VDD.$573.Metal2 0.0114538f
Cred_723 di_tg_ctrl|di_tg_ctrl_n|vin|vout.$136.Metal2 VDD.$597.Metal2 0.00150387f
Cred_724 di_tg_ctrl|di_tg_ctrl_n|vin|vout.$136.Metal2 VDD.$606.Metal2 0.0917213f
Cred_725 di_tg_ctrl|di_tg_ctrl_n|vin|vout.$136.Metal2 VDD.$607.Metal2 0.0171942f
Cred_726 di_tg_ctrl|di_tg_ctrl_n|vin|vout.$136.Metal2 VDD.$608.Metal2 0.0164395f
Cred_727 di_tg_ctrl|di_tg_ctrl_n|vin|vout.$136.Metal2 VDD.$609.Metal2 0.0159635f
Cred_728 di_tg_ctrl|di_tg_ctrl_n|vin|vout.$136.Metal2 VDD.$610.Metal2 0.0157557f
Cred_729 di_tg_ctrl|di_tg_ctrl_n|vin|vout.$136.Metal2 VDD.$611.Metal2 0.0155327f
Cred_730 di_tg_ctrl|di_tg_ctrl_n|vin|vout.$136.Metal2 VDD.$612.Metal2 0.0155789f
Cred_731 di_tg_ctrl|di_tg_ctrl_n|vin|vout.$136.Metal2 VDD.$613.Metal2 0.0273873f
Cred_732 di_tg_ctrl|di_tg_ctrl_n|vin|vout.$136.Metal2 VDD.$614.Metal2 0.0217803f
Cred_733 di_tg_ctrl|di_tg_ctrl_n|vin|vout.$136.Metal2 VDD.$615.Metal2 0.0149338f
Cred_734 di_tg_ctrl|di_tg_ctrl_n|vin|vout.$136.Metal2 VDD.$616.Metal2 0.0148114f
Cred_735 di_tg_ctrl|di_tg_ctrl_n|vin|vout.$136.Metal2 VDD.$617.Metal2 0.0149287f
Cred_736 di_tg_ctrl|di_tg_ctrl_n|vin|vout.$136.Metal2 VDD.$618.Metal2 0.0150085f
Cred_737 di_tg_ctrl|di_tg_ctrl_n|vin|vout.$136.Metal2 VDD.$619.Metal2 0.0215929f
Cred_738 di_tg_ctrl|di_tg_ctrl_n|vin|vout.$136.Metal2 VDD.$620.Metal2 0.010533f
Cred_739 di_tg_ctrl|di_tg_ctrl_n|vin|vout.$136.Metal2 VDD.$621.Metal2 1.37707e-05f
Cred_740 di_tg_ctrl|di_tg_ctrl_n|vin|vout.$136.Metal2 VDD.$643.Metal2 0.00130614f
Cred_741 di_tg_ctrl|di_tg_ctrl_n|vin|vout.$136.Metal2 VDD.$651.Metal2 0.00173224f
Cred_742 di_tg_ctrl|di_tg_ctrl_n|vin|vout.$136.Metal2 VDD.$688.Metal2 6.42954e-05f
Cred_743 di_tg_ctrl|di_tg_ctrl_n|vin|vout.$136.Metal2 VDD.$703.Metal2 0.00126569f
Cred_744 di_tg_ctrl|di_tg_ctrl_n|vin|vout.$136.Metal2 VDD.$704.Metal2 8.21375e-07f
Cred_745 di_tg_ctrl|di_tg_ctrl_n|vin|vout.$136.Metal2 VDD.$844.Metal3 0.00260902f
Cred_746 di_tg_ctrl|di_tg_ctrl_n|vin|vout.$136.Metal2 VDD.$852.Metal3 0.00159241f
Cred_747 di_tg_ctrl|di_tg_ctrl_n|vin|vout.$136.Metal2 VDD.$856.Metal3 0.0130644f
Cred_748 di_tg_ctrl|di_tg_ctrl_n|vin|vout.$136.Metal2 VDD.$864.Metal3 0.00433144f
Cred_749 di_tg_ctrl|di_tg_ctrl_n|vin|vout.$136.Metal2 VDD.$90.Metal1 0.00823478f
Cred_750 di_tg_ctrl|di_tg_ctrl_n|vin|vout.$136.Metal2 VDD.$92.Metal1 0.00491082f
Cred_751 di_tg_ctrl|di_tg_ctrl_n|vin|vout.$136.Metal2 VDD.$94.Metal1 0.00489685f
Cred_752 di_tg_ctrl|di_tg_ctrl_n|vin|vout.$136.Metal2 VDD.$96.Metal1 0.00487829f
Cred_753 di_tg_ctrl|di_tg_ctrl_n|vin|vout.$136.Metal2 VDD.$98.Metal1 0.00485856f
Cred_754 di_tg_ctrl|di_tg_ctrl_n|vin|vout.$136.Metal2 VDD.P0.GatPoly 2.15973e-08f
Cred_755 di_tg_ctrl|di_tg_ctrl_n|vin|vout.$136.Metal2 VDD.P0.nSD 0.0870606f
Cred_756 di_tg_ctrl|di_tg_ctrl_n|vin|vout.$136.Metal2 VDD.P0.pSD 2.31451e-06f
Cred_757 di_tg_ctrl|di_tg_ctrl_n|vin|vout.$136.Metal2 VDD.P1.pSD 0.000327774f
Cred_758 di_tg_ctrl|di_tg_ctrl_n|vin|vout.$136.Metal2 VDD.P10.pSD 0.00122522f
Cred_759 di_tg_ctrl|di_tg_ctrl_n|vin|vout.$136.Metal2 VDD.P11.pSD 1.58832e-07f
Cred_760 di_tg_ctrl|di_tg_ctrl_n|vin|vout.$136.Metal2 VDD.P2.GatPoly 0.0549813f
Cred_761 di_tg_ctrl|di_tg_ctrl_n|vin|vout.$136.Metal2 VDD.P3.GatPoly 0.0562319f
Cred_762 di_tg_ctrl|di_tg_ctrl_n|vin|vout.$136.Metal2 VDD.P3.pSD 0.00130738f
Cred_763 di_tg_ctrl|di_tg_ctrl_n|vin|vout.$136.Metal2 VDD.P7.pSD 0.00250312f
Cred_764 di_tg_ctrl|di_tg_ctrl_n|vin|vout.$136.Metal2 VSS.$114.Metal1 0.00356197f
Cred_765 di_tg_ctrl|di_tg_ctrl_n|vin|vout.$136.Metal2 VSS.$129.Metal1 0.0318069f
Cred_766 di_tg_ctrl|di_tg_ctrl_n|vin|vout.$136.Metal2 VSS.$132.Metal1 3.39847e-06f
Cred_767 di_tg_ctrl|di_tg_ctrl_n|vin|vout.$136.Metal2 VSS.$134.Metal1 0.00176341f
Cred_768 di_tg_ctrl|di_tg_ctrl_n|vin|vout.$136.Metal2 VSS.$156.Metal1 1.60858e-06f
Cred_769 di_tg_ctrl|di_tg_ctrl_n|vin|vout.$136.Metal2 VSS.$175.Metal1 3.26951e-09f
Cred_770 di_tg_ctrl|di_tg_ctrl_n|vin|vout.$136.Metal2 VSS.$220.Metal1 0.00463067f
Cred_771 di_tg_ctrl|di_tg_ctrl_n|vin|vout.$136.Metal2 VSS.$284.Metal2 0.0279825f
Cred_772 di_tg_ctrl|di_tg_ctrl_n|vin|vout.$136.Metal2 VSS.$303.Metal2 0.00135504f
Cred_773 di_tg_ctrl|di_tg_ctrl_n|vin|vout.$136.Metal2 VSS.$307.Metal2 1.86503e-05f
Cred_774 di_tg_ctrl|di_tg_ctrl_n|vin|vout.$136.Metal2 VSS.$311.Metal2 0.129675f
Cred_775 di_tg_ctrl|di_tg_ctrl_n|vin|vout.$136.Metal2 VSS.$321.Metal2 4.80018e-06f
Cred_776 di_tg_ctrl|di_tg_ctrl_n|vin|vout.$136.Metal2 VSS.$329.Metal2 0.000148812f
Cred_777 di_tg_ctrl|di_tg_ctrl_n|vin|vout.$136.Metal2 VSS.$33.Metal1 0.0100602f
Cred_778 di_tg_ctrl|di_tg_ctrl_n|vin|vout.$136.Metal2 VSS.$339.Metal2 0.00226719f
Cred_779 di_tg_ctrl|di_tg_ctrl_n|vin|vout.$136.Metal2 VSS.$350.Metal2 0.00599776f
Cred_780 di_tg_ctrl|di_tg_ctrl_n|vin|vout.$136.Metal2 VSS.$354.Metal2 0.00326181f
Cred_781 di_tg_ctrl|di_tg_ctrl_n|vin|vout.$136.Metal2 VSS.$359.Metal2 0.00477342f
Cred_782 di_tg_ctrl|di_tg_ctrl_n|vin|vout.$136.Metal2 VSS.$368.Metal2 0.00146614f
Cred_783 di_tg_ctrl|di_tg_ctrl_n|vin|vout.$136.Metal2 VSS.$372.Metal2 0.000264588f
Cred_784 di_tg_ctrl|di_tg_ctrl_n|vin|vout.$136.Metal2 VSS.$376.Metal2 0.000244023f
Cred_785 di_tg_ctrl|di_tg_ctrl_n|vin|vout.$136.Metal2 VSS.$384.Metal2 1.64914e-06f
Cred_786 di_tg_ctrl|di_tg_ctrl_n|vin|vout.$136.Metal2 VSS.$392.Metal2 8.17193e-07f
Cred_787 di_tg_ctrl|di_tg_ctrl_n|vin|vout.$136.Metal2 VSS.$42.Metal1 0.000468576f
Cred_788 di_tg_ctrl|di_tg_ctrl_n|vin|vout.$136.Metal2 VSS.$478.Metal3 0.0030411f
Cred_789 di_tg_ctrl|di_tg_ctrl_n|vin|vout.$136.Metal2 VSS.$484.Metal3 0.00402551f
Cred_790 di_tg_ctrl|di_tg_ctrl_n|vin|vout.$136.Metal2 VSS.$488.Metal3 0.00503243f
Cred_791 di_tg_ctrl|di_tg_ctrl_n|vin|vout.$136.Metal2 VSS.$496.Metal3 0.0034127f
Cred_792 di_tg_ctrl|di_tg_ctrl_n|vin|vout.$136.Metal2 VSS.$5.Metal1 0.000228319f
Cred_793 di_tg_ctrl|di_tg_ctrl_n|vin|vout.$136.Metal2 VSS.$502.Metal3 0.00286679f
Cred_794 di_tg_ctrl|di_tg_ctrl_n|vin|vout.$136.Metal2 VSS.$510.Metal3 0.00199304f
Cred_795 di_tg_ctrl|di_tg_ctrl_n|vin|vout.$136.Metal2 VSS.$518.Metal3 5.10629e-05f
Cred_796 di_tg_ctrl|di_tg_ctrl_n|vin|vout.$136.Metal2 VSS.$61.Metal1 0.000233097f
Cred_797 di_tg_ctrl|di_tg_ctrl_n|vin|vout.$136.Metal2 VSS.$78.Metal1 0.0168535f
Cred_798 di_tg_ctrl|di_tg_ctrl_n|vin|vout.$136.Metal2 VSS.$87.Metal1 0.108042f
Cred_799 di_tg_ctrl|di_tg_ctrl_n|vin|vout.$136.Metal2 VSS.$94.Metal1 9.90042e-07f
Cred_800 di_tg_ctrl|di_tg_ctrl_n|vin|vout.$136.Metal2 VSS.P0.nSD 7.42776e-05f
Cred_801 di_tg_ctrl|di_tg_ctrl_n|vin|vout.$136.Metal2 VSS.P0.pSD 0.0211586f
Cred_802 di_tg_ctrl|di_tg_ctrl_n|vin|vout.$136.Metal2 VSS.P1.GatPoly 1.12825e-05f
Cred_803 di_tg_ctrl|di_tg_ctrl_n|vin|vout.$136.Metal2 VSS.P1.nSD 7.42776e-05f
Cred_804 di_tg_ctrl|di_tg_ctrl_n|vin|vout.$136.Metal2 VSS.P2.GatPoly 0.00770747f
Cred_805 di_tg_ctrl|di_tg_ctrl_n|vin|vout.$136.Metal2 VSS.P3.GatPoly 0.0080431f
Cred_806 di_tg_ctrl|di_tg_ctrl_n|vin|vout.$136.Metal2 VSS.P3.nSD 0.00012247f
Cred_807 di_tg_ctrl|di_tg_ctrl_n|vin|vout.$136.Metal2 VSS.P5.nSD 8.26086e-05f
Cred_808 di_tg_ctrl|di_tg_ctrl_n|vin|vout.$136.Metal2 VSS.P6.nSD 1.76592e-05f
Cred_809 di_tg_ctrl|di_tg_ctrl_n|vin|vout.$136.Metal2 VSS.P7.nSD 2.22496e-05f
Cred_810 di_tg_ctrl|di_tg_ctrl_n|vin|vout.$149.Metal2 di_tg_ctrl|di_tg_ctrl_n|vout.$180.Metal3 4.31746e-05f
Cred_811 di_tg_ctrl|di_tg_ctrl_n|vin|vout.$149.Metal2 di_tg_ctrl|di_tg_ctrl_n|vout.$206.Metal4 0.000127302f
Cred_812 di_tg_ctrl|di_tg_ctrl_n|vin|vout.$149.Metal2 di_tg_ctrl|di_tg_ctrl_n|vout.P0.nSD 4.96047e-06f
Cred_813 di_tg_ctrl|di_tg_ctrl_n|vin|vout.$149.Metal2 di_tg_ctrl|di_tg_ctrl_n|vout.P0.pSD 2.57495e-05f
Cred_814 di_tg_ctrl|di_tg_ctrl_n|vin|vout.$149.Metal2 v_a 2.63671e-06f
Cred_815 di_tg_ctrl|di_tg_ctrl_n|vin|vout.$149.Metal2 v_a.$148.Metal2 0.0161751f
Cred_816 di_tg_ctrl|di_tg_ctrl_n|vin|vout.$149.Metal2 v_a.$182.Metal2 0.00671654f
Cred_817 di_tg_ctrl|di_tg_ctrl_n|vin|vout.$149.Metal2 v_a.P0.pSD 0.0121323f
Cred_818 di_tg_ctrl|di_tg_ctrl_n|vin|vout.$149.Metal2 v_a.P1.nSD 5.58659e-05f
Cred_819 di_tg_ctrl|di_tg_ctrl_n|vin|vout.$149.Metal2 v_a.P1.pSD 0.0168134f
Cred_820 di_tg_ctrl|di_tg_ctrl_n|vin|vout.$149.Metal2 v_c.$220.Metal2 4.95198e-08f
Cred_821 di_tg_ctrl|di_tg_ctrl_n|vin|vout.$149.Metal2 v_c.$228.Metal2 0.0102556f
Cred_822 di_tg_ctrl|di_tg_ctrl_n|vin|vout.$149.Metal2 v_c.$23.Metal1 0.00342774f
Cred_823 di_tg_ctrl|di_tg_ctrl_n|vin|vout.$149.Metal2 v_c.$411.Metal3 6.17625e-06f
Cred_824 di_tg_ctrl|di_tg_ctrl_n|vin|vout.$149.Metal2 v_c.$415.Metal3 0.0189889f
Cred_825 di_tg_ctrl|di_tg_ctrl_n|vin|vout.$149.Metal2 v_c.$425.Metal3 3.68976e-05f
Cred_826 di_tg_ctrl|di_tg_ctrl_n|vin|vout.$149.Metal2 v_c.P6.nSD 1.66341e-07f
Cred_827 di_tg_ctrl|di_tg_ctrl_n|vin|vout.$149.Metal2 v_c.P6.pSD 0.00799452f
Cred_828 di_tg_ctrl|di_tg_ctrl_n|vin|vout.$149.Metal2 VDD.$378.Metal1 9.25903e-05f
Cred_829 di_tg_ctrl|di_tg_ctrl_n|vin|vout.$149.Metal2 VDD.$382.Metal1 8.58372e-06f
Cred_830 di_tg_ctrl|di_tg_ctrl_n|vin|vout.$149.Metal2 VDD.$405.Metal1 0.000165405f
Cred_831 di_tg_ctrl|di_tg_ctrl_n|vin|vout.$149.Metal2 VDD.$414.Metal1 0.00293239f
Cred_832 di_tg_ctrl|di_tg_ctrl_n|vin|vout.$149.Metal2 VDD.$418.Metal1 0.00396286f
Cred_833 di_tg_ctrl|di_tg_ctrl_n|vin|vout.$149.Metal2 VDD.$422.Metal1 0.00347782f
Cred_834 di_tg_ctrl|di_tg_ctrl_n|vin|vout.$149.Metal2 VDD.$426.Metal1 0.00274022f
Cred_835 di_tg_ctrl|di_tg_ctrl_n|vin|vout.$149.Metal2 VDD.$620.Metal2 0.00100783f
Cred_836 di_tg_ctrl|di_tg_ctrl_n|vin|vout.$149.Metal2 VDD.$738.Metal2 0.0029299f
Cred_837 di_tg_ctrl|di_tg_ctrl_n|vin|vout.$149.Metal2 VDD.$746.Metal2 0.0141994f
Cred_838 di_tg_ctrl|di_tg_ctrl_n|vin|vout.$149.Metal2 VDD.$754.Metal2 0.0439938f
Cred_839 di_tg_ctrl|di_tg_ctrl_n|vin|vout.$149.Metal2 VDD.$762.Metal2 0.0120528f
Cred_840 di_tg_ctrl|di_tg_ctrl_n|vin|vout.$149.Metal2 VDD.$874.Metal3 3.86747e-05f
Cred_841 di_tg_ctrl|di_tg_ctrl_n|vin|vout.$149.Metal2 VDD.$878.Metal3 0.000336973f
Cred_842 di_tg_ctrl|di_tg_ctrl_n|vin|vout.$149.Metal2 VDD.$882.Metal3 0.000897475f
Cred_843 di_tg_ctrl|di_tg_ctrl_n|vin|vout.$149.Metal2 VDD.P0.nSD 1.80672e-05f
Cred_844 di_tg_ctrl|di_tg_ctrl_n|vin|vout.$151.Metal2 v_a.$148.Metal2 0.000784979f
Cred_845 di_tg_ctrl|di_tg_ctrl_n|vin|vout.$151.Metal2 v_a.$182.Metal2 0.000784979f
Cred_846 di_tg_ctrl|di_tg_ctrl_n|vin|vout.$151.Metal2 v_a.P1.nSD 6.5292e-06f
Cred_847 di_tg_ctrl|di_tg_ctrl_n|vin|vout.$151.Metal2 v_a.P1.pSD 0.00275719f
Cred_848 di_tg_ctrl|di_tg_ctrl_n|vin|vout.$151.Metal2 v_c.$425.Metal3 0.0127386f
Cred_849 di_tg_ctrl|di_tg_ctrl_n|vin|vout.$151.Metal2 v_c.P8.pSD 0.00958589f
Cred_850 di_tg_ctrl|di_tg_ctrl_n|vin|vout.$151.Metal2 VDD.$426.Metal1 0.00322345f
Cred_851 di_tg_ctrl|di_tg_ctrl_n|vin|vout.$151.Metal2 VDD.$434.Metal1 0.00121852f
Cred_852 di_tg_ctrl|di_tg_ctrl_n|vin|vout.$151.Metal2 VDD.$762.Metal2 0.0242444f
Cred_853 di_tg_ctrl|di_tg_ctrl_n|vin|vout.$151.Metal2 VDD.$766.Metal2 6.75913e-06f
Cred_854 di_tg_ctrl|di_tg_ctrl_n|vin|vout.$151.Metal2 VDD.P0.nSD 2.06362e-06f
Cred_855 di_tg_ctrl|di_tg_ctrl_n|vin|vout.$153.Metal2 di_tg_ctrl|di_tg_ctrl_n|vout.$206.Metal4 0.000108323f
Cred_856 di_tg_ctrl|di_tg_ctrl_n|vin|vout.$153.Metal2 v_a.$182.Metal2 0.00163896f
Cred_857 di_tg_ctrl|di_tg_ctrl_n|vin|vout.$153.Metal2 v_a.P3.pSD 0.00279417f
Cred_858 di_tg_ctrl|di_tg_ctrl_n|vin|vout.$153.Metal2 v_c.$284.Metal2 1.48311e-08f
Cred_859 di_tg_ctrl|di_tg_ctrl_n|vin|vout.$153.Metal2 v_c.$292.Metal2 4.51484e-06f
Cred_860 di_tg_ctrl|di_tg_ctrl_n|vin|vout.$153.Metal2 v_c.$425.Metal3 0.0113568f
Cred_861 di_tg_ctrl|di_tg_ctrl_n|vin|vout.$153.Metal2 v_c.$446.Metal3 1.84977e-06f
Cred_862 di_tg_ctrl|di_tg_ctrl_n|vin|vout.$153.Metal2 v_c.$450.Metal3 3.45149e-05f
Cred_863 di_tg_ctrl|di_tg_ctrl_n|vin|vout.$153.Metal2 v_c.$459.Metal3 2.18568e-06f
Cred_864 di_tg_ctrl|di_tg_ctrl_n|vin|vout.$153.Metal2 v_c.$95.Metal1 1.20035e-06f
Cred_865 di_tg_ctrl|di_tg_ctrl_n|vin|vout.$153.Metal2 v_c.P10.nSD 3.9131e-08f
Cred_866 di_tg_ctrl|di_tg_ctrl_n|vin|vout.$153.Metal2 v_c.P10.pSD 9.25348e-07f
Cred_867 di_tg_ctrl|di_tg_ctrl_n|vin|vout.$153.Metal2 v_c.P8.pSD 0.00917835f
Cred_868 di_tg_ctrl|di_tg_ctrl_n|vin|vout.$153.Metal2 VDD.$426.Metal1 0.00114126f
Cred_869 di_tg_ctrl|di_tg_ctrl_n|vin|vout.$153.Metal2 VDD.$434.Metal1 0.002225f
Cred_870 di_tg_ctrl|di_tg_ctrl_n|vin|vout.$153.Metal2 VDD.$762.Metal2 7.26375e-06f
Cred_871 di_tg_ctrl|di_tg_ctrl_n|vin|vout.$153.Metal2 VDD.$766.Metal2 0.0250657f
Cred_872 di_tg_ctrl|di_tg_ctrl_n|vin|vout.$153.Metal2 VDD.$882.Metal3 0.00011639f
Cred_873 di_tg_ctrl|di_tg_ctrl_n|vin|vout.$153.Metal2 VDD.$888.Metal3 0.000416531f
Cred_874 di_tg_ctrl|di_tg_ctrl_n|vin|vout.$153.Metal2 VDD.P0.nSD 3.76061e-06f
Cred_875 di_tg_ctrl|di_tg_ctrl_n|vin|vout.$155.Metal2 di_tg_ctrl|di_tg_ctrl_n|vout.$14.GatPoly 0.000158839f
Cred_876 di_tg_ctrl|di_tg_ctrl_n|vin|vout.$155.Metal2 di_tg_ctrl|di_tg_ctrl_n|vout.$144.Metal2 0.00338042f
Cred_877 di_tg_ctrl|di_tg_ctrl_n|vin|vout.$155.Metal2 di_tg_ctrl|di_tg_ctrl_n|vout.$17.GatPoly 4.99222e-05f
Cred_878 di_tg_ctrl|di_tg_ctrl_n|vin|vout.$155.Metal2 di_tg_ctrl|di_tg_ctrl_n|vout.$192.Metal3 0.000131222f
Cred_879 di_tg_ctrl|di_tg_ctrl_n|vin|vout.$155.Metal2 di_tg_ctrl|di_tg_ctrl_n|vout.$206.Metal4 0.00258584f
Cred_880 di_tg_ctrl|di_tg_ctrl_n|vin|vout.$155.Metal2 di_tg_ctrl|di_tg_ctrl_n|vout.$209.Metal4 8.53715e-07f
Cred_881 di_tg_ctrl|di_tg_ctrl_n|vin|vout.$155.Metal2 di_tg_ctrl|di_tg_ctrl_n|vout.$21.GatPoly 5.55439e-05f
Cred_882 di_tg_ctrl|di_tg_ctrl_n|vin|vout.$155.Metal2 di_tg_ctrl|di_tg_ctrl_n|vout.$77.Metal1 0.000142023f
Cred_883 di_tg_ctrl|di_tg_ctrl_n|vin|vout.$155.Metal2 di_tg_ctrl|di_tg_ctrl_n|vout.$79.Metal1 1.36138e-05f
Cred_884 di_tg_ctrl|di_tg_ctrl_n|vin|vout.$155.Metal2 di_tg_ctrl|di_tg_ctrl_n|vout.$81.Metal1 1.9773e-06f
Cred_885 di_tg_ctrl|di_tg_ctrl_n|vin|vout.$155.Metal2 di_tg_ctrl|di_tg_ctrl_n|vout.$84.Metal1 7.4476e-06f
Cred_886 di_tg_ctrl|di_tg_ctrl_n|vin|vout.$155.Metal2 di_tg_ctrl|di_tg_ctrl_n|vout.$86.Metal1 4.29523e-06f
Cred_887 di_tg_ctrl|di_tg_ctrl_n|vin|vout.$155.Metal2 di_tg_ctrl|di_tg_ctrl_n|vout.P6.GatPoly 6.10302e-06f
Cred_888 di_tg_ctrl|di_tg_ctrl_n|vin|vout.$155.Metal2 di_tg_ctrl|di_tg_ctrl_n|vout.P8.GatPoly 4.15135e-07f
Cred_889 di_tg_ctrl|di_tg_ctrl_n|vin|vout.$155.Metal2 di_tg_ctrl|di_tg_ctrl_n|vout.P9.GatPoly 9.01786e-07f
Cred_890 di_tg_ctrl|di_tg_ctrl_n|vin|vout.$155.Metal2 VSS 0.000171592f
Cred_891 di_tg_ctrl|di_tg_ctrl_n|vin|vout.$155.Metal2 v_a.$182.Metal2 0.0224785f
Cred_892 di_tg_ctrl|di_tg_ctrl_n|vin|vout.$155.Metal2 v_a.P3.pSD 0.0166587f
Cred_893 di_tg_ctrl|di_tg_ctrl_n|vin|vout.$155.Metal2 v_a.P5.nSD 6.43329e-05f
Cred_894 di_tg_ctrl|di_tg_ctrl_n|vin|vout.$155.Metal2 v_a.P5.pSD 0.013627f
Cred_895 di_tg_ctrl|di_tg_ctrl_n|vin|vout.$155.Metal2 v_c.$284.Metal2 7.77956e-08f
Cred_896 di_tg_ctrl|di_tg_ctrl_n|vin|vout.$155.Metal2 v_c.$292.Metal2 0.0104279f
Cred_897 di_tg_ctrl|di_tg_ctrl_n|vin|vout.$155.Metal2 v_c.$425.Metal3 0.000197684f
Cred_898 di_tg_ctrl|di_tg_ctrl_n|vin|vout.$155.Metal2 v_c.$446.Metal3 9.70289e-06f
Cred_899 di_tg_ctrl|di_tg_ctrl_n|vin|vout.$155.Metal2 v_c.$450.Metal3 0.0185547f
Cred_900 di_tg_ctrl|di_tg_ctrl_n|vin|vout.$155.Metal2 v_c.$459.Metal3 1.14649e-05f
Cred_901 di_tg_ctrl|di_tg_ctrl_n|vin|vout.$155.Metal2 v_c.$95.Metal1 0.0037605f
Cred_902 di_tg_ctrl|di_tg_ctrl_n|vin|vout.$155.Metal2 v_c.P10.nSD 2.0526e-07f
Cred_903 di_tg_ctrl|di_tg_ctrl_n|vin|vout.$155.Metal2 v_c.P10.pSD 0.00859675f
Cred_904 di_tg_ctrl|di_tg_ctrl_n|vin|vout.$155.Metal2 v_c.P8.pSD 4.87877e-05f
Cred_905 di_tg_ctrl|di_tg_ctrl_n|vin|vout.$155.Metal2 VDD.$382.Metal1 3.61991e-06f
Cred_906 di_tg_ctrl|di_tg_ctrl_n|vin|vout.$155.Metal2 VDD.$426.Metal1 2.73591e-06f
Cred_907 di_tg_ctrl|di_tg_ctrl_n|vin|vout.$155.Metal2 VDD.$434.Metal1 0.00287499f
Cred_908 di_tg_ctrl|di_tg_ctrl_n|vin|vout.$155.Metal2 VDD.$438.Metal1 0.00461609f
Cred_909 di_tg_ctrl|di_tg_ctrl_n|vin|vout.$155.Metal2 VDD.$442.Metal1 0.00523914f
Cred_910 di_tg_ctrl|di_tg_ctrl_n|vin|vout.$155.Metal2 VDD.$446.Metal1 0.00374091f
Cred_911 di_tg_ctrl|di_tg_ctrl_n|vin|vout.$155.Metal2 VDD.$477.Metal1 0.0004988f
Cred_912 di_tg_ctrl|di_tg_ctrl_n|vin|vout.$155.Metal2 VDD.$526.Metal1 4.71608e-07f
Cred_913 di_tg_ctrl|di_tg_ctrl_n|vin|vout.$155.Metal2 VDD.$762.Metal2 4.77142e-07f
Cred_914 di_tg_ctrl|di_tg_ctrl_n|vin|vout.$155.Metal2 VDD.$766.Metal2 0.0120538f
Cred_915 di_tg_ctrl|di_tg_ctrl_n|vin|vout.$155.Metal2 VDD.$774.Metal2 0.0442717f
Cred_916 di_tg_ctrl|di_tg_ctrl_n|vin|vout.$155.Metal2 VDD.$782.Metal2 0.0096231f
Cred_917 di_tg_ctrl|di_tg_ctrl_n|vin|vout.$155.Metal2 VDD.$882.Metal3 5.76177e-05f
Cred_918 di_tg_ctrl|di_tg_ctrl_n|vin|vout.$155.Metal2 VDD.$888.Metal3 0.000581634f
Cred_919 di_tg_ctrl|di_tg_ctrl_n|vin|vout.$155.Metal2 VDD.$892.Metal3 0.000510898f
Cred_920 di_tg_ctrl|di_tg_ctrl_n|vin|vout.$155.Metal2 VDD.P0.nSD 5.09108e-05f
Cred_921 di_tg_ctrl|di_tg_ctrl_n|vin|vout.$163.Metal2 di_tg_ctrl|di_tg_ctrl_n|vout.$10.GatPoly 4.63058e-06f
Cred_922 di_tg_ctrl|di_tg_ctrl_n|vin|vout.$163.Metal2 di_tg_ctrl|di_tg_ctrl_n|vout.$136.Metal2 0.00337531f
Cred_923 di_tg_ctrl|di_tg_ctrl_n|vin|vout.$163.Metal2 di_tg_ctrl|di_tg_ctrl_n|vout.$186.Metal3 0.000284839f
Cred_924 di_tg_ctrl|di_tg_ctrl_n|vin|vout.$163.Metal2 di_tg_ctrl|di_tg_ctrl_n|vout.$70.Metal1 0.000185104f
Cred_925 di_tg_ctrl|di_tg_ctrl_n|vin|vout.$163.Metal2 di_tg_ctrl|di_tg_ctrl_n|vout.P5.GatPoly 3.81625e-07f
Cred_926 di_tg_ctrl|di_tg_ctrl_n|vin|vout.$163.Metal2 VSS 0.00979931f
Cred_927 di_tg_ctrl|di_tg_ctrl_n|vin|vout.$163.Metal2 v_b.$161.Metal2 0.0249742f
Cred_928 di_tg_ctrl|di_tg_ctrl_n|vin|vout.$163.Metal2 v_b.P0.nSD 0.00189997f
Cred_929 di_tg_ctrl|di_tg_ctrl_n|vin|vout.$163.Metal2 v_b.P0.pSD 0.000621497f
Cred_930 di_tg_ctrl|di_tg_ctrl_n|vin|vout.$163.Metal2 v_b.P1.nSD 8.67502e-06f
Cred_931 di_tg_ctrl|di_tg_ctrl_n|vin|vout.$163.Metal2 v_c.$459.Metal3 0.0263654f
Cred_932 di_tg_ctrl|di_tg_ctrl_n|vin|vout.$163.Metal2 v_c.P0.nSD 0.0111239f
Cred_933 di_tg_ctrl|di_tg_ctrl_n|vin|vout.$163.Metal2 VSS.$211.Metal1 0.00100868f
Cred_934 di_tg_ctrl|di_tg_ctrl_n|vin|vout.$163.Metal2 VSS.$220.Metal1 0.000199344f
Cred_935 di_tg_ctrl|di_tg_ctrl_n|vin|vout.$163.Metal2 VSS.$231.Metal1 0.00384606f
Cred_936 di_tg_ctrl|di_tg_ctrl_n|vin|vout.$163.Metal2 VSS.$241.Metal1 0.00154932f
Cred_937 di_tg_ctrl|di_tg_ctrl_n|vin|vout.$163.Metal2 VSS.$255.Metal1 1.11121e-06f
Cred_938 di_tg_ctrl|di_tg_ctrl_n|vin|vout.$163.Metal2 VSS.$424.Metal2 8.15315e-07f
Cred_939 di_tg_ctrl|di_tg_ctrl_n|vin|vout.$163.Metal2 VSS.$428.Metal2 0.00821971f
Cred_940 di_tg_ctrl|di_tg_ctrl_n|vin|vout.$163.Metal2 VSS.$436.Metal2 0.0273788f
Cred_941 di_tg_ctrl|di_tg_ctrl_n|vin|vout.$163.Metal2 VSS.$440.Metal2 3.32664e-06f
Cred_942 di_tg_ctrl|di_tg_ctrl_n|vin|vout.$163.Metal2 VSS.$452.Metal2 4.52001e-08f
Cred_943 di_tg_ctrl|di_tg_ctrl_n|vin|vout.$163.Metal2 VSS.$536.Metal3 0.000437549f
Cred_944 di_tg_ctrl|di_tg_ctrl_n|vin|vout.$163.Metal2 VSS.$548.Metal3 3.2518e-09f
Cred_945 di_tg_ctrl|di_tg_ctrl_n|vin|vout.$163.Metal2 VSS.P0.pSD 4.92761e-05f
Cred_946 di_tg_ctrl|di_tg_ctrl_n|vin|vout.$165.Metal2 VSS 0.00346454f
Cred_947 di_tg_ctrl|di_tg_ctrl_n|vin|vout.$165.Metal2 v_b 1.55228e-06f
Cred_948 di_tg_ctrl|di_tg_ctrl_n|vin|vout.$165.Metal2 v_b.$161.Metal2 0.0308752f
Cred_949 di_tg_ctrl|di_tg_ctrl_n|vin|vout.$165.Metal2 v_b.$195.Metal2 5.14919e-07f
Cred_950 di_tg_ctrl|di_tg_ctrl_n|vin|vout.$165.Metal2 v_b.P1.nSD 0.00177307f
Cred_951 di_tg_ctrl|di_tg_ctrl_n|vin|vout.$165.Metal2 v_c.$459.Metal3 0.00132999f
Cred_952 di_tg_ctrl|di_tg_ctrl_n|vin|vout.$165.Metal2 v_c.$476.Metal3 1.98767e-05f
Cred_953 di_tg_ctrl|di_tg_ctrl_n|vin|vout.$165.Metal2 v_c.P0.nSD 4.75602e-05f
Cred_954 di_tg_ctrl|di_tg_ctrl_n|vin|vout.$165.Metal2 VSS.$220.Metal1 4.6423e-06f
Cred_955 di_tg_ctrl|di_tg_ctrl_n|vin|vout.$165.Metal2 VSS.$231.Metal1 0.000468203f
Cred_956 di_tg_ctrl|di_tg_ctrl_n|vin|vout.$165.Metal2 VSS.$241.Metal1 0.00296302f
Cred_957 di_tg_ctrl|di_tg_ctrl_n|vin|vout.$165.Metal2 VSS.$255.Metal1 7.07638e-07f
Cred_958 di_tg_ctrl|di_tg_ctrl_n|vin|vout.$165.Metal2 VSS.$436.Metal2 3.59013e-06f
Cred_959 di_tg_ctrl|di_tg_ctrl_n|vin|vout.$165.Metal2 VSS.$440.Metal2 0.0191505f
Cred_960 di_tg_ctrl|di_tg_ctrl_n|vin|vout.$165.Metal2 VSS.$444.Metal2 2.90504e-09f
Cred_961 di_tg_ctrl|di_tg_ctrl_n|vin|vout.$165.Metal2 VSS.$448.Metal2 1.92385e-09f
Cred_962 di_tg_ctrl|di_tg_ctrl_n|vin|vout.$165.Metal2 VSS.$452.Metal2 2.97424e-08f
Cred_963 di_tg_ctrl|di_tg_ctrl_n|vin|vout.$165.Metal2 VSS.$536.Metal3 2.4283e-07f
Cred_964 di_tg_ctrl|di_tg_ctrl_n|vin|vout.$165.Metal2 VSS.$540.Metal3 0.000224789f
Cred_965 di_tg_ctrl|di_tg_ctrl_n|vin|vout.$165.Metal2 VSS.$548.Metal3 1.21566e-07f
Cred_966 di_tg_ctrl|di_tg_ctrl_n|vin|vout.$165.Metal2 VSS.P0.pSD 3.71478e-06f
Cred_967 di_tg_ctrl|di_tg_ctrl_n|vin|vout.$167.Metal2 VSS 0.00405816f
Cred_968 di_tg_ctrl|di_tg_ctrl_n|vin|vout.$167.Metal2 v_b.$161.Metal2 0.00683559f
Cred_969 di_tg_ctrl|di_tg_ctrl_n|vin|vout.$167.Metal2 v_c.$476.Metal3 0.0171358f
Cred_970 di_tg_ctrl|di_tg_ctrl_n|vin|vout.$167.Metal2 v_c.P2.nSD 0.00529574f
Cred_971 di_tg_ctrl|di_tg_ctrl_n|vin|vout.$167.Metal2 VSS.$220.Metal1 1.24147e-05f
Cred_972 di_tg_ctrl|di_tg_ctrl_n|vin|vout.$167.Metal2 VSS.$241.Metal1 0.00204096f
Cred_973 di_tg_ctrl|di_tg_ctrl_n|vin|vout.$167.Metal2 VSS.$245.Metal1 0.00147288f
Cred_974 di_tg_ctrl|di_tg_ctrl_n|vin|vout.$167.Metal2 VSS.$255.Metal1 2.50698e-06f
Cred_975 di_tg_ctrl|di_tg_ctrl_n|vin|vout.$167.Metal2 VSS.$444.Metal2 0.019094f
Cred_976 di_tg_ctrl|di_tg_ctrl_n|vin|vout.$167.Metal2 VSS.$452.Metal2 1.01975e-07f
Cred_977 di_tg_ctrl|di_tg_ctrl_n|vin|vout.$167.Metal2 VSS.$548.Metal3 7.33635e-09f
Cred_978 di_tg_ctrl|di_tg_ctrl_n|vin|vout.$167.Metal2 VSS.P0.pSD 5.724e-06f
Cred_979 di_tg_ctrl|di_tg_ctrl_n|vin|vout.$169.Metal2 VSS 0.00403633f
Cred_980 di_tg_ctrl|di_tg_ctrl_n|vin|vout.$169.Metal2 v_b.$161.Metal2 0.00338127f
Cred_981 di_tg_ctrl|di_tg_ctrl_n|vin|vout.$169.Metal2 v_b.$195.Metal2 0.00338127f
Cred_982 di_tg_ctrl|di_tg_ctrl_n|vin|vout.$169.Metal2 v_b.P3.nSD 2.81243e-05f
Cred_983 di_tg_ctrl|di_tg_ctrl_n|vin|vout.$169.Metal2 v_b.P3.pSD 0.00010761f
Cred_984 di_tg_ctrl|di_tg_ctrl_n|vin|vout.$169.Metal2 v_c.$476.Metal3 0.013385f
Cred_985 di_tg_ctrl|di_tg_ctrl_n|vin|vout.$169.Metal2 v_c.P2.nSD 0.00452452f
Cred_986 di_tg_ctrl|di_tg_ctrl_n|vin|vout.$169.Metal2 VSS.$220.Metal1 1.65373e-06f
Cred_987 di_tg_ctrl|di_tg_ctrl_n|vin|vout.$169.Metal2 VSS.$245.Metal1 0.00270895f
Cred_988 di_tg_ctrl|di_tg_ctrl_n|vin|vout.$169.Metal2 VSS.$255.Metal1 1.63511e-06f
Cred_989 di_tg_ctrl|di_tg_ctrl_n|vin|vout.$169.Metal2 VSS.$444.Metal2 8.33906e-07f
Cred_990 di_tg_ctrl|di_tg_ctrl_n|vin|vout.$169.Metal2 VSS.$448.Metal2 0.0197454f
Cred_991 di_tg_ctrl|di_tg_ctrl_n|vin|vout.$169.Metal2 VSS.$452.Metal2 8.64315e-07f
Cred_992 di_tg_ctrl|di_tg_ctrl_n|vin|vout.$169.Metal2 VSS.$540.Metal3 0.000104007f
Cred_993 di_tg_ctrl|di_tg_ctrl_n|vin|vout.$169.Metal2 VSS.$548.Metal3 0.000104009f
Cred_994 di_tg_ctrl|di_tg_ctrl_n|vin|vout.$169.Metal2 VSS.P0.pSD 1.07567e-06f
Cred_995 di_tg_ctrl|di_tg_ctrl_n|vin|vout.$17.GatPoly di_tg_ctrl|di_tg_ctrl_n|vout.$10.GatPoly 0.00231971f
Cred_996 di_tg_ctrl|di_tg_ctrl_n|vin|vout.$17.GatPoly di_tg_ctrl|di_tg_ctrl_n|vout.$136.Metal2 7.65877e-05f
Cred_997 di_tg_ctrl|di_tg_ctrl_n|vin|vout.$17.GatPoly di_tg_ctrl|di_tg_ctrl_n|vout.$186.Metal3 3.5475e-06f
Cred_998 di_tg_ctrl|di_tg_ctrl_n|vin|vout.$17.GatPoly di_tg_ctrl|di_tg_ctrl_n|vout.$70.Metal1 0.00110008f
Cred_999 di_tg_ctrl|di_tg_ctrl_n|vin|vout.$17.GatPoly di_tg_ctrl|di_tg_ctrl_n|vout.P5.GatPoly 0.000363207f
Cred_1000 di_tg_ctrl|di_tg_ctrl_n|vin|vout.$17.GatPoly VSS 0.0689228f
Cred_1001 di_tg_ctrl|di_tg_ctrl_n|vin|vout.$17.GatPoly v_b.$161.Metal2 0.00134481f
Cred_1002 di_tg_ctrl|di_tg_ctrl_n|vin|vout.$17.GatPoly v_b.P1.nSD 0.00122231f
Cred_1003 di_tg_ctrl|di_tg_ctrl_n|vin|vout.$17.GatPoly v_c.$459.Metal3 0.00172665f
Cred_1004 di_tg_ctrl|di_tg_ctrl_n|vin|vout.$17.GatPoly v_c.$476.Metal3 6.88468e-05f
Cred_1005 di_tg_ctrl|di_tg_ctrl_n|vin|vout.$17.GatPoly v_c.P0.nSD 0.00282411f
Cred_1006 di_tg_ctrl|di_tg_ctrl_n|vin|vout.$17.GatPoly v_c.P2.nSD 0.000112774f
Cred_1007 di_tg_ctrl|di_tg_ctrl_n|vin|vout.$17.GatPoly VSS.$220.Metal1 9.05742e-06f
Cred_1008 di_tg_ctrl|di_tg_ctrl_n|vin|vout.$17.GatPoly VSS.$231.Metal1 0.00306379f
Cred_1009 di_tg_ctrl|di_tg_ctrl_n|vin|vout.$17.GatPoly VSS.$241.Metal1 0.00384178f
Cred_1010 di_tg_ctrl|di_tg_ctrl_n|vin|vout.$17.GatPoly VSS.$255.Metal1 1.38065e-06f
Cred_1011 di_tg_ctrl|di_tg_ctrl_n|vin|vout.$17.GatPoly VSS.$436.Metal2 1.85191e-05f
Cred_1012 di_tg_ctrl|di_tg_ctrl_n|vin|vout.$17.GatPoly VSS.$440.Metal2 8.27813e-06f
Cred_1013 di_tg_ctrl|di_tg_ctrl_n|vin|vout.$17.GatPoly VSS.$452.Metal2 5.616e-08f
Cred_1014 di_tg_ctrl|di_tg_ctrl_n|vin|vout.$17.GatPoly VSS.$548.Metal3 4.04028e-09f
Cred_1015 di_tg_ctrl|di_tg_ctrl_n|vin|vout.$17.GatPoly VSS.P0.pSD 1.01794e-05f
Cred_1016 di_tg_ctrl|di_tg_ctrl_n|vin|vout.$171.Metal2 VSS 0.00343863f
Cred_1017 di_tg_ctrl|di_tg_ctrl_n|vin|vout.$171.Metal2 v_b.$161.Metal2 0.0150945f
Cred_1018 di_tg_ctrl|di_tg_ctrl_n|vin|vout.$171.Metal2 v_b.$195.Metal2 0.0150945f
Cred_1019 di_tg_ctrl|di_tg_ctrl_n|vin|vout.$171.Metal2 v_b.P3.nSD 0.00189423f
Cred_1020 di_tg_ctrl|di_tg_ctrl_n|vin|vout.$171.Metal2 v_b.P3.pSD 0.000480387f
Cred_1021 di_tg_ctrl|di_tg_ctrl_n|vin|vout.$171.Metal2 v_c.$493.Metal3 0.0012176f
Cred_1022 di_tg_ctrl|di_tg_ctrl_n|vin|vout.$171.Metal2 v_c.P4.nSD 4.64333e-05f
Cred_1023 di_tg_ctrl|di_tg_ctrl_n|vin|vout.$171.Metal2 VSS.$220.Metal1 2.97465e-06f
Cred_1024 di_tg_ctrl|di_tg_ctrl_n|vin|vout.$171.Metal2 VSS.$245.Metal1 0.00157147f
Cred_1025 di_tg_ctrl|di_tg_ctrl_n|vin|vout.$171.Metal2 VSS.$255.Metal1 0.00185394f
Cred_1026 di_tg_ctrl|di_tg_ctrl_n|vin|vout.$171.Metal2 VSS.$448.Metal2 1.32971e-06f
Cred_1027 di_tg_ctrl|di_tg_ctrl_n|vin|vout.$171.Metal2 VSS.$452.Metal2 0.0191576f
Cred_1028 di_tg_ctrl|di_tg_ctrl_n|vin|vout.$171.Metal2 VSS.$548.Metal3 8.19068e-09f
Cred_1029 di_tg_ctrl|di_tg_ctrl_n|vin|vout.$171.Metal2 VSS.P0.pSD 7.01636e-06f
Cred_1030 di_tg_ctrl|di_tg_ctrl_n|vin|vout.$173.Metal2 VSS 0.0137322f
Cred_1031 di_tg_ctrl|di_tg_ctrl_n|vin|vout.$173.Metal2 v_b 3.45377e-05f
Cred_1032 di_tg_ctrl|di_tg_ctrl_n|vin|vout.$173.Metal2 v_b.$161.Metal2 0.000781251f
Cred_1033 di_tg_ctrl|di_tg_ctrl_n|vin|vout.$173.Metal2 v_b.$195.Metal2 0.0255029f
Cred_1034 di_tg_ctrl|di_tg_ctrl_n|vin|vout.$173.Metal2 v_b.P3.nSD 1.55132e-05f
Cred_1035 di_tg_ctrl|di_tg_ctrl_n|vin|vout.$173.Metal2 v_b.P3.pSD 2.48636e-05f
Cred_1036 di_tg_ctrl|di_tg_ctrl_n|vin|vout.$173.Metal2 v_b.P5.nSD 0.00137165f
Cred_1037 di_tg_ctrl|di_tg_ctrl_n|vin|vout.$173.Metal2 v_c.$493.Metal3 0.0287277f
Cred_1038 di_tg_ctrl|di_tg_ctrl_n|vin|vout.$173.Metal2 v_c.P4.nSD 0.0111625f
Cred_1039 di_tg_ctrl|di_tg_ctrl_n|vin|vout.$173.Metal2 VSS.$220.Metal1 0.00010507f
Cred_1040 di_tg_ctrl|di_tg_ctrl_n|vin|vout.$173.Metal2 VSS.$245.Metal1 0.000354516f
Cred_1041 di_tg_ctrl|di_tg_ctrl_n|vin|vout.$173.Metal2 VSS.$255.Metal1 0.0070713f
Cred_1042 di_tg_ctrl|di_tg_ctrl_n|vin|vout.$173.Metal2 VSS.$444.Metal2 1.62325e-08f
Cred_1043 di_tg_ctrl|di_tg_ctrl_n|vin|vout.$173.Metal2 VSS.$448.Metal2 3.3257e-07f
Cred_1044 di_tg_ctrl|di_tg_ctrl_n|vin|vout.$173.Metal2 VSS.$452.Metal2 0.0331611f
Cred_1045 di_tg_ctrl|di_tg_ctrl_n|vin|vout.$173.Metal2 VSS.$540.Metal3 2.02457e-06f
Cred_1046 di_tg_ctrl|di_tg_ctrl_n|vin|vout.$173.Metal2 VSS.$548.Metal3 0.00324438f
Cred_1047 di_tg_ctrl|di_tg_ctrl_n|vin|vout.$173.Metal2 VSS.P0.pSD 0.000327945f
Cred_1048 di_tg_ctrl|di_tg_ctrl_n|vin|vout.$199.Metal3 di_tg_ctrl|di_tg_ctrl_n|vout.$180.Metal3 0.0746747f
Cred_1049 di_tg_ctrl|di_tg_ctrl_n|vin|vout.$199.Metal3 di_tg_ctrl|di_tg_ctrl_n|vout.$206.Metal4 0.043504f
Cred_1050 di_tg_ctrl|di_tg_ctrl_n|vin|vout.$199.Metal3 di_tg_ctrl|di_tg_ctrl_n|vout.P0.nSD 0.00941952f
Cred_1051 di_tg_ctrl|di_tg_ctrl_n|vin|vout.$199.Metal3 di_tg_ctrl|di_tg_ctrl_n|vout.P0.pSD 0.0721089f
Cred_1052 di_tg_ctrl|di_tg_ctrl_n|vin|vout.$199.Metal3 VSS 0.0368215f
Cred_1053 di_tg_ctrl|di_tg_ctrl_n|vin|vout.$199.Metal3 v_a 0.0625019f
Cred_1054 di_tg_ctrl|di_tg_ctrl_n|vin|vout.$199.Metal3 v_a.$148.Metal2 0.0120001f
Cred_1055 di_tg_ctrl|di_tg_ctrl_n|vin|vout.$199.Metal3 v_a.$182.Metal2 0.000917218f
Cred_1056 di_tg_ctrl|di_tg_ctrl_n|vin|vout.$199.Metal3 v_a.P0.nSD 7.58291e-06f
Cred_1057 di_tg_ctrl|di_tg_ctrl_n|vin|vout.$199.Metal3 v_a.P0.pSD 0.0078089f
Cred_1058 di_tg_ctrl|di_tg_ctrl_n|vin|vout.$199.Metal3 v_a.P1.nSD 7.62911e-06f
Cred_1059 di_tg_ctrl|di_tg_ctrl_n|vin|vout.$199.Metal3 v_a.P1.pSD 0.00210259f
Cred_1060 di_tg_ctrl|di_tg_ctrl_n|vin|vout.$199.Metal3 v_b 0.04407f
Cred_1061 di_tg_ctrl|di_tg_ctrl_n|vin|vout.$199.Metal3 v_c.$220.Metal2 8.38389e-07f
Cred_1062 di_tg_ctrl|di_tg_ctrl_n|vin|vout.$199.Metal3 v_c.$228.Metal2 0.00498136f
Cred_1063 di_tg_ctrl|di_tg_ctrl_n|vin|vout.$199.Metal3 v_c.$23.Metal1 0.0013481f
Cred_1064 di_tg_ctrl|di_tg_ctrl_n|vin|vout.$199.Metal3 v_c.$411.Metal3 0.000104566f
Cred_1065 di_tg_ctrl|di_tg_ctrl_n|vin|vout.$199.Metal3 v_c.$415.Metal3 0.0361235f
Cred_1066 di_tg_ctrl|di_tg_ctrl_n|vin|vout.$199.Metal3 v_c.$425.Metal3 0.00062469f
Cred_1067 di_tg_ctrl|di_tg_ctrl_n|vin|vout.$199.Metal3 v_c.P6.nSD 2.81622e-06f
Cred_1068 di_tg_ctrl|di_tg_ctrl_n|vin|vout.$199.Metal3 v_c.P6.pSD 0.00121439f
Cred_1069 di_tg_ctrl|di_tg_ctrl_n|vin|vout.$199.Metal3 VDD.$100.Metal1 0.00392225f
Cred_1070 di_tg_ctrl|di_tg_ctrl_n|vin|vout.$199.Metal3 VDD.$102.Metal1 0.00654554f
Cred_1071 di_tg_ctrl|di_tg_ctrl_n|vin|vout.$199.Metal3 VDD.$105.Metal1 0.000509661f
Cred_1072 di_tg_ctrl|di_tg_ctrl_n|vin|vout.$199.Metal3 VDD.$113.Metal1 0.000509705f
Cred_1073 di_tg_ctrl|di_tg_ctrl_n|vin|vout.$199.Metal3 VDD.$125.Metal1 0.0094258f
Cred_1074 di_tg_ctrl|di_tg_ctrl_n|vin|vout.$199.Metal3 VDD.$131.Metal1 0.00683217f
Cred_1075 di_tg_ctrl|di_tg_ctrl_n|vin|vout.$199.Metal3 VDD.$133.Metal1 0.00413516f
Cred_1076 di_tg_ctrl|di_tg_ctrl_n|vin|vout.$199.Metal3 VDD.$135.Metal1 0.00412339f
Cred_1077 di_tg_ctrl|di_tg_ctrl_n|vin|vout.$199.Metal3 VDD.$137.Metal1 0.00410777f
Cred_1078 di_tg_ctrl|di_tg_ctrl_n|vin|vout.$199.Metal3 VDD.$139.Metal1 0.00411844f
Cred_1079 di_tg_ctrl|di_tg_ctrl_n|vin|vout.$199.Metal3 VDD.$215.Metal1 0.000694119f
Cred_1080 di_tg_ctrl|di_tg_ctrl_n|vin|vout.$199.Metal3 VDD.$218.Metal1 4.79639e-06f
Cred_1081 di_tg_ctrl|di_tg_ctrl_n|vin|vout.$199.Metal3 VDD.$257.Metal1 0.000705043f
Cred_1082 di_tg_ctrl|di_tg_ctrl_n|vin|vout.$199.Metal3 VDD.$29.Metal1 0.000431529f
Cred_1083 di_tg_ctrl|di_tg_ctrl_n|vin|vout.$199.Metal3 VDD.$298.Metal1 0.00210215f
Cred_1084 di_tg_ctrl|di_tg_ctrl_n|vin|vout.$199.Metal3 VDD.$339.Metal1 0.000704554f
Cred_1085 di_tg_ctrl|di_tg_ctrl_n|vin|vout.$199.Metal3 VDD.$378.Metal1 4.53138e-06f
Cred_1086 di_tg_ctrl|di_tg_ctrl_n|vin|vout.$199.Metal3 VDD.$382.Metal1 0.00199881f
Cred_1087 di_tg_ctrl|di_tg_ctrl_n|vin|vout.$199.Metal3 VDD.$405.Metal1 0.00241865f
Cred_1088 di_tg_ctrl|di_tg_ctrl_n|vin|vout.$199.Metal3 VDD.$414.Metal1 0.00248511f
Cred_1089 di_tg_ctrl|di_tg_ctrl_n|vin|vout.$199.Metal3 VDD.$418.Metal1 0.000163169f
Cred_1090 di_tg_ctrl|di_tg_ctrl_n|vin|vout.$199.Metal3 VDD.$422.Metal1 6.28745e-05f
Cred_1091 di_tg_ctrl|di_tg_ctrl_n|vin|vout.$199.Metal3 VDD.$51.Metal1 9.55892e-05f
Cred_1092 di_tg_ctrl|di_tg_ctrl_n|vin|vout.$199.Metal3 VDD.$552.Metal2 6.52311e-05f
Cred_1093 di_tg_ctrl|di_tg_ctrl_n|vin|vout.$199.Metal3 VDD.$562.Metal2 0.0242105f
Cred_1094 di_tg_ctrl|di_tg_ctrl_n|vin|vout.$199.Metal3 VDD.$563.Metal2 0.00698616f
Cred_1095 di_tg_ctrl|di_tg_ctrl_n|vin|vout.$199.Metal3 VDD.$564.Metal2 0.00693372f
Cred_1096 di_tg_ctrl|di_tg_ctrl_n|vin|vout.$199.Metal3 VDD.$565.Metal2 0.0068573f
Cred_1097 di_tg_ctrl|di_tg_ctrl_n|vin|vout.$199.Metal3 VDD.$566.Metal2 0.0068026f
Cred_1098 di_tg_ctrl|di_tg_ctrl_n|vin|vout.$199.Metal3 VDD.$567.Metal2 0.00674691f
Cred_1099 di_tg_ctrl|di_tg_ctrl_n|vin|vout.$199.Metal3 VDD.$568.Metal2 0.00669104f
Cred_1100 di_tg_ctrl|di_tg_ctrl_n|vin|vout.$199.Metal3 VDD.$569.Metal2 0.00665983f
Cred_1101 di_tg_ctrl|di_tg_ctrl_n|vin|vout.$199.Metal3 VDD.$570.Metal2 0.00660741f
Cred_1102 di_tg_ctrl|di_tg_ctrl_n|vin|vout.$199.Metal3 VDD.$571.Metal2 0.0065998f
Cred_1103 di_tg_ctrl|di_tg_ctrl_n|vin|vout.$199.Metal3 VDD.$572.Metal2 0.00659238f
Cred_1104 di_tg_ctrl|di_tg_ctrl_n|vin|vout.$199.Metal3 VDD.$573.Metal2 0.00904462f
Cred_1105 di_tg_ctrl|di_tg_ctrl_n|vin|vout.$199.Metal3 VDD.$597.Metal2 0.00118755f
Cred_1106 di_tg_ctrl|di_tg_ctrl_n|vin|vout.$199.Metal3 VDD.$606.Metal2 0.0224005f
Cred_1107 di_tg_ctrl|di_tg_ctrl_n|vin|vout.$199.Metal3 VDD.$607.Metal2 0.0136451f
Cred_1108 di_tg_ctrl|di_tg_ctrl_n|vin|vout.$199.Metal3 VDD.$608.Metal2 0.0129584f
Cred_1109 di_tg_ctrl|di_tg_ctrl_n|vin|vout.$199.Metal3 VDD.$609.Metal2 0.0126051f
Cred_1110 di_tg_ctrl|di_tg_ctrl_n|vin|vout.$199.Metal3 VDD.$610.Metal2 0.0124417f
Cred_1111 di_tg_ctrl|di_tg_ctrl_n|vin|vout.$199.Metal3 VDD.$611.Metal2 0.0122656f
Cred_1112 di_tg_ctrl|di_tg_ctrl_n|vin|vout.$199.Metal3 VDD.$612.Metal2 0.0123021f
Cred_1113 di_tg_ctrl|di_tg_ctrl_n|vin|vout.$199.Metal3 VDD.$613.Metal2 0.0254713f
Cred_1114 di_tg_ctrl|di_tg_ctrl_n|vin|vout.$199.Metal3 VDD.$614.Metal2 0.0173043f
Cred_1115 di_tg_ctrl|di_tg_ctrl_n|vin|vout.$199.Metal3 VDD.$615.Metal2 0.0117927f
Cred_1116 di_tg_ctrl|di_tg_ctrl_n|vin|vout.$199.Metal3 VDD.$616.Metal2 0.011696f
Cred_1117 di_tg_ctrl|di_tg_ctrl_n|vin|vout.$199.Metal3 VDD.$617.Metal2 0.0117886f
Cred_1118 di_tg_ctrl|di_tg_ctrl_n|vin|vout.$199.Metal3 VDD.$618.Metal2 0.0118516f
Cred_1119 di_tg_ctrl|di_tg_ctrl_n|vin|vout.$199.Metal3 VDD.$619.Metal2 0.0170511f
Cred_1120 di_tg_ctrl|di_tg_ctrl_n|vin|vout.$199.Metal3 VDD.$620.Metal2 0.0159555f
Cred_1121 di_tg_ctrl|di_tg_ctrl_n|vin|vout.$199.Metal3 VDD.$621.Metal2 1.08742e-05f
Cred_1122 di_tg_ctrl|di_tg_ctrl_n|vin|vout.$199.Metal3 VDD.$643.Metal2 0.00103141f
Cred_1123 di_tg_ctrl|di_tg_ctrl_n|vin|vout.$199.Metal3 VDD.$651.Metal2 0.00144343f
Cred_1124 di_tg_ctrl|di_tg_ctrl_n|vin|vout.$199.Metal3 VDD.$688.Metal2 0.000972163f
Cred_1125 di_tg_ctrl|di_tg_ctrl_n|vin|vout.$199.Metal3 VDD.$696.Metal2 0.000874939f
Cred_1126 di_tg_ctrl|di_tg_ctrl_n|vin|vout.$199.Metal3 VDD.$708.Metal2 0.084124f
Cred_1127 di_tg_ctrl|di_tg_ctrl_n|vin|vout.$199.Metal3 VDD.$712.Metal2 0.00972006f
Cred_1128 di_tg_ctrl|di_tg_ctrl_n|vin|vout.$199.Metal3 VDD.$714.Metal2 0.0185875f
Cred_1129 di_tg_ctrl|di_tg_ctrl_n|vin|vout.$199.Metal3 VDD.$734.Metal2 0.034414f
Cred_1130 di_tg_ctrl|di_tg_ctrl_n|vin|vout.$199.Metal3 VDD.$738.Metal2 0.0140497f
Cred_1131 di_tg_ctrl|di_tg_ctrl_n|vin|vout.$199.Metal3 VDD.$746.Metal2 0.0099719f
Cred_1132 di_tg_ctrl|di_tg_ctrl_n|vin|vout.$199.Metal3 VDD.$754.Metal2 0.00131168f
Cred_1133 di_tg_ctrl|di_tg_ctrl_n|vin|vout.$199.Metal3 VDD.$844.Metal3 0.00206025f
Cred_1134 di_tg_ctrl|di_tg_ctrl_n|vin|vout.$199.Metal3 VDD.$852.Metal3 0.00125747f
Cred_1135 di_tg_ctrl|di_tg_ctrl_n|vin|vout.$199.Metal3 VDD.$856.Metal3 0.0150369f
Cred_1136 di_tg_ctrl|di_tg_ctrl_n|vin|vout.$199.Metal3 VDD.$864.Metal3 0.0575077f
Cred_1137 di_tg_ctrl|di_tg_ctrl_n|vin|vout.$199.Metal3 VDD.$868.Metal3 0.0745365f
Cred_1138 di_tg_ctrl|di_tg_ctrl_n|vin|vout.$199.Metal3 VDD.$874.Metal3 0.0746915f
Cred_1139 di_tg_ctrl|di_tg_ctrl_n|vin|vout.$199.Metal3 VDD.$878.Metal3 0.0489532f
Cred_1140 di_tg_ctrl|di_tg_ctrl_n|vin|vout.$199.Metal3 VDD.$882.Metal3 0.0183069f
Cred_1141 di_tg_ctrl|di_tg_ctrl_n|vin|vout.$199.Metal3 VDD.$90.Metal1 0.0065027f
Cred_1142 di_tg_ctrl|di_tg_ctrl_n|vin|vout.$199.Metal3 VDD.$92.Metal1 0.0038779f
Cred_1143 di_tg_ctrl|di_tg_ctrl_n|vin|vout.$199.Metal3 VDD.$94.Metal1 0.00386686f
Cred_1144 di_tg_ctrl|di_tg_ctrl_n|vin|vout.$199.Metal3 VDD.$96.Metal1 0.00385221f
Cred_1145 di_tg_ctrl|di_tg_ctrl_n|vin|vout.$199.Metal3 VDD.$98.Metal1 0.00383663f
Cred_1146 di_tg_ctrl|di_tg_ctrl_n|vin|vout.$199.Metal3 VDD.P0.GatPoly 1.70546e-08f
Cred_1147 di_tg_ctrl|di_tg_ctrl_n|vin|vout.$199.Metal3 VDD.P0.nSD 0.00610692f
Cred_1148 di_tg_ctrl|di_tg_ctrl_n|vin|vout.$199.Metal3 VDD.P0.pSD 1.82769e-06f
Cred_1149 di_tg_ctrl|di_tg_ctrl_n|vin|vout.$199.Metal3 VDD.P1.pSD 0.000258831f
Cred_1150 di_tg_ctrl|di_tg_ctrl_n|vin|vout.$199.Metal3 VDD.P10.pSD 0.0033294f
Cred_1151 di_tg_ctrl|di_tg_ctrl_n|vin|vout.$199.Metal3 VDD.P3.GatPoly 3.13891e-06f
Cred_1152 di_tg_ctrl|di_tg_ctrl_n|vin|vout.$199.Metal3 VDD.P3.pSD 0.00103239f
Cred_1153 di_tg_ctrl|di_tg_ctrl_n|vin|vout.$199.Metal3 VDD.P7.pSD 0.00236975f
Cred_1154 di_tg_ctrl|di_tg_ctrl_n|vin|vout.$199.Metal3 VSS.$129.Metal1 7.24623e-05f
Cred_1155 di_tg_ctrl|di_tg_ctrl_n|vin|vout.$199.Metal3 VSS.$132.Metal1 2.57966e-06f
Cred_1156 di_tg_ctrl|di_tg_ctrl_n|vin|vout.$199.Metal3 VSS.$156.Metal1 1.22102e-06f
Cred_1157 di_tg_ctrl|di_tg_ctrl_n|vin|vout.$199.Metal3 VSS.$175.Metal1 2.48178e-09f
Cred_1158 di_tg_ctrl|di_tg_ctrl_n|vin|vout.$199.Metal3 VSS.$220.Metal1 1.1168e-05f
Cred_1159 di_tg_ctrl|di_tg_ctrl_n|vin|vout.$199.Metal3 VSS.$284.Metal2 0.0220588f
Cred_1160 di_tg_ctrl|di_tg_ctrl_n|vin|vout.$199.Metal3 VSS.$303.Metal2 0.00107003f
Cred_1161 di_tg_ctrl|di_tg_ctrl_n|vin|vout.$199.Metal3 VSS.$307.Metal2 1.47275e-05f
Cred_1162 di_tg_ctrl|di_tg_ctrl_n|vin|vout.$199.Metal3 VSS.$311.Metal2 0.0530847f
Cred_1163 di_tg_ctrl|di_tg_ctrl_n|vin|vout.$199.Metal3 VSS.$321.Metal2 3.67512e-06f
Cred_1164 di_tg_ctrl|di_tg_ctrl_n|vin|vout.$199.Metal3 VSS.$329.Metal2 0.000112958f
Cred_1165 di_tg_ctrl|di_tg_ctrl_n|vin|vout.$199.Metal3 VSS.$33.Metal1 0.00761061f
Cred_1166 di_tg_ctrl|di_tg_ctrl_n|vin|vout.$199.Metal3 VSS.$339.Metal2 0.000104774f
Cred_1167 di_tg_ctrl|di_tg_ctrl_n|vin|vout.$199.Metal3 VSS.$350.Metal2 4.67705e-06f
Cred_1168 di_tg_ctrl|di_tg_ctrl_n|vin|vout.$199.Metal3 VSS.$354.Metal2 4.65389e-06f
Cred_1169 di_tg_ctrl|di_tg_ctrl_n|vin|vout.$199.Metal3 VSS.$359.Metal2 0.00362335f
Cred_1170 di_tg_ctrl|di_tg_ctrl_n|vin|vout.$199.Metal3 VSS.$368.Metal2 0.0011129f
Cred_1171 di_tg_ctrl|di_tg_ctrl_n|vin|vout.$199.Metal3 VSS.$372.Metal2 0.00020084f
Cred_1172 di_tg_ctrl|di_tg_ctrl_n|vin|vout.$199.Metal3 VSS.$376.Metal2 0.00018523f
Cred_1173 di_tg_ctrl|di_tg_ctrl_n|vin|vout.$199.Metal3 VSS.$384.Metal2 1.25181e-06f
Cred_1174 di_tg_ctrl|di_tg_ctrl_n|vin|vout.$199.Metal3 VSS.$392.Metal2 6.20304e-07f
Cred_1175 di_tg_ctrl|di_tg_ctrl_n|vin|vout.$199.Metal3 VSS.$42.Metal1 0.000370017f
Cred_1176 di_tg_ctrl|di_tg_ctrl_n|vin|vout.$199.Metal3 VSS.$478.Metal3 0.00240145f
Cred_1177 di_tg_ctrl|di_tg_ctrl_n|vin|vout.$199.Metal3 VSS.$484.Metal3 0.00316441f
Cred_1178 di_tg_ctrl|di_tg_ctrl_n|vin|vout.$199.Metal3 VSS.$488.Metal3 0.00382388f
Cred_1179 di_tg_ctrl|di_tg_ctrl_n|vin|vout.$199.Metal3 VSS.$496.Metal3 0.00257751f
Cred_1180 di_tg_ctrl|di_tg_ctrl_n|vin|vout.$199.Metal3 VSS.$5.Metal1 0.000105641f
Cred_1181 di_tg_ctrl|di_tg_ctrl_n|vin|vout.$199.Metal3 VSS.$502.Metal3 0.00217608f
Cred_1182 di_tg_ctrl|di_tg_ctrl_n|vin|vout.$199.Metal3 VSS.$510.Metal3 0.00151285f
Cred_1183 di_tg_ctrl|di_tg_ctrl_n|vin|vout.$199.Metal3 VSS.$518.Metal3 3.87601e-05f
Cred_1184 di_tg_ctrl|di_tg_ctrl_n|vin|vout.$199.Metal3 VSS.$61.Metal1 0.000184068f
Cred_1185 di_tg_ctrl|di_tg_ctrl_n|vin|vout.$199.Metal3 VSS.$78.Metal1 0.00700926f
Cred_1186 di_tg_ctrl|di_tg_ctrl_n|vin|vout.$199.Metal3 VSS.$87.Metal1 0.00471523f
Cred_1187 di_tg_ctrl|di_tg_ctrl_n|vin|vout.$199.Metal3 VSS.$94.Metal1 7.51508e-07f
Cred_1188 di_tg_ctrl|di_tg_ctrl_n|vin|vout.$199.Metal3 VSS.P0.nSD 5.86421e-05f
Cred_1189 di_tg_ctrl|di_tg_ctrl_n|vin|vout.$199.Metal3 VSS.P0.pSD 0.000874131f
Cred_1190 di_tg_ctrl|di_tg_ctrl_n|vin|vout.$199.Metal3 VSS.P1.GatPoly 8.82017e-06f
Cred_1191 di_tg_ctrl|di_tg_ctrl_n|vin|vout.$199.Metal3 VSS.P1.nSD 5.86421e-05f
Cred_1192 di_tg_ctrl|di_tg_ctrl_n|vin|vout.$199.Metal3 VSS.P2.GatPoly 4.15641e-07f
Cred_1193 di_tg_ctrl|di_tg_ctrl_n|vin|vout.$199.Metal3 VSS.P3.nSD 9.58273e-05f
Cred_1194 di_tg_ctrl|di_tg_ctrl_n|vin|vout.$199.Metal3 VSS.P5.nSD 6.45273e-05f
Cred_1195 di_tg_ctrl|di_tg_ctrl_n|vin|vout.$199.Metal3 VSS.P6.nSD 3.28246e-06f
Cred_1196 di_tg_ctrl|di_tg_ctrl_n|vin|vout.$199.Metal3 VSS.P7.nSD 4.11901e-06f
Cred_1197 di_tg_ctrl|di_tg_ctrl_n|vin|vout.$202.Metal3 di_tg_ctrl|di_tg_ctrl_n|vout.$180.Metal3 0.00110331f
Cred_1198 di_tg_ctrl|di_tg_ctrl_n|vin|vout.$202.Metal3 di_tg_ctrl|di_tg_ctrl_n|vout.$206.Metal4 0.0141199f
Cred_1199 di_tg_ctrl|di_tg_ctrl_n|vin|vout.$202.Metal3 di_tg_ctrl|di_tg_ctrl_n|vout.P0.nSD 0.000126763f
Cred_1200 di_tg_ctrl|di_tg_ctrl_n|vin|vout.$202.Metal3 di_tg_ctrl|di_tg_ctrl_n|vout.P0.pSD 0.00065802f
Cred_1201 di_tg_ctrl|di_tg_ctrl_n|vin|vout.$202.Metal3 v_a 1.71541e-08f
Cred_1202 di_tg_ctrl|di_tg_ctrl_n|vin|vout.$202.Metal3 v_a.$148.Metal2 0.00191335f
Cred_1203 di_tg_ctrl|di_tg_ctrl_n|vin|vout.$202.Metal3 v_a.$182.Metal2 0.00372194f
Cred_1204 di_tg_ctrl|di_tg_ctrl_n|vin|vout.$202.Metal3 v_a.P0.pSD 7.89314e-05f
Cred_1205 di_tg_ctrl|di_tg_ctrl_n|vin|vout.$202.Metal3 v_a.P1.nSD 1.54028e-05f
Cred_1206 di_tg_ctrl|di_tg_ctrl_n|vin|vout.$202.Metal3 v_a.P1.pSD 0.00661477f
Cred_1207 di_tg_ctrl|di_tg_ctrl_n|vin|vout.$202.Metal3 v_a.P3.pSD 0.00362608f
Cred_1208 di_tg_ctrl|di_tg_ctrl_n|vin|vout.$202.Metal3 v_c.$220.Metal2 1.69266e-06f
Cred_1209 di_tg_ctrl|di_tg_ctrl_n|vin|vout.$202.Metal3 v_c.$228.Metal2 0.00243675f
Cred_1210 di_tg_ctrl|di_tg_ctrl_n|vin|vout.$202.Metal3 v_c.$23.Metal1 0.000652413f
Cred_1211 di_tg_ctrl|di_tg_ctrl_n|vin|vout.$202.Metal3 v_c.$284.Metal2 7.39908e-07f
Cred_1212 di_tg_ctrl|di_tg_ctrl_n|vin|vout.$202.Metal3 v_c.$292.Metal2 0.000225242f
Cred_1213 di_tg_ctrl|di_tg_ctrl_n|vin|vout.$202.Metal3 v_c.$411.Metal3 0.000211114f
Cred_1214 di_tg_ctrl|di_tg_ctrl_n|vin|vout.$202.Metal3 v_c.$415.Metal3 0.0182321f
Cred_1215 di_tg_ctrl|di_tg_ctrl_n|vin|vout.$202.Metal3 v_c.$425.Metal3 0.0434959f
Cred_1216 di_tg_ctrl|di_tg_ctrl_n|vin|vout.$202.Metal3 v_c.$446.Metal3 9.22835e-05f
Cred_1217 di_tg_ctrl|di_tg_ctrl_n|vin|vout.$202.Metal3 v_c.$450.Metal3 0.00172192f
Cred_1218 di_tg_ctrl|di_tg_ctrl_n|vin|vout.$202.Metal3 v_c.$459.Metal3 0.000109042f
Cred_1219 di_tg_ctrl|di_tg_ctrl_n|vin|vout.$202.Metal3 v_c.$95.Metal1 5.98843e-05f
Cred_1220 di_tg_ctrl|di_tg_ctrl_n|vin|vout.$202.Metal3 v_c.P10.nSD 1.95221e-06f
Cred_1221 di_tg_ctrl|di_tg_ctrl_n|vin|vout.$202.Metal3 v_c.P10.pSD 4.61648e-05f
Cred_1222 di_tg_ctrl|di_tg_ctrl_n|vin|vout.$202.Metal3 v_c.P6.nSD 5.6858e-06f
Cred_1223 di_tg_ctrl|di_tg_ctrl_n|vin|vout.$202.Metal3 v_c.P6.pSD 0.000537765f
Cred_1224 di_tg_ctrl|di_tg_ctrl_n|vin|vout.$202.Metal3 v_c.P8.pSD 0.01282f
Cred_1225 di_tg_ctrl|di_tg_ctrl_n|vin|vout.$202.Metal3 VDD.$378.Metal1 6.0238e-07f
Cred_1226 di_tg_ctrl|di_tg_ctrl_n|vin|vout.$202.Metal3 VDD.$382.Metal1 5.58445e-08f
Cred_1227 di_tg_ctrl|di_tg_ctrl_n|vin|vout.$202.Metal3 VDD.$405.Metal1 1.0761e-06f
Cred_1228 di_tg_ctrl|di_tg_ctrl_n|vin|vout.$202.Metal3 VDD.$414.Metal1 1.90777e-05f
Cred_1229 di_tg_ctrl|di_tg_ctrl_n|vin|vout.$202.Metal3 VDD.$418.Metal1 2.57818e-05f
Cred_1230 di_tg_ctrl|di_tg_ctrl_n|vin|vout.$202.Metal3 VDD.$422.Metal1 1.23745e-05f
Cred_1231 di_tg_ctrl|di_tg_ctrl_n|vin|vout.$202.Metal3 VDD.$426.Metal1 0.00027572f
Cred_1232 di_tg_ctrl|di_tg_ctrl_n|vin|vout.$202.Metal3 VDD.$434.Metal1 0.00053647f
Cred_1233 di_tg_ctrl|di_tg_ctrl_n|vin|vout.$202.Metal3 VDD.$620.Metal2 6.55678e-06f
Cred_1234 di_tg_ctrl|di_tg_ctrl_n|vin|vout.$202.Metal3 VDD.$738.Metal2 1.90616e-05f
Cred_1235 di_tg_ctrl|di_tg_ctrl_n|vin|vout.$202.Metal3 VDD.$746.Metal2 9.23796e-05f
Cred_1236 di_tg_ctrl|di_tg_ctrl_n|vin|vout.$202.Metal3 VDD.$754.Metal2 0.000244217f
Cred_1237 di_tg_ctrl|di_tg_ctrl_n|vin|vout.$202.Metal3 VDD.$762.Metal2 0.000197272f
Cred_1238 di_tg_ctrl|di_tg_ctrl_n|vin|vout.$202.Metal3 VDD.$766.Metal2 0.000170757f
Cred_1239 di_tg_ctrl|di_tg_ctrl_n|vin|vout.$202.Metal3 VDD.$874.Metal3 2.51612e-07f
Cred_1240 di_tg_ctrl|di_tg_ctrl_n|vin|vout.$202.Metal3 VDD.$878.Metal3 0.0045437f
Cred_1241 di_tg_ctrl|di_tg_ctrl_n|vin|vout.$202.Metal3 VDD.$882.Metal3 0.047382f
Cred_1242 di_tg_ctrl|di_tg_ctrl_n|vin|vout.$202.Metal3 VDD.$888.Metal3 0.0300467f
Cred_1243 di_tg_ctrl|di_tg_ctrl_n|vin|vout.$202.Metal3 VDD.P0.nSD 1.02608e-06f
Cred_1244 di_tg_ctrl|di_tg_ctrl_n|vin|vout.$205.Metal3 di_tg_ctrl|di_tg_ctrl_n|vout.$14.GatPoly 7.28599e-06f
Cred_1245 di_tg_ctrl|di_tg_ctrl_n|vin|vout.$205.Metal3 di_tg_ctrl|di_tg_ctrl_n|vout.$144.Metal2 0.00043749f
Cred_1246 di_tg_ctrl|di_tg_ctrl_n|vin|vout.$205.Metal3 di_tg_ctrl|di_tg_ctrl_n|vout.$17.GatPoly 2.28995e-06f
Cred_1247 di_tg_ctrl|di_tg_ctrl_n|vin|vout.$205.Metal3 di_tg_ctrl|di_tg_ctrl_n|vout.$192.Metal3 0.00395665f
Cred_1248 di_tg_ctrl|di_tg_ctrl_n|vin|vout.$205.Metal3 di_tg_ctrl|di_tg_ctrl_n|vout.$206.Metal4 0.0240952f
Cred_1249 di_tg_ctrl|di_tg_ctrl_n|vin|vout.$205.Metal3 di_tg_ctrl|di_tg_ctrl_n|vout.$209.Metal4 2.57414e-05f
Cred_1250 di_tg_ctrl|di_tg_ctrl_n|vin|vout.$205.Metal3 di_tg_ctrl|di_tg_ctrl_n|vout.$21.GatPoly 2.54782e-06f
Cred_1251 di_tg_ctrl|di_tg_ctrl_n|vin|vout.$205.Metal3 di_tg_ctrl|di_tg_ctrl_n|vout.$77.Metal1 1.05314e-05f
Cred_1252 di_tg_ctrl|di_tg_ctrl_n|vin|vout.$205.Metal3 di_tg_ctrl|di_tg_ctrl_n|vout.$79.Metal1 6.24471e-07f
Cred_1253 di_tg_ctrl|di_tg_ctrl_n|vin|vout.$205.Metal3 di_tg_ctrl|di_tg_ctrl_n|vout.$81.Metal1 9.06993e-08f
Cred_1254 di_tg_ctrl|di_tg_ctrl_n|vin|vout.$205.Metal3 di_tg_ctrl|di_tg_ctrl_n|vout.$84.Metal1 3.41624e-07f
Cred_1255 di_tg_ctrl|di_tg_ctrl_n|vin|vout.$205.Metal3 di_tg_ctrl|di_tg_ctrl_n|vout.$86.Metal1 1.97024e-07f
Cred_1256 di_tg_ctrl|di_tg_ctrl_n|vin|vout.$205.Metal3 di_tg_ctrl|di_tg_ctrl_n|vout.P6.GatPoly 2.79948e-07f
Cred_1257 di_tg_ctrl|di_tg_ctrl_n|vin|vout.$205.Metal3 di_tg_ctrl|di_tg_ctrl_n|vout.P8.GatPoly 1.90424e-08f
Cred_1258 di_tg_ctrl|di_tg_ctrl_n|vin|vout.$205.Metal3 di_tg_ctrl|di_tg_ctrl_n|vout.P9.GatPoly 4.13653e-08f
Cred_1259 di_tg_ctrl|di_tg_ctrl_n|vin|vout.$205.Metal3 VSS 7.79569e-06f
Cred_1260 di_tg_ctrl|di_tg_ctrl_n|vin|vout.$205.Metal3 v_a.$182.Metal2 0.00786333f
Cred_1261 di_tg_ctrl|di_tg_ctrl_n|vin|vout.$205.Metal3 v_a.P3.pSD 0.00495854f
Cred_1262 di_tg_ctrl|di_tg_ctrl_n|vin|vout.$205.Metal3 v_a.P5.nSD 2.98973e-05f
Cred_1263 di_tg_ctrl|di_tg_ctrl_n|vin|vout.$205.Metal3 v_a.P5.pSD 0.00625119f
Cred_1264 di_tg_ctrl|di_tg_ctrl_n|vin|vout.$205.Metal3 v_c.$284.Metal2 4.1618e-06f
Cred_1265 di_tg_ctrl|di_tg_ctrl_n|vin|vout.$205.Metal3 v_c.$292.Metal2 0.00713579f
Cred_1266 di_tg_ctrl|di_tg_ctrl_n|vin|vout.$205.Metal3 v_c.$425.Metal3 0.00998556f
Cred_1267 di_tg_ctrl|di_tg_ctrl_n|vin|vout.$205.Metal3 v_c.$446.Metal3 0.000519071f
Cred_1268 di_tg_ctrl|di_tg_ctrl_n|vin|vout.$205.Metal3 v_c.$450.Metal3 0.0521202f
Cred_1269 di_tg_ctrl|di_tg_ctrl_n|vin|vout.$205.Metal3 v_c.$459.Metal3 0.000613332f
Cred_1270 di_tg_ctrl|di_tg_ctrl_n|vin|vout.$205.Metal3 v_c.$95.Metal1 0.00193778f
Cred_1271 di_tg_ctrl|di_tg_ctrl_n|vin|vout.$205.Metal3 v_c.P10.nSD 1.09807e-05f
Cred_1272 di_tg_ctrl|di_tg_ctrl_n|vin|vout.$205.Metal3 v_c.P10.pSD 0.00171841f
Cred_1273 di_tg_ctrl|di_tg_ctrl_n|vin|vout.$205.Metal3 v_c.P8.pSD 0.00243397f
Cred_1274 di_tg_ctrl|di_tg_ctrl_n|vin|vout.$205.Metal3 VDD.$382.Metal1 1.75996e-07f
Cred_1275 di_tg_ctrl|di_tg_ctrl_n|vin|vout.$205.Metal3 VDD.$426.Metal1 0.000136492f
Cred_1276 di_tg_ctrl|di_tg_ctrl_n|vin|vout.$205.Metal3 VDD.$434.Metal1 0.000271017f
Cred_1277 di_tg_ctrl|di_tg_ctrl_n|vin|vout.$205.Metal3 VDD.$438.Metal1 0.000123181f
Cred_1278 di_tg_ctrl|di_tg_ctrl_n|vin|vout.$205.Metal3 VDD.$442.Metal1 0.000242177f
Cred_1279 di_tg_ctrl|di_tg_ctrl_n|vin|vout.$205.Metal3 VDD.$446.Metal1 0.000206387f
Cred_1280 di_tg_ctrl|di_tg_ctrl_n|vin|vout.$205.Metal3 VDD.$477.Metal1 2.42512e-05f
Cred_1281 di_tg_ctrl|di_tg_ctrl_n|vin|vout.$205.Metal3 VDD.$526.Metal1 2.29291e-08f
Cred_1282 di_tg_ctrl|di_tg_ctrl_n|vin|vout.$205.Metal3 VDD.$762.Metal2 2.38042e-05f
Cred_1283 di_tg_ctrl|di_tg_ctrl_n|vin|vout.$205.Metal3 VDD.$766.Metal2 4.77525e-05f
Cred_1284 di_tg_ctrl|di_tg_ctrl_n|vin|vout.$205.Metal3 VDD.$774.Metal2 0.00157078f
Cred_1285 di_tg_ctrl|di_tg_ctrl_n|vin|vout.$205.Metal3 VDD.$782.Metal2 0.000578159f
Cred_1286 di_tg_ctrl|di_tg_ctrl_n|vin|vout.$205.Metal3 VDD.$882.Metal3 0.0028745f
Cred_1287 di_tg_ctrl|di_tg_ctrl_n|vin|vout.$205.Metal3 VDD.$888.Metal3 0.0381884f
Cred_1288 di_tg_ctrl|di_tg_ctrl_n|vin|vout.$205.Metal3 VDD.$892.Metal3 0.0381806f
Cred_1289 di_tg_ctrl|di_tg_ctrl_n|vin|vout.$205.Metal3 VDD.P0.nSD 2.92456e-06f
Cred_1290 di_tg_ctrl|di_tg_ctrl_n|vin|vout.$209.Metal3 di_tg_ctrl|di_tg_ctrl_n|vout.$10.GatPoly 1.9404e-07f
Cred_1291 di_tg_ctrl|di_tg_ctrl_n|vin|vout.$209.Metal3 di_tg_ctrl|di_tg_ctrl_n|vout.$136.Metal2 0.000141439f
Cred_1292 di_tg_ctrl|di_tg_ctrl_n|vin|vout.$209.Metal3 di_tg_ctrl|di_tg_ctrl_n|vout.$186.Metal3 0.00426476f
Cred_1293 di_tg_ctrl|di_tg_ctrl_n|vin|vout.$209.Metal3 di_tg_ctrl|di_tg_ctrl_n|vout.$70.Metal1 7.75661e-06f
Cred_1294 di_tg_ctrl|di_tg_ctrl_n|vin|vout.$209.Metal3 di_tg_ctrl|di_tg_ctrl_n|vout.P5.GatPoly 1.59916e-08f
Cred_1295 di_tg_ctrl|di_tg_ctrl_n|vin|vout.$209.Metal3 VSS 0.00742228f
Cred_1296 di_tg_ctrl|di_tg_ctrl_n|vin|vout.$209.Metal3 v_b 0.000190593f
Cred_1297 di_tg_ctrl|di_tg_ctrl_n|vin|vout.$209.Metal3 v_b.$161.Metal2 0.00957066f
Cred_1298 di_tg_ctrl|di_tg_ctrl_n|vin|vout.$209.Metal3 v_b.$195.Metal2 6.32234e-05f
Cred_1299 di_tg_ctrl|di_tg_ctrl_n|vin|vout.$209.Metal3 v_b.P0.nSD 0.000470565f
Cred_1300 di_tg_ctrl|di_tg_ctrl_n|vin|vout.$209.Metal3 v_b.P0.pSD 0.00014683f
Cred_1301 di_tg_ctrl|di_tg_ctrl_n|vin|vout.$209.Metal3 v_b.P1.nSD 0.000221187f
Cred_1302 di_tg_ctrl|di_tg_ctrl_n|vin|vout.$209.Metal3 v_c.$459.Metal3 0.069722f
Cred_1303 di_tg_ctrl|di_tg_ctrl_n|vin|vout.$209.Metal3 v_c.$476.Metal3 0.00103828f
Cred_1304 di_tg_ctrl|di_tg_ctrl_n|vin|vout.$209.Metal3 v_c.P0.nSD 0.00112891f
Cred_1305 di_tg_ctrl|di_tg_ctrl_n|vin|vout.$209.Metal3 VSS.$211.Metal1 1.94392e-05f
Cred_1306 di_tg_ctrl|di_tg_ctrl_n|vin|vout.$209.Metal3 VSS.$220.Metal1 3.70123e-06f
Cred_1307 di_tg_ctrl|di_tg_ctrl_n|vin|vout.$209.Metal3 VSS.$231.Metal1 3.72125e-05f
Cred_1308 di_tg_ctrl|di_tg_ctrl_n|vin|vout.$209.Metal3 VSS.$241.Metal1 1.47737e-07f
Cred_1309 di_tg_ctrl|di_tg_ctrl_n|vin|vout.$209.Metal3 VSS.$424.Metal2 1.57126e-08f
Cred_1310 di_tg_ctrl|di_tg_ctrl_n|vin|vout.$209.Metal3 VSS.$428.Metal2 0.000158409f
Cred_1311 di_tg_ctrl|di_tg_ctrl_n|vin|vout.$209.Metal3 VSS.$436.Metal2 0.000249459f
Cred_1312 di_tg_ctrl|di_tg_ctrl_n|vin|vout.$209.Metal3 VSS.$440.Metal2 3.19465e-10f
Cred_1313 di_tg_ctrl|di_tg_ctrl_n|vin|vout.$209.Metal3 VSS.$444.Metal2 2.91298e-07f
Cred_1314 di_tg_ctrl|di_tg_ctrl_n|vin|vout.$209.Metal3 VSS.$448.Metal2 1.92911e-07f
Cred_1315 di_tg_ctrl|di_tg_ctrl_n|vin|vout.$209.Metal3 VSS.$452.Metal2 9.60704e-08f
Cred_1316 di_tg_ctrl|di_tg_ctrl_n|vin|vout.$209.Metal3 VSS.$536.Metal3 0.0306419f
Cred_1317 di_tg_ctrl|di_tg_ctrl_n|vin|vout.$209.Metal3 VSS.$540.Metal3 0.0226331f
Cred_1318 di_tg_ctrl|di_tg_ctrl_n|vin|vout.$209.Metal3 VSS.$548.Metal3 1.19822e-05f
Cred_1319 di_tg_ctrl|di_tg_ctrl_n|vin|vout.$209.Metal3 VSS.P0.pSD 8.00053e-07f
Cred_1320 di_tg_ctrl|di_tg_ctrl_n|vin|vout.$21.GatPoly VSS 0.0536731f
Cred_1321 di_tg_ctrl|di_tg_ctrl_n|vin|vout.$21.GatPoly v_b.$161.Metal2 0.00146835f
Cred_1322 di_tg_ctrl|di_tg_ctrl_n|vin|vout.$21.GatPoly v_b.$195.Metal2 0.000128829f
Cred_1323 di_tg_ctrl|di_tg_ctrl_n|vin|vout.$21.GatPoly v_b.P1.nSD 0.00121153f
Cred_1324 di_tg_ctrl|di_tg_ctrl_n|vin|vout.$21.GatPoly v_b.P3.nSD 0.000239032f
Cred_1325 di_tg_ctrl|di_tg_ctrl_n|vin|vout.$21.GatPoly v_b.P3.pSD 4.10004e-06f
Cred_1326 di_tg_ctrl|di_tg_ctrl_n|vin|vout.$21.GatPoly v_c.$459.Metal3 6.88468e-05f
Cred_1327 di_tg_ctrl|di_tg_ctrl_n|vin|vout.$21.GatPoly v_c.$476.Metal3 0.00145095f
Cred_1328 di_tg_ctrl|di_tg_ctrl_n|vin|vout.$21.GatPoly v_c.P0.nSD 0.000112774f
Cred_1329 di_tg_ctrl|di_tg_ctrl_n|vin|vout.$21.GatPoly v_c.P2.nSD 0.00238586f
Cred_1330 di_tg_ctrl|di_tg_ctrl_n|vin|vout.$21.GatPoly VSS.$220.Metal1 6.7461e-06f
Cred_1331 di_tg_ctrl|di_tg_ctrl_n|vin|vout.$21.GatPoly VSS.$231.Metal1 0.000129077f
Cred_1332 di_tg_ctrl|di_tg_ctrl_n|vin|vout.$21.GatPoly VSS.$241.Metal1 0.00341401f
Cred_1333 di_tg_ctrl|di_tg_ctrl_n|vin|vout.$21.GatPoly VSS.$245.Metal1 0.00352667f
Cred_1334 di_tg_ctrl|di_tg_ctrl_n|vin|vout.$21.GatPoly VSS.$255.Metal1 8.28956e-05f
Cred_1335 di_tg_ctrl|di_tg_ctrl_n|vin|vout.$21.GatPoly VSS.$436.Metal2 9.95583e-07f
Cred_1336 di_tg_ctrl|di_tg_ctrl_n|vin|vout.$21.GatPoly VSS.$440.Metal2 2.00125e-06f
Cred_1337 di_tg_ctrl|di_tg_ctrl_n|vin|vout.$21.GatPoly VSS.$444.Metal2 1.35277e-05f
Cred_1338 di_tg_ctrl|di_tg_ctrl_n|vin|vout.$21.GatPoly VSS.$448.Metal2 1.26408e-06f
Cred_1339 di_tg_ctrl|di_tg_ctrl_n|vin|vout.$21.GatPoly VSS.$452.Metal2 6.84304e-07f
Cred_1340 di_tg_ctrl|di_tg_ctrl_n|vin|vout.$21.GatPoly VSS.$548.Metal3 3.98656e-09f
Cred_1341 di_tg_ctrl|di_tg_ctrl_n|vin|vout.$21.GatPoly VSS.P0.pSD 3.94632e-06f
Cred_1342 di_tg_ctrl|di_tg_ctrl_n|vin|vout.$213.Metal3 VSS 0.00492279f
Cred_1343 di_tg_ctrl|di_tg_ctrl_n|vin|vout.$213.Metal3 v_b 0.000194389f
Cred_1344 di_tg_ctrl|di_tg_ctrl_n|vin|vout.$213.Metal3 v_b.$161.Metal2 0.00404556f
Cred_1345 di_tg_ctrl|di_tg_ctrl_n|vin|vout.$213.Metal3 v_b.$195.Metal2 6.44826e-05f
Cred_1346 di_tg_ctrl|di_tg_ctrl_n|vin|vout.$213.Metal3 v_b.P1.nSD 0.000221187f
Cred_1347 di_tg_ctrl|di_tg_ctrl_n|vin|vout.$213.Metal3 v_c.$459.Metal3 0.00571214f
Cred_1348 di_tg_ctrl|di_tg_ctrl_n|vin|vout.$213.Metal3 v_c.$476.Metal3 0.0546794f
Cred_1349 di_tg_ctrl|di_tg_ctrl_n|vin|vout.$213.Metal3 v_c.P0.nSD 5.62298e-05f
Cred_1350 di_tg_ctrl|di_tg_ctrl_n|vin|vout.$213.Metal3 v_c.P2.nSD 0.00090374f
Cred_1351 di_tg_ctrl|di_tg_ctrl_n|vin|vout.$213.Metal3 VSS.$245.Metal1 0.000588661f
Cred_1352 di_tg_ctrl|di_tg_ctrl_n|vin|vout.$213.Metal3 VSS.$436.Metal2 1.95228e-07f
Cred_1353 di_tg_ctrl|di_tg_ctrl_n|vin|vout.$213.Metal3 VSS.$444.Metal2 0.000177513f
Cred_1354 di_tg_ctrl|di_tg_ctrl_n|vin|vout.$213.Metal3 VSS.$448.Metal2 0.000173545f
Cred_1355 di_tg_ctrl|di_tg_ctrl_n|vin|vout.$213.Metal3 VSS.$452.Metal2 8.64262e-05f
Cred_1356 di_tg_ctrl|di_tg_ctrl_n|vin|vout.$213.Metal3 VSS.$536.Metal3 2.43494e-05f
Cred_1357 di_tg_ctrl|di_tg_ctrl_n|vin|vout.$213.Metal3 VSS.$540.Metal3 0.0334004f
Cred_1358 di_tg_ctrl|di_tg_ctrl_n|vin|vout.$213.Metal3 VSS.$548.Metal3 0.0107793f
Cred_1359 di_tg_ctrl|di_tg_ctrl_n|vin|vout.$217.Metal3 VSS 0.015031f
Cred_1360 di_tg_ctrl|di_tg_ctrl_n|vin|vout.$217.Metal3 v_b 0.000911514f
Cred_1361 di_tg_ctrl|di_tg_ctrl_n|vin|vout.$217.Metal3 v_b.$161.Metal2 0.00406825f
Cred_1362 di_tg_ctrl|di_tg_ctrl_n|vin|vout.$217.Metal3 v_b.$195.Metal2 0.0100958f
Cred_1363 di_tg_ctrl|di_tg_ctrl_n|vin|vout.$217.Metal3 v_b.P3.nSD 0.000487623f
Cred_1364 di_tg_ctrl|di_tg_ctrl_n|vin|vout.$217.Metal3 v_b.P3.pSD 0.000129473f
Cred_1365 di_tg_ctrl|di_tg_ctrl_n|vin|vout.$217.Metal3 v_b.P5.nSD 0.00031511f
Cred_1366 di_tg_ctrl|di_tg_ctrl_n|vin|vout.$217.Metal3 v_c.$476.Metal3 0.0186624f
Cred_1367 di_tg_ctrl|di_tg_ctrl_n|vin|vout.$217.Metal3 v_c.$493.Metal3 0.0724585f
Cred_1368 di_tg_ctrl|di_tg_ctrl_n|vin|vout.$217.Metal3 v_c.P2.nSD 0.00028104f
Cred_1369 di_tg_ctrl|di_tg_ctrl_n|vin|vout.$217.Metal3 v_c.P4.nSD 0.00111328f
Cred_1370 di_tg_ctrl|di_tg_ctrl_n|vin|vout.$217.Metal3 VSS.$220.Metal1 1.92665e-06f
Cred_1371 di_tg_ctrl|di_tg_ctrl_n|vin|vout.$217.Metal3 VSS.$245.Metal1 0.000588661f
Cred_1372 di_tg_ctrl|di_tg_ctrl_n|vin|vout.$217.Metal3 VSS.$255.Metal1 8.65168e-05f
Cred_1373 di_tg_ctrl|di_tg_ctrl_n|vin|vout.$217.Metal3 VSS.$444.Metal2 8.67552e-05f
Cred_1374 di_tg_ctrl|di_tg_ctrl_n|vin|vout.$217.Metal3 VSS.$448.Metal2 0.000174206f
Cred_1375 di_tg_ctrl|di_tg_ctrl_n|vin|vout.$217.Metal3 VSS.$452.Metal2 0.000825205f
Cred_1376 di_tg_ctrl|di_tg_ctrl_n|vin|vout.$217.Metal3 VSS.$540.Metal3 0.0108204f
Cred_1377 di_tg_ctrl|di_tg_ctrl_n|vin|vout.$217.Metal3 VSS.$548.Metal3 0.061882f
Cred_1378 di_tg_ctrl|di_tg_ctrl_n|vin|vout.$217.Metal3 VSS.P0.pSD 6.22581e-06f
Cred_1379 di_tg_ctrl|di_tg_ctrl_n|vin|vout.$225.Metal4 di_tg_ctrl|di_tg_ctrl_n|vout.$10.GatPoly 3.47492e-06f
Cred_1380 di_tg_ctrl|di_tg_ctrl_n|vin|vout.$225.Metal4 di_tg_ctrl|di_tg_ctrl_n|vout.$128.Metal2 0.000108323f
Cred_1381 di_tg_ctrl|di_tg_ctrl_n|vin|vout.$225.Metal4 di_tg_ctrl|di_tg_ctrl_n|vout.$130.Metal2 0.000108323f
Cred_1382 di_tg_ctrl|di_tg_ctrl_n|vin|vout.$225.Metal4 di_tg_ctrl|di_tg_ctrl_n|vout.$134.Metal2 0.000108323f
Cred_1383 di_tg_ctrl|di_tg_ctrl_n|vin|vout.$225.Metal4 di_tg_ctrl|di_tg_ctrl_n|vout.$136.Metal2 0.00264125f
Cred_1384 di_tg_ctrl|di_tg_ctrl_n|vin|vout.$225.Metal4 di_tg_ctrl|di_tg_ctrl_n|vout.$180.Metal3 0.052383f
Cred_1385 di_tg_ctrl|di_tg_ctrl_n|vin|vout.$225.Metal4 di_tg_ctrl|di_tg_ctrl_n|vout.$183.Metal3 0.0163207f
Cred_1386 di_tg_ctrl|di_tg_ctrl_n|vin|vout.$225.Metal4 di_tg_ctrl|di_tg_ctrl_n|vout.$186.Metal3 0.0272957f
Cred_1387 di_tg_ctrl|di_tg_ctrl_n|vin|vout.$225.Metal4 di_tg_ctrl|di_tg_ctrl_n|vout.$206.Metal4 0.00474497f
Cred_1388 di_tg_ctrl|di_tg_ctrl_n|vin|vout.$225.Metal4 di_tg_ctrl|di_tg_ctrl_n|vout.$70.Metal1 0.000138908f
Cred_1389 di_tg_ctrl|di_tg_ctrl_n|vin|vout.$225.Metal4 di_tg_ctrl|di_tg_ctrl_n|vout.P0.nSD 0.00395377f
Cred_1390 di_tg_ctrl|di_tg_ctrl_n|vin|vout.$225.Metal4 di_tg_ctrl|di_tg_ctrl_n|vout.P0.pSD 0.0218379f
Cred_1391 di_tg_ctrl|di_tg_ctrl_n|vin|vout.$225.Metal4 di_tg_ctrl|di_tg_ctrl_n|vout.P5.GatPoly 2.86382e-07f
Cred_1392 di_tg_ctrl|di_tg_ctrl_n|vin|vout.$225.Metal4 VSS 0.262888f
Cred_1393 di_tg_ctrl|di_tg_ctrl_n|vin|vout.$225.Metal4 v_a 0.0895393f
Cred_1394 di_tg_ctrl|di_tg_ctrl_n|vin|vout.$225.Metal4 v_a.$148.Metal2 0.0178275f
Cred_1395 di_tg_ctrl|di_tg_ctrl_n|vin|vout.$225.Metal4 v_a.$182.Metal2 0.0139918f
Cred_1396 di_tg_ctrl|di_tg_ctrl_n|vin|vout.$225.Metal4 v_a.P0.nSD 4.79877e-05f
Cred_1397 di_tg_ctrl|di_tg_ctrl_n|vin|vout.$225.Metal4 v_a.P1.nSD 0.000580841f
Cred_1398 di_tg_ctrl|di_tg_ctrl_n|vin|vout.$225.Metal4 v_a.P1.pSD 0.000154225f
Cred_1399 di_tg_ctrl|di_tg_ctrl_n|vin|vout.$225.Metal4 v_a.P3.nSD 0.000260334f
Cred_1400 di_tg_ctrl|di_tg_ctrl_n|vin|vout.$225.Metal4 v_a.P5.nSD 0.000372742f
Cred_1401 di_tg_ctrl|di_tg_ctrl_n|vin|vout.$225.Metal4 v_a.P5.pSD 0.000116512f
Cred_1402 di_tg_ctrl|di_tg_ctrl_n|vin|vout.$225.Metal4 v_b 0.0782369f
Cred_1403 di_tg_ctrl|di_tg_ctrl_n|vin|vout.$225.Metal4 v_b.$161.Metal2 0.0057805f
Cred_1404 di_tg_ctrl|di_tg_ctrl_n|vin|vout.$225.Metal4 v_b.$195.Metal2 0.0180949f
Cred_1405 di_tg_ctrl|di_tg_ctrl_n|vin|vout.$225.Metal4 v_b.P0.nSD 0.000329769f
Cred_1406 di_tg_ctrl|di_tg_ctrl_n|vin|vout.$225.Metal4 v_b.P0.pSD 0.000103075f
Cred_1407 di_tg_ctrl|di_tg_ctrl_n|vin|vout.$225.Metal4 v_b.P1.nSD 0.000103983f
Cred_1408 di_tg_ctrl|di_tg_ctrl_n|vin|vout.$225.Metal4 v_c.$220.Metal2 2.25157e-05f
Cred_1409 di_tg_ctrl|di_tg_ctrl_n|vin|vout.$225.Metal4 v_c.$284.Metal2 3.3316e-05f
Cred_1410 di_tg_ctrl|di_tg_ctrl_n|vin|vout.$225.Metal4 v_c.$411.Metal3 0.00280822f
Cred_1411 di_tg_ctrl|di_tg_ctrl_n|vin|vout.$225.Metal4 v_c.$425.Metal3 0.0517509f
Cred_1412 di_tg_ctrl|di_tg_ctrl_n|vin|vout.$225.Metal4 v_c.$446.Metal3 0.00415527f
Cred_1413 di_tg_ctrl|di_tg_ctrl_n|vin|vout.$225.Metal4 v_c.$459.Metal3 0.024556f
Cred_1414 di_tg_ctrl|di_tg_ctrl_n|vin|vout.$225.Metal4 v_c.$476.Metal3 0.00232707f
Cred_1415 di_tg_ctrl|di_tg_ctrl_n|vin|vout.$225.Metal4 v_c.P0.nSD 2.31019e-06f
Cred_1416 di_tg_ctrl|di_tg_ctrl_n|vin|vout.$225.Metal4 v_c.P10.nSD 8.79028e-05f
Cred_1417 di_tg_ctrl|di_tg_ctrl_n|vin|vout.$225.Metal4 v_c.P6.nSD 7.56322e-05f
Cred_1418 di_tg_ctrl|di_tg_ctrl_n|vin|vout.$225.Metal4 VDD.$100.Metal1 0.00221525f
Cred_1419 di_tg_ctrl|di_tg_ctrl_n|vin|vout.$225.Metal4 VDD.$102.Metal1 0.00369687f
Cred_1420 di_tg_ctrl|di_tg_ctrl_n|vin|vout.$225.Metal4 VDD.$105.Metal1 0.000287853f
Cred_1421 di_tg_ctrl|di_tg_ctrl_n|vin|vout.$225.Metal4 VDD.$113.Metal1 0.000287877f
Cred_1422 di_tg_ctrl|di_tg_ctrl_n|vin|vout.$225.Metal4 VDD.$125.Metal1 0.00532361f
Cred_1423 di_tg_ctrl|di_tg_ctrl_n|vin|vout.$225.Metal4 VDD.$131.Metal1 0.00385875f
Cred_1424 di_tg_ctrl|di_tg_ctrl_n|vin|vout.$225.Metal4 VDD.$133.Metal1 0.0023355f
Cred_1425 di_tg_ctrl|di_tg_ctrl_n|vin|vout.$225.Metal4 VDD.$135.Metal1 0.00232886f
Cred_1426 di_tg_ctrl|di_tg_ctrl_n|vin|vout.$225.Metal4 VDD.$137.Metal1 0.00232003f
Cred_1427 di_tg_ctrl|di_tg_ctrl_n|vin|vout.$225.Metal4 VDD.$139.Metal1 0.00232606f
Cred_1428 di_tg_ctrl|di_tg_ctrl_n|vin|vout.$225.Metal4 VDD.$215.Metal1 0.000376816f
Cred_1429 di_tg_ctrl|di_tg_ctrl_n|vin|vout.$225.Metal4 VDD.$218.Metal1 2.70896e-06f
Cred_1430 di_tg_ctrl|di_tg_ctrl_n|vin|vout.$225.Metal4 VDD.$257.Metal1 1.05728e-07f
Cred_1431 di_tg_ctrl|di_tg_ctrl_n|vin|vout.$225.Metal4 VDD.$29.Metal1 0.00023851f
Cred_1432 di_tg_ctrl|di_tg_ctrl_n|vin|vout.$225.Metal4 VDD.$382.Metal1 0.00171151f
Cred_1433 di_tg_ctrl|di_tg_ctrl_n|vin|vout.$225.Metal4 VDD.$477.Metal1 0.000382366f
Cred_1434 di_tg_ctrl|di_tg_ctrl_n|vin|vout.$225.Metal4 VDD.$51.Metal1 5.3988e-05f
Cred_1435 di_tg_ctrl|di_tg_ctrl_n|vin|vout.$225.Metal4 VDD.$526.Metal1 8.21359e-05f
Cred_1436 di_tg_ctrl|di_tg_ctrl_n|vin|vout.$225.Metal4 VDD.$552.Metal2 3.6842e-05f
Cred_1437 di_tg_ctrl|di_tg_ctrl_n|vin|vout.$225.Metal4 VDD.$562.Metal2 0.0136739f
Cred_1438 di_tg_ctrl|di_tg_ctrl_n|vin|vout.$225.Metal4 VDD.$563.Metal2 0.00394573f
Cred_1439 di_tg_ctrl|di_tg_ctrl_n|vin|vout.$225.Metal4 VDD.$564.Metal2 0.00391611f
Cred_1440 di_tg_ctrl|di_tg_ctrl_n|vin|vout.$225.Metal4 VDD.$565.Metal2 0.00387295f
Cred_1441 di_tg_ctrl|di_tg_ctrl_n|vin|vout.$225.Metal4 VDD.$566.Metal2 0.00384205f
Cred_1442 di_tg_ctrl|di_tg_ctrl_n|vin|vout.$225.Metal4 VDD.$567.Metal2 0.0038106f
Cred_1443 di_tg_ctrl|di_tg_ctrl_n|vin|vout.$225.Metal4 VDD.$568.Metal2 0.00377904f
Cred_1444 di_tg_ctrl|di_tg_ctrl_n|vin|vout.$225.Metal4 VDD.$569.Metal2 0.00376141f
Cred_1445 di_tg_ctrl|di_tg_ctrl_n|vin|vout.$225.Metal4 VDD.$570.Metal2 0.00373181f
Cred_1446 di_tg_ctrl|di_tg_ctrl_n|vin|vout.$225.Metal4 VDD.$571.Metal2 0.00372751f
Cred_1447 di_tg_ctrl|di_tg_ctrl_n|vin|vout.$225.Metal4 VDD.$572.Metal2 0.00372332f
Cred_1448 di_tg_ctrl|di_tg_ctrl_n|vin|vout.$225.Metal4 VDD.$573.Metal2 0.00510833f
Cred_1449 di_tg_ctrl|di_tg_ctrl_n|vin|vout.$225.Metal4 VDD.$597.Metal2 0.000670719f
Cred_1450 di_tg_ctrl|di_tg_ctrl_n|vin|vout.$225.Metal4 VDD.$606.Metal2 0.0121839f
Cred_1451 di_tg_ctrl|di_tg_ctrl_n|vin|vout.$225.Metal4 VDD.$607.Metal2 0.00758646f
Cred_1452 di_tg_ctrl|di_tg_ctrl_n|vin|vout.$225.Metal4 VDD.$608.Metal2 0.00731878f
Cred_1453 di_tg_ctrl|di_tg_ctrl_n|vin|vout.$225.Metal4 VDD.$609.Metal2 0.00711927f
Cred_1454 di_tg_ctrl|di_tg_ctrl_n|vin|vout.$225.Metal4 VDD.$610.Metal2 0.00702699f
Cred_1455 di_tg_ctrl|di_tg_ctrl_n|vin|vout.$225.Metal4 VDD.$611.Metal2 0.00692752f
Cred_1456 di_tg_ctrl|di_tg_ctrl_n|vin|vout.$225.Metal4 VDD.$612.Metal2 0.00694811f
Cred_1457 di_tg_ctrl|di_tg_ctrl_n|vin|vout.$225.Metal4 VDD.$613.Metal2 0.0122146f
Cred_1458 di_tg_ctrl|di_tg_ctrl_n|vin|vout.$225.Metal4 VDD.$614.Metal2 0.00965492f
Cred_1459 di_tg_ctrl|di_tg_ctrl_n|vin|vout.$225.Metal4 VDD.$615.Metal2 0.00666042f
Cred_1460 di_tg_ctrl|di_tg_ctrl_n|vin|vout.$225.Metal4 VDD.$616.Metal2 0.00660581f
Cred_1461 di_tg_ctrl|di_tg_ctrl_n|vin|vout.$225.Metal4 VDD.$617.Metal2 0.00665812f
Cred_1462 di_tg_ctrl|di_tg_ctrl_n|vin|vout.$225.Metal4 VDD.$618.Metal2 0.0066937f
Cred_1463 di_tg_ctrl|di_tg_ctrl_n|vin|vout.$225.Metal4 VDD.$619.Metal2 0.00963032f
Cred_1464 di_tg_ctrl|di_tg_ctrl_n|vin|vout.$225.Metal4 VDD.$620.Metal2 0.00469765f
Cred_1465 di_tg_ctrl|di_tg_ctrl_n|vin|vout.$225.Metal4 VDD.$621.Metal2 6.14168e-06f
Cred_1466 di_tg_ctrl|di_tg_ctrl_n|vin|vout.$225.Metal4 VDD.$643.Metal2 0.000582534f
Cred_1467 di_tg_ctrl|di_tg_ctrl_n|vin|vout.$225.Metal4 VDD.$651.Metal2 0.00077257f
Cred_1468 di_tg_ctrl|di_tg_ctrl_n|vin|vout.$225.Metal4 VDD.$688.Metal2 2.86755e-05f
Cred_1469 di_tg_ctrl|di_tg_ctrl_n|vin|vout.$225.Metal4 VDD.$844.Metal3 0.00116361f
Cred_1470 di_tg_ctrl|di_tg_ctrl_n|vin|vout.$225.Metal4 VDD.$852.Metal3 0.000710209f
Cred_1471 di_tg_ctrl|di_tg_ctrl_n|vin|vout.$225.Metal4 VDD.$856.Metal3 0.00582666f
Cred_1472 di_tg_ctrl|di_tg_ctrl_n|vin|vout.$225.Metal4 VDD.$864.Metal3 0.00193181f
Cred_1473 di_tg_ctrl|di_tg_ctrl_n|vin|vout.$225.Metal4 VDD.$90.Metal1 0.00367267f
Cred_1474 di_tg_ctrl|di_tg_ctrl_n|vin|vout.$225.Metal4 VDD.$92.Metal1 0.0021902f
Cred_1475 di_tg_ctrl|di_tg_ctrl_n|vin|vout.$225.Metal4 VDD.$94.Metal1 0.00218397f
Cred_1476 di_tg_ctrl|di_tg_ctrl_n|vin|vout.$225.Metal4 VDD.$96.Metal1 0.0021757f
Cred_1477 di_tg_ctrl|di_tg_ctrl_n|vin|vout.$225.Metal4 VDD.$98.Metal1 0.0021669f
Cred_1478 di_tg_ctrl|di_tg_ctrl_n|vin|vout.$225.Metal4 VDD.P0.GatPoly 9.63229e-09f
Cred_1479 di_tg_ctrl|di_tg_ctrl_n|vin|vout.$225.Metal4 VDD.P0.nSD 0.00564324f
Cred_1480 di_tg_ctrl|di_tg_ctrl_n|vin|vout.$225.Metal4 VDD.P0.pSD 1.03226e-06f
Cred_1481 di_tg_ctrl|di_tg_ctrl_n|vin|vout.$225.Metal4 VDD.P1.pSD 0.000146186f
Cred_1482 di_tg_ctrl|di_tg_ctrl_n|vin|vout.$225.Metal4 VDD.P3.pSD 0.000583088f
Cred_1483 di_tg_ctrl|di_tg_ctrl_n|vin|vout.$225.Metal4 VSS.$129.Metal1 4.53759e-05f
Cred_1484 di_tg_ctrl|di_tg_ctrl_n|vin|vout.$225.Metal4 VSS.$132.Metal1 1.63251e-05f
Cred_1485 di_tg_ctrl|di_tg_ctrl_n|vin|vout.$225.Metal4 VSS.$156.Metal1 7.4823e-06f
Cred_1486 di_tg_ctrl|di_tg_ctrl_n|vin|vout.$225.Metal4 VSS.$175.Metal1 3.12551e-07f
Cred_1487 di_tg_ctrl|di_tg_ctrl_n|vin|vout.$225.Metal4 VSS.$181.Metal1 0.00115299f
Cred_1488 di_tg_ctrl|di_tg_ctrl_n|vin|vout.$225.Metal4 VSS.$185.Metal1 0.00115299f
Cred_1489 di_tg_ctrl|di_tg_ctrl_n|vin|vout.$225.Metal4 VSS.$199.Metal1 3.50212e-07f
Cred_1490 di_tg_ctrl|di_tg_ctrl_n|vin|vout.$225.Metal4 VSS.$211.Metal1 0.00475439f
Cred_1491 di_tg_ctrl|di_tg_ctrl_n|vin|vout.$225.Metal4 VSS.$220.Metal1 0.0042607f
Cred_1492 di_tg_ctrl|di_tg_ctrl_n|vin|vout.$225.Metal4 VSS.$231.Metal1 7.45904e-07f
Cred_1493 di_tg_ctrl|di_tg_ctrl_n|vin|vout.$225.Metal4 VSS.$241.Metal1 2.9613e-09f
Cred_1494 di_tg_ctrl|di_tg_ctrl_n|vin|vout.$225.Metal4 VSS.$284.Metal2 0.0178093f
Cred_1495 di_tg_ctrl|di_tg_ctrl_n|vin|vout.$225.Metal4 VSS.$303.Metal2 0.000604344f
Cred_1496 di_tg_ctrl|di_tg_ctrl_n|vin|vout.$225.Metal4 VSS.$307.Metal2 8.31796e-06f
Cred_1497 di_tg_ctrl|di_tg_ctrl_n|vin|vout.$225.Metal4 VSS.$311.Metal2 0.0936194f
Cred_1498 di_tg_ctrl|di_tg_ctrl_n|vin|vout.$225.Metal4 VSS.$321.Metal2 2.2056e-06f
Cred_1499 di_tg_ctrl|di_tg_ctrl_n|vin|vout.$225.Metal4 VSS.$329.Metal2 0.000674894f
Cred_1500 di_tg_ctrl|di_tg_ctrl_n|vin|vout.$225.Metal4 VSS.$33.Metal1 0.0045401f
Cred_1501 di_tg_ctrl|di_tg_ctrl_n|vin|vout.$225.Metal4 VSS.$339.Metal2 0.000643252f
Cred_1502 di_tg_ctrl|di_tg_ctrl_n|vin|vout.$225.Metal4 VSS.$350.Metal2 2.95982e-05f
Cred_1503 di_tg_ctrl|di_tg_ctrl_n|vin|vout.$225.Metal4 VSS.$354.Metal2 2.94517e-05f
Cred_1504 di_tg_ctrl|di_tg_ctrl_n|vin|vout.$225.Metal4 VSS.$359.Metal2 0.0228664f
Cred_1505 di_tg_ctrl|di_tg_ctrl_n|vin|vout.$225.Metal4 VSS.$368.Metal2 0.00704285f
Cred_1506 di_tg_ctrl|di_tg_ctrl_n|vin|vout.$225.Metal4 VSS.$372.Metal2 0.00127099f
Cred_1507 di_tg_ctrl|di_tg_ctrl_n|vin|vout.$225.Metal4 VSS.$376.Metal2 0.00117221f
Cred_1508 di_tg_ctrl|di_tg_ctrl_n|vin|vout.$225.Metal4 VSS.$384.Metal2 9.57929e-05f
Cred_1509 di_tg_ctrl|di_tg_ctrl_n|vin|vout.$225.Metal4 VSS.$392.Metal2 9.86848e-05f
Cred_1510 di_tg_ctrl|di_tg_ctrl_n|vin|vout.$225.Metal4 VSS.$400.Metal2 2.05645e-05f
Cred_1511 di_tg_ctrl|di_tg_ctrl_n|vin|vout.$225.Metal4 VSS.$408.Metal2 0.000108098f
Cred_1512 di_tg_ctrl|di_tg_ctrl_n|vin|vout.$225.Metal4 VSS.$416.Metal2 0.000113269f
Cred_1513 di_tg_ctrl|di_tg_ctrl_n|vin|vout.$225.Metal4 VSS.$42.Metal1 0.000208983f
Cred_1514 di_tg_ctrl|di_tg_ctrl_n|vin|vout.$225.Metal4 VSS.$424.Metal2 7.11766e-05f
Cred_1515 di_tg_ctrl|di_tg_ctrl_n|vin|vout.$225.Metal4 VSS.$428.Metal2 6.43572e-05f
Cred_1516 di_tg_ctrl|di_tg_ctrl_n|vin|vout.$225.Metal4 VSS.$436.Metal2 1.82486e-05f
Cred_1517 di_tg_ctrl|di_tg_ctrl_n|vin|vout.$225.Metal4 VSS.$440.Metal2 6.4035e-12f
Cred_1518 di_tg_ctrl|di_tg_ctrl_n|vin|vout.$225.Metal4 VSS.$444.Metal2 7.30218e-06f
Cred_1519 di_tg_ctrl|di_tg_ctrl_n|vin|vout.$225.Metal4 VSS.$448.Metal2 4.83584e-06f
Cred_1520 di_tg_ctrl|di_tg_ctrl_n|vin|vout.$225.Metal4 VSS.$452.Metal2 2.40826e-06f
Cred_1521 di_tg_ctrl|di_tg_ctrl_n|vin|vout.$225.Metal4 VSS.$478.Metal3 0.00135632f
Cred_1522 di_tg_ctrl|di_tg_ctrl_n|vin|vout.$225.Metal4 VSS.$484.Metal3 0.00180343f
Cred_1523 di_tg_ctrl|di_tg_ctrl_n|vin|vout.$225.Metal4 VSS.$488.Metal3 0.00881276f
Cred_1524 di_tg_ctrl|di_tg_ctrl_n|vin|vout.$225.Metal4 VSS.$496.Metal3 0.0150745f
Cred_1525 di_tg_ctrl|di_tg_ctrl_n|vin|vout.$225.Metal4 VSS.$5.Metal1 6.02651e-05f
Cred_1526 di_tg_ctrl|di_tg_ctrl_n|vin|vout.$225.Metal4 VSS.$502.Metal3 0.0137711f
Cred_1527 di_tg_ctrl|di_tg_ctrl_n|vin|vout.$225.Metal4 VSS.$510.Metal3 0.0159158f
Cred_1528 di_tg_ctrl|di_tg_ctrl_n|vin|vout.$225.Metal4 VSS.$518.Metal3 0.0151614f
Cred_1529 di_tg_ctrl|di_tg_ctrl_n|vin|vout.$225.Metal4 VSS.$522.Metal3 0.0157496f
Cred_1530 di_tg_ctrl|di_tg_ctrl_n|vin|vout.$225.Metal4 VSS.$530.Metal3 0.0361129f
Cred_1531 di_tg_ctrl|di_tg_ctrl_n|vin|vout.$225.Metal4 VSS.$536.Metal3 0.0152372f
Cred_1532 di_tg_ctrl|di_tg_ctrl_n|vin|vout.$225.Metal4 VSS.$540.Metal3 0.00537401f
Cred_1533 di_tg_ctrl|di_tg_ctrl_n|vin|vout.$225.Metal4 VSS.$548.Metal3 0.000300366f
Cred_1534 di_tg_ctrl|di_tg_ctrl_n|vin|vout.$225.Metal4 VSS.$61.Metal1 0.00010396f
Cred_1535 di_tg_ctrl|di_tg_ctrl_n|vin|vout.$225.Metal4 VSS.$78.Metal1 0.00542017f
Cred_1536 di_tg_ctrl|di_tg_ctrl_n|vin|vout.$225.Metal4 VSS.$87.Metal1 0.00280861f
Cred_1537 di_tg_ctrl|di_tg_ctrl_n|vin|vout.$225.Metal4 VSS.$94.Metal1 4.67663e-06f
Cred_1538 di_tg_ctrl|di_tg_ctrl_n|vin|vout.$225.Metal4 VSS.P0.nSD 3.48424e-05f
Cred_1539 di_tg_ctrl|di_tg_ctrl_n|vin|vout.$225.Metal4 VSS.P0.pSD 0.000891305f
Cred_1540 di_tg_ctrl|di_tg_ctrl_n|vin|vout.$225.Metal4 VSS.P1.GatPoly 5.47688e-06f
Cred_1541 di_tg_ctrl|di_tg_ctrl_n|vin|vout.$225.Metal4 VSS.P1.nSD 3.48424e-05f
Cred_1542 di_tg_ctrl|di_tg_ctrl_n|vin|vout.$225.Metal4 VSS.P2.GatPoly 1.43074e-06f
Cred_1543 di_tg_ctrl|di_tg_ctrl_n|vin|vout.$225.Metal4 VSS.P3.nSD 5.903e-05f
Cred_1544 di_tg_ctrl|di_tg_ctrl_n|vin|vout.$225.Metal4 VSS.P5.nSD 4.03562e-05f
Cred_1545 di_tg_ctrl|di_tg_ctrl_n|vin|vout.$225.Metal4 VSS.P6.nSD 1.12785e-05f
Cred_1546 di_tg_ctrl|di_tg_ctrl_n|vin|vout.$225.Metal4 VSS.P7.nSD 1.41951e-05f
Cred_1547 di_tg_ctrl|di_tg_ctrl_n|vin|vout.$229.Metal4 VSS 0.0552815f
Cred_1548 di_tg_ctrl|di_tg_ctrl_n|vin|vout.$229.Metal4 v_b 0.0205452f
Cred_1549 di_tg_ctrl|di_tg_ctrl_n|vin|vout.$229.Metal4 v_b.$161.Metal2 0.00370033f
Cred_1550 di_tg_ctrl|di_tg_ctrl_n|vin|vout.$229.Metal4 v_b.$195.Metal2 0.011533f
Cred_1551 di_tg_ctrl|di_tg_ctrl_n|vin|vout.$229.Metal4 v_b.P1.nSD 0.000103983f
Cred_1552 di_tg_ctrl|di_tg_ctrl_n|vin|vout.$229.Metal4 v_b.P3.nSD 0.000215563f
Cred_1553 di_tg_ctrl|di_tg_ctrl_n|vin|vout.$229.Metal4 v_b.P3.pSD 5.72363e-05f
Cred_1554 di_tg_ctrl|di_tg_ctrl_n|vin|vout.$229.Metal4 v_b.P5.nSD 0.000159728f
Cred_1555 di_tg_ctrl|di_tg_ctrl_n|vin|vout.$229.Metal4 v_c.$459.Metal3 0.00525916f
Cred_1556 di_tg_ctrl|di_tg_ctrl_n|vin|vout.$229.Metal4 v_c.$476.Metal3 0.0191977f
Cred_1557 di_tg_ctrl|di_tg_ctrl_n|vin|vout.$229.Metal4 v_c.$493.Metal3 0.0220484f
Cred_1558 di_tg_ctrl|di_tg_ctrl_n|vin|vout.$229.Metal4 v_c.P0.nSD 5.41617e-07f
Cred_1559 di_tg_ctrl|di_tg_ctrl_n|vin|vout.$229.Metal4 v_c.P2.nSD 5.6333e-06f
Cred_1560 di_tg_ctrl|di_tg_ctrl_n|vin|vout.$229.Metal4 v_c.P4.nSD 3.69296e-05f
Cred_1561 di_tg_ctrl|di_tg_ctrl_n|vin|vout.$229.Metal4 VSS.$220.Metal1 1.61895e-07f
Cred_1562 di_tg_ctrl|di_tg_ctrl_n|vin|vout.$229.Metal4 VSS.$245.Metal1 1.17994e-05f
Cred_1563 di_tg_ctrl|di_tg_ctrl_n|vin|vout.$229.Metal4 VSS.$255.Metal1 9.84972e-06f
Cred_1564 di_tg_ctrl|di_tg_ctrl_n|vin|vout.$229.Metal4 VSS.$436.Metal2 4.89392e-06f
Cred_1565 di_tg_ctrl|di_tg_ctrl_n|vin|vout.$229.Metal4 VSS.$444.Metal2 5.32242e-05f
Cred_1566 di_tg_ctrl|di_tg_ctrl_n|vin|vout.$229.Metal4 VSS.$448.Metal2 7.6606e-05f
Cred_1567 di_tg_ctrl|di_tg_ctrl_n|vin|vout.$229.Metal4 VSS.$452.Metal2 0.000172772f
Cred_1568 di_tg_ctrl|di_tg_ctrl_n|vin|vout.$229.Metal4 VSS.$536.Metal3 0.000610383f
Cred_1569 di_tg_ctrl|di_tg_ctrl_n|vin|vout.$229.Metal4 VSS.$540.Metal3 0.00983183f
Cred_1570 di_tg_ctrl|di_tg_ctrl_n|vin|vout.$229.Metal4 VSS.$548.Metal3 0.0174399f
Cred_1571 di_tg_ctrl|di_tg_ctrl_n|vin|vout.$229.Metal4 VSS.P0.pSD 5.61416e-07f
Cred_1572 di_tg_ctrl|di_tg_ctrl_n|vin|vout.$24.GatPoly VSS 0.0406782f
Cred_1573 di_tg_ctrl|di_tg_ctrl_n|vin|vout.$24.GatPoly v_b.$161.Metal2 0.000963153f
Cred_1574 di_tg_ctrl|di_tg_ctrl_n|vin|vout.$24.GatPoly v_b.$195.Metal2 0.000963153f
Cred_1575 di_tg_ctrl|di_tg_ctrl_n|vin|vout.$24.GatPoly v_b.P3.nSD 0.00178374f
Cred_1576 di_tg_ctrl|di_tg_ctrl_n|vin|vout.$24.GatPoly v_b.P3.pSD 3.06527e-05f
Cred_1577 di_tg_ctrl|di_tg_ctrl_n|vin|vout.$24.GatPoly v_c.$476.Metal3 0.00053929f
Cred_1578 di_tg_ctrl|di_tg_ctrl_n|vin|vout.$24.GatPoly v_c.$493.Metal3 0.000183044f
Cred_1579 di_tg_ctrl|di_tg_ctrl_n|vin|vout.$24.GatPoly v_c.P2.nSD 0.000882845f
Cred_1580 di_tg_ctrl|di_tg_ctrl_n|vin|vout.$24.GatPoly v_c.P4.nSD 0.000299834f
Cred_1581 di_tg_ctrl|di_tg_ctrl_n|vin|vout.$24.GatPoly VSS.$245.Metal1 0.00276091f
Cred_1582 di_tg_ctrl|di_tg_ctrl_n|vin|vout.$24.GatPoly VSS.$255.Metal1 0.00155014f
Cred_1583 di_tg_ctrl|di_tg_ctrl_n|vin|vout.$24.GatPoly VSS.$448.Metal2 2.33615e-06f
Cred_1584 di_tg_ctrl|di_tg_ctrl_n|vin|vout.$24.GatPoly VSS.$452.Metal2 1.19567e-05f
Cred_1585 di_tg_ctrl|di_tg_ctrl_n|vin|vout.$24.GatPoly VSS.P0.pSD 3.87709e-06f
Cred_1586 di_tg_ctrl|di_tg_ctrl_n|vin|vout.$26.GatPoly VSS 0.0591836f
Cred_1587 di_tg_ctrl|di_tg_ctrl_n|vin|vout.$26.GatPoly v_b.$161.Metal2 0.000343475f
Cred_1588 di_tg_ctrl|di_tg_ctrl_n|vin|vout.$26.GatPoly v_b.$195.Metal2 0.000343475f
Cred_1589 di_tg_ctrl|di_tg_ctrl_n|vin|vout.$26.GatPoly v_b.P3.nSD 0.00064328f
Cred_1590 di_tg_ctrl|di_tg_ctrl_n|vin|vout.$26.GatPoly v_b.P3.pSD 1.09312e-05f
Cred_1591 di_tg_ctrl|di_tg_ctrl_n|vin|vout.$26.GatPoly v_c.$493.Metal3 0.00165121f
Cred_1592 di_tg_ctrl|di_tg_ctrl_n|vin|vout.$26.GatPoly v_c.P4.nSD 0.00270056f
Cred_1593 di_tg_ctrl|di_tg_ctrl_n|vin|vout.$26.GatPoly VSS.$220.Metal1 9.33196e-06f
Cred_1594 di_tg_ctrl|di_tg_ctrl_n|vin|vout.$26.GatPoly VSS.$245.Metal1 0.000692097f
Cred_1595 di_tg_ctrl|di_tg_ctrl_n|vin|vout.$26.GatPoly VSS.$255.Metal1 0.00516139f
Cred_1596 di_tg_ctrl|di_tg_ctrl_n|vin|vout.$26.GatPoly VSS.$448.Metal2 5.8562e-07f
Cred_1597 di_tg_ctrl|di_tg_ctrl_n|vin|vout.$26.GatPoly VSS.$452.Metal2 1.8378e-05f
Cred_1598 di_tg_ctrl|di_tg_ctrl_n|vin|vout.$26.GatPoly VSS.$548.Metal3 8.3973e-07f
Cred_1599 di_tg_ctrl|di_tg_ctrl_n|vin|vout.$26.GatPoly VSS.P0.pSD 2.20304e-05f
Cred_1600 di_tg_ctrl|di_tg_ctrl_n|vin|vout.$4.GatPoly di_tg_ctrl|di_tg_ctrl_n|vout.$180.Metal3 7.06328e-09f
Cred_1601 di_tg_ctrl|di_tg_ctrl_n|vin|vout.$4.GatPoly di_tg_ctrl|di_tg_ctrl_n|vout.$206.Metal4 2.08263e-08f
Cred_1602 di_tg_ctrl|di_tg_ctrl_n|vin|vout.$4.GatPoly di_tg_ctrl|di_tg_ctrl_n|vout.P0.nSD 8.11523e-10f
Cred_1603 di_tg_ctrl|di_tg_ctrl_n|vin|vout.$4.GatPoly di_tg_ctrl|di_tg_ctrl_n|vout.P0.pSD 4.21256e-09f
Cred_1604 di_tg_ctrl|di_tg_ctrl_n|vin|vout.$4.GatPoly VSS 0.00701549f
Cred_1605 di_tg_ctrl|di_tg_ctrl_n|vin|vout.$4.GatPoly v_a 1.52694e-09f
Cred_1606 di_tg_ctrl|di_tg_ctrl_n|vin|vout.$4.GatPoly v_a.$148.Metal2 0.00294758f
Cred_1607 di_tg_ctrl|di_tg_ctrl_n|vin|vout.$4.GatPoly v_a.$182.Metal2 5.72102e-09f
Cred_1608 di_tg_ctrl|di_tg_ctrl_n|vin|vout.$4.GatPoly v_a.P0.pSD 0.00580997f
Cred_1609 di_tg_ctrl|di_tg_ctrl_n|vin|vout.$4.GatPoly v_a.P1.nSD 4.75855e-11f
Cred_1610 di_tg_ctrl|di_tg_ctrl_n|vin|vout.$4.GatPoly v_a.P1.pSD 1.31146e-08f
Cred_1611 di_tg_ctrl|di_tg_ctrl_n|vin|vout.$4.GatPoly v_c.$220.Metal2 5.22933e-12f
Cred_1612 di_tg_ctrl|di_tg_ctrl_n|vin|vout.$4.GatPoly v_c.$228.Metal2 0.00245722f
Cred_1613 di_tg_ctrl|di_tg_ctrl_n|vin|vout.$4.GatPoly v_c.$23.Metal1 0.0034715f
Cred_1614 di_tg_ctrl|di_tg_ctrl_n|vin|vout.$4.GatPoly v_c.$411.Metal3 6.52217e-10f
Cred_1615 di_tg_ctrl|di_tg_ctrl_n|vin|vout.$4.GatPoly v_c.$415.Metal3 0.0023251f
Cred_1616 di_tg_ctrl|di_tg_ctrl_n|vin|vout.$4.GatPoly v_c.$425.Metal3 3.89642e-09f
Cred_1617 di_tg_ctrl|di_tg_ctrl_n|vin|vout.$4.GatPoly v_c.P6.nSD 1.75658e-11f
Cred_1618 di_tg_ctrl|di_tg_ctrl_n|vin|vout.$4.GatPoly v_c.P6.pSD 0.00294752f
Cred_1619 di_tg_ctrl|di_tg_ctrl_n|vin|vout.$4.GatPoly VDD.$378.Metal1 2.74998e-05f
Cred_1620 di_tg_ctrl|di_tg_ctrl_n|vin|vout.$4.GatPoly VDD.$382.Metal1 2.54941e-06f
Cred_1621 di_tg_ctrl|di_tg_ctrl_n|vin|vout.$4.GatPoly VDD.$405.Metal1 3.76619e-05f
Cred_1622 di_tg_ctrl|di_tg_ctrl_n|vin|vout.$4.GatPoly VDD.$414.Metal1 0.00130974f
Cred_1623 di_tg_ctrl|di_tg_ctrl_n|vin|vout.$4.GatPoly VDD.$418.Metal1 0.00241287f
Cred_1624 di_tg_ctrl|di_tg_ctrl_n|vin|vout.$4.GatPoly VDD.$422.Metal1 0.00160829f
Cred_1625 di_tg_ctrl|di_tg_ctrl_n|vin|vout.$4.GatPoly VDD.$426.Metal1 0.000217819f
Cred_1626 di_tg_ctrl|di_tg_ctrl_n|vin|vout.$4.GatPoly VDD.$620.Metal2 5.8364e-07f
Cred_1627 di_tg_ctrl|di_tg_ctrl_n|vin|vout.$4.GatPoly VDD.$714.Metal2 0.00804424f
Cred_1628 di_tg_ctrl|di_tg_ctrl_n|vin|vout.$4.GatPoly VDD.$734.Metal2 0.00476191f
Cred_1629 di_tg_ctrl|di_tg_ctrl_n|vin|vout.$4.GatPoly VDD.$738.Metal2 0.000818024f
Cred_1630 di_tg_ctrl|di_tg_ctrl_n|vin|vout.$4.GatPoly VDD.$746.Metal2 9.07339e-06f
Cred_1631 di_tg_ctrl|di_tg_ctrl_n|vin|vout.$4.GatPoly VDD.$754.Metal2 1.91546e-05f
Cred_1632 di_tg_ctrl|di_tg_ctrl_n|vin|vout.$4.GatPoly VDD.$762.Metal2 2.33632e-07f
Cred_1633 di_tg_ctrl|di_tg_ctrl_n|vin|vout.$4.GatPoly VDD.$874.Metal3 2.23968e-08f
Cred_1634 di_tg_ctrl|di_tg_ctrl_n|vin|vout.$4.GatPoly VDD.$878.Metal3 1.07615e-07f
Cred_1635 di_tg_ctrl|di_tg_ctrl_n|vin|vout.$4.GatPoly VDD.$882.Metal3 1.1606e-07f
Cred_1636 di_tg_ctrl|di_tg_ctrl_n|vin|vout.$4.GatPoly VDD.P0.nSD 5.36605e-06f
Cred_1637 di_tg_ctrl|di_tg_ctrl_n|vin|vout.$4.GatPoly VDD.P3.GatPoly 0.00168948f
Cred_1638 di_tg_ctrl|di_tg_ctrl_n|vin|vout.$6.GatPoly di_tg_ctrl|di_tg_ctrl_n|vout.$14.GatPoly 0.00239985f
Cred_1639 di_tg_ctrl|di_tg_ctrl_n|vin|vout.$6.GatPoly di_tg_ctrl|di_tg_ctrl_n|vout.$77.Metal1 0.000696044f
Cred_1640 di_tg_ctrl|di_tg_ctrl_n|vin|vout.$6.GatPoly di_tg_ctrl|di_tg_ctrl_n|vout.$79.Metal1 0.000125892f
Cred_1641 di_tg_ctrl|di_tg_ctrl_n|vin|vout.$6.GatPoly di_tg_ctrl|di_tg_ctrl_n|vout.P6.GatPoly 5.64369e-05f
Cred_1642 di_tg_ctrl|di_tg_ctrl_n|vin|vout.$6.GatPoly VSS 0.00604049f
Cred_1643 di_tg_ctrl|di_tg_ctrl_n|vin|vout.$6.GatPoly v_a.$148.Metal2 0.00635106f
Cred_1644 di_tg_ctrl|di_tg_ctrl_n|vin|vout.$6.GatPoly v_a.$182.Metal2 0.00390773f
Cred_1645 di_tg_ctrl|di_tg_ctrl_n|vin|vout.$6.GatPoly v_a.P0.pSD 0.0050789f
Cred_1646 di_tg_ctrl|di_tg_ctrl_n|vin|vout.$6.GatPoly v_a.P1.nSD 3.25032e-05f
Cred_1647 di_tg_ctrl|di_tg_ctrl_n|vin|vout.$6.GatPoly v_a.P1.pSD 0.0162084f
Cred_1648 di_tg_ctrl|di_tg_ctrl_n|vin|vout.$6.GatPoly v_c.$228.Metal2 0.00842805f
Cred_1649 di_tg_ctrl|di_tg_ctrl_n|vin|vout.$6.GatPoly v_c.$23.Metal1 0.00993142f
Cred_1650 di_tg_ctrl|di_tg_ctrl_n|vin|vout.$6.GatPoly v_c.$415.Metal3 0.00853331f
Cred_1651 di_tg_ctrl|di_tg_ctrl_n|vin|vout.$6.GatPoly v_c.$425.Metal3 0.000989274f
Cred_1652 di_tg_ctrl|di_tg_ctrl_n|vin|vout.$6.GatPoly v_c.P6.pSD 0.00977395f
Cred_1653 di_tg_ctrl|di_tg_ctrl_n|vin|vout.$6.GatPoly v_c.P8.pSD 0.00160856f
Cred_1654 di_tg_ctrl|di_tg_ctrl_n|vin|vout.$6.GatPoly VDD.$418.Metal1 0.00102324f
Cred_1655 di_tg_ctrl|di_tg_ctrl_n|vin|vout.$6.GatPoly VDD.$422.Metal1 0.00185507f
Cred_1656 di_tg_ctrl|di_tg_ctrl_n|vin|vout.$6.GatPoly VDD.$426.Metal1 0.00195214f
Cred_1657 di_tg_ctrl|di_tg_ctrl_n|vin|vout.$6.GatPoly VDD.$714.Metal2 0.00369586f
Cred_1658 di_tg_ctrl|di_tg_ctrl_n|vin|vout.$6.GatPoly VDD.$734.Metal2 0.00272154f
Cred_1659 di_tg_ctrl|di_tg_ctrl_n|vin|vout.$6.GatPoly VDD.$738.Metal2 0.00046655f
Cred_1660 di_tg_ctrl|di_tg_ctrl_n|vin|vout.$6.GatPoly VDD.$754.Metal2 5.07612e-06f
Cred_1661 di_tg_ctrl|di_tg_ctrl_n|vin|vout.$6.GatPoly VDD.$762.Metal2 2.09385e-06f
Cred_1662 di_tg_ctrl|di_tg_ctrl_n|vin|vout.$6.GatPoly VDD.$882.Metal3 1.67881e-08f
Cred_1663 di_tg_ctrl|di_tg_ctrl_n|vin|vout.$6.GatPoly VDD.P3.GatPoly 0.000965577f
Cred_1664 di_tg_ctrl|di_tg_ctrl_n|vin|vout.$75.Metal1 di_tg_ctrl|di_tg_ctrl_n|vout.$180.Metal3 7.95822e-07f
Cred_1665 di_tg_ctrl|di_tg_ctrl_n|vin|vout.$75.Metal1 di_tg_ctrl|di_tg_ctrl_n|vout.$206.Metal4 2.3465e-06f
Cred_1666 di_tg_ctrl|di_tg_ctrl_n|vin|vout.$75.Metal1 di_tg_ctrl|di_tg_ctrl_n|vout.P0.nSD 9.14345e-08f
Cred_1667 di_tg_ctrl|di_tg_ctrl_n|vin|vout.$75.Metal1 di_tg_ctrl|di_tg_ctrl_n|vout.P0.pSD 4.74631e-07f
Cred_1668 di_tg_ctrl|di_tg_ctrl_n|vin|vout.$75.Metal1 VSS 0.000486042f
Cred_1669 di_tg_ctrl|di_tg_ctrl_n|vin|vout.$75.Metal1 v_a 1.53492e-07f
Cred_1670 di_tg_ctrl|di_tg_ctrl_n|vin|vout.$75.Metal1 v_a.$148.Metal2 0.00577311f
Cred_1671 di_tg_ctrl|di_tg_ctrl_n|vin|vout.$75.Metal1 v_a.$182.Metal2 0.000267967f
Cred_1672 di_tg_ctrl|di_tg_ctrl_n|vin|vout.$75.Metal1 v_a.P0.pSD 0.0142493f
Cred_1673 di_tg_ctrl|di_tg_ctrl_n|vin|vout.$75.Metal1 v_a.P1.nSD 2.22886e-06f
Cred_1674 di_tg_ctrl|di_tg_ctrl_n|vin|vout.$75.Metal1 v_a.P1.pSD 0.00213246f
Cred_1675 di_tg_ctrl|di_tg_ctrl_n|vin|vout.$75.Metal1 v_c.$220.Metal2 5.8919e-10f
Cred_1676 di_tg_ctrl|di_tg_ctrl_n|vin|vout.$75.Metal1 v_c.$228.Metal2 0.0054237f
Cred_1677 di_tg_ctrl|di_tg_ctrl_n|vin|vout.$75.Metal1 v_c.$23.Metal1 0.00685634f
Cred_1678 di_tg_ctrl|di_tg_ctrl_n|vin|vout.$75.Metal1 v_c.$411.Metal3 7.34855e-08f
Cred_1679 di_tg_ctrl|di_tg_ctrl_n|vin|vout.$75.Metal1 v_c.$415.Metal3 0.00786989f
Cred_1680 di_tg_ctrl|di_tg_ctrl_n|vin|vout.$75.Metal1 v_c.$425.Metal3 4.3901e-07f
Cred_1681 di_tg_ctrl|di_tg_ctrl_n|vin|vout.$75.Metal1 v_c.P6.nSD 1.97914e-09f
Cred_1682 di_tg_ctrl|di_tg_ctrl_n|vin|vout.$75.Metal1 v_c.P6.pSD 0.0140034f
Cred_1683 di_tg_ctrl|di_tg_ctrl_n|vin|vout.$75.Metal1 VDD.$378.Metal1 0.00230567f
Cred_1684 di_tg_ctrl|di_tg_ctrl_n|vin|vout.$75.Metal1 VDD.$382.Metal1 0.00021375f
Cred_1685 di_tg_ctrl|di_tg_ctrl_n|vin|vout.$75.Metal1 VDD.$405.Metal1 0.00315806f
Cred_1686 di_tg_ctrl|di_tg_ctrl_n|vin|vout.$75.Metal1 VDD.$414.Metal1 0.0198997f
Cred_1687 di_tg_ctrl|di_tg_ctrl_n|vin|vout.$75.Metal1 VDD.$418.Metal1 0.0307065f
Cred_1688 di_tg_ctrl|di_tg_ctrl_n|vin|vout.$75.Metal1 VDD.$422.Metal1 0.0278132f
Cred_1689 di_tg_ctrl|di_tg_ctrl_n|vin|vout.$75.Metal1 VDD.$426.Metal1 0.00318977f
Cred_1690 di_tg_ctrl|di_tg_ctrl_n|vin|vout.$75.Metal1 VDD.$620.Metal2 5.86691e-05f
Cred_1691 di_tg_ctrl|di_tg_ctrl_n|vin|vout.$75.Metal1 VDD.$738.Metal2 0.00017056f
Cred_1692 di_tg_ctrl|di_tg_ctrl_n|vin|vout.$75.Metal1 VDD.$746.Metal2 0.0008266f
Cred_1693 di_tg_ctrl|di_tg_ctrl_n|vin|vout.$75.Metal1 VDD.$754.Metal2 0.00139891f
Cred_1694 di_tg_ctrl|di_tg_ctrl_n|vin|vout.$75.Metal1 VDD.$762.Metal2 1.23565e-07f
Cred_1695 di_tg_ctrl|di_tg_ctrl_n|vin|vout.$75.Metal1 VDD.$874.Metal3 2.25139e-06f
Cred_1696 di_tg_ctrl|di_tg_ctrl_n|vin|vout.$75.Metal1 VDD.$878.Metal3 1.0828e-05f
Cred_1697 di_tg_ctrl|di_tg_ctrl_n|vin|vout.$75.Metal1 VDD.$882.Metal3 1.28664e-05f
Cred_1698 di_tg_ctrl|di_tg_ctrl_n|vin|vout.$75.Metal1 VDD.P0.nSD 0.000449905f
Cred_1699 di_tg_ctrl|di_tg_ctrl_n|vin|vout.$77.Metal1 di_tg_ctrl|di_tg_ctrl_n|vout.$14.GatPoly 3.33543e-05f
Cred_1700 di_tg_ctrl|di_tg_ctrl_n|vin|vout.$77.Metal1 di_tg_ctrl|di_tg_ctrl_n|vout.$77.Metal1 2.43834e-05f
Cred_1701 di_tg_ctrl|di_tg_ctrl_n|vin|vout.$77.Metal1 di_tg_ctrl|di_tg_ctrl_n|vout.$79.Metal1 4.41018e-06f
Cred_1702 di_tg_ctrl|di_tg_ctrl_n|vin|vout.$77.Metal1 di_tg_ctrl|di_tg_ctrl_n|vout.P6.GatPoly 1.97707e-06f
Cred_1703 di_tg_ctrl|di_tg_ctrl_n|vin|vout.$77.Metal1 VSS 0.000937936f
Cred_1704 di_tg_ctrl|di_tg_ctrl_n|vin|vout.$77.Metal1 v_a.$148.Metal2 0.00353094f
Cred_1705 di_tg_ctrl|di_tg_ctrl_n|vin|vout.$77.Metal1 v_a.$182.Metal2 0.00353094f
Cred_1706 di_tg_ctrl|di_tg_ctrl_n|vin|vout.$77.Metal1 v_a.P1.nSD 2.93692e-05f
Cred_1707 di_tg_ctrl|di_tg_ctrl_n|vin|vout.$77.Metal1 v_a.P1.pSD 0.0200383f
Cred_1708 di_tg_ctrl|di_tg_ctrl_n|vin|vout.$77.Metal1 v_c.$425.Metal3 0.00367585f
Cred_1709 di_tg_ctrl|di_tg_ctrl_n|vin|vout.$77.Metal1 v_c.P8.pSD 0.0062379f
Cred_1710 di_tg_ctrl|di_tg_ctrl_n|vin|vout.$77.Metal1 VDD.$422.Metal1 0.00403652f
Cred_1711 di_tg_ctrl|di_tg_ctrl_n|vin|vout.$77.Metal1 VDD.$426.Metal1 0.038582f
Cred_1712 di_tg_ctrl|di_tg_ctrl_n|vin|vout.$77.Metal1 VDD.$434.Metal1 0.00497656f
Cred_1713 di_tg_ctrl|di_tg_ctrl_n|vin|vout.$77.Metal1 VDD.$714.Metal2 5.67886e-05f
Cred_1714 di_tg_ctrl|di_tg_ctrl_n|vin|vout.$77.Metal1 VDD.$734.Metal2 4.18177e-05f
Cred_1715 di_tg_ctrl|di_tg_ctrl_n|vin|vout.$77.Metal1 VDD.$738.Metal2 7.16876e-06f
Cred_1716 di_tg_ctrl|di_tg_ctrl_n|vin|vout.$77.Metal1 VDD.$754.Metal2 4.59867e-07f
Cred_1717 di_tg_ctrl|di_tg_ctrl_n|vin|vout.$77.Metal1 VDD.$762.Metal2 1.46475e-05f
Cred_1718 di_tg_ctrl|di_tg_ctrl_n|vin|vout.$77.Metal1 VDD.$766.Metal2 2.7605e-05f
Cred_1719 di_tg_ctrl|di_tg_ctrl_n|vin|vout.$77.Metal1 VDD.$882.Metal3 3.68711e-09f
Cred_1720 di_tg_ctrl|di_tg_ctrl_n|vin|vout.$77.Metal1 VDD.P0.nSD 8.42805e-06f
Cred_1721 di_tg_ctrl|di_tg_ctrl_n|vin|vout.$77.Metal1 VDD.P3.GatPoly 1.48366e-05f
Cred_1722 di_tg_ctrl|di_tg_ctrl_n|vin|vout.$80.Metal1 di_tg_ctrl|di_tg_ctrl_n|vout.$14.GatPoly 0.000166378f
Cred_1723 di_tg_ctrl|di_tg_ctrl_n|vin|vout.$80.Metal1 di_tg_ctrl|di_tg_ctrl_n|vout.$77.Metal1 0.00012163f
Cred_1724 di_tg_ctrl|di_tg_ctrl_n|vin|vout.$80.Metal1 di_tg_ctrl|di_tg_ctrl_n|vout.$79.Metal1 2.19989e-05f
Cred_1725 di_tg_ctrl|di_tg_ctrl_n|vin|vout.$80.Metal1 di_tg_ctrl|di_tg_ctrl_n|vout.P6.GatPoly 9.86202e-06f
Cred_1726 di_tg_ctrl|di_tg_ctrl_n|vin|vout.$80.Metal1 VSS 0.00163547f
Cred_1727 di_tg_ctrl|di_tg_ctrl_n|vin|vout.$80.Metal1 v_a.$182.Metal2 0.00131977f
Cred_1728 di_tg_ctrl|di_tg_ctrl_n|vin|vout.$80.Metal1 v_a.P1.pSD 0.000605159f
Cred_1729 di_tg_ctrl|di_tg_ctrl_n|vin|vout.$80.Metal1 v_a.P3.pSD 0.00387776f
Cred_1730 di_tg_ctrl|di_tg_ctrl_n|vin|vout.$80.Metal1 v_c.$425.Metal3 0.0100472f
Cred_1731 di_tg_ctrl|di_tg_ctrl_n|vin|vout.$80.Metal1 v_c.P8.pSD 0.0191278f
Cred_1732 di_tg_ctrl|di_tg_ctrl_n|vin|vout.$80.Metal1 VDD.$426.Metal1 0.0207356f
Cred_1733 di_tg_ctrl|di_tg_ctrl_n|vin|vout.$80.Metal1 VDD.$434.Metal1 0.0278702f
Cred_1734 di_tg_ctrl|di_tg_ctrl_n|vin|vout.$80.Metal1 VDD.$438.Metal1 9.82271e-05f
Cred_1735 di_tg_ctrl|di_tg_ctrl_n|vin|vout.$80.Metal1 VDD.$714.Metal2 0.000213287f
Cred_1736 di_tg_ctrl|di_tg_ctrl_n|vin|vout.$80.Metal1 VDD.$734.Metal2 0.000157059f
Cred_1737 di_tg_ctrl|di_tg_ctrl_n|vin|vout.$80.Metal1 VDD.$738.Metal2 2.69244e-05f
Cred_1738 di_tg_ctrl|di_tg_ctrl_n|vin|vout.$80.Metal1 VDD.$762.Metal2 7.21963e-05f
Cred_1739 di_tg_ctrl|di_tg_ctrl_n|vin|vout.$80.Metal1 VDD.$766.Metal2 0.000141615f
Cred_1740 di_tg_ctrl|di_tg_ctrl_n|vin|vout.$80.Metal1 VDD.$774.Metal2 2.06135e-07f
Cred_1741 di_tg_ctrl|di_tg_ctrl_n|vin|vout.$80.Metal1 VDD.$888.Metal3 1.65275e-09f
Cred_1742 di_tg_ctrl|di_tg_ctrl_n|vin|vout.$80.Metal1 VDD.P0.nSD 4.28875e-05f
Cred_1743 di_tg_ctrl|di_tg_ctrl_n|vin|vout.$80.Metal1 VDD.P3.GatPoly 5.57232e-05f
Cred_1744 di_tg_ctrl|di_tg_ctrl_n|vin|vout.$82.Metal1 di_tg_ctrl|di_tg_ctrl_n|vout.$14.GatPoly 0.00253789f
Cred_1745 di_tg_ctrl|di_tg_ctrl_n|vin|vout.$82.Metal1 di_tg_ctrl|di_tg_ctrl_n|vout.$144.Metal2 0.000186261f
Cred_1746 di_tg_ctrl|di_tg_ctrl_n|vin|vout.$82.Metal1 di_tg_ctrl|di_tg_ctrl_n|vout.$17.GatPoly 0.000767488f
Cred_1747 di_tg_ctrl|di_tg_ctrl_n|vin|vout.$82.Metal1 di_tg_ctrl|di_tg_ctrl_n|vout.$192.Metal3 7.23036e-06f
Cred_1748 di_tg_ctrl|di_tg_ctrl_n|vin|vout.$82.Metal1 di_tg_ctrl|di_tg_ctrl_n|vout.$206.Metal4 0.000136511f
Cred_1749 di_tg_ctrl|di_tg_ctrl_n|vin|vout.$82.Metal1 di_tg_ctrl|di_tg_ctrl_n|vout.$209.Metal4 4.70397e-08f
Cred_1750 di_tg_ctrl|di_tg_ctrl_n|vin|vout.$82.Metal1 di_tg_ctrl|di_tg_ctrl_n|vout.$21.GatPoly 0.000853915f
Cred_1751 di_tg_ctrl|di_tg_ctrl_n|vin|vout.$82.Metal1 di_tg_ctrl|di_tg_ctrl_n|vout.$77.Metal1 0.00123099f
Cred_1752 di_tg_ctrl|di_tg_ctrl_n|vin|vout.$82.Metal1 di_tg_ctrl|di_tg_ctrl_n|vout.$79.Metal1 0.000221982f
Cred_1753 di_tg_ctrl|di_tg_ctrl_n|vin|vout.$82.Metal1 di_tg_ctrl|di_tg_ctrl_n|vout.$81.Metal1 3.03983e-05f
Cred_1754 di_tg_ctrl|di_tg_ctrl_n|vin|vout.$82.Metal1 di_tg_ctrl|di_tg_ctrl_n|vout.$84.Metal1 0.000114497f
Cred_1755 di_tg_ctrl|di_tg_ctrl_n|vin|vout.$82.Metal1 di_tg_ctrl|di_tg_ctrl_n|vout.$86.Metal1 6.60335e-05f
Cred_1756 di_tg_ctrl|di_tg_ctrl_n|vin|vout.$82.Metal1 di_tg_ctrl|di_tg_ctrl_n|vout.P6.GatPoly 9.95135e-05f
Cred_1757 di_tg_ctrl|di_tg_ctrl_n|vin|vout.$82.Metal1 di_tg_ctrl|di_tg_ctrl_n|vout.P8.GatPoly 6.38215e-06f
Cred_1758 di_tg_ctrl|di_tg_ctrl_n|vin|vout.$82.Metal1 di_tg_ctrl|di_tg_ctrl_n|vout.P9.GatPoly 1.38638e-05f
Cred_1759 di_tg_ctrl|di_tg_ctrl_n|vin|vout.$82.Metal1 VSS 0.00431129f
Cred_1760 di_tg_ctrl|di_tg_ctrl_n|vin|vout.$82.Metal1 v_a.$182.Metal2 0.0139499f
Cred_1761 di_tg_ctrl|di_tg_ctrl_n|vin|vout.$82.Metal1 v_a.P3.pSD 0.0222434f
Cred_1762 di_tg_ctrl|di_tg_ctrl_n|vin|vout.$82.Metal1 v_a.P5.nSD 4.22658e-05f
Cred_1763 di_tg_ctrl|di_tg_ctrl_n|vin|vout.$82.Metal1 v_a.P5.pSD 0.0164402f
Cred_1764 di_tg_ctrl|di_tg_ctrl_n|vin|vout.$82.Metal1 v_c.$284.Metal2 2.63578e-09f
Cred_1765 di_tg_ctrl|di_tg_ctrl_n|vin|vout.$82.Metal1 v_c.$292.Metal2 0.00615533f
Cred_1766 di_tg_ctrl|di_tg_ctrl_n|vin|vout.$82.Metal1 v_c.$425.Metal3 0.00102653f
Cred_1767 di_tg_ctrl|di_tg_ctrl_n|vin|vout.$82.Metal1 v_c.$446.Metal3 3.28742e-07f
Cred_1768 di_tg_ctrl|di_tg_ctrl_n|vin|vout.$82.Metal1 v_c.$450.Metal3 0.00838704f
Cred_1769 di_tg_ctrl|di_tg_ctrl_n|vin|vout.$82.Metal1 v_c.$459.Metal3 3.8844e-07f
Cred_1770 di_tg_ctrl|di_tg_ctrl_n|vin|vout.$82.Metal1 v_c.$95.Metal1 0.00793588f
Cred_1771 di_tg_ctrl|di_tg_ctrl_n|vin|vout.$82.Metal1 v_c.P10.nSD 6.95438e-09f
Cred_1772 di_tg_ctrl|di_tg_ctrl_n|vin|vout.$82.Metal1 v_c.P10.pSD 0.0144741f
Cred_1773 di_tg_ctrl|di_tg_ctrl_n|vin|vout.$82.Metal1 v_c.P8.pSD 0.0016747f
Cred_1774 di_tg_ctrl|di_tg_ctrl_n|vin|vout.$82.Metal1 VDD.$382.Metal1 4.33659e-05f
Cred_1775 di_tg_ctrl|di_tg_ctrl_n|vin|vout.$82.Metal1 VDD.$426.Metal1 0.000590278f
Cred_1776 di_tg_ctrl|di_tg_ctrl_n|vin|vout.$82.Metal1 VDD.$434.Metal1 0.031002f
Cred_1777 di_tg_ctrl|di_tg_ctrl_n|vin|vout.$82.Metal1 VDD.$438.Metal1 0.0312664f
Cred_1778 di_tg_ctrl|di_tg_ctrl_n|vin|vout.$82.Metal1 VDD.$442.Metal1 0.0303115f
Cred_1779 di_tg_ctrl|di_tg_ctrl_n|vin|vout.$82.Metal1 VDD.$446.Metal1 0.0193322f
Cred_1780 di_tg_ctrl|di_tg_ctrl_n|vin|vout.$82.Metal1 VDD.$477.Metal1 0.00597555f
Cred_1781 di_tg_ctrl|di_tg_ctrl_n|vin|vout.$82.Metal1 VDD.$526.Metal1 5.64979e-06f
Cred_1782 di_tg_ctrl|di_tg_ctrl_n|vin|vout.$82.Metal1 VDD.$714.Metal2 0.000123008f
Cred_1783 di_tg_ctrl|di_tg_ctrl_n|vin|vout.$82.Metal1 VDD.$734.Metal2 9.05803e-05f
Cred_1784 di_tg_ctrl|di_tg_ctrl_n|vin|vout.$82.Metal1 VDD.$738.Metal2 1.5528e-05f
Cred_1785 di_tg_ctrl|di_tg_ctrl_n|vin|vout.$82.Metal1 VDD.$762.Metal2 3.27428e-06f
Cred_1786 di_tg_ctrl|di_tg_ctrl_n|vin|vout.$82.Metal1 VDD.$766.Metal2 7.43888e-06f
Cred_1787 di_tg_ctrl|di_tg_ctrl_n|vin|vout.$82.Metal1 VDD.$774.Metal2 0.00134317f
Cred_1788 di_tg_ctrl|di_tg_ctrl_n|vin|vout.$82.Metal1 VDD.$782.Metal2 0.000530582f
Cred_1789 di_tg_ctrl|di_tg_ctrl_n|vin|vout.$82.Metal1 VDD.$888.Metal3 5.96622e-09f
Cred_1790 di_tg_ctrl|di_tg_ctrl_n|vin|vout.$82.Metal1 VDD.$892.Metal3 2.81533e-05f
Cred_1791 di_tg_ctrl|di_tg_ctrl_n|vin|vout.$82.Metal1 VDD.P0.nSD 0.000611741f
Cred_1792 di_tg_ctrl|di_tg_ctrl_n|vin|vout.$82.Metal1 VDD.P3.GatPoly 3.2137e-05f
Cred_1793 di_tg_ctrl|di_tg_ctrl_n|vin|vout.$89.Metal1 di_tg_ctrl|di_tg_ctrl_n|vout.$10.GatPoly 0.00122696f
Cred_1794 di_tg_ctrl|di_tg_ctrl_n|vin|vout.$89.Metal1 di_tg_ctrl|di_tg_ctrl_n|vout.$136.Metal2 0.000107211f
Cred_1795 di_tg_ctrl|di_tg_ctrl_n|vin|vout.$89.Metal1 di_tg_ctrl|di_tg_ctrl_n|vout.$186.Metal3 7.5054e-06f
Cred_1796 di_tg_ctrl|di_tg_ctrl_n|vin|vout.$89.Metal1 di_tg_ctrl|di_tg_ctrl_n|vout.$70.Metal1 0.000585479f
Cred_1797 di_tg_ctrl|di_tg_ctrl_n|vin|vout.$89.Metal1 di_tg_ctrl|di_tg_ctrl_n|vout.P5.GatPoly 0.000192104f
Cred_1798 di_tg_ctrl|di_tg_ctrl_n|vin|vout.$89.Metal1 VSS 0.0297494f
Cred_1799 di_tg_ctrl|di_tg_ctrl_n|vin|vout.$89.Metal1 v_b.$161.Metal2 0.00936922f
Cred_1800 di_tg_ctrl|di_tg_ctrl_n|vin|vout.$89.Metal1 v_b.P0.nSD 0.0102068f
Cred_1801 di_tg_ctrl|di_tg_ctrl_n|vin|vout.$89.Metal1 v_b.P0.pSD 0.000237211f
Cred_1802 di_tg_ctrl|di_tg_ctrl_n|vin|vout.$89.Metal1 v_b.P1.nSD 0.000903349f
Cred_1803 di_tg_ctrl|di_tg_ctrl_n|vin|vout.$89.Metal1 v_c.$459.Metal3 0.00881341f
Cred_1804 di_tg_ctrl|di_tg_ctrl_n|vin|vout.$89.Metal1 v_c.P0.nSD 0.0140682f
Cred_1805 di_tg_ctrl|di_tg_ctrl_n|vin|vout.$89.Metal1 VSS.$211.Metal1 0.00718565f
Cred_1806 di_tg_ctrl|di_tg_ctrl_n|vin|vout.$89.Metal1 VSS.$220.Metal1 0.00384675f
Cred_1807 di_tg_ctrl|di_tg_ctrl_n|vin|vout.$89.Metal1 VSS.$231.Metal1 0.0317653f
Cred_1808 di_tg_ctrl|di_tg_ctrl_n|vin|vout.$89.Metal1 VSS.$241.Metal1 0.012834f
Cred_1809 di_tg_ctrl|di_tg_ctrl_n|vin|vout.$89.Metal1 VSS.$255.Metal1 0.000307304f
Cred_1810 di_tg_ctrl|di_tg_ctrl_n|vin|vout.$89.Metal1 VSS.$424.Metal2 6.06798e-06f
Cred_1811 di_tg_ctrl|di_tg_ctrl_n|vin|vout.$89.Metal1 VSS.$428.Metal2 0.000177262f
Cred_1812 di_tg_ctrl|di_tg_ctrl_n|vin|vout.$89.Metal1 VSS.$436.Metal2 0.000243975f
Cred_1813 di_tg_ctrl|di_tg_ctrl_n|vin|vout.$89.Metal1 VSS.$440.Metal2 2.52956e-05f
Cred_1814 di_tg_ctrl|di_tg_ctrl_n|vin|vout.$89.Metal1 VSS.$452.Metal2 1.25001e-05f
Cred_1815 di_tg_ctrl|di_tg_ctrl_n|vin|vout.$89.Metal1 VSS.$536.Metal3 8.64712e-06f
Cred_1816 di_tg_ctrl|di_tg_ctrl_n|vin|vout.$89.Metal1 VSS.$548.Metal3 8.99286e-07f
Cred_1817 di_tg_ctrl|di_tg_ctrl_n|vin|vout.$89.Metal1 VSS.P0.pSD 0.00112802f
Cred_1818 di_tg_ctrl|di_tg_ctrl_n|vin|vout.$9.GatPoly di_tg_ctrl|di_tg_ctrl_n|vout.$14.GatPoly 0.000919163f
Cred_1819 di_tg_ctrl|di_tg_ctrl_n|vin|vout.$9.GatPoly di_tg_ctrl|di_tg_ctrl_n|vout.$77.Metal1 0.000671947f
Cred_1820 di_tg_ctrl|di_tg_ctrl_n|vin|vout.$9.GatPoly di_tg_ctrl|di_tg_ctrl_n|vout.$79.Metal1 0.000121534f
Cred_1821 di_tg_ctrl|di_tg_ctrl_n|vin|vout.$9.GatPoly di_tg_ctrl|di_tg_ctrl_n|vout.P6.GatPoly 5.44831e-05f
Cred_1822 di_tg_ctrl|di_tg_ctrl_n|vin|vout.$9.GatPoly VSS 0.00993138f
Cred_1823 di_tg_ctrl|di_tg_ctrl_n|vin|vout.$9.GatPoly v_a.$148.Metal2 0.00270519f
Cred_1824 di_tg_ctrl|di_tg_ctrl_n|vin|vout.$9.GatPoly v_a.$182.Metal2 0.00520056f
Cred_1825 di_tg_ctrl|di_tg_ctrl_n|vin|vout.$9.GatPoly v_a.P1.nSD 2.25009e-05f
Cred_1826 di_tg_ctrl|di_tg_ctrl_n|vin|vout.$9.GatPoly v_a.P1.pSD 0.0111776f
Cred_1827 di_tg_ctrl|di_tg_ctrl_n|vin|vout.$9.GatPoly v_a.P3.pSD 0.00501171f
Cred_1828 di_tg_ctrl|di_tg_ctrl_n|vin|vout.$9.GatPoly v_c.$425.Metal3 0.0111472f
Cred_1829 di_tg_ctrl|di_tg_ctrl_n|vin|vout.$9.GatPoly v_c.P8.pSD 0.018259f
Cred_1830 di_tg_ctrl|di_tg_ctrl_n|vin|vout.$9.GatPoly VDD.$405.Metal1 7.5594e-06f
Cred_1831 di_tg_ctrl|di_tg_ctrl_n|vin|vout.$9.GatPoly VDD.$422.Metal1 0.000410761f
Cred_1832 di_tg_ctrl|di_tg_ctrl_n|vin|vout.$9.GatPoly VDD.$426.Metal1 0.00694749f
Cred_1833 di_tg_ctrl|di_tg_ctrl_n|vin|vout.$9.GatPoly VDD.$434.Metal1 0.00432993f
Cred_1834 di_tg_ctrl|di_tg_ctrl_n|vin|vout.$9.GatPoly VDD.$438.Metal1 0.000185723f
Cred_1835 di_tg_ctrl|di_tg_ctrl_n|vin|vout.$9.GatPoly VDD.$714.Metal2 0.00143263f
Cred_1836 di_tg_ctrl|di_tg_ctrl_n|vin|vout.$9.GatPoly VDD.$734.Metal2 0.00105495f
Cred_1837 di_tg_ctrl|di_tg_ctrl_n|vin|vout.$9.GatPoly VDD.$738.Metal2 0.00075353f
Cred_1838 di_tg_ctrl|di_tg_ctrl_n|vin|vout.$9.GatPoly VDD.$746.Metal2 0.00094283f
Cred_1839 di_tg_ctrl|di_tg_ctrl_n|vin|vout.$9.GatPoly VDD.$754.Metal2 8.62007e-07f
Cred_1840 di_tg_ctrl|di_tg_ctrl_n|vin|vout.$9.GatPoly VDD.$762.Metal2 3.44334e-05f
Cred_1841 di_tg_ctrl|di_tg_ctrl_n|vin|vout.$9.GatPoly VDD.$766.Metal2 2.23923e-05f
Cred_1842 di_tg_ctrl|di_tg_ctrl_n|vin|vout.$9.GatPoly VDD.$774.Metal2 3.89752e-07f
Cred_1843 di_tg_ctrl|di_tg_ctrl_n|vin|vout.$9.GatPoly VDD.$874.Metal3 7.5594e-06f
Cred_1844 di_tg_ctrl|di_tg_ctrl_n|vin|vout.$9.GatPoly VDD.$882.Metal3 6.91138e-09f
Cred_1845 di_tg_ctrl|di_tg_ctrl_n|vin|vout.$9.GatPoly VDD.$888.Metal3 3.12494e-09f
Cred_1846 di_tg_ctrl|di_tg_ctrl_n|vin|vout.$9.GatPoly VDD.P0.nSD 6.17707e-06f
Cred_1847 di_tg_ctrl|di_tg_ctrl_n|vin|vout.$9.GatPoly VDD.P3.GatPoly 0.000374287f
Cred_1848 di_tg_ctrl|di_tg_ctrl_n|vin|vout.$93.Metal1 VSS 0.0157961f
Cred_1849 di_tg_ctrl|di_tg_ctrl_n|vin|vout.$93.Metal1 v_b.$161.Metal2 0.0125206f
Cred_1850 di_tg_ctrl|di_tg_ctrl_n|vin|vout.$93.Metal1 v_b.P1.nSD 0.0151536f
Cred_1851 di_tg_ctrl|di_tg_ctrl_n|vin|vout.$93.Metal1 v_c.$459.Metal3 0.00283342f
Cred_1852 di_tg_ctrl|di_tg_ctrl_n|vin|vout.$93.Metal1 v_c.$476.Metal3 0.00259864f
Cred_1853 di_tg_ctrl|di_tg_ctrl_n|vin|vout.$93.Metal1 v_c.P0.nSD 0.00452187f
Cred_1854 di_tg_ctrl|di_tg_ctrl_n|vin|vout.$93.Metal1 v_c.P2.nSD 0.00519632f
Cred_1855 di_tg_ctrl|di_tg_ctrl_n|vin|vout.$93.Metal1 VSS.$220.Metal1 0.00145901f
Cred_1856 di_tg_ctrl|di_tg_ctrl_n|vin|vout.$93.Metal1 VSS.$231.Metal1 0.00468068f
Cred_1857 di_tg_ctrl|di_tg_ctrl_n|vin|vout.$93.Metal1 VSS.$241.Metal1 0.0336405f
Cred_1858 di_tg_ctrl|di_tg_ctrl_n|vin|vout.$93.Metal1 VSS.$245.Metal1 0.00518963f
Cred_1859 di_tg_ctrl|di_tg_ctrl_n|vin|vout.$93.Metal1 VSS.$255.Metal1 0.000257023f
Cred_1860 di_tg_ctrl|di_tg_ctrl_n|vin|vout.$93.Metal1 VSS.$436.Metal2 3.23198e-05f
Cred_1861 di_tg_ctrl|di_tg_ctrl_n|vin|vout.$93.Metal1 VSS.$440.Metal2 1.57676e-05f
Cred_1862 di_tg_ctrl|di_tg_ctrl_n|vin|vout.$93.Metal1 VSS.$452.Metal2 1.04548e-05f
Cred_1863 di_tg_ctrl|di_tg_ctrl_n|vin|vout.$93.Metal1 VSS.$548.Metal3 7.52145e-07f
Cred_1864 di_tg_ctrl|di_tg_ctrl_n|vin|vout.$93.Metal1 VSS.P0.pSD 0.000625325f
Cred_1865 di_tg_ctrl|di_tg_ctrl_n|vin|vout.$96.Metal1 VSS 0.0136734f
Cred_1866 di_tg_ctrl|di_tg_ctrl_n|vin|vout.$96.Metal1 v_b.$161.Metal2 6.81365e-05f
Cred_1867 di_tg_ctrl|di_tg_ctrl_n|vin|vout.$96.Metal1 v_b.$195.Metal2 6.81365e-05f
Cred_1868 di_tg_ctrl|di_tg_ctrl_n|vin|vout.$96.Metal1 v_b.P3.nSD 0.000126421f
Cred_1869 di_tg_ctrl|di_tg_ctrl_n|vin|vout.$96.Metal1 v_b.P3.pSD 2.16847e-06f
Cred_1870 di_tg_ctrl|di_tg_ctrl_n|vin|vout.$96.Metal1 v_c.$476.Metal3 0.00726665f
Cred_1871 di_tg_ctrl|di_tg_ctrl_n|vin|vout.$96.Metal1 v_c.P2.nSD 0.0146439f
Cred_1872 di_tg_ctrl|di_tg_ctrl_n|vin|vout.$96.Metal1 VSS.$220.Metal1 0.00190492f
Cred_1873 di_tg_ctrl|di_tg_ctrl_n|vin|vout.$96.Metal1 VSS.$241.Metal1 0.00419442f
Cred_1874 di_tg_ctrl|di_tg_ctrl_n|vin|vout.$96.Metal1 VSS.$245.Metal1 0.0265967f
Cred_1875 di_tg_ctrl|di_tg_ctrl_n|vin|vout.$96.Metal1 VSS.$255.Metal1 0.00113192f
Cred_1876 di_tg_ctrl|di_tg_ctrl_n|vin|vout.$96.Metal1 VSS.$448.Metal2 1.37211e-06f
Cred_1877 di_tg_ctrl|di_tg_ctrl_n|vin|vout.$96.Metal1 VSS.$452.Metal2 2.68988e-05f
Cred_1878 di_tg_ctrl|di_tg_ctrl_n|vin|vout.$96.Metal1 VSS.$548.Metal3 1.61289e-06f
Cred_1879 di_tg_ctrl|di_tg_ctrl_n|vin|vout.$96.Metal1 VSS.P0.pSD 0.00113038f
Cred_1880 di_tg_ctrl|di_tg_ctrl_n|vin|vout.$98.Metal1 VSS 0.00722534f
Cred_1881 di_tg_ctrl|di_tg_ctrl_n|vin|vout.$98.Metal1 v_b.$161.Metal2 0.00596339f
Cred_1882 di_tg_ctrl|di_tg_ctrl_n|vin|vout.$98.Metal1 v_b.$195.Metal2 0.00596339f
Cred_1883 di_tg_ctrl|di_tg_ctrl_n|vin|vout.$98.Metal1 v_b.P3.nSD 0.0148829f
Cred_1884 di_tg_ctrl|di_tg_ctrl_n|vin|vout.$98.Metal1 v_b.P3.pSD 0.000189787f
Cred_1885 di_tg_ctrl|di_tg_ctrl_n|vin|vout.$98.Metal1 v_c.$493.Metal3 0.00279553f
Cred_1886 di_tg_ctrl|di_tg_ctrl_n|vin|vout.$98.Metal1 v_c.P4.nSD 0.0044598f
Cred_1887 di_tg_ctrl|di_tg_ctrl_n|vin|vout.$98.Metal1 VSS.$220.Metal1 0.000579921f
Cred_1888 di_tg_ctrl|di_tg_ctrl_n|vin|vout.$98.Metal1 VSS.$245.Metal1 0.0149999f
Cred_1889 di_tg_ctrl|di_tg_ctrl_n|vin|vout.$98.Metal1 VSS.$255.Metal1 0.0172719f
Cred_1890 di_tg_ctrl|di_tg_ctrl_n|vin|vout.$98.Metal1 VSS.$448.Metal2 1.19697e-05f
Cred_1891 di_tg_ctrl|di_tg_ctrl_n|vin|vout.$98.Metal1 VSS.$452.Metal2 9.87407e-05f
Cred_1892 di_tg_ctrl|di_tg_ctrl_n|vin|vout.$98.Metal1 VSS.$548.Metal3 1.4293e-06f
Cred_1893 di_tg_ctrl|di_tg_ctrl_n|vin|vout.$98.Metal1 VSS.P0.pSD 0.000533498f
Cred_1894 di_tg_ctrl|di_tg_ctrl_n|vin|vout.P0.nSD di_tg_ctrl|di_tg_ctrl_n|vout.$180.Metal3 0.0124796f
Cred_1895 di_tg_ctrl|di_tg_ctrl_n|vin|vout.P0.nSD di_tg_ctrl|di_tg_ctrl_n|vout.$206.Metal4 0.00206667f
Cred_1896 di_tg_ctrl|di_tg_ctrl_n|vin|vout.P0.nSD di_tg_ctrl|di_tg_ctrl_n|vout.P0.nSD 0.00158358f
Cred_1897 di_tg_ctrl|di_tg_ctrl_n|vin|vout.P0.nSD di_tg_ctrl|di_tg_ctrl_n|vout.P0.pSD 0.0104905f
Cred_1898 di_tg_ctrl|di_tg_ctrl_n|vin|vout.P0.nSD VSS 0.0176035f
Cred_1899 di_tg_ctrl|di_tg_ctrl_n|vin|vout.P0.nSD v_a 0.0238587f
Cred_1900 di_tg_ctrl|di_tg_ctrl_n|vin|vout.P0.nSD v_a.$148.Metal2 0.000925677f
Cred_1901 di_tg_ctrl|di_tg_ctrl_n|vin|vout.P0.nSD v_a.P0.nSD 2.77068e-06f
Cred_1902 di_tg_ctrl|di_tg_ctrl_n|vin|vout.P0.nSD v_b 0.0168567f
Cred_1903 di_tg_ctrl|di_tg_ctrl_n|vin|vout.P0.nSD VDD.$100.Metal1 0.00162962f
Cred_1904 di_tg_ctrl|di_tg_ctrl_n|vin|vout.P0.nSD VDD.$102.Metal1 0.00271955f
Cred_1905 di_tg_ctrl|di_tg_ctrl_n|vin|vout.P0.nSD VDD.$105.Metal1 0.000211755f
Cred_1906 di_tg_ctrl|di_tg_ctrl_n|vin|vout.P0.nSD VDD.$113.Metal1 0.000211773f
Cred_1907 di_tg_ctrl|di_tg_ctrl_n|vin|vout.P0.nSD VDD.$125.Metal1 0.00391624f
Cred_1908 di_tg_ctrl|di_tg_ctrl_n|vin|vout.P0.nSD VDD.$131.Metal1 0.00283864f
Cred_1909 di_tg_ctrl|di_tg_ctrl_n|vin|vout.P0.nSD VDD.$133.Metal1 0.00171808f
Cred_1910 di_tg_ctrl|di_tg_ctrl_n|vin|vout.P0.nSD VDD.$135.Metal1 0.00171319f
Cred_1911 di_tg_ctrl|di_tg_ctrl_n|vin|vout.P0.nSD VDD.$137.Metal1 0.0017067f
Cred_1912 di_tg_ctrl|di_tg_ctrl_n|vin|vout.P0.nSD VDD.$139.Metal1 0.00171114f
Cred_1913 di_tg_ctrl|di_tg_ctrl_n|vin|vout.P0.nSD VDD.$215.Metal1 0.00025759f
Cred_1914 di_tg_ctrl|di_tg_ctrl_n|vin|vout.P0.nSD VDD.$218.Metal1 1.99281e-06f
Cred_1915 di_tg_ctrl|di_tg_ctrl_n|vin|vout.P0.nSD VDD.$257.Metal1 7.77774e-08f
Cred_1916 di_tg_ctrl|di_tg_ctrl_n|vin|vout.P0.nSD VDD.$29.Metal1 0.000168567f
Cred_1917 di_tg_ctrl|di_tg_ctrl_n|vin|vout.P0.nSD VDD.$382.Metal1 0.00073542f
Cred_1918 di_tg_ctrl|di_tg_ctrl_n|vin|vout.P0.nSD VDD.$51.Metal1 3.97156e-05f
Cred_1919 di_tg_ctrl|di_tg_ctrl_n|vin|vout.P0.nSD VDD.$552.Metal2 2.71023e-05f
Cred_1920 di_tg_ctrl|di_tg_ctrl_n|vin|vout.P0.nSD VDD.$562.Metal2 0.010059f
Cred_1921 di_tg_ctrl|di_tg_ctrl_n|vin|vout.P0.nSD VDD.$563.Metal2 0.00290262f
Cred_1922 di_tg_ctrl|di_tg_ctrl_n|vin|vout.P0.nSD VDD.$564.Metal2 0.00288083f
Cred_1923 di_tg_ctrl|di_tg_ctrl_n|vin|vout.P0.nSD VDD.$565.Metal2 0.00284908f
Cred_1924 di_tg_ctrl|di_tg_ctrl_n|vin|vout.P0.nSD VDD.$566.Metal2 0.00282635f
Cred_1925 di_tg_ctrl|di_tg_ctrl_n|vin|vout.P0.nSD VDD.$567.Metal2 0.00280322f
Cred_1926 di_tg_ctrl|di_tg_ctrl_n|vin|vout.P0.nSD VDD.$568.Metal2 0.00278f
Cred_1927 di_tg_ctrl|di_tg_ctrl_n|vin|vout.P0.nSD VDD.$569.Metal2 0.00276703f
Cred_1928 di_tg_ctrl|di_tg_ctrl_n|vin|vout.P0.nSD VDD.$570.Metal2 0.00274526f
Cred_1929 di_tg_ctrl|di_tg_ctrl_n|vin|vout.P0.nSD VDD.$571.Metal2 0.0027421f
Cred_1930 di_tg_ctrl|di_tg_ctrl_n|vin|vout.P0.nSD VDD.$572.Metal2 0.00273901f
Cred_1931 di_tg_ctrl|di_tg_ctrl_n|vin|vout.P0.nSD VDD.$573.Metal2 0.00375787f
Cred_1932 di_tg_ctrl|di_tg_ctrl_n|vin|vout.P0.nSD VDD.$597.Metal2 0.000493405f
Cred_1933 di_tg_ctrl|di_tg_ctrl_n|vin|vout.P0.nSD VDD.$606.Metal2 0.0083928f
Cred_1934 di_tg_ctrl|di_tg_ctrl_n|vin|vout.P0.nSD VDD.$607.Metal2 0.0054491f
Cred_1935 di_tg_ctrl|di_tg_ctrl_n|vin|vout.P0.nSD VDD.$608.Metal2 0.00538397f
Cred_1936 di_tg_ctrl|di_tg_ctrl_n|vin|vout.P0.nSD VDD.$609.Metal2 0.0052372f
Cred_1937 di_tg_ctrl|di_tg_ctrl_n|vin|vout.P0.nSD VDD.$610.Metal2 0.00516931f
Cred_1938 di_tg_ctrl|di_tg_ctrl_n|vin|vout.P0.nSD VDD.$611.Metal2 0.00509614f
Cred_1939 di_tg_ctrl|di_tg_ctrl_n|vin|vout.P0.nSD VDD.$612.Metal2 0.00511129f
Cred_1940 di_tg_ctrl|di_tg_ctrl_n|vin|vout.P0.nSD VDD.$613.Metal2 0.00898553f
Cred_1941 di_tg_ctrl|di_tg_ctrl_n|vin|vout.P0.nSD VDD.$614.Metal2 0.00695958f
Cred_1942 di_tg_ctrl|di_tg_ctrl_n|vin|vout.P0.nSD VDD.$615.Metal2 0.00489965f
Cred_1943 di_tg_ctrl|di_tg_ctrl_n|vin|vout.P0.nSD VDD.$616.Metal2 0.00485948f
Cred_1944 di_tg_ctrl|di_tg_ctrl_n|vin|vout.P0.nSD VDD.$617.Metal2 0.00489796f
Cred_1945 di_tg_ctrl|di_tg_ctrl_n|vin|vout.P0.nSD VDD.$618.Metal2 0.00492414f
Cred_1946 di_tg_ctrl|di_tg_ctrl_n|vin|vout.P0.nSD VDD.$619.Metal2 0.00708442f
Cred_1947 di_tg_ctrl|di_tg_ctrl_n|vin|vout.P0.nSD VDD.$620.Metal2 0.00345577f
Cred_1948 di_tg_ctrl|di_tg_ctrl_n|vin|vout.P0.nSD VDD.$621.Metal2 4.51805e-06f
Cred_1949 di_tg_ctrl|di_tg_ctrl_n|vin|vout.P0.nSD VDD.$643.Metal2 0.000428533f
Cred_1950 di_tg_ctrl|di_tg_ctrl_n|vin|vout.P0.nSD VDD.$651.Metal2 0.000568331f
Cred_1951 di_tg_ctrl|di_tg_ctrl_n|vin|vout.P0.nSD VDD.$688.Metal2 2.10947e-05f
Cred_1952 di_tg_ctrl|di_tg_ctrl_n|vin|vout.P0.nSD VDD.$844.Metal3 0.000855994f
Cred_1953 di_tg_ctrl|di_tg_ctrl_n|vin|vout.P0.nSD VDD.$852.Metal3 0.000522456f
Cred_1954 di_tg_ctrl|di_tg_ctrl_n|vin|vout.P0.nSD VDD.$856.Metal3 0.0042863f
Cred_1955 di_tg_ctrl|di_tg_ctrl_n|vin|vout.P0.nSD VDD.$864.Metal3 0.00142111f
Cred_1956 di_tg_ctrl|di_tg_ctrl_n|vin|vout.P0.nSD VDD.$90.Metal1 0.00270175f
Cred_1957 di_tg_ctrl|di_tg_ctrl_n|vin|vout.P0.nSD VDD.$92.Metal1 0.00161119f
Cred_1958 di_tg_ctrl|di_tg_ctrl_n|vin|vout.P0.nSD VDD.$94.Metal1 0.00160661f
Cred_1959 di_tg_ctrl|di_tg_ctrl_n|vin|vout.P0.nSD VDD.$96.Metal1 0.00160052f
Cred_1960 di_tg_ctrl|di_tg_ctrl_n|vin|vout.P0.nSD VDD.$98.Metal1 0.00159405f
Cred_1961 di_tg_ctrl|di_tg_ctrl_n|vin|vout.P0.nSD VDD.P0.GatPoly 7.08587e-09f
Cred_1962 di_tg_ctrl|di_tg_ctrl_n|vin|vout.P0.nSD VDD.P0.nSD 0.00231565f
Cred_1963 di_tg_ctrl|di_tg_ctrl_n|vin|vout.P0.nSD VDD.P0.pSD 7.59371e-07f
Cred_1964 di_tg_ctrl|di_tg_ctrl_n|vin|vout.P0.nSD VDD.P1.pSD 0.00010754f
Cred_1965 di_tg_ctrl|di_tg_ctrl_n|vin|vout.P0.nSD VDD.P3.pSD 0.000428941f
Cred_1966 di_tg_ctrl|di_tg_ctrl_n|vin|vout.P0.nSD VSS.$129.Metal1 2.64766e-05f
Cred_1967 di_tg_ctrl|di_tg_ctrl_n|vin|vout.P0.nSD VSS.$132.Metal1 9.42569e-07f
Cred_1968 di_tg_ctrl|di_tg_ctrl_n|vin|vout.P0.nSD VSS.$156.Metal1 4.46143e-07f
Cred_1969 di_tg_ctrl|di_tg_ctrl_n|vin|vout.P0.nSD VSS.$175.Metal1 9.06802e-10f
Cred_1970 di_tg_ctrl|di_tg_ctrl_n|vin|vout.P0.nSD VSS.$220.Metal1 4.08062e-06f
Cred_1971 di_tg_ctrl|di_tg_ctrl_n|vin|vout.P0.nSD VSS.$284.Metal2 0.04393f
Cred_1972 di_tg_ctrl|di_tg_ctrl_n|vin|vout.P0.nSD VSS.$303.Metal2 0.00395375f
Cred_1973 di_tg_ctrl|di_tg_ctrl_n|vin|vout.P0.nSD VSS.$307.Metal2 1.99095e-05f
Cred_1974 di_tg_ctrl|di_tg_ctrl_n|vin|vout.P0.nSD VSS.$311.Metal2 0.0562929f
Cred_1975 di_tg_ctrl|di_tg_ctrl_n|vin|vout.P0.nSD VSS.$321.Metal2 1.34283e-06f
Cred_1976 di_tg_ctrl|di_tg_ctrl_n|vin|vout.P0.nSD VSS.$329.Metal2 4.12733e-05f
Cred_1977 di_tg_ctrl|di_tg_ctrl_n|vin|vout.P0.nSD VSS.$33.Metal1 0.0590579f
Cred_1978 di_tg_ctrl|di_tg_ctrl_n|vin|vout.P0.nSD VSS.$339.Metal2 3.82827e-05f
Cred_1979 di_tg_ctrl|di_tg_ctrl_n|vin|vout.P0.nSD VSS.$350.Metal2 1.70892e-06f
Cred_1980 di_tg_ctrl|di_tg_ctrl_n|vin|vout.P0.nSD VSS.$354.Metal2 1.70046e-06f
Cred_1981 di_tg_ctrl|di_tg_ctrl_n|vin|vout.P0.nSD VSS.$359.Metal2 0.00132391f
Cred_1982 di_tg_ctrl|di_tg_ctrl_n|vin|vout.P0.nSD VSS.$368.Metal2 0.000406635f
Cred_1983 di_tg_ctrl|di_tg_ctrl_n|vin|vout.P0.nSD VSS.$372.Metal2 7.33837e-05f
Cred_1984 di_tg_ctrl|di_tg_ctrl_n|vin|vout.P0.nSD VSS.$376.Metal2 6.76802e-05f
Cred_1985 di_tg_ctrl|di_tg_ctrl_n|vin|vout.P0.nSD VSS.$384.Metal2 4.57392e-07f
Cred_1986 di_tg_ctrl|di_tg_ctrl_n|vin|vout.P0.nSD VSS.$392.Metal2 2.26649e-07f
Cred_1987 di_tg_ctrl|di_tg_ctrl_n|vin|vout.P0.nSD VSS.$42.Metal1 0.00345982f
Cred_1988 di_tg_ctrl|di_tg_ctrl_n|vin|vout.P0.nSD VSS.$478.Metal3 0.00127457f
Cred_1989 di_tg_ctrl|di_tg_ctrl_n|vin|vout.P0.nSD VSS.$484.Metal3 0.00142964f
Cred_1990 di_tg_ctrl|di_tg_ctrl_n|vin|vout.P0.nSD VSS.$488.Metal3 0.00139718f
Cred_1991 di_tg_ctrl|di_tg_ctrl_n|vin|vout.P0.nSD VSS.$496.Metal3 0.000941782f
Cred_1992 di_tg_ctrl|di_tg_ctrl_n|vin|vout.P0.nSD VSS.$5.Metal1 4.29148e-05f
Cred_1993 di_tg_ctrl|di_tg_ctrl_n|vin|vout.P0.nSD VSS.$502.Metal3 0.000795107f
Cred_1994 di_tg_ctrl|di_tg_ctrl_n|vin|vout.P0.nSD VSS.$510.Metal3 0.000552772f
Cred_1995 di_tg_ctrl|di_tg_ctrl_n|vin|vout.P0.nSD VSS.$518.Metal3 1.41623e-05f
Cred_1996 di_tg_ctrl|di_tg_ctrl_n|vin|vout.P0.nSD VSS.$61.Metal1 0.00172111f
Cred_1997 di_tg_ctrl|di_tg_ctrl_n|vin|vout.P0.nSD VSS.$78.Metal1 0.0542198f
Cred_1998 di_tg_ctrl|di_tg_ctrl_n|vin|vout.P0.nSD VSS.$87.Metal1 0.0018245f
Cred_1999 di_tg_ctrl|di_tg_ctrl_n|vin|vout.P0.nSD VSS.$94.Metal1 2.74589e-07f
Cred_2000 di_tg_ctrl|di_tg_ctrl_n|vin|vout.P0.nSD VSS.P0.nSD 0.000490432f
Cred_2001 di_tg_ctrl|di_tg_ctrl_n|vin|vout.P0.nSD VSS.P0.pSD 0.000356874f
Cred_2002 di_tg_ctrl|di_tg_ctrl_n|vin|vout.P0.nSD VSS.P1.GatPoly 7.71613e-05f
Cred_2003 di_tg_ctrl|di_tg_ctrl_n|vin|vout.P0.nSD VSS.P1.nSD 0.000490432f
Cred_2004 di_tg_ctrl|di_tg_ctrl_n|vin|vout.P0.nSD VSS.P2.GatPoly 1.51869e-07f
Cred_2005 di_tg_ctrl|di_tg_ctrl_n|vin|vout.P0.nSD VSS.P3.nSD 0.000846849f
Cred_2006 di_tg_ctrl|di_tg_ctrl_n|vin|vout.P0.nSD VSS.P5.nSD 0.000559458f
Cred_2007 di_tg_ctrl|di_tg_ctrl_n|vin|vout.P0.nSD VSS.P6.nSD 1.19936e-06f
Cred_2008 di_tg_ctrl|di_tg_ctrl_n|vin|vout.P0.nSD VSS.P7.nSD 1.50502e-06f
Cred_2009 di_tg_ctrl|di_tg_ctrl_n|vin|vout.P0.pSD di_tg_ctrl|di_tg_ctrl_n|vout.$180.Metal3 0.0816848f
Cred_2010 di_tg_ctrl|di_tg_ctrl_n|vin|vout.P0.pSD di_tg_ctrl|di_tg_ctrl_n|vout.$206.Metal4 0.0140309f
Cred_2011 di_tg_ctrl|di_tg_ctrl_n|vin|vout.P0.pSD di_tg_ctrl|di_tg_ctrl_n|vout.P0.nSD 0.0104131f
Cred_2012 di_tg_ctrl|di_tg_ctrl_n|vin|vout.P0.pSD di_tg_ctrl|di_tg_ctrl_n|vout.P0.pSD 0.0754303f
Cred_2013 di_tg_ctrl|di_tg_ctrl_n|vin|vout.P0.pSD VSS 0.0764104f
Cred_2014 di_tg_ctrl|di_tg_ctrl_n|vin|vout.P0.pSD v_a 0.123443f
Cred_2015 di_tg_ctrl|di_tg_ctrl_n|vin|vout.P0.pSD v_a.$148.Metal2 0.00480513f
Cred_2016 di_tg_ctrl|di_tg_ctrl_n|vin|vout.P0.pSD v_a.P0.nSD 1.43824e-05f
Cred_2017 di_tg_ctrl|di_tg_ctrl_n|vin|vout.P0.pSD v_b 0.115987f
Cred_2018 di_tg_ctrl|di_tg_ctrl_n|vin|vout.P0.pSD VDD.$100.Metal1 0.0488994f
Cred_2019 di_tg_ctrl|di_tg_ctrl_n|vin|vout.P0.pSD VDD.$102.Metal1 0.0826753f
Cred_2020 di_tg_ctrl|di_tg_ctrl_n|vin|vout.P0.pSD VDD.$105.Metal1 0.00603321f
Cred_2021 di_tg_ctrl|di_tg_ctrl_n|vin|vout.P0.pSD VDD.$113.Metal1 0.00603339f
Cred_2022 di_tg_ctrl|di_tg_ctrl_n|vin|vout.P0.pSD VDD.$125.Metal1 0.118395f
Cred_2023 di_tg_ctrl|di_tg_ctrl_n|vin|vout.P0.pSD VDD.$131.Metal1 0.0840988f
Cred_2024 di_tg_ctrl|di_tg_ctrl_n|vin|vout.P0.pSD VDD.$133.Metal1 0.050579f
Cred_2025 di_tg_ctrl|di_tg_ctrl_n|vin|vout.P0.pSD VDD.$135.Metal1 0.0505101f
Cred_2026 di_tg_ctrl|di_tg_ctrl_n|vin|vout.P0.pSD VDD.$137.Metal1 0.0505308f
Cred_2027 di_tg_ctrl|di_tg_ctrl_n|vin|vout.P0.pSD VDD.$139.Metal1 0.0509587f
Cred_2028 di_tg_ctrl|di_tg_ctrl_n|vin|vout.P0.pSD VDD.$215.Metal1 0.00134082f
Cred_2029 di_tg_ctrl|di_tg_ctrl_n|vin|vout.P0.pSD VDD.$218.Metal1 1.94635e-05f
Cred_2030 di_tg_ctrl|di_tg_ctrl_n|vin|vout.P0.pSD VDD.$257.Metal1 7.59641e-07f
Cred_2031 di_tg_ctrl|di_tg_ctrl_n|vin|vout.P0.pSD VDD.$29.Metal1 0.000892415f
Cred_2032 di_tg_ctrl|di_tg_ctrl_n|vin|vout.P0.pSD VDD.$382.Metal1 0.00382715f
Cred_2033 di_tg_ctrl|di_tg_ctrl_n|vin|vout.P0.pSD VDD.$51.Metal1 0.000466942f
Cred_2034 di_tg_ctrl|di_tg_ctrl_n|vin|vout.P0.pSD VDD.$552.Metal2 0.000264705f
Cred_2035 di_tg_ctrl|di_tg_ctrl_n|vin|vout.P0.pSD VDD.$562.Metal2 0.119901f
Cred_2036 di_tg_ctrl|di_tg_ctrl_n|vin|vout.P0.pSD VDD.$563.Metal2 0.0359585f
Cred_2037 di_tg_ctrl|di_tg_ctrl_n|vin|vout.P0.pSD VDD.$564.Metal2 0.0364131f
Cred_2038 di_tg_ctrl|di_tg_ctrl_n|vin|vout.P0.pSD VDD.$565.Metal2 0.0365097f
Cred_2039 di_tg_ctrl|di_tg_ctrl_n|vin|vout.P0.pSD VDD.$566.Metal2 0.0367919f
Cred_2040 di_tg_ctrl|di_tg_ctrl_n|vin|vout.P0.pSD VDD.$567.Metal2 0.0369702f
Cred_2041 di_tg_ctrl|di_tg_ctrl_n|vin|vout.P0.pSD VDD.$568.Metal2 0.0370421f
Cred_2042 di_tg_ctrl|di_tg_ctrl_n|vin|vout.P0.pSD VDD.$569.Metal2 0.0373071f
Cred_2043 di_tg_ctrl|di_tg_ctrl_n|vin|vout.P0.pSD VDD.$570.Metal2 0.0371884f
Cred_2044 di_tg_ctrl|di_tg_ctrl_n|vin|vout.P0.pSD VDD.$571.Metal2 0.0375016f
Cred_2045 di_tg_ctrl|di_tg_ctrl_n|vin|vout.P0.pSD VDD.$572.Metal2 0.0376893f
Cred_2046 di_tg_ctrl|di_tg_ctrl_n|vin|vout.P0.pSD VDD.$573.Metal2 0.0520011f
Cred_2047 di_tg_ctrl|di_tg_ctrl_n|vin|vout.P0.pSD VDD.$597.Metal2 0.0105723f
Cred_2048 di_tg_ctrl|di_tg_ctrl_n|vin|vout.P0.pSD VDD.$606.Metal2 0.0698702f
Cred_2049 di_tg_ctrl|di_tg_ctrl_n|vin|vout.P0.pSD VDD.$607.Metal2 0.0514793f
Cred_2050 di_tg_ctrl|di_tg_ctrl_n|vin|vout.P0.pSD VDD.$608.Metal2 0.0541254f
Cred_2051 di_tg_ctrl|di_tg_ctrl_n|vin|vout.P0.pSD VDD.$609.Metal2 0.0541118f
Cred_2052 di_tg_ctrl|di_tg_ctrl_n|vin|vout.P0.pSD VDD.$610.Metal2 0.0549455f
Cred_2053 di_tg_ctrl|di_tg_ctrl_n|vin|vout.P0.pSD VDD.$611.Metal2 0.0553558f
Cred_2054 di_tg_ctrl|di_tg_ctrl_n|vin|vout.P0.pSD VDD.$612.Metal2 0.0565737f
Cred_2055 di_tg_ctrl|di_tg_ctrl_n|vin|vout.P0.pSD VDD.$613.Metal2 0.0954519f
Cred_2056 di_tg_ctrl|di_tg_ctrl_n|vin|vout.P0.pSD VDD.$614.Metal2 0.0671322f
Cred_2057 di_tg_ctrl|di_tg_ctrl_n|vin|vout.P0.pSD VDD.$615.Metal2 0.0570656f
Cred_2058 di_tg_ctrl|di_tg_ctrl_n|vin|vout.P0.pSD VDD.$616.Metal2 0.0570449f
Cred_2059 di_tg_ctrl|di_tg_ctrl_n|vin|vout.P0.pSD VDD.$617.Metal2 0.0591131f
Cred_2060 di_tg_ctrl|di_tg_ctrl_n|vin|vout.P0.pSD VDD.$618.Metal2 0.0605149f
Cred_2061 di_tg_ctrl|di_tg_ctrl_n|vin|vout.P0.pSD VDD.$619.Metal2 0.0855458f
Cred_2062 di_tg_ctrl|di_tg_ctrl_n|vin|vout.P0.pSD VDD.$620.Metal2 0.033752f
Cred_2063 di_tg_ctrl|di_tg_ctrl_n|vin|vout.P0.pSD VDD.$621.Metal2 4.41272e-05f
Cred_2064 di_tg_ctrl|di_tg_ctrl_n|vin|vout.P0.pSD VDD.$643.Metal2 0.00418542f
Cred_2065 di_tg_ctrl|di_tg_ctrl_n|vin|vout.P0.pSD VDD.$651.Metal2 0.00555081f
Cred_2066 di_tg_ctrl|di_tg_ctrl_n|vin|vout.P0.pSD VDD.$688.Metal2 0.000206029f
Cred_2067 di_tg_ctrl|di_tg_ctrl_n|vin|vout.P0.pSD VDD.$844.Metal3 0.00836038f
Cred_2068 di_tg_ctrl|di_tg_ctrl_n|vin|vout.P0.pSD VDD.$852.Metal3 0.00510275f
Cred_2069 di_tg_ctrl|di_tg_ctrl_n|vin|vout.P0.pSD VDD.$856.Metal3 0.0418637f
Cred_2070 di_tg_ctrl|di_tg_ctrl_n|vin|vout.P0.pSD VDD.$864.Metal3 0.0138798f
Cred_2071 di_tg_ctrl|di_tg_ctrl_n|vin|vout.P0.pSD VDD.$90.Metal1 0.0793337f
Cred_2072 di_tg_ctrl|di_tg_ctrl_n|vin|vout.P0.pSD VDD.$92.Metal1 0.0474323f
Cred_2073 di_tg_ctrl|di_tg_ctrl_n|vin|vout.P0.pSD VDD.$94.Metal1 0.0473677f
Cred_2074 di_tg_ctrl|di_tg_ctrl_n|vin|vout.P0.pSD VDD.$96.Metal1 0.0473871f
Cred_2075 di_tg_ctrl|di_tg_ctrl_n|vin|vout.P0.pSD VDD.$98.Metal1 0.0474701f
Cred_2076 di_tg_ctrl|di_tg_ctrl_n|vin|vout.P0.pSD VDD.P0.GatPoly 6.92067e-08f
Cred_2077 di_tg_ctrl|di_tg_ctrl_n|vin|vout.P0.pSD VDD.P0.nSD 0.0121177f
Cred_2078 di_tg_ctrl|di_tg_ctrl_n|vin|vout.P0.pSD VDD.P0.pSD 8.91592e-06f
Cred_2079 di_tg_ctrl|di_tg_ctrl_n|vin|vout.P0.pSD VDD.P1.pSD 0.00321599f
Cred_2080 di_tg_ctrl|di_tg_ctrl_n|vin|vout.P0.pSD VDD.P3.pSD 0.00917968f
Cred_2081 di_tg_ctrl|di_tg_ctrl_n|vin|vout.P0.pSD VSS.$129.Metal1 0.000137438f
Cred_2082 di_tg_ctrl|di_tg_ctrl_n|vin|vout.P0.pSD VSS.$132.Metal1 4.89282e-06f
Cred_2083 di_tg_ctrl|di_tg_ctrl_n|vin|vout.P0.pSD VSS.$156.Metal1 2.3159e-06f
Cred_2084 di_tg_ctrl|di_tg_ctrl_n|vin|vout.P0.pSD VSS.$175.Metal1 4.70715e-09f
Cred_2085 di_tg_ctrl|di_tg_ctrl_n|vin|vout.P0.pSD VSS.$220.Metal1 2.11822e-05f
Cred_2086 di_tg_ctrl|di_tg_ctrl_n|vin|vout.P0.pSD VSS.$284.Metal2 0.0473307f
Cred_2087 di_tg_ctrl|di_tg_ctrl_n|vin|vout.P0.pSD VSS.$303.Metal2 0.00230777f
Cred_2088 di_tg_ctrl|di_tg_ctrl_n|vin|vout.P0.pSD VSS.$307.Metal2 3.17633e-05f
Cred_2089 di_tg_ctrl|di_tg_ctrl_n|vin|vout.P0.pSD VSS.$311.Metal2 0.106466f
Cred_2090 di_tg_ctrl|di_tg_ctrl_n|vin|vout.P0.pSD VSS.$321.Metal2 6.97056e-06f
Cred_2091 di_tg_ctrl|di_tg_ctrl_n|vin|vout.P0.pSD VSS.$329.Metal2 0.000214247f
Cred_2092 di_tg_ctrl|di_tg_ctrl_n|vin|vout.P0.pSD VSS.$33.Metal1 0.0163806f
Cred_2093 di_tg_ctrl|di_tg_ctrl_n|vin|vout.P0.pSD VSS.$339.Metal2 0.000198723f
Cred_2094 di_tg_ctrl|di_tg_ctrl_n|vin|vout.P0.pSD VSS.$350.Metal2 8.87089e-06f
Cred_2095 di_tg_ctrl|di_tg_ctrl_n|vin|vout.P0.pSD VSS.$354.Metal2 8.82697e-06f
Cred_2096 di_tg_ctrl|di_tg_ctrl_n|vin|vout.P0.pSD VSS.$359.Metal2 0.00687236f
Cred_2097 di_tg_ctrl|di_tg_ctrl_n|vin|vout.P0.pSD VSS.$368.Metal2 0.00211082f
Cred_2098 di_tg_ctrl|di_tg_ctrl_n|vin|vout.P0.pSD VSS.$372.Metal2 0.00038093f
Cred_2099 di_tg_ctrl|di_tg_ctrl_n|vin|vout.P0.pSD VSS.$376.Metal2 0.000351324f
Cred_2100 di_tg_ctrl|di_tg_ctrl_n|vin|vout.P0.pSD VSS.$384.Metal2 2.37429e-06f
Cred_2101 di_tg_ctrl|di_tg_ctrl_n|vin|vout.P0.pSD VSS.$392.Metal2 1.17652e-06f
Cred_2102 di_tg_ctrl|di_tg_ctrl_n|vin|vout.P0.pSD VSS.$42.Metal1 0.000798031f
Cred_2103 di_tg_ctrl|di_tg_ctrl_n|vin|vout.P0.pSD VSS.$478.Metal3 0.00517929f
Cred_2104 di_tg_ctrl|di_tg_ctrl_n|vin|vout.P0.pSD VSS.$484.Metal3 0.0067056f
Cred_2105 di_tg_ctrl|di_tg_ctrl_n|vin|vout.P0.pSD VSS.$488.Metal3 0.0072527f
Cred_2106 di_tg_ctrl|di_tg_ctrl_n|vin|vout.P0.pSD VSS.$496.Metal3 0.00488873f
Cred_2107 di_tg_ctrl|di_tg_ctrl_n|vin|vout.P0.pSD VSS.$5.Metal1 0.000222768f
Cred_2108 di_tg_ctrl|di_tg_ctrl_n|vin|vout.P0.pSD VSS.$502.Metal3 0.00412735f
Cred_2109 di_tg_ctrl|di_tg_ctrl_n|vin|vout.P0.pSD VSS.$510.Metal3 0.0028694f
Cred_2110 di_tg_ctrl|di_tg_ctrl_n|vin|vout.P0.pSD VSS.$518.Metal3 7.35158e-05f
Cred_2111 di_tg_ctrl|di_tg_ctrl_n|vin|vout.P0.pSD VSS.$61.Metal1 0.000396987f
Cred_2112 di_tg_ctrl|di_tg_ctrl_n|vin|vout.P0.pSD VSS.$78.Metal1 0.0148332f
Cred_2113 di_tg_ctrl|di_tg_ctrl_n|vin|vout.P0.pSD VSS.$87.Metal1 0.00947085f
Cred_2114 di_tg_ctrl|di_tg_ctrl_n|vin|vout.P0.pSD VSS.$94.Metal1 1.42538e-06f
Cred_2115 di_tg_ctrl|di_tg_ctrl_n|vin|vout.P0.pSD VSS.P0.nSD 0.000126397f
Cred_2116 di_tg_ctrl|di_tg_ctrl_n|vin|vout.P0.pSD VSS.P0.pSD 0.00181845f
Cred_2117 di_tg_ctrl|di_tg_ctrl_n|vin|vout.P0.pSD VSS.P1.GatPoly 1.89195e-05f
Cred_2118 di_tg_ctrl|di_tg_ctrl_n|vin|vout.P0.pSD VSS.P1.nSD 0.000126397f
Cred_2119 di_tg_ctrl|di_tg_ctrl_n|vin|vout.P0.pSD VSS.P2.GatPoly 7.88342e-07f
Cred_2120 di_tg_ctrl|di_tg_ctrl_n|vin|vout.P0.pSD VSS.P3.nSD 0.000205652f
Cred_2121 di_tg_ctrl|di_tg_ctrl_n|vin|vout.P0.pSD VSS.P5.nSD 0.000138351f
Cred_2122 di_tg_ctrl|di_tg_ctrl_n|vin|vout.P0.pSD VSS.P6.nSD 6.22579e-06f
Cred_2123 di_tg_ctrl|di_tg_ctrl_n|vin|vout.P0.pSD VSS.P7.nSD 7.81248e-06f
Cred_2124 di_tg_ctrl|di_tg_ctrl_n|vin|vout.P1.GatPoly di_tg_ctrl|di_tg_ctrl_n|vout.P5.GatPoly 0.00203485f
Cred_2125 di_tg_ctrl|di_tg_ctrl_n|vin|vout.P1.GatPoly VSS 0.0134859f
Cred_2126 di_tg_ctrl|di_tg_ctrl_n|vin|vout.P1.GatPoly v_b.$161.Metal2 0.0082325f
Cred_2127 di_tg_ctrl|di_tg_ctrl_n|vin|vout.P1.GatPoly v_b.P1.nSD 0.00449935f
Cred_2128 di_tg_ctrl|di_tg_ctrl_n|vin|vout.P1.GatPoly v_c.$459.Metal3 0.0049386f
Cred_2129 di_tg_ctrl|di_tg_ctrl_n|vin|vout.P1.GatPoly v_c.$476.Metal3 3.7292e-06f
Cred_2130 di_tg_ctrl|di_tg_ctrl_n|vin|vout.P1.GatPoly v_c.P0.nSD 0.00602682f
Cred_2131 di_tg_ctrl|di_tg_ctrl_n|vin|vout.P1.GatPoly v_c.P2.nSD 6.10862e-06f
Cred_2132 di_tg_ctrl|di_tg_ctrl_n|vin|vout.P1.GatPoly VSS.$220.Metal1 0.00145405f
Cred_2133 di_tg_ctrl|di_tg_ctrl_n|vin|vout.P1.GatPoly VSS.$231.Metal1 6.99167e-06f
Cred_2134 di_tg_ctrl|di_tg_ctrl_n|vin|vout.P1.GatPoly VSS.$241.Metal1 5.01301e-05f
Cred_2135 di_tg_ctrl|di_tg_ctrl_n|vin|vout.P1.GatPoly VSS.$255.Metal1 0.000221645f
Cred_2136 di_tg_ctrl|di_tg_ctrl_n|vin|vout.P1.GatPoly VSS.$436.Metal2 5.39274e-08f
Cred_2137 di_tg_ctrl|di_tg_ctrl_n|vin|vout.P1.GatPoly VSS.$440.Metal2 1.08401e-07f
Cred_2138 di_tg_ctrl|di_tg_ctrl_n|vin|vout.P1.GatPoly VSS.$452.Metal2 9.01576e-06f
Cred_2139 di_tg_ctrl|di_tg_ctrl_n|vin|vout.P1.GatPoly VSS.$548.Metal3 6.48615e-07f
Cred_2140 di_tg_ctrl|di_tg_ctrl_n|vin|vout.P1.GatPoly VSS.P0.pSD 0.00054598f
Cred_2141 di_tg_ctrl|di_tg_ctrl_n|vin|vout.P10.GatPoly di_tg_ctrl|di_tg_ctrl_n|vout.$206.Metal4 0.00169193f
Cred_2142 di_tg_ctrl|di_tg_ctrl_n|vin|vout.P10.GatPoly di_tg_ctrl|di_tg_ctrl_n|vout.P6.GatPoly 0.010218f
Cred_2143 di_tg_ctrl|di_tg_ctrl_n|vin|vout.P10.GatPoly v_a.$182.Metal2 0.031171f
Cred_2144 di_tg_ctrl|di_tg_ctrl_n|vin|vout.P10.GatPoly v_a.P3.pSD 0.0327646f
Cred_2145 di_tg_ctrl|di_tg_ctrl_n|vin|vout.P10.GatPoly v_b 0.00190169f
Cred_2146 di_tg_ctrl|di_tg_ctrl_n|vin|vout.P10.GatPoly v_b.$195.Metal2 0.000630827f
Cred_2147 di_tg_ctrl|di_tg_ctrl_n|vin|vout.P10.GatPoly v_c.$284.Metal2 0.00177662f
Cred_2148 di_tg_ctrl|di_tg_ctrl_n|vin|vout.P10.GatPoly v_c.$288.Metal2 0.000118269f
Cred_2149 di_tg_ctrl|di_tg_ctrl_n|vin|vout.P10.GatPoly v_c.$290.Metal2 2.26676e-06f
Cred_2150 di_tg_ctrl|di_tg_ctrl_n|vin|vout.P10.GatPoly v_c.$292.Metal2 0.00520909f
Cred_2151 di_tg_ctrl|di_tg_ctrl_n|vin|vout.P10.GatPoly v_c.$425.Metal3 0.00125625f
Cred_2152 di_tg_ctrl|di_tg_ctrl_n|vin|vout.P10.GatPoly v_c.$446.Metal3 0.00134092f
Cred_2153 di_tg_ctrl|di_tg_ctrl_n|vin|vout.P10.GatPoly v_c.$450.Metal3 0.00224067f
Cred_2154 di_tg_ctrl|di_tg_ctrl_n|vin|vout.P10.GatPoly v_c.$459.Metal3 0.000421504f
Cred_2155 di_tg_ctrl|di_tg_ctrl_n|vin|vout.P10.GatPoly v_c.$93.Metal1 0.0285568f
Cred_2156 di_tg_ctrl|di_tg_ctrl_n|vin|vout.P10.GatPoly v_c.$95.Metal1 0.0236301f
Cred_2157 di_tg_ctrl|di_tg_ctrl_n|vin|vout.P10.GatPoly v_c.P10.nSD 7.54634e-06f
Cred_2158 di_tg_ctrl|di_tg_ctrl_n|vin|vout.P10.GatPoly v_c.P10.pSD 0.00716497f
Cred_2159 di_tg_ctrl|di_tg_ctrl_n|vin|vout.P10.GatPoly VDD.$382.Metal1 0.00149368f
Cred_2160 di_tg_ctrl|di_tg_ctrl_n|vin|vout.P10.GatPoly VDD.$477.Metal1 0.000230119f
Cred_2161 di_tg_ctrl|di_tg_ctrl_n|vin|vout.P10.GatPoly VDD.$526.Metal1 5.73156e-05f
Cred_2162 di_tg_ctrl|di_tg_ctrl_n|vin|vout.P10.GatPoly VDD.P0.nSD 0.00208773f
Cred_2163 di_tg_ctrl|di_tg_ctrl_n|vin|vout.P10.GatPoly VDD.P3.GatPoly 0.00637054f
Cred_2164 di_tg_ctrl|di_tg_ctrl_n|vin|vout.P11.GatPoly di_tg_ctrl|di_tg_ctrl_n|vout.$14.GatPoly 0.000184601f
Cred_2165 di_tg_ctrl|di_tg_ctrl_n|vin|vout.P11.GatPoly di_tg_ctrl|di_tg_ctrl_n|vout.$144.Metal2 1.39043e-07f
Cred_2166 di_tg_ctrl|di_tg_ctrl_n|vin|vout.P11.GatPoly di_tg_ctrl|di_tg_ctrl_n|vout.$17.GatPoly 5.8019e-05f
Cred_2167 di_tg_ctrl|di_tg_ctrl_n|vin|vout.P11.GatPoly di_tg_ctrl|di_tg_ctrl_n|vout.$192.Metal3 5.39744e-09f
Cred_2168 di_tg_ctrl|di_tg_ctrl_n|vin|vout.P11.GatPoly di_tg_ctrl|di_tg_ctrl_n|vout.$206.Metal4 0.00169203f
Cred_2169 di_tg_ctrl|di_tg_ctrl_n|vin|vout.P11.GatPoly di_tg_ctrl|di_tg_ctrl_n|vout.$209.Metal4 3.5115e-11f
Cred_2170 di_tg_ctrl|di_tg_ctrl_n|vin|vout.P11.GatPoly di_tg_ctrl|di_tg_ctrl_n|vout.$21.GatPoly 6.45525e-05f
Cred_2171 di_tg_ctrl|di_tg_ctrl_n|vin|vout.P11.GatPoly di_tg_ctrl|di_tg_ctrl_n|vout.$77.Metal1 8.74799e-05f
Cred_2172 di_tg_ctrl|di_tg_ctrl_n|vin|vout.P11.GatPoly di_tg_ctrl|di_tg_ctrl_n|vout.$79.Metal1 1.58218e-05f
Cred_2173 di_tg_ctrl|di_tg_ctrl_n|vin|vout.P11.GatPoly di_tg_ctrl|di_tg_ctrl_n|vout.$81.Metal1 2.29799e-06f
Cred_2174 di_tg_ctrl|di_tg_ctrl_n|vin|vout.P11.GatPoly di_tg_ctrl|di_tg_ctrl_n|vout.$84.Metal1 8.65551e-06f
Cred_2175 di_tg_ctrl|di_tg_ctrl_n|vin|vout.P11.GatPoly di_tg_ctrl|di_tg_ctrl_n|vout.$86.Metal1 4.99187e-06f
Cred_2176 di_tg_ctrl|di_tg_ctrl_n|vin|vout.P11.GatPoly di_tg_ctrl|di_tg_ctrl_n|vout.P10.GatPoly 0.00676391f
Cred_2177 di_tg_ctrl|di_tg_ctrl_n|vin|vout.P11.GatPoly di_tg_ctrl|di_tg_ctrl_n|vout.P11.GatPoly 0.00615484f
Cred_2178 di_tg_ctrl|di_tg_ctrl_n|vin|vout.P11.GatPoly di_tg_ctrl|di_tg_ctrl_n|vout.P6.GatPoly 0.025351f
Cred_2179 di_tg_ctrl|di_tg_ctrl_n|vin|vout.P11.GatPoly di_tg_ctrl|di_tg_ctrl_n|vout.P7.GatPoly 0.0100713f
Cred_2180 di_tg_ctrl|di_tg_ctrl_n|vin|vout.P11.GatPoly di_tg_ctrl|di_tg_ctrl_n|vout.P8.GatPoly 0.00863685f
Cred_2181 di_tg_ctrl|di_tg_ctrl_n|vin|vout.P11.GatPoly di_tg_ctrl|di_tg_ctrl_n|vout.P9.GatPoly 0.00757851f
Cred_2182 di_tg_ctrl|di_tg_ctrl_n|vin|vout.P11.GatPoly VSS 0.000177726f
Cred_2183 di_tg_ctrl|di_tg_ctrl_n|vin|vout.P11.GatPoly v_a.$182.Metal2 0.0293904f
Cred_2184 di_tg_ctrl|di_tg_ctrl_n|vin|vout.P11.GatPoly v_a.P3.pSD 8.45246e-07f
Cred_2185 di_tg_ctrl|di_tg_ctrl_n|vin|vout.P11.GatPoly v_a.P5.nSD 0.000215116f
Cred_2186 di_tg_ctrl|di_tg_ctrl_n|vin|vout.P11.GatPoly v_a.P5.pSD 0.035246f
Cred_2187 di_tg_ctrl|di_tg_ctrl_n|vin|vout.P11.GatPoly v_b 0.00440359f
Cred_2188 di_tg_ctrl|di_tg_ctrl_n|vin|vout.P11.GatPoly v_b.$195.Metal2 0.00146075f
Cred_2189 di_tg_ctrl|di_tg_ctrl_n|vin|vout.P11.GatPoly v_c.$284.Metal2 0.0017578f
Cred_2190 di_tg_ctrl|di_tg_ctrl_n|vin|vout.P11.GatPoly v_c.$288.Metal2 0.000116456f
Cred_2191 di_tg_ctrl|di_tg_ctrl_n|vin|vout.P11.GatPoly v_c.$290.Metal2 2.26676e-06f
Cred_2192 di_tg_ctrl|di_tg_ctrl_n|vin|vout.P11.GatPoly v_c.$292.Metal2 0.00533202f
Cred_2193 di_tg_ctrl|di_tg_ctrl_n|vin|vout.P11.GatPoly v_c.$425.Metal3 0.00125625f
Cred_2194 di_tg_ctrl|di_tg_ctrl_n|vin|vout.P11.GatPoly v_c.$446.Metal3 0.00134088f
Cred_2195 di_tg_ctrl|di_tg_ctrl_n|vin|vout.P11.GatPoly v_c.$450.Metal3 0.00233996f
Cred_2196 di_tg_ctrl|di_tg_ctrl_n|vin|vout.P11.GatPoly v_c.$459.Metal3 0.000421504f
Cred_2197 di_tg_ctrl|di_tg_ctrl_n|vin|vout.P11.GatPoly v_c.$93.Metal1 0.0280048f
Cred_2198 di_tg_ctrl|di_tg_ctrl_n|vin|vout.P11.GatPoly v_c.$95.Metal1 0.0238135f
Cred_2199 di_tg_ctrl|di_tg_ctrl_n|vin|vout.P11.GatPoly v_c.P10.nSD 7.54634e-06f
Cred_2200 di_tg_ctrl|di_tg_ctrl_n|vin|vout.P11.GatPoly v_c.P10.pSD 0.00730609f
Cred_2201 di_tg_ctrl|di_tg_ctrl_n|vin|vout.P11.GatPoly VDD.$382.Metal1 0.00132017f
Cred_2202 di_tg_ctrl|di_tg_ctrl_n|vin|vout.P11.GatPoly VDD.$434.Metal1 8.0532e-06f
Cred_2203 di_tg_ctrl|di_tg_ctrl_n|vin|vout.P11.GatPoly VDD.$438.Metal1 8.13884e-05f
Cred_2204 di_tg_ctrl|di_tg_ctrl_n|vin|vout.P11.GatPoly VDD.$442.Metal1 0.000111511f
Cred_2205 di_tg_ctrl|di_tg_ctrl_n|vin|vout.P11.GatPoly VDD.$446.Metal1 4.87105e-05f
Cred_2206 di_tg_ctrl|di_tg_ctrl_n|vin|vout.P11.GatPoly VDD.$477.Metal1 0.000261976f
Cred_2207 di_tg_ctrl|di_tg_ctrl_n|vin|vout.P11.GatPoly VDD.$526.Metal1 6.40479e-05f
Cred_2208 di_tg_ctrl|di_tg_ctrl_n|vin|vout.P11.GatPoly VDD.$766.Metal2 7.32454e-09f
Cred_2209 di_tg_ctrl|di_tg_ctrl_n|vin|vout.P11.GatPoly VDD.$774.Metal2 1.23346e-06f
Cred_2210 di_tg_ctrl|di_tg_ctrl_n|vin|vout.P11.GatPoly VDD.$782.Metal2 4.22298e-07f
Cred_2211 di_tg_ctrl|di_tg_ctrl_n|vin|vout.P11.GatPoly VDD.$888.Metal3 5.87266e-11f
Cred_2212 di_tg_ctrl|di_tg_ctrl_n|vin|vout.P11.GatPoly VDD.$892.Metal3 2.12266e-08f
Cred_2213 di_tg_ctrl|di_tg_ctrl_n|vin|vout.P11.GatPoly VDD.P0.nSD 0.00220339f
Cred_2214 di_tg_ctrl|di_tg_ctrl_n|vin|vout.P11.GatPoly VDD.P3.GatPoly 0.0137881f
Cred_2215 di_tg_ctrl|di_tg_ctrl_n|vin|vout.P12.GatPoly di_tg_ctrl|di_tg_ctrl_n|vout.$180.Metal3 0.0117119f
Cred_2216 di_tg_ctrl|di_tg_ctrl_n|vin|vout.P12.GatPoly di_tg_ctrl|di_tg_ctrl_n|vout.$206.Metal4 0.00278649f
Cred_2217 di_tg_ctrl|di_tg_ctrl_n|vin|vout.P12.GatPoly di_tg_ctrl|di_tg_ctrl_n|vout.P0.nSD 0.00156877f
Cred_2218 di_tg_ctrl|di_tg_ctrl_n|vin|vout.P12.GatPoly di_tg_ctrl|di_tg_ctrl_n|vout.P0.pSD 0.0498858f
Cred_2219 di_tg_ctrl|di_tg_ctrl_n|vin|vout.P12.GatPoly VSS 0.0019003f
Cred_2220 di_tg_ctrl|di_tg_ctrl_n|vin|vout.P12.GatPoly v_a 1.37602e-05f
Cred_2221 di_tg_ctrl|di_tg_ctrl_n|vin|vout.P12.GatPoly v_a.$148.Metal2 5.31161e-05f
Cred_2222 di_tg_ctrl|di_tg_ctrl_n|vin|vout.P12.GatPoly v_a.$182.Metal2 1.33858e-05f
Cred_2223 di_tg_ctrl|di_tg_ctrl_n|vin|vout.P12.GatPoly v_a.P0.nSD 1.90038e-07f
Cred_2224 di_tg_ctrl|di_tg_ctrl_n|vin|vout.P12.GatPoly v_a.P0.pSD 2.63701e-06f
Cred_2225 di_tg_ctrl|di_tg_ctrl_n|vin|vout.P12.GatPoly v_a.P1.nSD 8.46631e-08f
Cred_2226 di_tg_ctrl|di_tg_ctrl_n|vin|vout.P12.GatPoly v_a.P1.pSD 7.17324e-07f
Cred_2227 di_tg_ctrl|di_tg_ctrl_n|vin|vout.P12.GatPoly v_a.P5.nSD 2.89585e-08f
Cred_2228 di_tg_ctrl|di_tg_ctrl_n|vin|vout.P12.GatPoly v_a.P5.pSD 1.05143e-07f
Cred_2229 di_tg_ctrl|di_tg_ctrl_n|vin|vout.P12.GatPoly v_b 0.00168405f
Cred_2230 di_tg_ctrl|di_tg_ctrl_n|vin|vout.P12.GatPoly VDD.$215.Metal1 9.93556e-05f
Cred_2231 di_tg_ctrl|di_tg_ctrl_n|vin|vout.P12.GatPoly VDD.$257.Metal1 0.00135236f
Cred_2232 di_tg_ctrl|di_tg_ctrl_n|vin|vout.P12.GatPoly VDD.$279.Metal1 0.000895261f
Cred_2233 di_tg_ctrl|di_tg_ctrl_n|vin|vout.P12.GatPoly VDD.$281.Metal1 0.00606353f
Cred_2234 di_tg_ctrl|di_tg_ctrl_n|vin|vout.P12.GatPoly VDD.$283.Metal1 0.00786109f
Cred_2235 di_tg_ctrl|di_tg_ctrl_n|vin|vout.P12.GatPoly VDD.$285.Metal1 0.00591403f
Cred_2236 di_tg_ctrl|di_tg_ctrl_n|vin|vout.P12.GatPoly VDD.$286.Metal1 0.00588717f
Cred_2237 di_tg_ctrl|di_tg_ctrl_n|vin|vout.P12.GatPoly VDD.$288.Metal1 0.00976004f
Cred_2238 di_tg_ctrl|di_tg_ctrl_n|vin|vout.P12.GatPoly VDD.$29.Metal1 2.61758e-05f
Cred_2239 di_tg_ctrl|di_tg_ctrl_n|vin|vout.P12.GatPoly VDD.$291.Metal1 0.0150114f
Cred_2240 di_tg_ctrl|di_tg_ctrl_n|vin|vout.P12.GatPoly VDD.$298.Metal1 0.00201162f
Cred_2241 di_tg_ctrl|di_tg_ctrl_n|vin|vout.P12.GatPoly VDD.$320.Metal1 0.000655548f
Cred_2242 di_tg_ctrl|di_tg_ctrl_n|vin|vout.P12.GatPoly VDD.$322.Metal1 8.28578e-05f
Cred_2243 di_tg_ctrl|di_tg_ctrl_n|vin|vout.P12.GatPoly VDD.$359.Metal1 4.631e-07f
Cred_2244 di_tg_ctrl|di_tg_ctrl_n|vin|vout.P12.GatPoly VDD.$378.Metal1 1.14658e-06f
Cred_2245 di_tg_ctrl|di_tg_ctrl_n|vin|vout.P12.GatPoly VDD.$382.Metal1 0.00120861f
Cred_2246 di_tg_ctrl|di_tg_ctrl_n|vin|vout.P12.GatPoly VDD.$405.Metal1 1.56934e-06f
Cred_2247 di_tg_ctrl|di_tg_ctrl_n|vin|vout.P12.GatPoly VDD.$606.Metal2 0.000136069f
Cred_2248 di_tg_ctrl|di_tg_ctrl_n|vin|vout.P12.GatPoly VDD.$607.Metal2 3.87176e-06f
Cred_2249 di_tg_ctrl|di_tg_ctrl_n|vin|vout.P12.GatPoly VDD.$608.Metal2 2.76943e-06f
Cred_2250 di_tg_ctrl|di_tg_ctrl_n|vin|vout.P12.GatPoly VDD.$609.Metal2 1.2129e-06f
Cred_2251 di_tg_ctrl|di_tg_ctrl_n|vin|vout.P12.GatPoly VDD.$610.Metal2 3.95746e-05f
Cred_2252 di_tg_ctrl|di_tg_ctrl_n|vin|vout.P12.GatPoly VDD.$611.Metal2 1.97047e-05f
Cred_2253 di_tg_ctrl|di_tg_ctrl_n|vin|vout.P12.GatPoly VDD.$612.Metal2 3.34227e-05f
Cred_2254 di_tg_ctrl|di_tg_ctrl_n|vin|vout.P12.GatPoly VDD.$613.Metal2 9.91131e-06f
Cred_2255 di_tg_ctrl|di_tg_ctrl_n|vin|vout.P12.GatPoly VDD.$614.Metal2 3.73742e-05f
Cred_2256 di_tg_ctrl|di_tg_ctrl_n|vin|vout.P12.GatPoly VDD.$615.Metal2 8.60609e-06f
Cred_2257 di_tg_ctrl|di_tg_ctrl_n|vin|vout.P12.GatPoly VDD.$616.Metal2 8.14526e-05f
Cred_2258 di_tg_ctrl|di_tg_ctrl_n|vin|vout.P12.GatPoly VDD.$617.Metal2 7.12055e-05f
Cred_2259 di_tg_ctrl|di_tg_ctrl_n|vin|vout.P12.GatPoly VDD.$618.Metal2 5.94388e-05f
Cred_2260 di_tg_ctrl|di_tg_ctrl_n|vin|vout.P12.GatPoly VDD.$619.Metal2 0.00159944f
Cred_2261 di_tg_ctrl|di_tg_ctrl_n|vin|vout.P12.GatPoly VDD.$620.Metal2 0.0445212f
Cred_2262 di_tg_ctrl|di_tg_ctrl_n|vin|vout.P12.GatPoly VDD.$688.Metal2 0.00298621f
Cred_2263 di_tg_ctrl|di_tg_ctrl_n|vin|vout.P12.GatPoly VDD.$703.Metal2 7.43103e-05f
Cred_2264 di_tg_ctrl|di_tg_ctrl_n|vin|vout.P12.GatPoly VDD.$704.Metal2 4.82241e-08f
Cred_2265 di_tg_ctrl|di_tg_ctrl_n|vin|vout.P12.GatPoly VDD.$714.Metal2 0.0047969f
Cred_2266 di_tg_ctrl|di_tg_ctrl_n|vin|vout.P12.GatPoly VDD.$734.Metal2 0.00353232f
Cred_2267 di_tg_ctrl|di_tg_ctrl_n|vin|vout.P12.GatPoly VDD.$738.Metal2 0.000605541f
Cred_2268 di_tg_ctrl|di_tg_ctrl_n|vin|vout.P12.GatPoly VDD.P0.nSD 0.000817992f
Cred_2269 di_tg_ctrl|di_tg_ctrl_n|vin|vout.P12.GatPoly VDD.P10.pSD 3.72743e-05f
Cred_2270 di_tg_ctrl|di_tg_ctrl_n|vin|vout.P12.GatPoly VDD.P11.pSD 9.32526e-09f
Cred_2271 di_tg_ctrl|di_tg_ctrl_n|vin|vout.P12.GatPoly VDD.P2.GatPoly 0.135491f
Cred_2272 di_tg_ctrl|di_tg_ctrl_n|vin|vout.P12.GatPoly VDD.P3.GatPoly 0.0271144f
Cred_2273 di_tg_ctrl|di_tg_ctrl_n|vin|vout.P12.GatPoly VDD.P7.pSD 0.000388368f
Cred_2274 di_tg_ctrl|di_tg_ctrl_n|vin|vout.P12.GatPoly VSS.$114.Metal1 3.09412e-06f
Cred_2275 di_tg_ctrl|di_tg_ctrl_n|vin|vout.P12.GatPoly VSS.$129.Metal1 2.54624e-05f
Cred_2276 di_tg_ctrl|di_tg_ctrl_n|vin|vout.P12.GatPoly VSS.$134.Metal1 1.53179e-06f
Cred_2277 di_tg_ctrl|di_tg_ctrl_n|vin|vout.P12.GatPoly VSS.$220.Metal1 3.68756e-06f
Cred_2278 di_tg_ctrl|di_tg_ctrl_n|vin|vout.P12.GatPoly VSS.$311.Metal2 1.83313e-05f
Cred_2279 di_tg_ctrl|di_tg_ctrl_n|vin|vout.P12.GatPoly VSS.$339.Metal2 1.8495e-06f
Cred_2280 di_tg_ctrl|di_tg_ctrl_n|vin|vout.P12.GatPoly VSS.$350.Metal2 5.20462e-06f
Cred_2281 di_tg_ctrl|di_tg_ctrl_n|vin|vout.P12.GatPoly VSS.$354.Metal2 2.82806e-06f
Cred_2282 di_tg_ctrl|di_tg_ctrl_n|vin|vout.P12.GatPoly VSS.$496.Metal3 1.48289e-08f
Cred_2283 di_tg_ctrl|di_tg_ctrl_n|vin|vout.P12.GatPoly VSS.$78.Metal1 1.9877e-06f
Cred_2284 di_tg_ctrl|di_tg_ctrl_n|vin|vout.P12.GatPoly VSS.$87.Metal1 5.30048e-05f
Cred_2285 di_tg_ctrl|di_tg_ctrl_n|vin|vout.P12.GatPoly VSS.P0.pSD 1.4633e-05f
Cred_2286 di_tg_ctrl|di_tg_ctrl_n|vin|vout.P12.GatPoly VSS.P2.GatPoly 6.69376e-06f
Cred_2287 di_tg_ctrl|di_tg_ctrl_n|vin|vout.P12.GatPoly VSS.P3.GatPoly 6.98667e-06f
Cred_2288 di_tg_ctrl|di_tg_ctrl_n|vin|vout.P12.GatPoly VSS.P6.nSD 4.62996e-09f
Cred_2289 di_tg_ctrl|di_tg_ctrl_n|vin|vout.P12.GatPoly VSS.P7.nSD 5.91886e-09f
Cred_2290 di_tg_ctrl|di_tg_ctrl_n|vin|vout.P13.GatPoly di_tg_ctrl|di_tg_ctrl_n|vout.$180.Metal3 0.012734f
Cred_2291 di_tg_ctrl|di_tg_ctrl_n|vin|vout.P13.GatPoly di_tg_ctrl|di_tg_ctrl_n|vout.$206.Metal4 0.00300413f
Cred_2292 di_tg_ctrl|di_tg_ctrl_n|vin|vout.P13.GatPoly di_tg_ctrl|di_tg_ctrl_n|vout.P0.nSD 0.00170379f
Cred_2293 di_tg_ctrl|di_tg_ctrl_n|vin|vout.P13.GatPoly di_tg_ctrl|di_tg_ctrl_n|vout.P0.pSD 0.0510403f
Cred_2294 di_tg_ctrl|di_tg_ctrl_n|vin|vout.P13.GatPoly VSS 0.000449874f
Cred_2295 di_tg_ctrl|di_tg_ctrl_n|vin|vout.P13.GatPoly v_a 1.37602e-05f
Cred_2296 di_tg_ctrl|di_tg_ctrl_n|vin|vout.P13.GatPoly v_a.$148.Metal2 5.31202e-05f
Cred_2297 di_tg_ctrl|di_tg_ctrl_n|vin|vout.P13.GatPoly v_a.$182.Metal2 1.33862e-05f
Cred_2298 di_tg_ctrl|di_tg_ctrl_n|vin|vout.P13.GatPoly v_a.P0.nSD 1.90038e-07f
Cred_2299 di_tg_ctrl|di_tg_ctrl_n|vin|vout.P13.GatPoly v_a.P0.pSD 2.63798e-06f
Cred_2300 di_tg_ctrl|di_tg_ctrl_n|vin|vout.P13.GatPoly v_a.P1.nSD 8.46664e-08f
Cred_2301 di_tg_ctrl|di_tg_ctrl_n|vin|vout.P13.GatPoly v_a.P1.pSD 7.17547e-07f
Cred_2302 di_tg_ctrl|di_tg_ctrl_n|vin|vout.P13.GatPoly v_a.P5.nSD 2.89585e-08f
Cred_2303 di_tg_ctrl|di_tg_ctrl_n|vin|vout.P13.GatPoly v_a.P5.pSD 1.05143e-07f
Cred_2304 di_tg_ctrl|di_tg_ctrl_n|vin|vout.P13.GatPoly v_b 0.00168405f
Cred_2305 di_tg_ctrl|di_tg_ctrl_n|vin|vout.P13.GatPoly VDD.$215.Metal1 9.8657e-05f
Cred_2306 di_tg_ctrl|di_tg_ctrl_n|vin|vout.P13.GatPoly VDD.$279.Metal1 0.000655085f
Cred_2307 di_tg_ctrl|di_tg_ctrl_n|vin|vout.P13.GatPoly VDD.$281.Metal1 8.28578e-05f
Cred_2308 di_tg_ctrl|di_tg_ctrl_n|vin|vout.P13.GatPoly VDD.$29.Metal1 2.59896e-05f
Cred_2309 di_tg_ctrl|di_tg_ctrl_n|vin|vout.P13.GatPoly VDD.$298.Metal1 0.00201162f
Cred_2310 di_tg_ctrl|di_tg_ctrl_n|vin|vout.P13.GatPoly VDD.$320.Metal1 0.000895874f
Cred_2311 di_tg_ctrl|di_tg_ctrl_n|vin|vout.P13.GatPoly VDD.$322.Metal1 0.00606353f
Cred_2312 di_tg_ctrl|di_tg_ctrl_n|vin|vout.P13.GatPoly VDD.$324.Metal1 0.00786109f
Cred_2313 di_tg_ctrl|di_tg_ctrl_n|vin|vout.P13.GatPoly VDD.$326.Metal1 0.00591403f
Cred_2314 di_tg_ctrl|di_tg_ctrl_n|vin|vout.P13.GatPoly VDD.$327.Metal1 0.00588717f
Cred_2315 di_tg_ctrl|di_tg_ctrl_n|vin|vout.P13.GatPoly VDD.$329.Metal1 0.00976004f
Cred_2316 di_tg_ctrl|di_tg_ctrl_n|vin|vout.P13.GatPoly VDD.$332.Metal1 0.0150114f
Cred_2317 di_tg_ctrl|di_tg_ctrl_n|vin|vout.P13.GatPoly VDD.$339.Metal1 0.00135236f
Cred_2318 di_tg_ctrl|di_tg_ctrl_n|vin|vout.P13.GatPoly VDD.$359.Metal1 6.13391e-07f
Cred_2319 di_tg_ctrl|di_tg_ctrl_n|vin|vout.P13.GatPoly VDD.$378.Metal1 1.15123e-06f
Cred_2320 di_tg_ctrl|di_tg_ctrl_n|vin|vout.P13.GatPoly VDD.$382.Metal1 0.00121389f
Cred_2321 di_tg_ctrl|di_tg_ctrl_n|vin|vout.P13.GatPoly VDD.$405.Metal1 1.57571e-06f
Cred_2322 di_tg_ctrl|di_tg_ctrl_n|vin|vout.P13.GatPoly VDD.$606.Metal2 0.000113145f
Cred_2323 di_tg_ctrl|di_tg_ctrl_n|vin|vout.P13.GatPoly VDD.$607.Metal2 2.92311e-06f
Cred_2324 di_tg_ctrl|di_tg_ctrl_n|vin|vout.P13.GatPoly VDD.$608.Metal2 1.73339e-06f
Cred_2325 di_tg_ctrl|di_tg_ctrl_n|vin|vout.P13.GatPoly VDD.$609.Metal2 4.82241e-08f
Cred_2326 di_tg_ctrl|di_tg_ctrl_n|vin|vout.P13.GatPoly VDD.$620.Metal2 0.00893557f
Cred_2327 di_tg_ctrl|di_tg_ctrl_n|vin|vout.P13.GatPoly VDD.$696.Metal2 0.00376343f
Cred_2328 di_tg_ctrl|di_tg_ctrl_n|vin|vout.P13.GatPoly VDD.$703.Metal2 9.89e-05f
Cred_2329 di_tg_ctrl|di_tg_ctrl_n|vin|vout.P13.GatPoly VDD.$704.Metal2 1.2129e-06f
Cred_2330 di_tg_ctrl|di_tg_ctrl_n|vin|vout.P13.GatPoly VDD.$705.Metal2 3.95746e-05f
Cred_2331 di_tg_ctrl|di_tg_ctrl_n|vin|vout.P13.GatPoly VDD.$706.Metal2 1.97047e-05f
Cred_2332 di_tg_ctrl|di_tg_ctrl_n|vin|vout.P13.GatPoly VDD.$707.Metal2 3.34227e-05f
Cred_2333 di_tg_ctrl|di_tg_ctrl_n|vin|vout.P13.GatPoly VDD.$708.Metal2 9.91131e-06f
Cred_2334 di_tg_ctrl|di_tg_ctrl_n|vin|vout.P13.GatPoly VDD.$709.Metal2 3.73742e-05f
Cred_2335 di_tg_ctrl|di_tg_ctrl_n|vin|vout.P13.GatPoly VDD.$710.Metal2 8.60609e-06f
Cred_2336 di_tg_ctrl|di_tg_ctrl_n|vin|vout.P13.GatPoly VDD.$711.Metal2 8.14526e-05f
Cred_2337 di_tg_ctrl|di_tg_ctrl_n|vin|vout.P13.GatPoly VDD.$712.Metal2 7.12055e-05f
Cred_2338 di_tg_ctrl|di_tg_ctrl_n|vin|vout.P13.GatPoly VDD.$713.Metal2 5.94388e-05f
Cred_2339 di_tg_ctrl|di_tg_ctrl_n|vin|vout.P13.GatPoly VDD.$714.Metal2 0.02409f
Cred_2340 di_tg_ctrl|di_tg_ctrl_n|vin|vout.P13.GatPoly VDD.$734.Metal2 0.0165615f
Cred_2341 di_tg_ctrl|di_tg_ctrl_n|vin|vout.P13.GatPoly VDD.$738.Metal2 0.00283912f
Cred_2342 di_tg_ctrl|di_tg_ctrl_n|vin|vout.P13.GatPoly VDD.P0.nSD 0.000813674f
Cred_2343 di_tg_ctrl|di_tg_ctrl_n|vin|vout.P13.GatPoly VDD.P10.pSD 0.00038727f
Cred_2344 di_tg_ctrl|di_tg_ctrl_n|vin|vout.P13.GatPoly VDD.P11.pSD 1.23516e-08f
Cred_2345 di_tg_ctrl|di_tg_ctrl_n|vin|vout.P13.GatPoly VDD.P2.GatPoly 0.0270402f
Cred_2346 di_tg_ctrl|di_tg_ctrl_n|vin|vout.P13.GatPoly VDD.P3.GatPoly 0.133228f
Cred_2347 di_tg_ctrl|di_tg_ctrl_n|vin|vout.P13.GatPoly VDD.P7.pSD 3.83752e-05f
Cred_2348 di_tg_ctrl|di_tg_ctrl_n|vin|vout.P13.GatPoly VSS.$114.Metal1 3.09412e-06f
Cred_2349 di_tg_ctrl|di_tg_ctrl_n|vin|vout.P13.GatPoly VSS.$129.Metal1 2.54624e-05f
Cred_2350 di_tg_ctrl|di_tg_ctrl_n|vin|vout.P13.GatPoly VSS.$134.Metal1 1.53179e-06f
Cred_2351 di_tg_ctrl|di_tg_ctrl_n|vin|vout.P13.GatPoly VSS.$220.Metal1 3.68756e-06f
Cred_2352 di_tg_ctrl|di_tg_ctrl_n|vin|vout.P13.GatPoly VSS.$311.Metal2 1.83313e-05f
Cred_2353 di_tg_ctrl|di_tg_ctrl_n|vin|vout.P13.GatPoly VSS.$339.Metal2 1.8495e-06f
Cred_2354 di_tg_ctrl|di_tg_ctrl_n|vin|vout.P13.GatPoly VSS.$350.Metal2 5.20462e-06f
Cred_2355 di_tg_ctrl|di_tg_ctrl_n|vin|vout.P13.GatPoly VSS.$354.Metal2 2.82806e-06f
Cred_2356 di_tg_ctrl|di_tg_ctrl_n|vin|vout.P13.GatPoly VSS.$496.Metal3 1.48289e-08f
Cred_2357 di_tg_ctrl|di_tg_ctrl_n|vin|vout.P13.GatPoly VSS.$78.Metal1 1.9877e-06f
Cred_2358 di_tg_ctrl|di_tg_ctrl_n|vin|vout.P13.GatPoly VSS.$87.Metal1 5.30048e-05f
Cred_2359 di_tg_ctrl|di_tg_ctrl_n|vin|vout.P13.GatPoly VSS.P0.pSD 1.4633e-05f
Cred_2360 di_tg_ctrl|di_tg_ctrl_n|vin|vout.P13.GatPoly VSS.P2.GatPoly 6.69376e-06f
Cred_2361 di_tg_ctrl|di_tg_ctrl_n|vin|vout.P13.GatPoly VSS.P3.GatPoly 6.98667e-06f
Cred_2362 di_tg_ctrl|di_tg_ctrl_n|vin|vout.P13.GatPoly VSS.P6.nSD 4.62996e-09f
Cred_2363 di_tg_ctrl|di_tg_ctrl_n|vin|vout.P13.GatPoly VSS.P7.nSD 5.91886e-09f
Cred_2364 di_tg_ctrl|di_tg_ctrl_n|vin|vout.P14.GatPoly di_tg_ctrl|di_tg_ctrl_n|vout.$180.Metal3 0.00303676f
Cred_2365 di_tg_ctrl|di_tg_ctrl_n|vin|vout.P14.GatPoly di_tg_ctrl|di_tg_ctrl_n|vout.$206.Metal4 0.00051967f
Cred_2366 di_tg_ctrl|di_tg_ctrl_n|vin|vout.P14.GatPoly di_tg_ctrl|di_tg_ctrl_n|vout.P0.nSD 0.00915815f
Cred_2367 di_tg_ctrl|di_tg_ctrl_n|vin|vout.P14.GatPoly di_tg_ctrl|di_tg_ctrl_n|vout.P0.pSD 0.00223718f
Cred_2368 di_tg_ctrl|di_tg_ctrl_n|vin|vout.P14.GatPoly VSS 0.0288242f
Cred_2369 di_tg_ctrl|di_tg_ctrl_n|vin|vout.P14.GatPoly v_a 3.82912e-05f
Cred_2370 di_tg_ctrl|di_tg_ctrl_n|vin|vout.P14.GatPoly v_a.$148.Metal2 0.000169419f
Cred_2371 di_tg_ctrl|di_tg_ctrl_n|vin|vout.P14.GatPoly v_a.$182.Metal2 4.45071e-05f
Cred_2372 di_tg_ctrl|di_tg_ctrl_n|vin|vout.P14.GatPoly v_a.P0.nSD 2.02982e-06f
Cred_2373 di_tg_ctrl|di_tg_ctrl_n|vin|vout.P14.GatPoly v_a.P0.pSD 2.39172e-06f
Cred_2374 di_tg_ctrl|di_tg_ctrl_n|vin|vout.P14.GatPoly v_a.P1.nSD 6.3871e-07f
Cred_2375 di_tg_ctrl|di_tg_ctrl_n|vin|vout.P14.GatPoly v_a.P1.pSD 1.0121e-06f
Cred_2376 di_tg_ctrl|di_tg_ctrl_n|vin|vout.P14.GatPoly v_a.P5.nSD 9.50168e-08f
Cred_2377 di_tg_ctrl|di_tg_ctrl_n|vin|vout.P14.GatPoly v_a.P5.pSD 3.44987e-07f
Cred_2378 di_tg_ctrl|di_tg_ctrl_n|vin|vout.P14.GatPoly VDD.$215.Metal1 1.75674e-05f
Cred_2379 di_tg_ctrl|di_tg_ctrl_n|vin|vout.P14.GatPoly VDD.$279.Metal1 2.69497e-05f
Cred_2380 di_tg_ctrl|di_tg_ctrl_n|vin|vout.P14.GatPoly VDD.$281.Metal1 3.4087e-06f
Cred_2381 di_tg_ctrl|di_tg_ctrl_n|vin|vout.P14.GatPoly VDD.$29.Metal1 4.68798e-06f
Cred_2382 di_tg_ctrl|di_tg_ctrl_n|vin|vout.P14.GatPoly VDD.$320.Metal1 2.69687e-05f
Cred_2383 di_tg_ctrl|di_tg_ctrl_n|vin|vout.P14.GatPoly VDD.$322.Metal1 3.4087e-06f
Cred_2384 di_tg_ctrl|di_tg_ctrl_n|vin|vout.P14.GatPoly VDD.$359.Metal1 1.90515e-08f
Cred_2385 di_tg_ctrl|di_tg_ctrl_n|vin|vout.P14.GatPoly VDD.$378.Metal1 1.09293e-07f
Cred_2386 di_tg_ctrl|di_tg_ctrl_n|vin|vout.P14.GatPoly VDD.$382.Metal1 0.000187208f
Cred_2387 di_tg_ctrl|di_tg_ctrl_n|vin|vout.P14.GatPoly VDD.$405.Metal1 1.49592e-07f
Cred_2388 di_tg_ctrl|di_tg_ctrl_n|vin|vout.P14.GatPoly VDD.$606.Metal2 5.93824e-05f
Cred_2389 di_tg_ctrl|di_tg_ctrl_n|vin|vout.P14.GatPoly VDD.$607.Metal2 1.20254e-07f
Cred_2390 di_tg_ctrl|di_tg_ctrl_n|vin|vout.P14.GatPoly VDD.$608.Metal2 7.13104e-08f
Cred_2391 di_tg_ctrl|di_tg_ctrl_n|vin|vout.P14.GatPoly VDD.$609.Metal2 1.9839e-09f
Cred_2392 di_tg_ctrl|di_tg_ctrl_n|vin|vout.P14.GatPoly VDD.$703.Metal2 3.05706e-06f
Cred_2393 di_tg_ctrl|di_tg_ctrl_n|vin|vout.P14.GatPoly VDD.$704.Metal2 1.9839e-09f
Cred_2394 di_tg_ctrl|di_tg_ctrl_n|vin|vout.P14.GatPoly VDD.P0.nSD 0.000137952f
Cred_2395 di_tg_ctrl|di_tg_ctrl_n|vin|vout.P14.GatPoly VDD.P10.pSD 2.95934e-06f
Cred_2396 di_tg_ctrl|di_tg_ctrl_n|vin|vout.P14.GatPoly VDD.P11.pSD 3.83634e-10f
Cred_2397 di_tg_ctrl|di_tg_ctrl_n|vin|vout.P14.GatPoly VDD.P2.GatPoly 0.000132799f
Cred_2398 di_tg_ctrl|di_tg_ctrl_n|vin|vout.P14.GatPoly VDD.P3.GatPoly 0.000135819f
Cred_2399 di_tg_ctrl|di_tg_ctrl_n|vin|vout.P14.GatPoly VDD.P7.pSD 6.04589e-06f
Cred_2400 di_tg_ctrl|di_tg_ctrl_n|vin|vout.P14.GatPoly VSS.$114.Metal1 0.00205102f
Cred_2401 di_tg_ctrl|di_tg_ctrl_n|vin|vout.P14.GatPoly VSS.$129.Metal1 0.00122867f
Cred_2402 di_tg_ctrl|di_tg_ctrl_n|vin|vout.P14.GatPoly VSS.$132.Metal1 0.00126417f
Cred_2403 di_tg_ctrl|di_tg_ctrl_n|vin|vout.P14.GatPoly VSS.$134.Metal1 0.000261524f
Cred_2404 di_tg_ctrl|di_tg_ctrl_n|vin|vout.P14.GatPoly VSS.$220.Metal1 0.000167212f
Cred_2405 di_tg_ctrl|di_tg_ctrl_n|vin|vout.P14.GatPoly VSS.$311.Metal2 0.00278954f
Cred_2406 di_tg_ctrl|di_tg_ctrl_n|vin|vout.P14.GatPoly VSS.$339.Metal2 0.000688544f
Cred_2407 di_tg_ctrl|di_tg_ctrl_n|vin|vout.P14.GatPoly VSS.$350.Metal2 0.000727638f
Cred_2408 di_tg_ctrl|di_tg_ctrl_n|vin|vout.P14.GatPoly VSS.$354.Metal2 3.26164e-05f
Cred_2409 di_tg_ctrl|di_tg_ctrl_n|vin|vout.P14.GatPoly VSS.$496.Metal3 5.52059e-06f
Cred_2410 di_tg_ctrl|di_tg_ctrl_n|vin|vout.P14.GatPoly VSS.$78.Metal1 0.019981f
Cred_2411 di_tg_ctrl|di_tg_ctrl_n|vin|vout.P14.GatPoly VSS.$87.Metal1 0.00202941f
Cred_2412 di_tg_ctrl|di_tg_ctrl_n|vin|vout.P14.GatPoly VSS.P0.pSD 0.000666312f
Cred_2413 di_tg_ctrl|di_tg_ctrl_n|vin|vout.P14.GatPoly VSS.P2.GatPoly 0.0367201f
Cred_2414 di_tg_ctrl|di_tg_ctrl_n|vin|vout.P14.GatPoly VSS.P3.GatPoly 0.00786638f
Cred_2415 di_tg_ctrl|di_tg_ctrl_n|vin|vout.P14.GatPoly VSS.P6.nSD 0.000205803f
Cred_2416 di_tg_ctrl|di_tg_ctrl_n|vin|vout.P14.GatPoly VSS.P7.nSD 0.000295991f
Cred_2417 di_tg_ctrl|di_tg_ctrl_n|vin|vout.P15.GatPoly di_tg_ctrl|di_tg_ctrl_n|vout.$180.Metal3 0.00303677f
Cred_2418 di_tg_ctrl|di_tg_ctrl_n|vin|vout.P15.GatPoly di_tg_ctrl|di_tg_ctrl_n|vout.$206.Metal4 0.000519671f
Cred_2419 di_tg_ctrl|di_tg_ctrl_n|vin|vout.P15.GatPoly di_tg_ctrl|di_tg_ctrl_n|vout.P0.nSD 0.00915811f
Cred_2420 di_tg_ctrl|di_tg_ctrl_n|vin|vout.P15.GatPoly di_tg_ctrl|di_tg_ctrl_n|vout.P0.pSD 0.00223719f
Cred_2421 di_tg_ctrl|di_tg_ctrl_n|vin|vout.P15.GatPoly VSS 0.0288644f
Cred_2422 di_tg_ctrl|di_tg_ctrl_n|vin|vout.P15.GatPoly v_a 3.82912e-05f
Cred_2423 di_tg_ctrl|di_tg_ctrl_n|vin|vout.P15.GatPoly v_a.$148.Metal2 0.000169431f
Cred_2424 di_tg_ctrl|di_tg_ctrl_n|vin|vout.P15.GatPoly v_a.$182.Metal2 4.45088e-05f
Cred_2425 di_tg_ctrl|di_tg_ctrl_n|vin|vout.P15.GatPoly v_a.P0.nSD 2.03038e-06f
Cred_2426 di_tg_ctrl|di_tg_ctrl_n|vin|vout.P15.GatPoly v_a.P0.pSD 2.39172e-06f
Cred_2427 di_tg_ctrl|di_tg_ctrl_n|vin|vout.P15.GatPoly v_a.P1.nSD 6.38911e-07f
Cred_2428 di_tg_ctrl|di_tg_ctrl_n|vin|vout.P15.GatPoly v_a.P1.pSD 1.01215e-06f
Cred_2429 di_tg_ctrl|di_tg_ctrl_n|vin|vout.P15.GatPoly v_a.P5.nSD 9.50168e-08f
Cred_2430 di_tg_ctrl|di_tg_ctrl_n|vin|vout.P15.GatPoly v_a.P5.pSD 3.44987e-07f
Cred_2431 di_tg_ctrl|di_tg_ctrl_n|vin|vout.P15.GatPoly VDD.$215.Metal1 1.75674e-05f
Cred_2432 di_tg_ctrl|di_tg_ctrl_n|vin|vout.P15.GatPoly VDD.$279.Metal1 2.69497e-05f
Cred_2433 di_tg_ctrl|di_tg_ctrl_n|vin|vout.P15.GatPoly VDD.$281.Metal1 3.4087e-06f
Cred_2434 di_tg_ctrl|di_tg_ctrl_n|vin|vout.P15.GatPoly VDD.$29.Metal1 4.68798e-06f
Cred_2435 di_tg_ctrl|di_tg_ctrl_n|vin|vout.P15.GatPoly VDD.$320.Metal1 2.69687e-05f
Cred_2436 di_tg_ctrl|di_tg_ctrl_n|vin|vout.P15.GatPoly VDD.$322.Metal1 3.4087e-06f
Cred_2437 di_tg_ctrl|di_tg_ctrl_n|vin|vout.P15.GatPoly VDD.$359.Metal1 1.90515e-08f
Cred_2438 di_tg_ctrl|di_tg_ctrl_n|vin|vout.P15.GatPoly VDD.$378.Metal1 1.09293e-07f
Cred_2439 di_tg_ctrl|di_tg_ctrl_n|vin|vout.P15.GatPoly VDD.$382.Metal1 0.000187208f
Cred_2440 di_tg_ctrl|di_tg_ctrl_n|vin|vout.P15.GatPoly VDD.$405.Metal1 1.49592e-07f
Cred_2441 di_tg_ctrl|di_tg_ctrl_n|vin|vout.P15.GatPoly VDD.$606.Metal2 5.93824e-05f
Cred_2442 di_tg_ctrl|di_tg_ctrl_n|vin|vout.P15.GatPoly VDD.$607.Metal2 1.20254e-07f
Cred_2443 di_tg_ctrl|di_tg_ctrl_n|vin|vout.P15.GatPoly VDD.$608.Metal2 7.13104e-08f
Cred_2444 di_tg_ctrl|di_tg_ctrl_n|vin|vout.P15.GatPoly VDD.$609.Metal2 1.9839e-09f
Cred_2445 di_tg_ctrl|di_tg_ctrl_n|vin|vout.P15.GatPoly VDD.$703.Metal2 3.05706e-06f
Cred_2446 di_tg_ctrl|di_tg_ctrl_n|vin|vout.P15.GatPoly VDD.$704.Metal2 1.9839e-09f
Cred_2447 di_tg_ctrl|di_tg_ctrl_n|vin|vout.P15.GatPoly VDD.P0.nSD 0.000137952f
Cred_2448 di_tg_ctrl|di_tg_ctrl_n|vin|vout.P15.GatPoly VDD.P10.pSD 2.95934e-06f
Cred_2449 di_tg_ctrl|di_tg_ctrl_n|vin|vout.P15.GatPoly VDD.P11.pSD 3.83634e-10f
Cred_2450 di_tg_ctrl|di_tg_ctrl_n|vin|vout.P15.GatPoly VDD.P2.GatPoly 0.000132799f
Cred_2451 di_tg_ctrl|di_tg_ctrl_n|vin|vout.P15.GatPoly VDD.P3.GatPoly 0.000135819f
Cred_2452 di_tg_ctrl|di_tg_ctrl_n|vin|vout.P15.GatPoly VDD.P7.pSD 6.04589e-06f
Cred_2453 di_tg_ctrl|di_tg_ctrl_n|vin|vout.P15.GatPoly VSS.$114.Metal1 0.00102627f
Cred_2454 di_tg_ctrl|di_tg_ctrl_n|vin|vout.P15.GatPoly VSS.$127.Metal1 0.00519054f
Cred_2455 di_tg_ctrl|di_tg_ctrl_n|vin|vout.P15.GatPoly VSS.$129.Metal1 0.00342242f
Cred_2456 di_tg_ctrl|di_tg_ctrl_n|vin|vout.P15.GatPoly VSS.$132.Metal1 0.0062987f
Cred_2457 di_tg_ctrl|di_tg_ctrl_n|vin|vout.P15.GatPoly VSS.$134.Metal1 0.00126646f
Cred_2458 di_tg_ctrl|di_tg_ctrl_n|vin|vout.P15.GatPoly VSS.$155.Metal1 0.00321309f
Cred_2459 di_tg_ctrl|di_tg_ctrl_n|vin|vout.P15.GatPoly VSS.$156.Metal1 0.00321309f
Cred_2460 di_tg_ctrl|di_tg_ctrl_n|vin|vout.P15.GatPoly VSS.$220.Metal1 0.00016891f
Cred_2461 di_tg_ctrl|di_tg_ctrl_n|vin|vout.P15.GatPoly VSS.$311.Metal2 0.000166683f
Cred_2462 di_tg_ctrl|di_tg_ctrl_n|vin|vout.P15.GatPoly VSS.$339.Metal2 1.48701e-05f
Cred_2463 di_tg_ctrl|di_tg_ctrl_n|vin|vout.P15.GatPoly VSS.$350.Metal2 5.78269e-05f
Cred_2464 di_tg_ctrl|di_tg_ctrl_n|vin|vout.P15.GatPoly VSS.$354.Metal2 0.00139852f
Cred_2465 di_tg_ctrl|di_tg_ctrl_n|vin|vout.P15.GatPoly VSS.$359.Metal2 0.00115594f
Cred_2466 di_tg_ctrl|di_tg_ctrl_n|vin|vout.P15.GatPoly VSS.$496.Metal3 1.19225e-07f
Cred_2467 di_tg_ctrl|di_tg_ctrl_n|vin|vout.P15.GatPoly VSS.$78.Metal1 0.0013348f
Cred_2468 di_tg_ctrl|di_tg_ctrl_n|vin|vout.P15.GatPoly VSS.$87.Metal1 0.0020142f
Cred_2469 di_tg_ctrl|di_tg_ctrl_n|vin|vout.P15.GatPoly VSS.P0.pSD 0.000672151f
Cred_2470 di_tg_ctrl|di_tg_ctrl_n|vin|vout.P15.GatPoly VSS.P10.nSD 8.58176e-07f
Cred_2471 di_tg_ctrl|di_tg_ctrl_n|vin|vout.P15.GatPoly VSS.P11.nSD 8.58176e-07f
Cred_2472 di_tg_ctrl|di_tg_ctrl_n|vin|vout.P15.GatPoly VSS.P2.GatPoly 0.00779765f
Cred_2473 di_tg_ctrl|di_tg_ctrl_n|vin|vout.P15.GatPoly VSS.P3.GatPoly 0.0368261f
Cred_2474 di_tg_ctrl|di_tg_ctrl_n|vin|vout.P15.GatPoly VSS.P6.nSD 1.23838e-05f
Cred_2475 di_tg_ctrl|di_tg_ctrl_n|vin|vout.P15.GatPoly VSS.P7.nSD 1.54928e-05f
Cred_2476 di_tg_ctrl|di_tg_ctrl_n|vin|vout.P2.GatPoly di_tg_ctrl|di_tg_ctrl_n|vout.P5.GatPoly 0.001728f
Cred_2477 di_tg_ctrl|di_tg_ctrl_n|vin|vout.P2.GatPoly VSS 0.0134859f
Cred_2478 di_tg_ctrl|di_tg_ctrl_n|vin|vout.P2.GatPoly v_b.$161.Metal2 0.00794709f
Cred_2479 di_tg_ctrl|di_tg_ctrl_n|vin|vout.P2.GatPoly v_b.P1.nSD 0.00424171f
Cred_2480 di_tg_ctrl|di_tg_ctrl_n|vin|vout.P2.GatPoly v_c.$459.Metal3 3.7292e-06f
Cred_2481 di_tg_ctrl|di_tg_ctrl_n|vin|vout.P2.GatPoly v_c.$476.Metal3 0.00517557f
Cred_2482 di_tg_ctrl|di_tg_ctrl_n|vin|vout.P2.GatPoly v_c.P0.nSD 6.10862e-06f
Cred_2483 di_tg_ctrl|di_tg_ctrl_n|vin|vout.P2.GatPoly v_c.P2.nSD 0.00641418f
Cred_2484 di_tg_ctrl|di_tg_ctrl_n|vin|vout.P2.GatPoly VSS.$220.Metal1 0.00134923f
Cred_2485 di_tg_ctrl|di_tg_ctrl_n|vin|vout.P2.GatPoly VSS.$231.Metal1 6.99167e-06f
Cred_2486 di_tg_ctrl|di_tg_ctrl_n|vin|vout.P2.GatPoly VSS.$241.Metal1 5.01301e-05f
Cred_2487 di_tg_ctrl|di_tg_ctrl_n|vin|vout.P2.GatPoly VSS.$255.Metal1 0.000272459f
Cred_2488 di_tg_ctrl|di_tg_ctrl_n|vin|vout.P2.GatPoly VSS.$436.Metal2 5.39274e-08f
Cred_2489 di_tg_ctrl|di_tg_ctrl_n|vin|vout.P2.GatPoly VSS.$440.Metal2 1.08401e-07f
Cred_2490 di_tg_ctrl|di_tg_ctrl_n|vin|vout.P2.GatPoly VSS.$452.Metal2 1.10827e-05f
Cred_2491 di_tg_ctrl|di_tg_ctrl_n|vin|vout.P2.GatPoly VSS.$548.Metal3 7.97315e-07f
Cred_2492 di_tg_ctrl|di_tg_ctrl_n|vin|vout.P2.GatPoly VSS.P0.pSD 0.000622114f
Cred_2493 di_tg_ctrl|di_tg_ctrl_n|vin|vout.P3.GatPoly di_tg_ctrl|di_tg_ctrl_n|vout.P5.GatPoly 0.00150156f
Cred_2494 di_tg_ctrl|di_tg_ctrl_n|vin|vout.P3.GatPoly VSS 0.0147086f
Cred_2495 di_tg_ctrl|di_tg_ctrl_n|vin|vout.P3.GatPoly v_b.$161.Metal2 0.00403827f
Cred_2496 di_tg_ctrl|di_tg_ctrl_n|vin|vout.P3.GatPoly v_b.$195.Metal2 0.00403827f
Cred_2497 di_tg_ctrl|di_tg_ctrl_n|vin|vout.P3.GatPoly v_b.P3.nSD 0.00453858f
Cred_2498 di_tg_ctrl|di_tg_ctrl_n|vin|vout.P3.GatPoly v_b.P3.pSD 0.00012852f
Cred_2499 di_tg_ctrl|di_tg_ctrl_n|vin|vout.P3.GatPoly v_c.$476.Metal3 0.00499276f
Cred_2500 di_tg_ctrl|di_tg_ctrl_n|vin|vout.P3.GatPoly v_c.P2.nSD 0.00611545f
Cred_2501 di_tg_ctrl|di_tg_ctrl_n|vin|vout.P3.GatPoly VSS.$220.Metal1 0.001136f
Cred_2502 di_tg_ctrl|di_tg_ctrl_n|vin|vout.P3.GatPoly VSS.$245.Metal1 0.000233283f
Cred_2503 di_tg_ctrl|di_tg_ctrl_n|vin|vout.P3.GatPoly VSS.$255.Metal1 0.000383614f
Cred_2504 di_tg_ctrl|di_tg_ctrl_n|vin|vout.P3.GatPoly VSS.$448.Metal2 1.97393e-07f
Cred_2505 di_tg_ctrl|di_tg_ctrl_n|vin|vout.P3.GatPoly VSS.$452.Metal2 1.51844e-05f
Cred_2506 di_tg_ctrl|di_tg_ctrl_n|vin|vout.P3.GatPoly VSS.$548.Metal3 1.08534e-06f
Cred_2507 di_tg_ctrl|di_tg_ctrl_n|vin|vout.P3.GatPoly VSS.P0.pSD 0.000736295f
Cred_2508 di_tg_ctrl|di_tg_ctrl_n|vin|vout.P4.GatPoly di_tg_ctrl|di_tg_ctrl_n|vout.P5.GatPoly 0.0013276f
Cred_2509 di_tg_ctrl|di_tg_ctrl_n|vin|vout.P4.GatPoly VSS 0.0128857f
Cred_2510 di_tg_ctrl|di_tg_ctrl_n|vin|vout.P4.GatPoly v_b.$161.Metal2 0.00387826f
Cred_2511 di_tg_ctrl|di_tg_ctrl_n|vin|vout.P4.GatPoly v_b.$195.Metal2 0.00387826f
Cred_2512 di_tg_ctrl|di_tg_ctrl_n|vin|vout.P4.GatPoly v_b.P3.nSD 0.00424245f
Cred_2513 di_tg_ctrl|di_tg_ctrl_n|vin|vout.P4.GatPoly v_b.P3.pSD 0.000123427f
Cred_2514 di_tg_ctrl|di_tg_ctrl_n|vin|vout.P4.GatPoly v_c.$493.Metal3 0.00505336f
Cred_2515 di_tg_ctrl|di_tg_ctrl_n|vin|vout.P4.GatPoly v_c.P4.nSD 0.00621439f
Cred_2516 di_tg_ctrl|di_tg_ctrl_n|vin|vout.P4.GatPoly VSS.$220.Metal1 0.000993975f
Cred_2517 di_tg_ctrl|di_tg_ctrl_n|vin|vout.P4.GatPoly VSS.$255.Metal1 0.000508889f
Cred_2518 di_tg_ctrl|di_tg_ctrl_n|vin|vout.P4.GatPoly VSS.$452.Metal2 2.06999e-05f
Cred_2519 di_tg_ctrl|di_tg_ctrl_n|vin|vout.P4.GatPoly VSS.$548.Metal3 1.4892e-06f
Cred_2520 di_tg_ctrl|di_tg_ctrl_n|vin|vout.P4.GatPoly VSS.P0.pSD 0.000868317f
Cred_2521 di_tg_ctrl|di_tg_ctrl_n|vin|vout.P5.GatPoly di_tg_ctrl|di_tg_ctrl_n|vout.P5.GatPoly 0.00127455f
Cred_2522 di_tg_ctrl|di_tg_ctrl_n|vin|vout.P5.GatPoly VSS 0.0211346f
Cred_2523 di_tg_ctrl|di_tg_ctrl_n|vin|vout.P5.GatPoly v_b.$195.Metal2 0.00871982f
Cred_2524 di_tg_ctrl|di_tg_ctrl_n|vin|vout.P5.GatPoly v_b.P5.nSD 0.00494138f
Cred_2525 di_tg_ctrl|di_tg_ctrl_n|vin|vout.P5.GatPoly v_c.$493.Metal3 0.00559207f
Cred_2526 di_tg_ctrl|di_tg_ctrl_n|vin|vout.P5.GatPoly v_c.P4.nSD 0.00709703f
Cred_2527 di_tg_ctrl|di_tg_ctrl_n|vin|vout.P5.GatPoly VSS.$220.Metal1 0.00163386f
Cred_2528 di_tg_ctrl|di_tg_ctrl_n|vin|vout.P5.GatPoly VSS.$255.Metal1 0.00140219f
Cred_2529 di_tg_ctrl|di_tg_ctrl_n|vin|vout.P5.GatPoly VSS.$452.Metal2 4.41471e-05f
Cred_2530 di_tg_ctrl|di_tg_ctrl_n|vin|vout.P5.GatPoly VSS.$548.Metal3 3.16698e-06f
Cred_2531 di_tg_ctrl|di_tg_ctrl_n|vin|vout.P5.GatPoly VSS.P0.pSD 0.00162664f
Cred_2532 di_tg_ctrl|di_tg_ctrl_n|vin|vout.P6.GatPoly di_tg_ctrl|di_tg_ctrl_n|vout.$180.Metal3 0.00101533f
Cred_2533 di_tg_ctrl|di_tg_ctrl_n|vin|vout.P6.GatPoly di_tg_ctrl|di_tg_ctrl_n|vout.$206.Metal4 0.00183099f
Cred_2534 di_tg_ctrl|di_tg_ctrl_n|vin|vout.P6.GatPoly di_tg_ctrl|di_tg_ctrl_n|vout.P0.nSD 0.000116654f
Cred_2535 di_tg_ctrl|di_tg_ctrl_n|vin|vout.P6.GatPoly di_tg_ctrl|di_tg_ctrl_n|vout.P0.pSD 0.000605544f
Cred_2536 di_tg_ctrl|di_tg_ctrl_n|vin|vout.P6.GatPoly di_tg_ctrl|di_tg_ctrl_n|vout.P6.GatPoly 0.00611523f
Cred_2537 di_tg_ctrl|di_tg_ctrl_n|vin|vout.P6.GatPoly v_a 3.06958e-05f
Cred_2538 di_tg_ctrl|di_tg_ctrl_n|vin|vout.P6.GatPoly v_a.$148.Metal2 0.0305573f
Cred_2539 di_tg_ctrl|di_tg_ctrl_n|vin|vout.P6.GatPoly v_a.P0.pSD 0.0328565f
Cred_2540 di_tg_ctrl|di_tg_ctrl_n|vin|vout.P6.GatPoly v_b 0.00190169f
Cred_2541 di_tg_ctrl|di_tg_ctrl_n|vin|vout.P6.GatPoly v_b.$195.Metal2 0.000630827f
Cred_2542 di_tg_ctrl|di_tg_ctrl_n|vin|vout.P6.GatPoly v_c.$21.Metal1 0.0263966f
Cred_2543 di_tg_ctrl|di_tg_ctrl_n|vin|vout.P6.GatPoly v_c.$220.Metal2 0.00170045f
Cred_2544 di_tg_ctrl|di_tg_ctrl_n|vin|vout.P6.GatPoly v_c.$224.Metal2 0.000111175f
Cred_2545 di_tg_ctrl|di_tg_ctrl_n|vin|vout.P6.GatPoly v_c.$226.Metal2 2.26676e-06f
Cred_2546 di_tg_ctrl|di_tg_ctrl_n|vin|vout.P6.GatPoly v_c.$228.Metal2 0.00525158f
Cred_2547 di_tg_ctrl|di_tg_ctrl_n|vin|vout.P6.GatPoly v_c.$23.Metal1 0.0237003f
Cred_2548 di_tg_ctrl|di_tg_ctrl_n|vin|vout.P6.GatPoly v_c.$411.Metal3 0.00102975f
Cred_2549 di_tg_ctrl|di_tg_ctrl_n|vin|vout.P6.GatPoly v_c.$415.Metal3 0.00226339f
Cred_2550 di_tg_ctrl|di_tg_ctrl_n|vin|vout.P6.GatPoly v_c.$425.Metal3 0.00018587f
Cred_2551 di_tg_ctrl|di_tg_ctrl_n|vin|vout.P6.GatPoly v_c.P6.nSD 8.37938e-07f
Cred_2552 di_tg_ctrl|di_tg_ctrl_n|vin|vout.P6.GatPoly v_c.P6.pSD 0.00715248f
Cred_2553 di_tg_ctrl|di_tg_ctrl_n|vin|vout.P6.GatPoly VDD.$320.Metal1 6.65742e-06f
Cred_2554 di_tg_ctrl|di_tg_ctrl_n|vin|vout.P6.GatPoly VDD.$359.Metal1 6.65742e-06f
Cred_2555 di_tg_ctrl|di_tg_ctrl_n|vin|vout.P6.GatPoly VDD.$382.Metal1 0.00240276f
Cred_2556 di_tg_ctrl|di_tg_ctrl_n|vin|vout.P6.GatPoly VDD.$477.Metal1 7.55732e-05f
Cred_2557 di_tg_ctrl|di_tg_ctrl_n|vin|vout.P6.GatPoly VDD.$526.Metal1 1.8823e-05f
Cred_2558 di_tg_ctrl|di_tg_ctrl_n|vin|vout.P6.GatPoly VDD.$703.Metal2 0.00102957f
Cred_2559 di_tg_ctrl|di_tg_ctrl_n|vin|vout.P6.GatPoly VDD.P0.nSD 0.000939601f
Cred_2560 di_tg_ctrl|di_tg_ctrl_n|vin|vout.P6.GatPoly VDD.P10.pSD 1.34681e-07f
Cred_2561 di_tg_ctrl|di_tg_ctrl_n|vin|vout.P6.GatPoly VDD.P11.pSD 1.34681e-07f
Cred_2562 di_tg_ctrl|di_tg_ctrl_n|vin|vout.P6.GatPoly VDD.P3.GatPoly 0.0398038f
Cred_2563 di_tg_ctrl|di_tg_ctrl_n|vin|vout.P7.GatPoly di_tg_ctrl|di_tg_ctrl_n|vout.$180.Metal3 0.000516666f
Cred_2564 di_tg_ctrl|di_tg_ctrl_n|vin|vout.P7.GatPoly di_tg_ctrl|di_tg_ctrl_n|vout.$206.Metal4 0.0015234f
Cred_2565 di_tg_ctrl|di_tg_ctrl_n|vin|vout.P7.GatPoly di_tg_ctrl|di_tg_ctrl_n|vout.P0.nSD 5.93613e-05f
Cred_2566 di_tg_ctrl|di_tg_ctrl_n|vin|vout.P7.GatPoly di_tg_ctrl|di_tg_ctrl_n|vout.P0.pSD 0.000308141f
Cred_2567 di_tg_ctrl|di_tg_ctrl_n|vin|vout.P7.GatPoly di_tg_ctrl|di_tg_ctrl_n|vout.P6.GatPoly 0.00695224f
Cred_2568 di_tg_ctrl|di_tg_ctrl_n|vin|vout.P7.GatPoly v_a.$148.Metal2 0.0153112f
Cred_2569 di_tg_ctrl|di_tg_ctrl_n|vin|vout.P7.GatPoly v_a.$182.Metal2 0.0153112f
Cred_2570 di_tg_ctrl|di_tg_ctrl_n|vin|vout.P7.GatPoly v_a.P1.nSD 0.000127353f
Cred_2571 di_tg_ctrl|di_tg_ctrl_n|vin|vout.P7.GatPoly v_a.P1.pSD 0.0332688f
Cred_2572 di_tg_ctrl|di_tg_ctrl_n|vin|vout.P7.GatPoly v_b 0.00190169f
Cred_2573 di_tg_ctrl|di_tg_ctrl_n|vin|vout.P7.GatPoly v_b.$195.Metal2 0.000630827f
Cred_2574 di_tg_ctrl|di_tg_ctrl_n|vin|vout.P7.GatPoly v_c.$21.Metal1 0.0285568f
Cred_2575 di_tg_ctrl|di_tg_ctrl_n|vin|vout.P7.GatPoly v_c.$220.Metal2 0.00177695f
Cred_2576 di_tg_ctrl|di_tg_ctrl_n|vin|vout.P7.GatPoly v_c.$224.Metal2 0.000118269f
Cred_2577 di_tg_ctrl|di_tg_ctrl_n|vin|vout.P7.GatPoly v_c.$226.Metal2 2.26676e-06f
Cred_2578 di_tg_ctrl|di_tg_ctrl_n|vin|vout.P7.GatPoly v_c.$228.Metal2 0.00520909f
Cred_2579 di_tg_ctrl|di_tg_ctrl_n|vin|vout.P7.GatPoly v_c.$23.Metal1 0.0236301f
Cred_2580 di_tg_ctrl|di_tg_ctrl_n|vin|vout.P7.GatPoly v_c.$411.Metal3 0.00138113f
Cred_2581 di_tg_ctrl|di_tg_ctrl_n|vin|vout.P7.GatPoly v_c.$415.Metal3 0.00224067f
Cred_2582 di_tg_ctrl|di_tg_ctrl_n|vin|vout.P7.GatPoly v_c.$425.Metal3 0.00169736f
Cred_2583 di_tg_ctrl|di_tg_ctrl_n|vin|vout.P7.GatPoly v_c.P6.nSD 7.65202e-06f
Cred_2584 di_tg_ctrl|di_tg_ctrl_n|vin|vout.P7.GatPoly v_c.P6.pSD 0.00716497f
Cred_2585 di_tg_ctrl|di_tg_ctrl_n|vin|vout.P7.GatPoly VDD.$382.Metal1 0.00246834f
Cred_2586 di_tg_ctrl|di_tg_ctrl_n|vin|vout.P7.GatPoly VDD.$477.Metal1 0.000107507f
Cred_2587 di_tg_ctrl|di_tg_ctrl_n|vin|vout.P7.GatPoly VDD.$526.Metal1 2.67767e-05f
Cred_2588 di_tg_ctrl|di_tg_ctrl_n|vin|vout.P7.GatPoly VDD.P0.nSD 0.00126622f
Cred_2589 di_tg_ctrl|di_tg_ctrl_n|vin|vout.P7.GatPoly VDD.P3.GatPoly 0.00967798f
Cred_2590 di_tg_ctrl|di_tg_ctrl_n|vin|vout.P8.GatPoly di_tg_ctrl|di_tg_ctrl_n|vout.$14.GatPoly 7.00276e-06f
Cred_2591 di_tg_ctrl|di_tg_ctrl_n|vin|vout.P8.GatPoly di_tg_ctrl|di_tg_ctrl_n|vout.$206.Metal4 0.00169193f
Cred_2592 di_tg_ctrl|di_tg_ctrl_n|vin|vout.P8.GatPoly di_tg_ctrl|di_tg_ctrl_n|vout.$77.Metal1 5.11931e-06f
Cred_2593 di_tg_ctrl|di_tg_ctrl_n|vin|vout.P8.GatPoly di_tg_ctrl|di_tg_ctrl_n|vout.$79.Metal1 9.2592e-07f
Cred_2594 di_tg_ctrl|di_tg_ctrl_n|vin|vout.P8.GatPoly di_tg_ctrl|di_tg_ctrl_n|vout.P6.GatPoly 0.00775395f
Cred_2595 di_tg_ctrl|di_tg_ctrl_n|vin|vout.P8.GatPoly VSS 2.03641e-05f
Cred_2596 di_tg_ctrl|di_tg_ctrl_n|vin|vout.P8.GatPoly v_a.$148.Metal2 0.0150616f
Cred_2597 di_tg_ctrl|di_tg_ctrl_n|vin|vout.P8.GatPoly v_a.$182.Metal2 0.0150616f
Cred_2598 di_tg_ctrl|di_tg_ctrl_n|vin|vout.P8.GatPoly v_a.P1.nSD 0.000125277f
Cred_2599 di_tg_ctrl|di_tg_ctrl_n|vin|vout.P8.GatPoly v_a.P1.pSD 0.0333723f
Cred_2600 di_tg_ctrl|di_tg_ctrl_n|vin|vout.P8.GatPoly v_b 0.00190169f
Cred_2601 di_tg_ctrl|di_tg_ctrl_n|vin|vout.P8.GatPoly v_b.$195.Metal2 0.000630827f
Cred_2602 di_tg_ctrl|di_tg_ctrl_n|vin|vout.P8.GatPoly v_c.$425.Metal3 0.0278243f
Cred_2603 di_tg_ctrl|di_tg_ctrl_n|vin|vout.P8.GatPoly v_c.P8.pSD 0.044117f
Cred_2604 di_tg_ctrl|di_tg_ctrl_n|vin|vout.P8.GatPoly VDD.$382.Metal1 0.00232872f
Cred_2605 di_tg_ctrl|di_tg_ctrl_n|vin|vout.P8.GatPoly VDD.$422.Metal1 4.75777e-06f
Cred_2606 di_tg_ctrl|di_tg_ctrl_n|vin|vout.P8.GatPoly VDD.$426.Metal1 9.30868e-06f
Cred_2607 di_tg_ctrl|di_tg_ctrl_n|vin|vout.P8.GatPoly VDD.$477.Metal1 0.000135306f
Cred_2608 di_tg_ctrl|di_tg_ctrl_n|vin|vout.P8.GatPoly VDD.$526.Metal1 3.37005e-05f
Cred_2609 di_tg_ctrl|di_tg_ctrl_n|vin|vout.P8.GatPoly VDD.$714.Metal2 1.19228e-05f
Cred_2610 di_tg_ctrl|di_tg_ctrl_n|vin|vout.P8.GatPoly VDD.$734.Metal2 8.77966e-06f
Cred_2611 di_tg_ctrl|di_tg_ctrl_n|vin|vout.P8.GatPoly VDD.$738.Metal2 1.50508e-06f
Cred_2612 di_tg_ctrl|di_tg_ctrl_n|vin|vout.P8.GatPoly VDD.$754.Metal2 9.98446e-09f
Cred_2613 di_tg_ctrl|di_tg_ctrl_n|vin|vout.P8.GatPoly VDD.$762.Metal2 9.98446e-09f
Cred_2614 di_tg_ctrl|di_tg_ctrl_n|vin|vout.P8.GatPoly VDD.$882.Metal3 8.00532e-11f
Cred_2615 di_tg_ctrl|di_tg_ctrl_n|vin|vout.P8.GatPoly VDD.P0.nSD 0.00150659f
Cred_2616 di_tg_ctrl|di_tg_ctrl_n|vin|vout.P8.GatPoly VDD.P3.GatPoly 0.00808404f
Cred_2617 di_tg_ctrl|di_tg_ctrl_n|vin|vout.P9.GatPoly di_tg_ctrl|di_tg_ctrl_n|vout.$14.GatPoly 2.01458e-05f
Cred_2618 di_tg_ctrl|di_tg_ctrl_n|vin|vout.P9.GatPoly di_tg_ctrl|di_tg_ctrl_n|vout.$206.Metal4 0.00169193f
Cred_2619 di_tg_ctrl|di_tg_ctrl_n|vin|vout.P9.GatPoly di_tg_ctrl|di_tg_ctrl_n|vout.$77.Metal1 1.47274e-05f
Cred_2620 di_tg_ctrl|di_tg_ctrl_n|vin|vout.P9.GatPoly di_tg_ctrl|di_tg_ctrl_n|vout.$79.Metal1 2.66372e-06f
Cred_2621 di_tg_ctrl|di_tg_ctrl_n|vin|vout.P9.GatPoly di_tg_ctrl|di_tg_ctrl_n|vout.P6.GatPoly 0.00879717f
Cred_2622 di_tg_ctrl|di_tg_ctrl_n|vin|vout.P9.GatPoly VSS 0.000139177f
Cred_2623 di_tg_ctrl|di_tg_ctrl_n|vin|vout.P9.GatPoly v_a.$182.Metal2 0.0308237f
Cred_2624 di_tg_ctrl|di_tg_ctrl_n|vin|vout.P9.GatPoly v_a.P3.pSD 0.0330856f
Cred_2625 di_tg_ctrl|di_tg_ctrl_n|vin|vout.P9.GatPoly v_b 0.00190169f
Cred_2626 di_tg_ctrl|di_tg_ctrl_n|vin|vout.P9.GatPoly v_b.$195.Metal2 0.000630827f
Cred_2627 di_tg_ctrl|di_tg_ctrl_n|vin|vout.P9.GatPoly v_c.$425.Metal3 0.0279572f
Cred_2628 di_tg_ctrl|di_tg_ctrl_n|vin|vout.P9.GatPoly v_c.P8.pSD 0.0443347f
Cred_2629 di_tg_ctrl|di_tg_ctrl_n|vin|vout.P9.GatPoly VDD.$382.Metal1 0.00184616f
Cred_2630 di_tg_ctrl|di_tg_ctrl_n|vin|vout.P9.GatPoly VDD.$426.Metal1 2.71093e-05f
Cred_2631 di_tg_ctrl|di_tg_ctrl_n|vin|vout.P9.GatPoly VDD.$434.Metal1 8.82796e-05f
Cred_2632 di_tg_ctrl|di_tg_ctrl_n|vin|vout.P9.GatPoly VDD.$438.Metal1 1.18937e-05f
Cred_2633 di_tg_ctrl|di_tg_ctrl_n|vin|vout.P9.GatPoly VDD.$477.Metal1 0.000176533f
Cred_2634 di_tg_ctrl|di_tg_ctrl_n|vin|vout.P9.GatPoly VDD.$526.Metal1 4.3969e-05f
Cred_2635 di_tg_ctrl|di_tg_ctrl_n|vin|vout.P9.GatPoly VDD.$714.Metal2 2.58256e-05f
Cred_2636 di_tg_ctrl|di_tg_ctrl_n|vin|vout.P9.GatPoly VDD.$734.Metal2 1.90174e-05f
Cred_2637 di_tg_ctrl|di_tg_ctrl_n|vin|vout.P9.GatPoly VDD.$738.Metal2 3.26012e-06f
Cred_2638 di_tg_ctrl|di_tg_ctrl_n|vin|vout.P9.GatPoly VDD.$762.Metal2 1.50375e-07f
Cred_2639 di_tg_ctrl|di_tg_ctrl_n|vin|vout.P9.GatPoly VDD.$766.Metal2 3.85567e-07f
Cred_2640 di_tg_ctrl|di_tg_ctrl_n|vin|vout.P9.GatPoly VDD.$774.Metal2 2.49597e-08f
Cred_2641 di_tg_ctrl|di_tg_ctrl_n|vin|vout.P9.GatPoly VDD.$888.Metal3 2.00122e-10f
Cred_2642 di_tg_ctrl|di_tg_ctrl_n|vin|vout.P9.GatPoly VDD.P0.nSD 0.00177763f
Cred_2643 di_tg_ctrl|di_tg_ctrl_n|vin|vout.P9.GatPoly VDD.P3.GatPoly 0.00702877f
Cred_2644 di_tg_ctrl|di_tg_ctrl_n|vout VSS 0.0200504f
Cred_2645 di_tg_ctrl|di_tg_ctrl_n|vout v_a 4.67745e-06f
Cred_2646 di_tg_ctrl|di_tg_ctrl_n|vout v_a.$148.Metal2 0.0085701f
Cred_2647 di_tg_ctrl|di_tg_ctrl_n|vout v_a.P0.nSD 0.00508643f
Cred_2648 di_tg_ctrl|di_tg_ctrl_n|vout v_c.$220.Metal2 6.48422e-06f
Cred_2649 di_tg_ctrl|di_tg_ctrl_n|vout v_c.$411.Metal3 0.000808731f
Cred_2650 di_tg_ctrl|di_tg_ctrl_n|vout v_c.$425.Metal3 0.00483145f
Cred_2651 di_tg_ctrl|di_tg_ctrl_n|vout v_c.P6.nSD 0.00733161f
Cred_2652 di_tg_ctrl|di_tg_ctrl_n|vout VSS.$129.Metal1 0.000894745f
Cred_2653 di_tg_ctrl|di_tg_ctrl_n|vout VSS.$132.Metal1 0.000484533f
Cred_2654 di_tg_ctrl|di_tg_ctrl_n|vout VSS.$134.Metal1 1.67152e-06f
Cred_2655 di_tg_ctrl|di_tg_ctrl_n|vout VSS.$147.Metal1 2.24754e-06f
Cred_2656 di_tg_ctrl|di_tg_ctrl_n|vout VSS.$165.Metal1 5.14671e-05f
Cred_2657 di_tg_ctrl|di_tg_ctrl_n|vout VSS.$175.Metal1 0.000248949f
Cred_2658 di_tg_ctrl|di_tg_ctrl_n|vout VSS.$220.Metal1 0.000619225f
Cred_2659 di_tg_ctrl|di_tg_ctrl_n|vout VSS.$368.Metal2 1.2893e-08f
Cred_2660 di_tg_ctrl|di_tg_ctrl_n|vout VSS.$384.Metal2 3.96913e-07f
Cred_2661 di_tg_ctrl|di_tg_ctrl_n|vout VSS.$87.Metal1 0.000188766f
Cred_2662 di_tg_ctrl|di_tg_ctrl_n|vout VSS.P0.pSD 0.00052872f
Cred_2663 di_tg_ctrl|di_tg_ctrl_n|vout VSS.P3.GatPoly 0.00660262f
Cred_2664 di_tg_ctrl|di_tg_ctrl_n|vout.$1.GatPoly VSS 0.0578001f
Cred_2665 di_tg_ctrl|di_tg_ctrl_n|vout.$1.GatPoly v_a.$148.Metal2 0.000343475f
Cred_2666 di_tg_ctrl|di_tg_ctrl_n|vout.$1.GatPoly v_a.$182.Metal2 0.000343475f
Cred_2667 di_tg_ctrl|di_tg_ctrl_n|vout.$1.GatPoly v_a.P1.nSD 0.00064328f
Cred_2668 di_tg_ctrl|di_tg_ctrl_n|vout.$1.GatPoly v_a.P1.pSD 1.09312e-05f
Cred_2669 di_tg_ctrl|di_tg_ctrl_n|vout.$1.GatPoly v_c.$220.Metal2 1.73288e-06f
Cred_2670 di_tg_ctrl|di_tg_ctrl_n|vout.$1.GatPoly v_c.$411.Metal3 0.000216129f
Cred_2671 di_tg_ctrl|di_tg_ctrl_n|vout.$1.GatPoly v_c.$425.Metal3 0.00129118f
Cred_2672 di_tg_ctrl|di_tg_ctrl_n|vout.$1.GatPoly v_c.P6.nSD 0.00250682f
Cred_2673 di_tg_ctrl|di_tg_ctrl_n|vout.$1.GatPoly VSS.$129.Metal1 4.96092e-06f
Cred_2674 di_tg_ctrl|di_tg_ctrl_n|vout.$1.GatPoly VSS.$132.Metal1 0.00307709f
Cred_2675 di_tg_ctrl|di_tg_ctrl_n|vout.$1.GatPoly VSS.$134.Metal1 1.06152e-05f
Cred_2676 di_tg_ctrl|di_tg_ctrl_n|vout.$1.GatPoly VSS.$147.Metal1 1.42732e-05f
Cred_2677 di_tg_ctrl|di_tg_ctrl_n|vout.$1.GatPoly VSS.$165.Metal1 0.000329757f
Cred_2678 di_tg_ctrl|di_tg_ctrl_n|vout.$1.GatPoly VSS.$175.Metal1 0.00397277f
Cred_2679 di_tg_ctrl|di_tg_ctrl_n|vout.$1.GatPoly VSS.$181.Metal1 0.00114362f
Cred_2680 di_tg_ctrl|di_tg_ctrl_n|vout.$1.GatPoly VSS.$220.Metal1 4.55244e-06f
Cred_2681 di_tg_ctrl|di_tg_ctrl_n|vout.$1.GatPoly VSS.$368.Metal2 8.18784e-08f
Cred_2682 di_tg_ctrl|di_tg_ctrl_n|vout.$1.GatPoly VSS.$384.Metal2 2.54308e-06f
Cred_2683 di_tg_ctrl|di_tg_ctrl_n|vout.$1.GatPoly VSS.$392.Metal2 2.44364e-06f
Cred_2684 di_tg_ctrl|di_tg_ctrl_n|vout.$1.GatPoly VSS.$87.Metal1 1.04661e-06f
Cred_2685 di_tg_ctrl|di_tg_ctrl_n|vout.$1.GatPoly VSS.P0.pSD 4.61643e-06f
Cred_2686 di_tg_ctrl|di_tg_ctrl_n|vout.$1.GatPoly VSS.P3.GatPoly 0.000986268f
Cred_2687 di_tg_ctrl|di_tg_ctrl_n|vout.$10.GatPoly VSS 0.06964f
Cred_2688 di_tg_ctrl|di_tg_ctrl_n|vout.$10.GatPoly v_a.$182.Metal2 0.00158834f
Cred_2689 di_tg_ctrl|di_tg_ctrl_n|vout.$10.GatPoly v_a.P3.nSD 0.00124385f
Cred_2690 di_tg_ctrl|di_tg_ctrl_n|vout.$10.GatPoly v_a.P5.nSD 0.000244895f
Cred_2691 di_tg_ctrl|di_tg_ctrl_n|vout.$10.GatPoly v_a.P5.pSD 6.15695e-06f
Cred_2692 di_tg_ctrl|di_tg_ctrl_n|vout.$10.GatPoly v_c.$284.Metal2 2.53812e-06f
Cred_2693 di_tg_ctrl|di_tg_ctrl_n|vout.$10.GatPoly v_c.$425.Metal3 0.00117673f
Cred_2694 di_tg_ctrl|di_tg_ctrl_n|vout.$10.GatPoly v_c.$446.Metal3 0.000316561f
Cred_2695 di_tg_ctrl|di_tg_ctrl_n|vout.$10.GatPoly v_c.$459.Metal3 0.000374047f
Cred_2696 di_tg_ctrl|di_tg_ctrl_n|vout.$10.GatPoly v_c.P10.nSD 0.00294331f
Cred_2697 di_tg_ctrl|di_tg_ctrl_n|vout.$10.GatPoly v_c.P8.nSD 0.000101441f
Cred_2698 di_tg_ctrl|di_tg_ctrl_n|vout.$10.GatPoly VSS.$129.Metal1 1.4572e-05f
Cred_2699 di_tg_ctrl|di_tg_ctrl_n|vout.$10.GatPoly VSS.$185.Metal1 0.00125406f
Cred_2700 di_tg_ctrl|di_tg_ctrl_n|vout.$10.GatPoly VSS.$195.Metal1 0.00554533f
Cred_2701 di_tg_ctrl|di_tg_ctrl_n|vout.$10.GatPoly VSS.$199.Metal1 0.00113705f
Cred_2702 di_tg_ctrl|di_tg_ctrl_n|vout.$10.GatPoly VSS.$209.Metal1 3.48562e-05f
Cred_2703 di_tg_ctrl|di_tg_ctrl_n|vout.$10.GatPoly VSS.$211.Metal1 0.000145022f
Cred_2704 di_tg_ctrl|di_tg_ctrl_n|vout.$10.GatPoly VSS.$220.Metal1 9.71706e-05f
Cred_2705 di_tg_ctrl|di_tg_ctrl_n|vout.$10.GatPoly VSS.$400.Metal2 1.06113e-06f
Cred_2706 di_tg_ctrl|di_tg_ctrl_n|vout.$10.GatPoly VSS.$404.Metal2 1.06541e-05f
Cred_2707 di_tg_ctrl|di_tg_ctrl_n|vout.$10.GatPoly VSS.$408.Metal2 2.59386e-05f
Cred_2708 di_tg_ctrl|di_tg_ctrl_n|vout.$10.GatPoly VSS.$416.Metal2 1.07697e-05f
Cred_2709 di_tg_ctrl|di_tg_ctrl_n|vout.$10.GatPoly VSS.$522.Metal3 2.7962e-07f
Cred_2710 di_tg_ctrl|di_tg_ctrl_n|vout.$10.GatPoly VSS.$530.Metal3 2.7962e-07f
Cred_2711 di_tg_ctrl|di_tg_ctrl_n|vout.$10.GatPoly VSS.$87.Metal1 3.07428e-06f
Cred_2712 di_tg_ctrl|di_tg_ctrl_n|vout.$10.GatPoly VSS.P0.pSD 2.8231e-05f
Cred_2713 di_tg_ctrl|di_tg_ctrl_n|vout.$128.Metal2 VSS 0.0084782f
Cred_2714 di_tg_ctrl|di_tg_ctrl_n|vout.$128.Metal2 v_a 1.33199e-05f
Cred_2715 di_tg_ctrl|di_tg_ctrl_n|vout.$128.Metal2 v_a.$148.Metal2 0.0248577f
Cred_2716 di_tg_ctrl|di_tg_ctrl_n|vout.$128.Metal2 v_a.$182.Metal2 0.000890832f
Cred_2717 di_tg_ctrl|di_tg_ctrl_n|vout.$128.Metal2 v_a.P0.nSD 0.00135326f
Cred_2718 di_tg_ctrl|di_tg_ctrl_n|vout.$128.Metal2 v_a.P1.nSD 1.89321e-05f
Cred_2719 di_tg_ctrl|di_tg_ctrl_n|vout.$128.Metal2 v_a.P1.pSD 2.83511e-05f
Cred_2720 di_tg_ctrl|di_tg_ctrl_n|vout.$128.Metal2 v_c.$220.Metal2 2.8231e-05f
Cred_2721 di_tg_ctrl|di_tg_ctrl_n|vout.$128.Metal2 v_c.$411.Metal3 0.00352105f
Cred_2722 di_tg_ctrl|di_tg_ctrl_n|vout.$128.Metal2 v_c.$425.Metal3 0.0210352f
Cred_2723 di_tg_ctrl|di_tg_ctrl_n|vout.$128.Metal2 v_c.P6.nSD 0.0113419f
Cred_2724 di_tg_ctrl|di_tg_ctrl_n|vout.$128.Metal2 VSS.$129.Metal1 3.99277e-06f
Cred_2725 di_tg_ctrl|di_tg_ctrl_n|vout.$128.Metal2 VSS.$132.Metal1 9.71303e-05f
Cred_2726 di_tg_ctrl|di_tg_ctrl_n|vout.$128.Metal2 VSS.$134.Metal1 1.53985e-06f
Cred_2727 di_tg_ctrl|di_tg_ctrl_n|vout.$128.Metal2 VSS.$147.Metal1 2.07049e-06f
Cred_2728 di_tg_ctrl|di_tg_ctrl_n|vout.$128.Metal2 VSS.$165.Metal1 0.00155474f
Cred_2729 di_tg_ctrl|di_tg_ctrl_n|vout.$128.Metal2 VSS.$175.Metal1 0.00342521f
Cred_2730 di_tg_ctrl|di_tg_ctrl_n|vout.$128.Metal2 VSS.$181.Metal1 0.000585326f
Cred_2731 di_tg_ctrl|di_tg_ctrl_n|vout.$128.Metal2 VSS.$220.Metal1 3.66401e-06f
Cred_2732 di_tg_ctrl|di_tg_ctrl_n|vout.$128.Metal2 VSS.$311.Metal2 0.00105837f
Cred_2733 di_tg_ctrl|di_tg_ctrl_n|vout.$128.Metal2 VSS.$368.Metal2 1.18773e-08f
Cred_2734 di_tg_ctrl|di_tg_ctrl_n|vout.$128.Metal2 VSS.$376.Metal2 0.00842962f
Cred_2735 di_tg_ctrl|di_tg_ctrl_n|vout.$128.Metal2 VSS.$384.Metal2 0.0265738f
Cred_2736 di_tg_ctrl|di_tg_ctrl_n|vout.$128.Metal2 VSS.$392.Metal2 0.009505f
Cred_2737 di_tg_ctrl|di_tg_ctrl_n|vout.$128.Metal2 VSS.$510.Metal3 0.000220608f
Cred_2738 di_tg_ctrl|di_tg_ctrl_n|vout.$128.Metal2 VSS.$518.Metal3 0.000294204f
Cred_2739 di_tg_ctrl|di_tg_ctrl_n|vout.$128.Metal2 VSS.$78.Metal1 2.58727e-05f
Cred_2740 di_tg_ctrl|di_tg_ctrl_n|vout.$128.Metal2 VSS.$87.Metal1 8.42363e-07f
Cred_2741 di_tg_ctrl|di_tg_ctrl_n|vout.$128.Metal2 VSS.P0.pSD 7.96526e-06f
Cred_2742 di_tg_ctrl|di_tg_ctrl_n|vout.$128.Metal2 VSS.P2.GatPoly 3.43347e-08f
Cred_2743 di_tg_ctrl|di_tg_ctrl_n|vout.$128.Metal2 VSS.P6.nSD 2.6839e-07f
Cred_2744 di_tg_ctrl|di_tg_ctrl_n|vout.$128.Metal2 VSS.P7.nSD 3.42014e-07f
Cred_2745 di_tg_ctrl|di_tg_ctrl_n|vout.$130.Metal2 VSS 0.00544663f
Cred_2746 di_tg_ctrl|di_tg_ctrl_n|vout.$130.Metal2 v_a.$148.Metal2 0.0168035f
Cred_2747 di_tg_ctrl|di_tg_ctrl_n|vout.$130.Metal2 v_a.$182.Metal2 0.0168035f
Cred_2748 di_tg_ctrl|di_tg_ctrl_n|vout.$130.Metal2 v_a.P1.nSD 0.0019142f
Cred_2749 di_tg_ctrl|di_tg_ctrl_n|vout.$130.Metal2 v_a.P1.pSD 0.000534777f
Cred_2750 di_tg_ctrl|di_tg_ctrl_n|vout.$130.Metal2 v_c.$220.Metal2 1.97643e-06f
Cred_2751 di_tg_ctrl|di_tg_ctrl_n|vout.$130.Metal2 v_c.$411.Metal3 0.000246506f
Cred_2752 di_tg_ctrl|di_tg_ctrl_n|vout.$130.Metal2 v_c.$425.Metal3 0.0085452f
Cred_2753 di_tg_ctrl|di_tg_ctrl_n|vout.$130.Metal2 v_c.P6.nSD 7.06228e-05f
Cred_2754 di_tg_ctrl|di_tg_ctrl_n|vout.$130.Metal2 v_c.P8.nSD 0.00253036f
Cred_2755 di_tg_ctrl|di_tg_ctrl_n|vout.$130.Metal2 VSS.$129.Metal1 3.14943e-06f
Cred_2756 di_tg_ctrl|di_tg_ctrl_n|vout.$130.Metal2 VSS.$165.Metal1 1.49114e-06f
Cred_2757 di_tg_ctrl|di_tg_ctrl_n|vout.$130.Metal2 VSS.$175.Metal1 0.000833403f
Cred_2758 di_tg_ctrl|di_tg_ctrl_n|vout.$130.Metal2 VSS.$181.Metal1 0.00358408f
Cred_2759 di_tg_ctrl|di_tg_ctrl_n|vout.$130.Metal2 VSS.$185.Metal1 0.000693413f
Cred_2760 di_tg_ctrl|di_tg_ctrl_n|vout.$130.Metal2 VSS.$220.Metal1 3.0641e-06f
Cred_2761 di_tg_ctrl|di_tg_ctrl_n|vout.$130.Metal2 VSS.$384.Metal2 2.34621e-06f
Cred_2762 di_tg_ctrl|di_tg_ctrl_n|vout.$130.Metal2 VSS.$392.Metal2 0.0237958f
Cred_2763 di_tg_ctrl|di_tg_ctrl_n|vout.$130.Metal2 VSS.$400.Metal2 0.00464262f
Cred_2764 di_tg_ctrl|di_tg_ctrl_n|vout.$130.Metal2 VSS.$510.Metal3 0.000145886f
Cred_2765 di_tg_ctrl|di_tg_ctrl_n|vout.$130.Metal2 VSS.$518.Metal3 0.000331778f
Cred_2766 di_tg_ctrl|di_tg_ctrl_n|vout.$130.Metal2 VSS.$87.Metal1 6.64442e-07f
Cred_2767 di_tg_ctrl|di_tg_ctrl_n|vout.$130.Metal2 VSS.P0.pSD 2.93804e-06f
Cred_2768 di_tg_ctrl|di_tg_ctrl_n|vout.$134.Metal2 VSS 0.00607009f
Cred_2769 di_tg_ctrl|di_tg_ctrl_n|vout.$134.Metal2 v_a.$148.Metal2 0.00165744f
Cred_2770 di_tg_ctrl|di_tg_ctrl_n|vout.$134.Metal2 v_a.$182.Metal2 0.00854511f
Cred_2771 di_tg_ctrl|di_tg_ctrl_n|vout.$134.Metal2 v_a.P1.nSD 1.37861e-05f
Cred_2772 di_tg_ctrl|di_tg_ctrl_n|vout.$134.Metal2 v_a.P1.pSD 5.27488e-05f
Cred_2773 di_tg_ctrl|di_tg_ctrl_n|vout.$134.Metal2 v_a.P3.nSD 2.8474e-06f
Cred_2774 di_tg_ctrl|di_tg_ctrl_n|vout.$134.Metal2 v_c.$284.Metal2 1.02159e-07f
Cred_2775 di_tg_ctrl|di_tg_ctrl_n|vout.$134.Metal2 v_c.$425.Metal3 0.0206676f
Cred_2776 di_tg_ctrl|di_tg_ctrl_n|vout.$134.Metal2 v_c.$446.Metal3 1.27416e-05f
Cred_2777 di_tg_ctrl|di_tg_ctrl_n|vout.$134.Metal2 v_c.$459.Metal3 1.50554e-05f
Cred_2778 di_tg_ctrl|di_tg_ctrl_n|vout.$134.Metal2 v_c.P10.nSD 1.01566e-06f
Cred_2779 di_tg_ctrl|di_tg_ctrl_n|vout.$134.Metal2 v_c.P8.nSD 0.007137f
Cred_2780 di_tg_ctrl|di_tg_ctrl_n|vout.$134.Metal2 VSS.$129.Metal1 6.9581e-06f
Cred_2781 di_tg_ctrl|di_tg_ctrl_n|vout.$134.Metal2 VSS.$181.Metal1 0.000984535f
Cred_2782 di_tg_ctrl|di_tg_ctrl_n|vout.$134.Metal2 VSS.$185.Metal1 0.00357635f
Cred_2783 di_tg_ctrl|di_tg_ctrl_n|vout.$134.Metal2 VSS.$195.Metal1 5.79318e-06f
Cred_2784 di_tg_ctrl|di_tg_ctrl_n|vout.$134.Metal2 VSS.$220.Metal1 1.36492e-05f
Cred_2785 di_tg_ctrl|di_tg_ctrl_n|vout.$134.Metal2 VSS.$392.Metal2 0.00464262f
Cred_2786 di_tg_ctrl|di_tg_ctrl_n|vout.$134.Metal2 VSS.$400.Metal2 0.0243875f
Cred_2787 di_tg_ctrl|di_tg_ctrl_n|vout.$134.Metal2 VSS.$404.Metal2 4.46845e-08f
Cred_2788 di_tg_ctrl|di_tg_ctrl_n|vout.$134.Metal2 VSS.$518.Metal3 0.000178031f
Cred_2789 di_tg_ctrl|di_tg_ctrl_n|vout.$134.Metal2 VSS.$522.Metal3 0.000288591f
Cred_2790 di_tg_ctrl|di_tg_ctrl_n|vout.$134.Metal2 VSS.$87.Metal1 1.46797e-06f
Cred_2791 di_tg_ctrl|di_tg_ctrl_n|vout.$134.Metal2 VSS.P0.pSD 6.38817e-06f
Cred_2792 di_tg_ctrl|di_tg_ctrl_n|vout.$136.Metal2 VSS 0.0144762f
Cred_2793 di_tg_ctrl|di_tg_ctrl_n|vout.$136.Metal2 v_a.$182.Metal2 0.0547149f
Cred_2794 di_tg_ctrl|di_tg_ctrl_n|vout.$136.Metal2 v_a.P3.nSD 0.0018396f
Cred_2795 di_tg_ctrl|di_tg_ctrl_n|vout.$136.Metal2 v_a.P5.nSD 0.00241192f
Cred_2796 di_tg_ctrl|di_tg_ctrl_n|vout.$136.Metal2 v_a.P5.pSD 0.000592906f
Cred_2797 di_tg_ctrl|di_tg_ctrl_n|vout.$136.Metal2 v_c.$284.Metal2 3.42489e-05f
Cred_2798 di_tg_ctrl|di_tg_ctrl_n|vout.$136.Metal2 v_c.$425.Metal3 0.0152905f
Cred_2799 di_tg_ctrl|di_tg_ctrl_n|vout.$136.Metal2 v_c.$446.Metal3 0.00427162f
Cred_2800 di_tg_ctrl|di_tg_ctrl_n|vout.$136.Metal2 v_c.$459.Metal3 0.00504732f
Cred_2801 di_tg_ctrl|di_tg_ctrl_n|vout.$136.Metal2 v_c.P10.nSD 0.0113356f
Cred_2802 di_tg_ctrl|di_tg_ctrl_n|vout.$136.Metal2 v_c.P8.nSD 3.73061e-06f
Cred_2803 di_tg_ctrl|di_tg_ctrl_n|vout.$136.Metal2 VSS.$129.Metal1 3.5417e-05f
Cred_2804 di_tg_ctrl|di_tg_ctrl_n|vout.$136.Metal2 VSS.$185.Metal1 0.00207782f
Cred_2805 di_tg_ctrl|di_tg_ctrl_n|vout.$136.Metal2 VSS.$195.Metal1 0.0053763f
Cred_2806 di_tg_ctrl|di_tg_ctrl_n|vout.$136.Metal2 VSS.$199.Metal1 0.0036249f
Cred_2807 di_tg_ctrl|di_tg_ctrl_n|vout.$136.Metal2 VSS.$209.Metal1 0.000282748f
Cred_2808 di_tg_ctrl|di_tg_ctrl_n|vout.$136.Metal2 VSS.$211.Metal1 0.00117905f
Cred_2809 di_tg_ctrl|di_tg_ctrl_n|vout.$136.Metal2 VSS.$220.Metal1 0.000423999f
Cred_2810 di_tg_ctrl|di_tg_ctrl_n|vout.$136.Metal2 VSS.$400.Metal2 2.31042e-06f
Cred_2811 di_tg_ctrl|di_tg_ctrl_n|vout.$136.Metal2 VSS.$404.Metal2 0.0191616f
Cred_2812 di_tg_ctrl|di_tg_ctrl_n|vout.$136.Metal2 VSS.$408.Metal2 0.0254612f
Cred_2813 di_tg_ctrl|di_tg_ctrl_n|vout.$136.Metal2 VSS.$416.Metal2 0.00765648f
Cred_2814 di_tg_ctrl|di_tg_ctrl_n|vout.$136.Metal2 VSS.$518.Metal3 6.97051e-05f
Cred_2815 di_tg_ctrl|di_tg_ctrl_n|vout.$136.Metal2 VSS.$522.Metal3 0.000572053f
Cred_2816 di_tg_ctrl|di_tg_ctrl_n|vout.$136.Metal2 VSS.$530.Metal3 0.00020382f
Cred_2817 di_tg_ctrl|di_tg_ctrl_n|vout.$136.Metal2 VSS.$87.Metal1 7.47199e-06f
Cred_2818 di_tg_ctrl|di_tg_ctrl_n|vout.$136.Metal2 VSS.P0.pSD 0.000107472f
Cred_2819 di_tg_ctrl|di_tg_ctrl_n|vout.$14.GatPoly VSS 0.00900589f
Cred_2820 di_tg_ctrl|di_tg_ctrl_n|vout.$14.GatPoly v_b.$161.Metal2 0.0115222f
Cred_2821 di_tg_ctrl|di_tg_ctrl_n|vout.$14.GatPoly v_b.P0.nSD 2.5983e-05f
Cred_2822 di_tg_ctrl|di_tg_ctrl_n|vout.$14.GatPoly v_b.P0.pSD 0.00838022f
Cred_2823 di_tg_ctrl|di_tg_ctrl_n|vout.$14.GatPoly v_b.P1.pSD 0.0160841f
Cred_2824 di_tg_ctrl|di_tg_ctrl_n|vout.$14.GatPoly v_c.$135.Metal1 0.00224706f
Cred_2825 di_tg_ctrl|di_tg_ctrl_n|vout.$14.GatPoly v_c.$136.Metal1 0.0186984f
Cred_2826 di_tg_ctrl|di_tg_ctrl_n|vout.$14.GatPoly v_c.$172.Metal1 0.00137559f
Cred_2827 di_tg_ctrl|di_tg_ctrl_n|vout.$14.GatPoly v_c.$332.Metal2 0.00028295f
Cred_2828 di_tg_ctrl|di_tg_ctrl_n|vout.$14.GatPoly v_c.$334.Metal2 0.00991154f
Cred_2829 di_tg_ctrl|di_tg_ctrl_n|vout.$14.GatPoly v_c.$364.Metal2 2.08159e-05f
Cred_2830 di_tg_ctrl|di_tg_ctrl_n|vout.$14.GatPoly v_c.$366.Metal2 0.000571149f
Cred_2831 di_tg_ctrl|di_tg_ctrl_n|vout.$14.GatPoly v_c.$472.Metal3 0.0058124f
Cred_2832 di_tg_ctrl|di_tg_ctrl_n|vout.$14.GatPoly v_c.$489.Metal3 0.000201652f
Cred_2833 di_tg_ctrl|di_tg_ctrl_n|vout.$14.GatPoly v_c.P0.pSD 0.00556102f
Cred_2834 di_tg_ctrl|di_tg_ctrl_n|vout.$14.GatPoly v_c.P2.pSD 0.000428623f
Cred_2835 di_tg_ctrl|di_tg_ctrl_n|vout.$14.GatPoly VDD.$484.Metal1 0.00122076f
Cred_2836 di_tg_ctrl|di_tg_ctrl_n|vout.$14.GatPoly VDD.$495.Metal1 0.00484475f
Cred_2837 di_tg_ctrl|di_tg_ctrl_n|vout.$14.GatPoly VDD.$499.Metal1 0.00206543f
Cred_2838 di_tg_ctrl|di_tg_ctrl_n|vout.$14.GatPoly VDD.$798.Metal2 9.41452e-06f
Cred_2839 di_tg_ctrl|di_tg_ctrl_n|vout.$14.GatPoly VDD.$802.Metal2 1.53962e-05f
Cred_2840 di_tg_ctrl|di_tg_ctrl_n|vout.$14.GatPoly VDD.$810.Metal2 2.21538e-06f
Cred_2841 di_tg_ctrl|di_tg_ctrl_n|vout.$14.GatPoly VDD.$906.Metal3 1.77624e-08f
Cred_2842 di_tg_ctrl|di_tg_ctrl_n|vout.$14.GatPoly VDD.P0.nSD 5.08541e-06f
Cred_2843 di_tg_ctrl|di_tg_ctrl_n|vout.$144.Metal2 VSS 6.03051e-06f
Cred_2844 di_tg_ctrl|di_tg_ctrl_n|vout.$144.Metal2 v_b 2.11929e-06f
Cred_2845 di_tg_ctrl|di_tg_ctrl_n|vout.$144.Metal2 v_b.$161.Metal2 0.0159407f
Cred_2846 di_tg_ctrl|di_tg_ctrl_n|vout.$144.Metal2 v_b.$195.Metal2 7.03007e-07f
Cred_2847 di_tg_ctrl|di_tg_ctrl_n|vout.$144.Metal2 v_b.P0.nSD 6.76859e-05f
Cred_2848 di_tg_ctrl|di_tg_ctrl_n|vout.$144.Metal2 v_b.P0.pSD 0.0137611f
Cred_2849 di_tg_ctrl|di_tg_ctrl_n|vout.$144.Metal2 v_b.P1.pSD 0.00811063f
Cred_2850 di_tg_ctrl|di_tg_ctrl_n|vout.$144.Metal2 v_c.$136.Metal1 0.00229466f
Cred_2851 di_tg_ctrl|di_tg_ctrl_n|vout.$144.Metal2 v_c.$322.Metal2 1.89965e-05f
Cred_2852 di_tg_ctrl|di_tg_ctrl_n|vout.$144.Metal2 v_c.$324.Metal2 3.81453e-05f
Cred_2853 di_tg_ctrl|di_tg_ctrl_n|vout.$144.Metal2 v_c.$326.Metal2 5.76e-05f
Cred_2854 di_tg_ctrl|di_tg_ctrl_n|vout.$144.Metal2 v_c.$330.Metal2 3.36469e-08f
Cred_2855 di_tg_ctrl|di_tg_ctrl_n|vout.$144.Metal2 v_c.$332.Metal2 3.4791e-05f
Cred_2856 di_tg_ctrl|di_tg_ctrl_n|vout.$144.Metal2 v_c.$334.Metal2 0.0195835f
Cred_2857 di_tg_ctrl|di_tg_ctrl_n|vout.$144.Metal2 v_c.$459.Metal3 0.000102917f
Cred_2858 di_tg_ctrl|di_tg_ctrl_n|vout.$144.Metal2 v_c.$464.Metal3 0.0023693f
Cred_2859 di_tg_ctrl|di_tg_ctrl_n|vout.$144.Metal2 v_c.$468.Metal3 0.00718823f
Cred_2860 di_tg_ctrl|di_tg_ctrl_n|vout.$144.Metal2 v_c.$472.Metal3 0.00581053f
Cred_2861 di_tg_ctrl|di_tg_ctrl_n|vout.$144.Metal2 v_c.P0.pSD 0.00611511f
Cred_2862 di_tg_ctrl|di_tg_ctrl_n|vout.$144.Metal2 VDD.$382.Metal1 6.51899e-07f
Cred_2863 di_tg_ctrl|di_tg_ctrl_n|vout.$144.Metal2 VDD.$477.Metal1 8.98276e-05f
Cred_2864 di_tg_ctrl|di_tg_ctrl_n|vout.$144.Metal2 VDD.$484.Metal1 0.00287835f
Cred_2865 di_tg_ctrl|di_tg_ctrl_n|vout.$144.Metal2 VDD.$495.Metal1 0.00583564f
Cred_2866 di_tg_ctrl|di_tg_ctrl_n|vout.$144.Metal2 VDD.$499.Metal1 0.00134324f
Cred_2867 di_tg_ctrl|di_tg_ctrl_n|vout.$144.Metal2 VDD.$526.Metal1 8.49306e-08f
Cred_2868 di_tg_ctrl|di_tg_ctrl_n|vout.$144.Metal2 VDD.$798.Metal2 0.0208695f
Cred_2869 di_tg_ctrl|di_tg_ctrl_n|vout.$144.Metal2 VDD.$802.Metal2 0.0302247f
Cred_2870 di_tg_ctrl|di_tg_ctrl_n|vout.$144.Metal2 VDD.$810.Metal2 0.00590821f
Cred_2871 di_tg_ctrl|di_tg_ctrl_n|vout.$144.Metal2 VDD.$902.Metal3 0.00180755f
Cred_2872 di_tg_ctrl|di_tg_ctrl_n|vout.$144.Metal2 VDD.$906.Metal3 0.000551207f
Cred_2873 di_tg_ctrl|di_tg_ctrl_n|vout.$144.Metal2 VDD.P0.nSD 1.90884e-05f
Cred_2874 di_tg_ctrl|di_tg_ctrl_n|vout.$148.Metal2 v_b.$161.Metal2 0.00867844f
Cred_2875 di_tg_ctrl|di_tg_ctrl_n|vout.$148.Metal2 v_b.$195.Metal2 0.000384784f
Cred_2876 di_tg_ctrl|di_tg_ctrl_n|vout.$148.Metal2 v_b.P1.pSD 0.0108648f
Cred_2877 di_tg_ctrl|di_tg_ctrl_n|vout.$148.Metal2 v_b.P3.nSD 3.2005e-06f
Cred_2878 di_tg_ctrl|di_tg_ctrl_n|vout.$148.Metal2 v_b.P3.pSD 0.00134628f
Cred_2879 di_tg_ctrl|di_tg_ctrl_n|vout.$148.Metal2 v_c.$172.Metal1 0.00173149f
Cred_2880 di_tg_ctrl|di_tg_ctrl_n|vout.$148.Metal2 v_c.$322.Metal2 1.43907e-06f
Cred_2881 di_tg_ctrl|di_tg_ctrl_n|vout.$148.Metal2 v_c.$324.Metal2 2.88968e-06f
Cred_2882 di_tg_ctrl|di_tg_ctrl_n|vout.$148.Metal2 v_c.$326.Metal2 4.36346e-06f
Cred_2883 di_tg_ctrl|di_tg_ctrl_n|vout.$148.Metal2 v_c.$354.Metal2 1.66472e-05f
Cred_2884 di_tg_ctrl|di_tg_ctrl_n|vout.$148.Metal2 v_c.$356.Metal2 3.34279e-05f
Cred_2885 di_tg_ctrl|di_tg_ctrl_n|vout.$148.Metal2 v_c.$358.Metal2 5.04767e-05f
Cred_2886 di_tg_ctrl|di_tg_ctrl_n|vout.$148.Metal2 v_c.$364.Metal2 2.62014e-05f
Cred_2887 di_tg_ctrl|di_tg_ctrl_n|vout.$148.Metal2 v_c.$366.Metal2 0.0146175f
Cred_2888 di_tg_ctrl|di_tg_ctrl_n|vout.$148.Metal2 v_c.$464.Metal3 0.000179485f
Cred_2889 di_tg_ctrl|di_tg_ctrl_n|vout.$148.Metal2 v_c.$468.Metal3 0.000544223f
Cred_2890 di_tg_ctrl|di_tg_ctrl_n|vout.$148.Metal2 v_c.$476.Metal3 9.85338e-06f
Cred_2891 di_tg_ctrl|di_tg_ctrl_n|vout.$148.Metal2 v_c.$481.Metal3 0.00207629f
Cred_2892 di_tg_ctrl|di_tg_ctrl_n|vout.$148.Metal2 v_c.$485.Metal3 0.00632411f
Cred_2893 di_tg_ctrl|di_tg_ctrl_n|vout.$148.Metal2 v_c.$489.Metal3 0.00311313f
Cred_2894 di_tg_ctrl|di_tg_ctrl_n|vout.$148.Metal2 v_c.P2.pSD 0.00459171f
Cred_2895 di_tg_ctrl|di_tg_ctrl_n|vout.$148.Metal2 VDD.$495.Metal1 0.000772433f
Cred_2896 di_tg_ctrl|di_tg_ctrl_n|vout.$148.Metal2 VDD.$499.Metal1 0.00512341f
Cred_2897 di_tg_ctrl|di_tg_ctrl_n|vout.$148.Metal2 VDD.$507.Metal1 0.0023039f
Cred_2898 di_tg_ctrl|di_tg_ctrl_n|vout.$148.Metal2 VDD.$802.Metal2 0.00590821f
Cred_2899 di_tg_ctrl|di_tg_ctrl_n|vout.$148.Metal2 VDD.$810.Metal2 0.0301571f
Cred_2900 di_tg_ctrl|di_tg_ctrl_n|vout.$148.Metal2 VDD.$814.Metal2 0.0122933f
Cred_2901 di_tg_ctrl|di_tg_ctrl_n|vout.$148.Metal2 VDD.$906.Metal3 0.00023019f
Cred_2902 di_tg_ctrl|di_tg_ctrl_n|vout.$148.Metal2 VDD.$912.Metal3 9.10444e-05f
Cred_2903 di_tg_ctrl|di_tg_ctrl_n|vout.$148.Metal2 VDD.P0.nSD 3.89808e-06f
Cred_2904 di_tg_ctrl|di_tg_ctrl_n|vout.$152.Metal2 VSS 0.00452261f
Cred_2905 di_tg_ctrl|di_tg_ctrl_n|vout.$152.Metal2 v_b 9.69621e-05f
Cred_2906 di_tg_ctrl|di_tg_ctrl_n|vout.$152.Metal2 v_b.$161.Metal2 0.00719919f
Cred_2907 di_tg_ctrl|di_tg_ctrl_n|vout.$152.Metal2 v_b.$195.Metal2 0.016869f
Cred_2908 di_tg_ctrl|di_tg_ctrl_n|vout.$152.Metal2 v_b.P3.nSD 5.98805e-05f
Cred_2909 di_tg_ctrl|di_tg_ctrl_n|vout.$152.Metal2 v_b.P3.pSD 0.0183995f
Cred_2910 di_tg_ctrl|di_tg_ctrl_n|vout.$152.Metal2 v_b.P5.pSD 0.0121998f
Cred_2911 di_tg_ctrl|di_tg_ctrl_n|vout.$152.Metal2 v_c.$172.Metal1 0.000546803f
Cred_2912 di_tg_ctrl|di_tg_ctrl_n|vout.$152.Metal2 v_c.$208.Metal1 0.00214594f
Cred_2913 di_tg_ctrl|di_tg_ctrl_n|vout.$152.Metal2 v_c.$354.Metal2 4.1732e-06f
Cred_2914 di_tg_ctrl|di_tg_ctrl_n|vout.$152.Metal2 v_c.$356.Metal2 8.37986e-06f
Cred_2915 di_tg_ctrl|di_tg_ctrl_n|vout.$152.Metal2 v_c.$358.Metal2 1.26537e-05f
Cred_2916 di_tg_ctrl|di_tg_ctrl_n|vout.$152.Metal2 v_c.$362.Metal2 1.39183e-07f
Cred_2917 di_tg_ctrl|di_tg_ctrl_n|vout.$152.Metal2 v_c.$364.Metal2 8.55386e-06f
Cred_2918 di_tg_ctrl|di_tg_ctrl_n|vout.$152.Metal2 v_c.$366.Metal2 0.00476423f
Cred_2919 di_tg_ctrl|di_tg_ctrl_n|vout.$152.Metal2 v_c.$386.Metal2 1.90686e-05f
Cred_2920 di_tg_ctrl|di_tg_ctrl_n|vout.$152.Metal2 v_c.$388.Metal2 3.829e-05f
Cred_2921 di_tg_ctrl|di_tg_ctrl_n|vout.$152.Metal2 v_c.$390.Metal2 5.78185e-05f
Cred_2922 di_tg_ctrl|di_tg_ctrl_n|vout.$152.Metal2 v_c.$394.Metal2 8.42961e-07f
Cred_2923 di_tg_ctrl|di_tg_ctrl_n|vout.$152.Metal2 v_c.$396.Metal2 3.41657e-05f
Cred_2924 di_tg_ctrl|di_tg_ctrl_n|vout.$152.Metal2 v_c.$398.Metal2 0.0183272f
Cred_2925 di_tg_ctrl|di_tg_ctrl_n|vout.$152.Metal2 v_c.$481.Metal3 0.000520493f
Cred_2926 di_tg_ctrl|di_tg_ctrl_n|vout.$152.Metal2 v_c.$485.Metal3 0.00159557f
Cred_2927 di_tg_ctrl|di_tg_ctrl_n|vout.$152.Metal2 v_c.$489.Metal3 0.00093335f
Cred_2928 di_tg_ctrl|di_tg_ctrl_n|vout.$152.Metal2 v_c.$493.Metal3 0.000259901f
Cred_2929 di_tg_ctrl|di_tg_ctrl_n|vout.$152.Metal2 v_c.$498.Metal3 0.00237829f
Cred_2930 di_tg_ctrl|di_tg_ctrl_n|vout.$152.Metal2 v_c.$502.Metal3 0.00731642f
Cred_2931 di_tg_ctrl|di_tg_ctrl_n|vout.$152.Metal2 v_c.$506.Metal3 0.00831194f
Cred_2932 di_tg_ctrl|di_tg_ctrl_n|vout.$152.Metal2 v_c.P2.pSD 0.00149351f
Cred_2933 di_tg_ctrl|di_tg_ctrl_n|vout.$152.Metal2 v_c.P4.pSD 0.00569342f
Cred_2934 di_tg_ctrl|di_tg_ctrl_n|vout.$152.Metal2 VDD.$382.Metal1 2.61498e-07f
Cred_2935 di_tg_ctrl|di_tg_ctrl_n|vout.$152.Metal2 VDD.$477.Metal1 1.36783e-07f
Cred_2936 di_tg_ctrl|di_tg_ctrl_n|vout.$152.Metal2 VDD.$499.Metal1 0.000556716f
Cred_2937 di_tg_ctrl|di_tg_ctrl_n|vout.$152.Metal2 VDD.$507.Metal1 0.00382561f
Cred_2938 di_tg_ctrl|di_tg_ctrl_n|vout.$152.Metal2 VDD.$511.Metal1 0.00501377f
Cred_2939 di_tg_ctrl|di_tg_ctrl_n|vout.$152.Metal2 VDD.$519.Metal1 0.0039771f
Cred_2940 di_tg_ctrl|di_tg_ctrl_n|vout.$152.Metal2 VDD.$526.Metal1 8.08516e-05f
Cred_2941 di_tg_ctrl|di_tg_ctrl_n|vout.$152.Metal2 VDD.$810.Metal2 3.15167e-06f
Cred_2942 di_tg_ctrl|di_tg_ctrl_n|vout.$152.Metal2 VDD.$814.Metal2 0.0243388f
Cred_2943 di_tg_ctrl|di_tg_ctrl_n|vout.$152.Metal2 VDD.$822.Metal2 0.0346904f
Cred_2944 di_tg_ctrl|di_tg_ctrl_n|vout.$152.Metal2 VDD.$826.Metal2 0.0194424f
Cred_2945 di_tg_ctrl|di_tg_ctrl_n|vout.$152.Metal2 VDD.$906.Metal3 7.92787e-06f
Cred_2946 di_tg_ctrl|di_tg_ctrl_n|vout.$152.Metal2 VDD.$912.Metal3 0.00381119f
Cred_2947 di_tg_ctrl|di_tg_ctrl_n|vout.$152.Metal2 VDD.$918.Metal3 0.00231862f
Cred_2948 di_tg_ctrl|di_tg_ctrl_n|vout.$152.Metal2 VDD.P0.nSD 1.91801e-05f
Cred_2949 di_tg_ctrl|di_tg_ctrl_n|vout.$17.GatPoly VSS 0.00993138f
Cred_2950 di_tg_ctrl|di_tg_ctrl_n|vout.$17.GatPoly v_b.$161.Metal2 0.00674211f
Cred_2951 di_tg_ctrl|di_tg_ctrl_n|vout.$17.GatPoly v_b.$195.Metal2 0.00122314f
Cred_2952 di_tg_ctrl|di_tg_ctrl_n|vout.$17.GatPoly v_b.P1.pSD 0.0110915f
Cred_2953 di_tg_ctrl|di_tg_ctrl_n|vout.$17.GatPoly v_b.P3.nSD 1.01736e-05f
Cred_2954 di_tg_ctrl|di_tg_ctrl_n|vout.$17.GatPoly v_b.P3.pSD 0.00505064f
Cred_2955 di_tg_ctrl|di_tg_ctrl_n|vout.$17.GatPoly v_c.$171.Metal1 0.00217684f
Cred_2956 di_tg_ctrl|di_tg_ctrl_n|vout.$17.GatPoly v_c.$172.Metal1 0.0144002f
Cred_2957 di_tg_ctrl|di_tg_ctrl_n|vout.$17.GatPoly v_c.$364.Metal2 0.000217908f
Cred_2958 di_tg_ctrl|di_tg_ctrl_n|vout.$17.GatPoly v_c.$366.Metal2 0.00597771f
Cred_2959 di_tg_ctrl|di_tg_ctrl_n|vout.$17.GatPoly v_c.$485.Metal3 1.91094e-05f
Cred_2960 di_tg_ctrl|di_tg_ctrl_n|vout.$17.GatPoly v_c.$489.Metal3 0.00210738f
Cred_2961 di_tg_ctrl|di_tg_ctrl_n|vout.$17.GatPoly v_c.P2.pSD 0.0045071f
Cred_2962 di_tg_ctrl|di_tg_ctrl_n|vout.$17.GatPoly VDD.$495.Metal1 0.000410761f
Cred_2963 di_tg_ctrl|di_tg_ctrl_n|vout.$17.GatPoly VDD.$499.Metal1 0.00694749f
Cred_2964 di_tg_ctrl|di_tg_ctrl_n|vout.$17.GatPoly VDD.$507.Metal1 0.00432993f
Cred_2965 di_tg_ctrl|di_tg_ctrl_n|vout.$17.GatPoly VDD.$511.Metal1 0.000185723f
Cred_2966 di_tg_ctrl|di_tg_ctrl_n|vout.$17.GatPoly VDD.$802.Metal2 8.62007e-07f
Cred_2967 di_tg_ctrl|di_tg_ctrl_n|vout.$17.GatPoly VDD.$810.Metal2 3.44334e-05f
Cred_2968 di_tg_ctrl|di_tg_ctrl_n|vout.$17.GatPoly VDD.$814.Metal2 2.23923e-05f
Cred_2969 di_tg_ctrl|di_tg_ctrl_n|vout.$17.GatPoly VDD.$822.Metal2 3.89752e-07f
Cred_2970 di_tg_ctrl|di_tg_ctrl_n|vout.$17.GatPoly VDD.$906.Metal3 6.91138e-09f
Cred_2971 di_tg_ctrl|di_tg_ctrl_n|vout.$17.GatPoly VDD.$912.Metal3 3.12494e-09f
Cred_2972 di_tg_ctrl|di_tg_ctrl_n|vout.$17.GatPoly VDD.P0.nSD 6.17707e-06f
Cred_2973 di_tg_ctrl|di_tg_ctrl_n|vout.$180.Metal3 VSS 0.0787953f
Cred_2974 di_tg_ctrl|di_tg_ctrl_n|vout.$180.Metal3 v_a 0.14463f
Cred_2975 di_tg_ctrl|di_tg_ctrl_n|vout.$180.Metal3 v_a.$148.Metal2 0.141818f
Cred_2976 di_tg_ctrl|di_tg_ctrl_n|vout.$180.Metal3 v_a.$182.Metal2 0.00165528f
Cred_2977 di_tg_ctrl|di_tg_ctrl_n|vout.$180.Metal3 v_a.P0.nSD 0.00215105f
Cred_2978 di_tg_ctrl|di_tg_ctrl_n|vout.$180.Metal3 v_a.P0.pSD 0.00828693f
Cred_2979 di_tg_ctrl|di_tg_ctrl_n|vout.$180.Metal3 v_a.P1.nSD 0.000155822f
Cred_2980 di_tg_ctrl|di_tg_ctrl_n|vout.$180.Metal3 v_a.P1.pSD 0.00199468f
Cred_2981 di_tg_ctrl|di_tg_ctrl_n|vout.$180.Metal3 v_a.P3.pSD 0.000522361f
Cred_2982 di_tg_ctrl|di_tg_ctrl_n|vout.$180.Metal3 v_a.P5.pSD 0.000333418f
Cred_2983 di_tg_ctrl|di_tg_ctrl_n|vout.$180.Metal3 v_b 0.113229f
Cred_2984 di_tg_ctrl|di_tg_ctrl_n|vout.$180.Metal3 v_b.$195.Metal2 0.000680605f
Cred_2985 di_tg_ctrl|di_tg_ctrl_n|vout.$180.Metal3 v_b.P0.pSD 0.000219064f
Cred_2986 di_tg_ctrl|di_tg_ctrl_n|vout.$180.Metal3 v_b.P1.pSD 0.00023799f
Cred_2987 di_tg_ctrl|di_tg_ctrl_n|vout.$180.Metal3 v_c.$129.Metal1 1.81947e-06f
Cred_2988 di_tg_ctrl|di_tg_ctrl_n|vout.$180.Metal3 v_c.$165.Metal1 1.71786e-06f
Cred_2989 di_tg_ctrl|di_tg_ctrl_n|vout.$180.Metal3 v_c.$220.Metal2 0.000294661f
Cred_2990 di_tg_ctrl|di_tg_ctrl_n|vout.$180.Metal3 v_c.$224.Metal2 9.06246e-05f
Cred_2991 di_tg_ctrl|di_tg_ctrl_n|vout.$180.Metal3 v_c.$226.Metal2 0.000123769f
Cred_2992 di_tg_ctrl|di_tg_ctrl_n|vout.$180.Metal3 v_c.$228.Metal2 0.00272479f
Cred_2993 di_tg_ctrl|di_tg_ctrl_n|vout.$180.Metal3 v_c.$23.Metal1 0.000649141f
Cred_2994 di_tg_ctrl|di_tg_ctrl_n|vout.$180.Metal3 v_c.$284.Metal2 4.44096e-05f
Cred_2995 di_tg_ctrl|di_tg_ctrl_n|vout.$180.Metal3 v_c.$288.Metal2 1.59924e-05f
Cred_2996 di_tg_ctrl|di_tg_ctrl_n|vout.$180.Metal3 v_c.$290.Metal2 2.17538e-05f
Cred_2997 di_tg_ctrl|di_tg_ctrl_n|vout.$180.Metal3 v_c.$292.Metal2 0.000483689f
Cred_2998 di_tg_ctrl|di_tg_ctrl_n|vout.$180.Metal3 v_c.$320.Metal2 3.79423e-05f
Cred_2999 di_tg_ctrl|di_tg_ctrl_n|vout.$180.Metal3 v_c.$322.Metal2 7.71552e-06f
Cred_3000 di_tg_ctrl|di_tg_ctrl_n|vout.$180.Metal3 v_c.$324.Metal2 1.02805e-05f
Cred_3001 di_tg_ctrl|di_tg_ctrl_n|vout.$180.Metal3 v_c.$326.Metal2 7.71552e-06f
Cred_3002 di_tg_ctrl|di_tg_ctrl_n|vout.$180.Metal3 v_c.$352.Metal2 3.57774e-05f
Cred_3003 di_tg_ctrl|di_tg_ctrl_n|vout.$180.Metal3 v_c.$354.Metal2 6.66716e-06f
Cred_3004 di_tg_ctrl|di_tg_ctrl_n|vout.$180.Metal3 v_c.$356.Metal2 8.88363e-06f
Cred_3005 di_tg_ctrl|di_tg_ctrl_n|vout.$180.Metal3 v_c.$358.Metal2 6.66716e-06f
Cred_3006 di_tg_ctrl|di_tg_ctrl_n|vout.$180.Metal3 v_c.$411.Metal3 0.0554407f
Cred_3007 di_tg_ctrl|di_tg_ctrl_n|vout.$180.Metal3 v_c.$415.Metal3 0.0529129f
Cred_3008 di_tg_ctrl|di_tg_ctrl_n|vout.$180.Metal3 v_c.$425.Metal3 0.143539f
Cred_3009 di_tg_ctrl|di_tg_ctrl_n|vout.$180.Metal3 v_c.$446.Metal3 0.00865252f
Cred_3010 di_tg_ctrl|di_tg_ctrl_n|vout.$180.Metal3 v_c.$450.Metal3 0.0086197f
Cred_3011 di_tg_ctrl|di_tg_ctrl_n|vout.$180.Metal3 v_c.$459.Metal3 0.00894246f
Cred_3012 di_tg_ctrl|di_tg_ctrl_n|vout.$180.Metal3 v_c.$464.Metal3 0.00353944f
Cred_3013 di_tg_ctrl|di_tg_ctrl_n|vout.$180.Metal3 v_c.$468.Metal3 0.00144886f
Cred_3014 di_tg_ctrl|di_tg_ctrl_n|vout.$180.Metal3 v_c.$476.Metal3 0.00530039f
Cred_3015 di_tg_ctrl|di_tg_ctrl_n|vout.$180.Metal3 v_c.$481.Metal3 0.00319501f
Cred_3016 di_tg_ctrl|di_tg_ctrl_n|vout.$180.Metal3 v_c.$485.Metal3 0.000831547f
Cred_3017 di_tg_ctrl|di_tg_ctrl_n|vout.$180.Metal3 v_c.$95.Metal1 0.000118052f
Cred_3018 di_tg_ctrl|di_tg_ctrl_n|vout.$180.Metal3 v_c.P0.nSD 6.103e-05f
Cred_3019 di_tg_ctrl|di_tg_ctrl_n|vout.$180.Metal3 v_c.P0.pSD 3.50322e-08f
Cred_3020 di_tg_ctrl|di_tg_ctrl_n|vout.$180.Metal3 v_c.P10.nSD 0.000207749f
Cred_3021 di_tg_ctrl|di_tg_ctrl_n|vout.$180.Metal3 v_c.P10.pSD 8.95439e-05f
Cred_3022 di_tg_ctrl|di_tg_ctrl_n|vout.$180.Metal3 v_c.P2.nSD 5.08573e-05f
Cred_3023 di_tg_ctrl|di_tg_ctrl_n|vout.$180.Metal3 v_c.P2.pSD 3.30936e-08f
Cred_3024 di_tg_ctrl|di_tg_ctrl_n|vout.$180.Metal3 v_c.P6.nSD 0.00260348f
Cred_3025 di_tg_ctrl|di_tg_ctrl_n|vout.$180.Metal3 v_c.P6.pSD 0.000488931f
Cred_3026 di_tg_ctrl|di_tg_ctrl_n|vout.$180.Metal3 v_c.P8.nSD 0.000221442f
Cred_3027 di_tg_ctrl|di_tg_ctrl_n|vout.$180.Metal3 v_c.P8.pSD 0.00359269f
Cred_3028 di_tg_ctrl|di_tg_ctrl_n|vout.$180.Metal3 VDD.$215.Metal1 0.000524424f
Cred_3029 di_tg_ctrl|di_tg_ctrl_n|vout.$180.Metal3 VDD.$257.Metal1 0.000554379f
Cred_3030 di_tg_ctrl|di_tg_ctrl_n|vout.$180.Metal3 VDD.$279.Metal1 0.0183496f
Cred_3031 di_tg_ctrl|di_tg_ctrl_n|vout.$180.Metal3 VDD.$281.Metal1 0.0112847f
Cred_3032 di_tg_ctrl|di_tg_ctrl_n|vout.$180.Metal3 VDD.$283.Metal1 0.0112564f
Cred_3033 di_tg_ctrl|di_tg_ctrl_n|vout.$180.Metal3 VDD.$285.Metal1 0.00844619f
Cred_3034 di_tg_ctrl|di_tg_ctrl_n|vout.$180.Metal3 VDD.$286.Metal1 0.00837771f
Cred_3035 di_tg_ctrl|di_tg_ctrl_n|vout.$180.Metal3 VDD.$288.Metal1 0.0137913f
Cred_3036 di_tg_ctrl|di_tg_ctrl_n|vout.$180.Metal3 VDD.$29.Metal1 0.000142014f
Cred_3037 di_tg_ctrl|di_tg_ctrl_n|vout.$180.Metal3 VDD.$291.Metal1 0.0209512f
Cred_3038 di_tg_ctrl|di_tg_ctrl_n|vout.$180.Metal3 VDD.$298.Metal1 0.00166186f
Cred_3039 di_tg_ctrl|di_tg_ctrl_n|vout.$180.Metal3 VDD.$320.Metal1 0.0181154f
Cred_3040 di_tg_ctrl|di_tg_ctrl_n|vout.$180.Metal3 VDD.$322.Metal1 0.0105864f
Cred_3041 di_tg_ctrl|di_tg_ctrl_n|vout.$180.Metal3 VDD.$324.Metal1 0.01056f
Cred_3042 di_tg_ctrl|di_tg_ctrl_n|vout.$180.Metal3 VDD.$326.Metal1 0.00792369f
Cred_3043 di_tg_ctrl|di_tg_ctrl_n|vout.$180.Metal3 VDD.$327.Metal1 0.00785946f
Cred_3044 di_tg_ctrl|di_tg_ctrl_n|vout.$180.Metal3 VDD.$329.Metal1 0.0129368f
Cred_3045 di_tg_ctrl|di_tg_ctrl_n|vout.$180.Metal3 VDD.$332.Metal1 0.0196518f
Cred_3046 di_tg_ctrl|di_tg_ctrl_n|vout.$180.Metal3 VDD.$339.Metal1 0.000554379f
Cred_3047 di_tg_ctrl|di_tg_ctrl_n|vout.$180.Metal3 VDD.$359.Metal1 0.000477359f
Cred_3048 di_tg_ctrl|di_tg_ctrl_n|vout.$180.Metal3 VDD.$378.Metal1 4.15283e-05f
Cred_3049 di_tg_ctrl|di_tg_ctrl_n|vout.$180.Metal3 VDD.$382.Metal1 0.0204266f
Cred_3050 di_tg_ctrl|di_tg_ctrl_n|vout.$180.Metal3 VDD.$405.Metal1 5.85187e-05f
Cred_3051 di_tg_ctrl|di_tg_ctrl_n|vout.$180.Metal3 VDD.$477.Metal1 9.94845e-06f
Cred_3052 di_tg_ctrl|di_tg_ctrl_n|vout.$180.Metal3 VDD.$526.Metal1 2.47785e-06f
Cred_3053 di_tg_ctrl|di_tg_ctrl_n|vout.$180.Metal3 VDD.$573.Metal2 0.000277317f
Cred_3054 di_tg_ctrl|di_tg_ctrl_n|vout.$180.Metal3 VDD.$606.Metal2 0.0261395f
Cred_3055 di_tg_ctrl|di_tg_ctrl_n|vout.$180.Metal3 VDD.$607.Metal2 0.0191524f
Cred_3056 di_tg_ctrl|di_tg_ctrl_n|vout.$180.Metal3 VDD.$608.Metal2 0.0192997f
Cred_3057 di_tg_ctrl|di_tg_ctrl_n|vout.$180.Metal3 VDD.$609.Metal2 0.0190461f
Cred_3058 di_tg_ctrl|di_tg_ctrl_n|vout.$180.Metal3 VDD.$610.Metal2 0.0189039f
Cred_3059 di_tg_ctrl|di_tg_ctrl_n|vout.$180.Metal3 VDD.$611.Metal2 0.0196153f
Cred_3060 di_tg_ctrl|di_tg_ctrl_n|vout.$180.Metal3 VDD.$612.Metal2 0.0199583f
Cred_3061 di_tg_ctrl|di_tg_ctrl_n|vout.$180.Metal3 VDD.$613.Metal2 0.0189496f
Cred_3062 di_tg_ctrl|di_tg_ctrl_n|vout.$180.Metal3 VDD.$614.Metal2 0.0188592f
Cred_3063 di_tg_ctrl|di_tg_ctrl_n|vout.$180.Metal3 VDD.$615.Metal2 0.0187078f
Cred_3064 di_tg_ctrl|di_tg_ctrl_n|vout.$180.Metal3 VDD.$616.Metal2 0.01872f
Cred_3065 di_tg_ctrl|di_tg_ctrl_n|vout.$180.Metal3 VDD.$617.Metal2 0.0186368f
Cred_3066 di_tg_ctrl|di_tg_ctrl_n|vout.$180.Metal3 VDD.$618.Metal2 0.0185726f
Cred_3067 di_tg_ctrl|di_tg_ctrl_n|vout.$180.Metal3 VDD.$619.Metal2 0.0251641f
Cred_3068 di_tg_ctrl|di_tg_ctrl_n|vout.$180.Metal3 VDD.$620.Metal2 0.000438798f
Cred_3069 di_tg_ctrl|di_tg_ctrl_n|vout.$180.Metal3 VDD.$688.Metal2 0.00157536f
Cred_3070 di_tg_ctrl|di_tg_ctrl_n|vout.$180.Metal3 VDD.$696.Metal2 0.00157536f
Cred_3071 di_tg_ctrl|di_tg_ctrl_n|vout.$180.Metal3 VDD.$703.Metal2 0.112324f
Cred_3072 di_tg_ctrl|di_tg_ctrl_n|vout.$180.Metal3 VDD.$704.Metal2 0.0285846f
Cred_3073 di_tg_ctrl|di_tg_ctrl_n|vout.$180.Metal3 VDD.$705.Metal2 0.0285657f
Cred_3074 di_tg_ctrl|di_tg_ctrl_n|vout.$180.Metal3 VDD.$706.Metal2 0.0303108f
Cred_3075 di_tg_ctrl|di_tg_ctrl_n|vout.$180.Metal3 VDD.$707.Metal2 0.0297932f
Cred_3076 di_tg_ctrl|di_tg_ctrl_n|vout.$180.Metal3 VDD.$708.Metal2 0.0377065f
Cred_3077 di_tg_ctrl|di_tg_ctrl_n|vout.$180.Metal3 VDD.$709.Metal2 0.0213702f
Cred_3078 di_tg_ctrl|di_tg_ctrl_n|vout.$180.Metal3 VDD.$710.Metal2 0.020146f
Cred_3079 di_tg_ctrl|di_tg_ctrl_n|vout.$180.Metal3 VDD.$711.Metal2 0.0202726f
Cred_3080 di_tg_ctrl|di_tg_ctrl_n|vout.$180.Metal3 VDD.$712.Metal2 0.0239766f
Cred_3081 di_tg_ctrl|di_tg_ctrl_n|vout.$180.Metal3 VDD.$713.Metal2 0.0199982f
Cred_3082 di_tg_ctrl|di_tg_ctrl_n|vout.$180.Metal3 VDD.$714.Metal2 0.0306137f
Cred_3083 di_tg_ctrl|di_tg_ctrl_n|vout.$180.Metal3 VDD.$734.Metal2 0.000205282f
Cred_3084 di_tg_ctrl|di_tg_ctrl_n|vout.$180.Metal3 VDD.$738.Metal2 0.000388486f
Cred_3085 di_tg_ctrl|di_tg_ctrl_n|vout.$180.Metal3 VDD.$746.Metal2 0.000214826f
Cred_3086 di_tg_ctrl|di_tg_ctrl_n|vout.$180.Metal3 VDD.$754.Metal2 5.5171e-06f
Cred_3087 di_tg_ctrl|di_tg_ctrl_n|vout.$180.Metal3 VDD.$864.Metal3 1.25966e-05f
Cred_3088 di_tg_ctrl|di_tg_ctrl_n|vout.$180.Metal3 VDD.$868.Metal3 0.000221538f
Cred_3089 di_tg_ctrl|di_tg_ctrl_n|vout.$180.Metal3 VDD.$874.Metal3 0.00278826f
Cred_3090 di_tg_ctrl|di_tg_ctrl_n|vout.$180.Metal3 VDD.$878.Metal3 0.00275795f
Cred_3091 di_tg_ctrl|di_tg_ctrl_n|vout.$180.Metal3 VDD.$882.Metal3 0.00179742f
Cred_3092 di_tg_ctrl|di_tg_ctrl_n|vout.$180.Metal3 VDD.P0.nSD 0.00500713f
Cred_3093 di_tg_ctrl|di_tg_ctrl_n|vout.$180.Metal3 VDD.P10.pSD 0.00259446f
Cred_3094 di_tg_ctrl|di_tg_ctrl_n|vout.$180.Metal3 VDD.P11.pSD 9.22006e-06f
Cred_3095 di_tg_ctrl|di_tg_ctrl_n|vout.$180.Metal3 VDD.P3.GatPoly 4.66697e-08f
Cred_3096 di_tg_ctrl|di_tg_ctrl_n|vout.$180.Metal3 VDD.P7.pSD 0.00108358f
Cred_3097 di_tg_ctrl|di_tg_ctrl_n|vout.$180.Metal3 VSS.$114.Metal1 0.00100441f
Cred_3098 di_tg_ctrl|di_tg_ctrl_n|vout.$180.Metal3 VSS.$127.Metal1 0.00428333f
Cred_3099 di_tg_ctrl|di_tg_ctrl_n|vout.$180.Metal3 VSS.$129.Metal1 0.0199386f
Cred_3100 di_tg_ctrl|di_tg_ctrl_n|vout.$180.Metal3 VSS.$132.Metal1 3.84606e-05f
Cred_3101 di_tg_ctrl|di_tg_ctrl_n|vout.$180.Metal3 VSS.$134.Metal1 0.000499675f
Cred_3102 di_tg_ctrl|di_tg_ctrl_n|vout.$180.Metal3 VSS.$147.Metal1 0.00055347f
Cred_3103 di_tg_ctrl|di_tg_ctrl_n|vout.$180.Metal3 VSS.$155.Metal1 0.00426952f
Cred_3104 di_tg_ctrl|di_tg_ctrl_n|vout.$180.Metal3 VSS.$156.Metal1 0.00450697f
Cred_3105 di_tg_ctrl|di_tg_ctrl_n|vout.$180.Metal3 VSS.$165.Metal1 0.00348654f
Cred_3106 di_tg_ctrl|di_tg_ctrl_n|vout.$180.Metal3 VSS.$175.Metal1 0.000509567f
Cred_3107 di_tg_ctrl|di_tg_ctrl_n|vout.$180.Metal3 VSS.$220.Metal1 0.00200038f
Cred_3108 di_tg_ctrl|di_tg_ctrl_n|vout.$180.Metal3 VSS.$311.Metal2 0.0550266f
Cred_3109 di_tg_ctrl|di_tg_ctrl_n|vout.$180.Metal3 VSS.$350.Metal2 0.00290458f
Cred_3110 di_tg_ctrl|di_tg_ctrl_n|vout.$180.Metal3 VSS.$354.Metal2 3.99774e-05f
Cred_3111 di_tg_ctrl|di_tg_ctrl_n|vout.$180.Metal3 VSS.$359.Metal2 0.153985f
Cred_3112 di_tg_ctrl|di_tg_ctrl_n|vout.$180.Metal3 VSS.$368.Metal2 0.00953363f
Cred_3113 di_tg_ctrl|di_tg_ctrl_n|vout.$180.Metal3 VSS.$372.Metal2 0.00351223f
Cred_3114 di_tg_ctrl|di_tg_ctrl_n|vout.$180.Metal3 VSS.$376.Metal2 0.0135326f
Cred_3115 di_tg_ctrl|di_tg_ctrl_n|vout.$180.Metal3 VSS.$384.Metal2 0.00126026f
Cred_3116 di_tg_ctrl|di_tg_ctrl_n|vout.$180.Metal3 VSS.$392.Metal2 0.000258875f
Cred_3117 di_tg_ctrl|di_tg_ctrl_n|vout.$180.Metal3 VSS.$496.Metal3 0.00651869f
Cred_3118 di_tg_ctrl|di_tg_ctrl_n|vout.$180.Metal3 VSS.$502.Metal3 0.0214224f
Cred_3119 di_tg_ctrl|di_tg_ctrl_n|vout.$180.Metal3 VSS.$510.Metal3 0.0730766f
Cred_3120 di_tg_ctrl|di_tg_ctrl_n|vout.$180.Metal3 VSS.$518.Metal3 0.0180082f
Cred_3121 di_tg_ctrl|di_tg_ctrl_n|vout.$180.Metal3 VSS.$78.Metal1 0.0170437f
Cred_3122 di_tg_ctrl|di_tg_ctrl_n|vout.$180.Metal3 VSS.$87.Metal1 0.00719475f
Cred_3123 di_tg_ctrl|di_tg_ctrl_n|vout.$180.Metal3 VSS.P0.pSD 0.00487817f
Cred_3124 di_tg_ctrl|di_tg_ctrl_n|vout.$180.Metal3 VSS.P10.nSD 1.13821e-06f
Cred_3125 di_tg_ctrl|di_tg_ctrl_n|vout.$180.Metal3 VSS.P11.nSD 1.13821e-06f
Cred_3126 di_tg_ctrl|di_tg_ctrl_n|vout.$180.Metal3 VSS.P2.GatPoly 2.42887e-05f
Cred_3127 di_tg_ctrl|di_tg_ctrl_n|vout.$180.Metal3 VSS.P6.nSD 0.000176803f
Cred_3128 di_tg_ctrl|di_tg_ctrl_n|vout.$180.Metal3 VSS.P7.nSD 0.000265359f
Cred_3129 di_tg_ctrl|di_tg_ctrl_n|vout.$183.Metal3 VSS 0.00649816f
Cred_3130 di_tg_ctrl|di_tg_ctrl_n|vout.$183.Metal3 v_a.$148.Metal2 0.00260583f
Cred_3131 di_tg_ctrl|di_tg_ctrl_n|vout.$183.Metal3 v_a.$182.Metal2 0.00520403f
Cred_3132 di_tg_ctrl|di_tg_ctrl_n|vout.$183.Metal3 v_a.P1.nSD 0.000308631f
Cred_3133 di_tg_ctrl|di_tg_ctrl_n|vout.$183.Metal3 v_a.P1.pSD 8.29314e-05f
Cred_3134 di_tg_ctrl|di_tg_ctrl_n|vout.$183.Metal3 v_a.P3.nSD 0.000142054f
Cred_3135 di_tg_ctrl|di_tg_ctrl_n|vout.$183.Metal3 v_c.$220.Metal2 2.95219e-05f
Cred_3136 di_tg_ctrl|di_tg_ctrl_n|vout.$183.Metal3 v_c.$284.Metal2 5.09663e-06f
Cred_3137 di_tg_ctrl|di_tg_ctrl_n|vout.$183.Metal3 v_c.$411.Metal3 0.00368205f
Cred_3138 di_tg_ctrl|di_tg_ctrl_n|vout.$183.Metal3 v_c.$425.Metal3 0.0841911f
Cred_3139 di_tg_ctrl|di_tg_ctrl_n|vout.$183.Metal3 v_c.$446.Metal3 0.000635666f
Cred_3140 di_tg_ctrl|di_tg_ctrl_n|vout.$183.Metal3 v_c.$459.Metal3 0.000751099f
Cred_3141 di_tg_ctrl|di_tg_ctrl_n|vout.$183.Metal3 v_c.P10.nSD 5.06706e-05f
Cred_3142 di_tg_ctrl|di_tg_ctrl_n|vout.$183.Metal3 v_c.P6.nSD 0.000619097f
Cred_3143 di_tg_ctrl|di_tg_ctrl_n|vout.$183.Metal3 v_c.P8.nSD 0.00105813f
Cred_3144 di_tg_ctrl|di_tg_ctrl_n|vout.$183.Metal3 VSS.$129.Metal1 1.21621e-08f
Cred_3145 di_tg_ctrl|di_tg_ctrl_n|vout.$183.Metal3 VSS.$175.Metal1 4.66013e-07f
Cred_3146 di_tg_ctrl|di_tg_ctrl_n|vout.$183.Metal3 VSS.$181.Metal1 1.97345e-05f
Cred_3147 di_tg_ctrl|di_tg_ctrl_n|vout.$183.Metal3 VSS.$185.Metal1 0.000801385f
Cred_3148 di_tg_ctrl|di_tg_ctrl_n|vout.$183.Metal3 VSS.$220.Metal1 1.46482e-08f
Cred_3149 di_tg_ctrl|di_tg_ctrl_n|vout.$183.Metal3 VSS.$384.Metal2 0.000116477f
Cred_3150 di_tg_ctrl|di_tg_ctrl_n|vout.$183.Metal3 VSS.$392.Metal2 0.000269003f
Cred_3151 di_tg_ctrl|di_tg_ctrl_n|vout.$183.Metal3 VSS.$400.Metal2 0.000149382f
Cred_3152 di_tg_ctrl|di_tg_ctrl_n|vout.$183.Metal3 VSS.$510.Metal3 0.00727814f
Cred_3153 di_tg_ctrl|di_tg_ctrl_n|vout.$183.Metal3 VSS.$518.Metal3 0.044433f
Cred_3154 di_tg_ctrl|di_tg_ctrl_n|vout.$183.Metal3 VSS.$522.Metal3 0.0143975f
Cred_3155 di_tg_ctrl|di_tg_ctrl_n|vout.$183.Metal3 VSS.$87.Metal1 2.56587e-09f
Cred_3156 di_tg_ctrl|di_tg_ctrl_n|vout.$183.Metal3 VSS.P0.pSD 9.17592e-09f
Cred_3157 di_tg_ctrl|di_tg_ctrl_n|vout.$186.Metal3 VSS 0.0085842f
Cred_3158 di_tg_ctrl|di_tg_ctrl_n|vout.$186.Metal3 v_a.$182.Metal2 0.0118145f
Cred_3159 di_tg_ctrl|di_tg_ctrl_n|vout.$186.Metal3 v_a.P3.nSD 0.000289915f
Cred_3160 di_tg_ctrl|di_tg_ctrl_n|vout.$186.Metal3 v_a.P5.nSD 0.00057854f
Cred_3161 di_tg_ctrl|di_tg_ctrl_n|vout.$186.Metal3 v_a.P5.pSD 0.000172929f
Cred_3162 di_tg_ctrl|di_tg_ctrl_n|vout.$186.Metal3 v_c.$284.Metal2 0.000103003f
Cred_3163 di_tg_ctrl|di_tg_ctrl_n|vout.$186.Metal3 v_c.$425.Metal3 0.0575879f
Cred_3164 di_tg_ctrl|di_tg_ctrl_n|vout.$186.Metal3 v_c.$446.Metal3 0.0128468f
Cred_3165 di_tg_ctrl|di_tg_ctrl_n|vout.$186.Metal3 v_c.$459.Metal3 0.0151797f
Cred_3166 di_tg_ctrl|di_tg_ctrl_n|vout.$186.Metal3 v_c.P10.nSD 0.00186418f
Cred_3167 di_tg_ctrl|di_tg_ctrl_n|vout.$186.Metal3 v_c.P8.nSD 0.000186117f
Cred_3168 di_tg_ctrl|di_tg_ctrl_n|vout.$186.Metal3 VSS.$129.Metal1 1.57293e-06f
Cred_3169 di_tg_ctrl|di_tg_ctrl_n|vout.$186.Metal3 VSS.$185.Metal1 0.000410532f
Cred_3170 di_tg_ctrl|di_tg_ctrl_n|vout.$186.Metal3 VSS.$195.Metal1 0.000147111f
Cred_3171 di_tg_ctrl|di_tg_ctrl_n|vout.$186.Metal3 VSS.$199.Metal1 0.000187839f
Cred_3172 di_tg_ctrl|di_tg_ctrl_n|vout.$186.Metal3 VSS.$209.Metal1 1.57256e-05f
Cred_3173 di_tg_ctrl|di_tg_ctrl_n|vout.$186.Metal3 VSS.$211.Metal1 6.55873e-05f
Cred_3174 di_tg_ctrl|di_tg_ctrl_n|vout.$186.Metal3 VSS.$220.Metal1 2.18526e-05f
Cred_3175 di_tg_ctrl|di_tg_ctrl_n|vout.$186.Metal3 VSS.$400.Metal2 2.78996e-05f
Cred_3176 di_tg_ctrl|di_tg_ctrl_n|vout.$186.Metal3 VSS.$404.Metal2 1.69229e-07f
Cred_3177 di_tg_ctrl|di_tg_ctrl_n|vout.$186.Metal3 VSS.$408.Metal2 0.00148825f
Cred_3178 di_tg_ctrl|di_tg_ctrl_n|vout.$186.Metal3 VSS.$416.Metal2 0.000703841f
Cred_3179 di_tg_ctrl|di_tg_ctrl_n|vout.$186.Metal3 VSS.$518.Metal3 0.00347753f
Cred_3180 di_tg_ctrl|di_tg_ctrl_n|vout.$186.Metal3 VSS.$522.Metal3 0.0449308f
Cred_3181 di_tg_ctrl|di_tg_ctrl_n|vout.$186.Metal3 VSS.$530.Metal3 0.0152491f
Cred_3182 di_tg_ctrl|di_tg_ctrl_n|vout.$186.Metal3 VSS.$87.Metal1 3.31844e-07f
Cred_3183 di_tg_ctrl|di_tg_ctrl_n|vout.$186.Metal3 VSS.P0.pSD 5.20782e-06f
Cred_3184 di_tg_ctrl|di_tg_ctrl_n|vout.$192.Metal3 VSS 0.000324793f
Cred_3185 di_tg_ctrl|di_tg_ctrl_n|vout.$192.Metal3 v_b 0.000114141f
Cred_3186 di_tg_ctrl|di_tg_ctrl_n|vout.$192.Metal3 v_b.$161.Metal2 0.00937797f
Cred_3187 di_tg_ctrl|di_tg_ctrl_n|vout.$192.Metal3 v_b.$195.Metal2 3.78628e-05f
Cred_3188 di_tg_ctrl|di_tg_ctrl_n|vout.$192.Metal3 v_b.P0.nSD 2.49126e-05f
Cred_3189 di_tg_ctrl|di_tg_ctrl_n|vout.$192.Metal3 v_b.P0.pSD 0.00519897f
Cred_3190 di_tg_ctrl|di_tg_ctrl_n|vout.$192.Metal3 v_b.P1.pSD 0.00781652f
Cred_3191 di_tg_ctrl|di_tg_ctrl_n|vout.$192.Metal3 v_c.$136.Metal1 0.000219606f
Cred_3192 di_tg_ctrl|di_tg_ctrl_n|vout.$192.Metal3 v_c.$172.Metal1 5.81583e-05f
Cred_3193 di_tg_ctrl|di_tg_ctrl_n|vout.$192.Metal3 v_c.$322.Metal2 6.92442e-08f
Cred_3194 di_tg_ctrl|di_tg_ctrl_n|vout.$192.Metal3 v_c.$324.Metal2 1.39044e-07f
Cred_3195 di_tg_ctrl|di_tg_ctrl_n|vout.$192.Metal3 v_c.$326.Metal2 2.09958e-07f
Cred_3196 di_tg_ctrl|di_tg_ctrl_n|vout.$192.Metal3 v_c.$330.Metal2 1.41146e-06f
Cred_3197 di_tg_ctrl|di_tg_ctrl_n|vout.$192.Metal3 v_c.$332.Metal2 6.15737e-06f
Cred_3198 di_tg_ctrl|di_tg_ctrl_n|vout.$192.Metal3 v_c.$334.Metal2 0.00212273f
Cred_3199 di_tg_ctrl|di_tg_ctrl_n|vout.$192.Metal3 v_c.$364.Metal2 8.80068e-07f
Cred_3200 di_tg_ctrl|di_tg_ctrl_n|vout.$192.Metal3 v_c.$366.Metal2 0.000561791f
Cred_3201 di_tg_ctrl|di_tg_ctrl_n|vout.$192.Metal3 v_c.$459.Metal3 0.00336346f
Cred_3202 di_tg_ctrl|di_tg_ctrl_n|vout.$192.Metal3 v_c.$464.Metal3 8.63633e-06f
Cred_3203 di_tg_ctrl|di_tg_ctrl_n|vout.$192.Metal3 v_c.$468.Metal3 0.000202228f
Cred_3204 di_tg_ctrl|di_tg_ctrl_n|vout.$192.Metal3 v_c.$472.Metal3 0.057823f
Cred_3205 di_tg_ctrl|di_tg_ctrl_n|vout.$192.Metal3 v_c.$476.Metal3 0.000491577f
Cred_3206 di_tg_ctrl|di_tg_ctrl_n|vout.$192.Metal3 v_c.$489.Metal3 0.0152667f
Cred_3207 di_tg_ctrl|di_tg_ctrl_n|vout.$192.Metal3 v_c.P0.pSD 6.36047e-05f
Cred_3208 di_tg_ctrl|di_tg_ctrl_n|vout.$192.Metal3 v_c.P2.pSD 1.68445e-05f
Cred_3209 di_tg_ctrl|di_tg_ctrl_n|vout.$192.Metal3 VDD.$382.Metal1 1.16476e-08f
Cred_3210 di_tg_ctrl|di_tg_ctrl_n|vout.$192.Metal3 VDD.$477.Metal1 1.60497e-06f
Cred_3211 di_tg_ctrl|di_tg_ctrl_n|vout.$192.Metal3 VDD.$484.Metal1 3.78067e-05f
Cred_3212 di_tg_ctrl|di_tg_ctrl_n|vout.$192.Metal3 VDD.$495.Metal1 4.42871e-05f
Cred_3213 di_tg_ctrl|di_tg_ctrl_n|vout.$192.Metal3 VDD.$499.Metal1 2.69245e-05f
Cred_3214 di_tg_ctrl|di_tg_ctrl_n|vout.$192.Metal3 VDD.$526.Metal1 1.51747e-09f
Cred_3215 di_tg_ctrl|di_tg_ctrl_n|vout.$192.Metal3 VDD.$798.Metal2 0.000372775f
Cred_3216 di_tg_ctrl|di_tg_ctrl_n|vout.$192.Metal3 VDD.$802.Metal2 0.00022309f
Cred_3217 di_tg_ctrl|di_tg_ctrl_n|vout.$192.Metal3 VDD.$810.Metal2 0.000191554f
Cred_3218 di_tg_ctrl|di_tg_ctrl_n|vout.$192.Metal3 VDD.$814.Metal2 3.64178e-05f
Cred_3219 di_tg_ctrl|di_tg_ctrl_n|vout.$192.Metal3 VDD.$902.Metal3 0.0350299f
Cred_3220 di_tg_ctrl|di_tg_ctrl_n|vout.$192.Metal3 VDD.$906.Metal3 0.0503833f
Cred_3221 di_tg_ctrl|di_tg_ctrl_n|vout.$192.Metal3 VDD.$912.Metal3 0.00454213f
Cred_3222 di_tg_ctrl|di_tg_ctrl_n|vout.$192.Metal3 VDD.P0.nSD 2.73766e-07f
Cred_3223 di_tg_ctrl|di_tg_ctrl_n|vout.$196.Metal3 VSS 0.00805371f
Cred_3224 di_tg_ctrl|di_tg_ctrl_n|vout.$196.Metal3 v_b 0.00129183f
Cred_3225 di_tg_ctrl|di_tg_ctrl_n|vout.$196.Metal3 v_b.$161.Metal2 0.00278158f
Cred_3226 di_tg_ctrl|di_tg_ctrl_n|vout.$196.Metal3 v_b.$195.Metal2 0.00739288f
Cred_3227 di_tg_ctrl|di_tg_ctrl_n|vout.$196.Metal3 v_b.P1.pSD 0.00116159f
Cred_3228 di_tg_ctrl|di_tg_ctrl_n|vout.$196.Metal3 v_b.P3.nSD 2.31363e-05f
Cred_3229 di_tg_ctrl|di_tg_ctrl_n|vout.$196.Metal3 v_b.P3.pSD 0.00899269f
Cred_3230 di_tg_ctrl|di_tg_ctrl_n|vout.$196.Metal3 v_b.P5.pSD 0.00548722f
Cred_3231 di_tg_ctrl|di_tg_ctrl_n|vout.$196.Metal3 v_c.$172.Metal1 0.000184765f
Cred_3232 di_tg_ctrl|di_tg_ctrl_n|vout.$196.Metal3 v_c.$208.Metal1 0.000269261f
Cred_3233 di_tg_ctrl|di_tg_ctrl_n|vout.$196.Metal3 v_c.$354.Metal2 8.36495e-08f
Cred_3234 di_tg_ctrl|di_tg_ctrl_n|vout.$196.Metal3 v_c.$356.Metal2 1.6797e-07f
Cred_3235 di_tg_ctrl|di_tg_ctrl_n|vout.$196.Metal3 v_c.$358.Metal2 2.53637e-07f
Cred_3236 di_tg_ctrl|di_tg_ctrl_n|vout.$196.Metal3 v_c.$362.Metal2 2.33167e-06f
Cred_3237 di_tg_ctrl|di_tg_ctrl_n|vout.$196.Metal3 v_c.$364.Metal2 7.47794e-06f
Cred_3238 di_tg_ctrl|di_tg_ctrl_n|vout.$196.Metal3 v_c.$366.Metal2 0.00177672f
Cred_3239 di_tg_ctrl|di_tg_ctrl_n|vout.$196.Metal3 v_c.$386.Metal2 5.63207e-07f
Cred_3240 di_tg_ctrl|di_tg_ctrl_n|vout.$196.Metal3 v_c.$388.Metal2 1.13093e-06f
Cred_3241 di_tg_ctrl|di_tg_ctrl_n|vout.$196.Metal3 v_c.$390.Metal2 1.70772e-06f
Cred_3242 di_tg_ctrl|di_tg_ctrl_n|vout.$196.Metal3 v_c.$394.Metal2 1.07623e-05f
Cred_3243 di_tg_ctrl|di_tg_ctrl_n|vout.$196.Metal3 v_c.$396.Metal2 2.56855e-05f
Cred_3244 di_tg_ctrl|di_tg_ctrl_n|vout.$196.Metal3 v_c.$398.Metal2 0.00253335f
Cred_3245 di_tg_ctrl|di_tg_ctrl_n|vout.$196.Metal3 v_c.$476.Metal3 0.00149444f
Cred_3246 di_tg_ctrl|di_tg_ctrl_n|vout.$196.Metal3 v_c.$481.Metal3 1.0433e-05f
Cred_3247 di_tg_ctrl|di_tg_ctrl_n|vout.$196.Metal3 v_c.$485.Metal3 0.000322446f
Cred_3248 di_tg_ctrl|di_tg_ctrl_n|vout.$196.Metal3 v_c.$489.Metal3 0.0459332f
Cred_3249 di_tg_ctrl|di_tg_ctrl_n|vout.$196.Metal3 v_c.$493.Metal3 0.00306571f
Cred_3250 di_tg_ctrl|di_tg_ctrl_n|vout.$196.Metal3 v_c.$498.Metal3 7.02448e-05f
Cred_3251 di_tg_ctrl|di_tg_ctrl_n|vout.$196.Metal3 v_c.$502.Metal3 0.0015553f
Cred_3252 di_tg_ctrl|di_tg_ctrl_n|vout.$196.Metal3 v_c.$506.Metal3 0.0539139f
Cred_3253 di_tg_ctrl|di_tg_ctrl_n|vout.$196.Metal3 v_c.P2.pSD 8.02758e-05f
Cred_3254 di_tg_ctrl|di_tg_ctrl_n|vout.$196.Metal3 v_c.P4.pSD 0.000243453f
Cred_3255 di_tg_ctrl|di_tg_ctrl_n|vout.$196.Metal3 VDD.$382.Metal1 1.3111e-08f
Cred_3256 di_tg_ctrl|di_tg_ctrl_n|vout.$196.Metal3 VDD.$477.Metal1 6.85805e-09f
Cred_3257 di_tg_ctrl|di_tg_ctrl_n|vout.$196.Metal3 VDD.$499.Metal1 0.000431634f
Cred_3258 di_tg_ctrl|di_tg_ctrl_n|vout.$196.Metal3 VDD.$507.Metal1 0.000839875f
Cred_3259 di_tg_ctrl|di_tg_ctrl_n|vout.$196.Metal3 VDD.$511.Metal1 0.000122042f
Cred_3260 di_tg_ctrl|di_tg_ctrl_n|vout.$196.Metal3 VDD.$519.Metal1 0.000180953f
Cred_3261 di_tg_ctrl|di_tg_ctrl_n|vout.$196.Metal3 VDD.$526.Metal1 4.05376e-06f
Cred_3262 di_tg_ctrl|di_tg_ctrl_n|vout.$196.Metal3 VDD.$810.Metal2 0.000147585f
Cred_3263 di_tg_ctrl|di_tg_ctrl_n|vout.$196.Metal3 VDD.$814.Metal2 0.000431923f
Cred_3264 di_tg_ctrl|di_tg_ctrl_n|vout.$196.Metal3 VDD.$822.Metal2 0.00092446f
Cred_3265 di_tg_ctrl|di_tg_ctrl_n|vout.$196.Metal3 VDD.$826.Metal2 0.00115067f
Cred_3266 di_tg_ctrl|di_tg_ctrl_n|vout.$196.Metal3 VDD.$906.Metal3 0.0181086f
Cred_3267 di_tg_ctrl|di_tg_ctrl_n|vout.$196.Metal3 VDD.$912.Metal3 0.0719962f
Cred_3268 di_tg_ctrl|di_tg_ctrl_n|vout.$196.Metal3 VDD.$918.Metal3 0.0220545f
Cred_3269 di_tg_ctrl|di_tg_ctrl_n|vout.$196.Metal3 VDD.P0.nSD 2.26071e-06f
Cred_3270 di_tg_ctrl|di_tg_ctrl_n|vout.$206.Metal4 VSS 0.140674f
Cred_3271 di_tg_ctrl|di_tg_ctrl_n|vout.$206.Metal4 v_a 0.023648f
Cred_3272 di_tg_ctrl|di_tg_ctrl_n|vout.$206.Metal4 v_a.$148.Metal2 0.0303591f
Cred_3273 di_tg_ctrl|di_tg_ctrl_n|vout.$206.Metal4 v_a.$182.Metal2 0.00742692f
Cred_3274 di_tg_ctrl|di_tg_ctrl_n|vout.$206.Metal4 v_a.P0.nSD 1.82129e-05f
Cred_3275 di_tg_ctrl|di_tg_ctrl_n|vout.$206.Metal4 v_a.P0.pSD 0.0137686f
Cred_3276 di_tg_ctrl|di_tg_ctrl_n|vout.$206.Metal4 v_a.P1.nSD 9.36204e-06f
Cred_3277 di_tg_ctrl|di_tg_ctrl_n|vout.$206.Metal4 v_a.P1.pSD 0.00713907f
Cred_3278 di_tg_ctrl|di_tg_ctrl_n|vout.$206.Metal4 v_a.P3.pSD 0.00875171f
Cred_3279 di_tg_ctrl|di_tg_ctrl_n|vout.$206.Metal4 v_a.P5.nSD 2.18514e-05f
Cred_3280 di_tg_ctrl|di_tg_ctrl_n|vout.$206.Metal4 v_a.P5.pSD 0.00747491f
Cred_3281 di_tg_ctrl|di_tg_ctrl_n|vout.$206.Metal4 v_b 0.0794043f
Cred_3282 di_tg_ctrl|di_tg_ctrl_n|vout.$206.Metal4 v_b.$161.Metal2 0.00487161f
Cred_3283 di_tg_ctrl|di_tg_ctrl_n|vout.$206.Metal4 v_b.$195.Metal2 0.013951f
Cred_3284 di_tg_ctrl|di_tg_ctrl_n|vout.$206.Metal4 v_b.P0.nSD 2.58556e-05f
Cred_3285 di_tg_ctrl|di_tg_ctrl_n|vout.$206.Metal4 v_b.P0.pSD 0.00759113f
Cred_3286 di_tg_ctrl|di_tg_ctrl_n|vout.$206.Metal4 v_b.P1.pSD 0.00254682f
Cred_3287 di_tg_ctrl|di_tg_ctrl_n|vout.$206.Metal4 v_c.$129.Metal1 4.38639e-07f
Cred_3288 di_tg_ctrl|di_tg_ctrl_n|vout.$206.Metal4 v_c.$136.Metal1 6.65192e-06f
Cred_3289 di_tg_ctrl|di_tg_ctrl_n|vout.$206.Metal4 v_c.$165.Metal1 4.06272e-07f
Cred_3290 di_tg_ctrl|di_tg_ctrl_n|vout.$206.Metal4 v_c.$220.Metal2 3.85785e-05f
Cred_3291 di_tg_ctrl|di_tg_ctrl_n|vout.$206.Metal4 v_c.$224.Metal2 4.38912e-05f
Cred_3292 di_tg_ctrl|di_tg_ctrl_n|vout.$206.Metal4 v_c.$226.Metal2 6.01809e-05f
Cred_3293 di_tg_ctrl|di_tg_ctrl_n|vout.$206.Metal4 v_c.$228.Metal2 0.00283879f
Cred_3294 di_tg_ctrl|di_tg_ctrl_n|vout.$206.Metal4 v_c.$23.Metal1 0.00068165f
Cred_3295 di_tg_ctrl|di_tg_ctrl_n|vout.$206.Metal4 v_c.$284.Metal2 6.71128e-06f
Cred_3296 di_tg_ctrl|di_tg_ctrl_n|vout.$206.Metal4 v_c.$288.Metal2 8.72352e-06f
Cred_3297 di_tg_ctrl|di_tg_ctrl_n|vout.$206.Metal4 v_c.$290.Metal2 1.18662e-05f
Cred_3298 di_tg_ctrl|di_tg_ctrl_n|vout.$206.Metal4 v_c.$292.Metal2 0.00143924f
Cred_3299 di_tg_ctrl|di_tg_ctrl_n|vout.$206.Metal4 v_c.$320.Metal2 9.32261e-06f
Cred_3300 di_tg_ctrl|di_tg_ctrl_n|vout.$206.Metal4 v_c.$322.Metal2 4.21083e-06f
Cred_3301 di_tg_ctrl|di_tg_ctrl_n|vout.$206.Metal4 v_c.$324.Metal2 5.61217e-06f
Cred_3302 di_tg_ctrl|di_tg_ctrl_n|vout.$206.Metal4 v_c.$326.Metal2 4.21526e-06f
Cred_3303 di_tg_ctrl|di_tg_ctrl_n|vout.$206.Metal4 v_c.$330.Metal2 5.28907e-05f
Cred_3304 di_tg_ctrl|di_tg_ctrl_n|vout.$206.Metal4 v_c.$332.Metal2 0.000106306f
Cred_3305 di_tg_ctrl|di_tg_ctrl_n|vout.$206.Metal4 v_c.$334.Metal2 0.000117146f
Cred_3306 di_tg_ctrl|di_tg_ctrl_n|vout.$206.Metal4 v_c.$352.Metal2 8.61517e-06f
Cred_3307 di_tg_ctrl|di_tg_ctrl_n|vout.$206.Metal4 v_c.$354.Metal2 3.63679e-06f
Cred_3308 di_tg_ctrl|di_tg_ctrl_n|vout.$206.Metal4 v_c.$356.Metal2 4.84582e-06f
Cred_3309 di_tg_ctrl|di_tg_ctrl_n|vout.$206.Metal4 v_c.$358.Metal2 3.63679e-06f
Cred_3310 di_tg_ctrl|di_tg_ctrl_n|vout.$206.Metal4 v_c.$411.Metal3 0.0136121f
Cred_3311 di_tg_ctrl|di_tg_ctrl_n|vout.$206.Metal4 v_c.$415.Metal3 0.0454678f
Cred_3312 di_tg_ctrl|di_tg_ctrl_n|vout.$206.Metal4 v_c.$425.Metal3 0.0307f
Cred_3313 di_tg_ctrl|di_tg_ctrl_n|vout.$206.Metal4 v_c.$446.Metal3 0.00253547f
Cred_3314 di_tg_ctrl|di_tg_ctrl_n|vout.$206.Metal4 v_c.$450.Metal3 0.0205148f
Cred_3315 di_tg_ctrl|di_tg_ctrl_n|vout.$206.Metal4 v_c.$459.Metal3 0.00115631f
Cred_3316 di_tg_ctrl|di_tg_ctrl_n|vout.$206.Metal4 v_c.$464.Metal3 0.00141181f
Cred_3317 di_tg_ctrl|di_tg_ctrl_n|vout.$206.Metal4 v_c.$468.Metal3 0.00739907f
Cred_3318 di_tg_ctrl|di_tg_ctrl_n|vout.$206.Metal4 v_c.$472.Metal3 0.00834282f
Cred_3319 di_tg_ctrl|di_tg_ctrl_n|vout.$206.Metal4 v_c.$476.Metal3 0.000674762f
Cred_3320 di_tg_ctrl|di_tg_ctrl_n|vout.$206.Metal4 v_c.$481.Metal3 0.00124527f
Cred_3321 di_tg_ctrl|di_tg_ctrl_n|vout.$206.Metal4 v_c.$485.Metal3 0.000453591f
Cred_3322 di_tg_ctrl|di_tg_ctrl_n|vout.$206.Metal4 v_c.$95.Metal1 0.000340814f
Cred_3323 di_tg_ctrl|di_tg_ctrl_n|vout.$206.Metal4 v_c.P0.nSD 4.37833e-06f
Cred_3324 di_tg_ctrl|di_tg_ctrl_n|vout.$206.Metal4 v_c.P0.pSD 1.93498e-06f
Cred_3325 di_tg_ctrl|di_tg_ctrl_n|vout.$206.Metal4 v_c.P10.nSD 1.56733e-05f
Cred_3326 di_tg_ctrl|di_tg_ctrl_n|vout.$206.Metal4 v_c.P10.pSD 0.00025346f
Cred_3327 di_tg_ctrl|di_tg_ctrl_n|vout.$206.Metal4 v_c.P2.nSD 3.56163e-06f
Cred_3328 di_tg_ctrl|di_tg_ctrl_n|vout.$206.Metal4 v_c.P2.pSD 7.76783e-09f
Cred_3329 di_tg_ctrl|di_tg_ctrl_n|vout.$206.Metal4 v_c.P6.nSD 0.000109615f
Cred_3330 di_tg_ctrl|di_tg_ctrl_n|vout.$206.Metal4 v_c.P6.pSD 0.00051132f
Cred_3331 di_tg_ctrl|di_tg_ctrl_n|vout.$206.Metal4 v_c.P8.nSD 1.45633e-05f
Cred_3332 di_tg_ctrl|di_tg_ctrl_n|vout.$206.Metal4 v_c.P8.pSD 0.00533857f
Cred_3333 di_tg_ctrl|di_tg_ctrl_n|vout.$206.Metal4 VDD.$215.Metal1 9.10394e-05f
Cred_3334 di_tg_ctrl|di_tg_ctrl_n|vout.$206.Metal4 VDD.$257.Metal1 9.48689e-05f
Cred_3335 di_tg_ctrl|di_tg_ctrl_n|vout.$206.Metal4 VDD.$279.Metal1 0.0031401f
Cred_3336 di_tg_ctrl|di_tg_ctrl_n|vout.$206.Metal4 VDD.$281.Metal1 0.00193111f
Cred_3337 di_tg_ctrl|di_tg_ctrl_n|vout.$206.Metal4 VDD.$283.Metal1 0.00192626f
Cred_3338 di_tg_ctrl|di_tg_ctrl_n|vout.$206.Metal4 VDD.$285.Metal1 0.00144537f
Cred_3339 di_tg_ctrl|di_tg_ctrl_n|vout.$206.Metal4 VDD.$286.Metal1 0.00143365f
Cred_3340 di_tg_ctrl|di_tg_ctrl_n|vout.$206.Metal4 VDD.$288.Metal1 0.00236006f
Cred_3341 di_tg_ctrl|di_tg_ctrl_n|vout.$206.Metal4 VDD.$29.Metal1 2.46536e-05f
Cred_3342 di_tg_ctrl|di_tg_ctrl_n|vout.$206.Metal4 VDD.$291.Metal1 0.0035853f
Cred_3343 di_tg_ctrl|di_tg_ctrl_n|vout.$206.Metal4 VDD.$298.Metal1 0.000284388f
Cred_3344 di_tg_ctrl|di_tg_ctrl_n|vout.$206.Metal4 VDD.$320.Metal1 0.00311477f
Cred_3345 di_tg_ctrl|di_tg_ctrl_n|vout.$206.Metal4 VDD.$322.Metal1 0.0018116f
Cred_3346 di_tg_ctrl|di_tg_ctrl_n|vout.$206.Metal4 VDD.$324.Metal1 0.0018071f
Cred_3347 di_tg_ctrl|di_tg_ctrl_n|vout.$206.Metal4 VDD.$326.Metal1 0.00135595f
Cred_3348 di_tg_ctrl|di_tg_ctrl_n|vout.$206.Metal4 VDD.$327.Metal1 0.00134496f
Cred_3349 di_tg_ctrl|di_tg_ctrl_n|vout.$206.Metal4 VDD.$329.Metal1 0.00221383f
Cred_3350 di_tg_ctrl|di_tg_ctrl_n|vout.$206.Metal4 VDD.$332.Metal1 0.00336294f
Cred_3351 di_tg_ctrl|di_tg_ctrl_n|vout.$206.Metal4 VDD.$339.Metal1 9.48689e-05f
Cred_3352 di_tg_ctrl|di_tg_ctrl_n|vout.$206.Metal4 VDD.$359.Metal1 9.6434e-05f
Cred_3353 di_tg_ctrl|di_tg_ctrl_n|vout.$206.Metal4 VDD.$378.Metal1 7.48835e-06f
Cred_3354 di_tg_ctrl|di_tg_ctrl_n|vout.$206.Metal4 VDD.$382.Metal1 0.00407088f
Cred_3355 di_tg_ctrl|di_tg_ctrl_n|vout.$206.Metal4 VDD.$405.Metal1 1.51976e-05f
Cred_3356 di_tg_ctrl|di_tg_ctrl_n|vout.$206.Metal4 VDD.$426.Metal1 0.0003944f
Cred_3357 di_tg_ctrl|di_tg_ctrl_n|vout.$206.Metal4 VDD.$434.Metal1 0.000767386f
Cred_3358 di_tg_ctrl|di_tg_ctrl_n|vout.$206.Metal4 VDD.$446.Metal1 0.0006102f
Cred_3359 di_tg_ctrl|di_tg_ctrl_n|vout.$206.Metal4 VDD.$453.Metal1 0.00138668f
Cred_3360 di_tg_ctrl|di_tg_ctrl_n|vout.$206.Metal4 VDD.$477.Metal1 0.00709997f
Cred_3361 di_tg_ctrl|di_tg_ctrl_n|vout.$206.Metal4 VDD.$484.Metal1 0.00146974f
Cred_3362 di_tg_ctrl|di_tg_ctrl_n|vout.$206.Metal4 VDD.$495.Metal1 1.55611e-06f
Cred_3363 di_tg_ctrl|di_tg_ctrl_n|vout.$206.Metal4 VDD.$526.Metal1 5.91427e-05f
Cred_3364 di_tg_ctrl|di_tg_ctrl_n|vout.$206.Metal4 VDD.$573.Metal2 0.000817678f
Cred_3365 di_tg_ctrl|di_tg_ctrl_n|vout.$206.Metal4 VDD.$606.Metal2 0.00447316f
Cred_3366 di_tg_ctrl|di_tg_ctrl_n|vout.$206.Metal4 VDD.$607.Metal2 0.00327748f
Cred_3367 di_tg_ctrl|di_tg_ctrl_n|vout.$206.Metal4 VDD.$608.Metal2 0.00330269f
Cred_3368 di_tg_ctrl|di_tg_ctrl_n|vout.$206.Metal4 VDD.$609.Metal2 0.00325929f
Cred_3369 di_tg_ctrl|di_tg_ctrl_n|vout.$206.Metal4 VDD.$610.Metal2 0.00323496f
Cred_3370 di_tg_ctrl|di_tg_ctrl_n|vout.$206.Metal4 VDD.$611.Metal2 0.00582981f
Cred_3371 di_tg_ctrl|di_tg_ctrl_n|vout.$206.Metal4 VDD.$612.Metal2 0.00597792f
Cred_3372 di_tg_ctrl|di_tg_ctrl_n|vout.$206.Metal4 VDD.$613.Metal2 0.0058142f
Cred_3373 di_tg_ctrl|di_tg_ctrl_n|vout.$206.Metal4 VDD.$614.Metal2 0.00579872f
Cred_3374 di_tg_ctrl|di_tg_ctrl_n|vout.$206.Metal4 VDD.$615.Metal2 0.00577282f
Cred_3375 di_tg_ctrl|di_tg_ctrl_n|vout.$206.Metal4 VDD.$616.Metal2 0.0057749f
Cred_3376 di_tg_ctrl|di_tg_ctrl_n|vout.$206.Metal4 VDD.$617.Metal2 0.00576067f
Cred_3377 di_tg_ctrl|di_tg_ctrl_n|vout.$206.Metal4 VDD.$618.Metal2 0.00574968f
Cred_3378 di_tg_ctrl|di_tg_ctrl_n|vout.$206.Metal4 VDD.$619.Metal2 0.00833667f
Cred_3379 di_tg_ctrl|di_tg_ctrl_n|vout.$206.Metal4 VDD.$620.Metal2 0.00129381f
Cred_3380 di_tg_ctrl|di_tg_ctrl_n|vout.$206.Metal4 VDD.$688.Metal2 0.000269586f
Cred_3381 di_tg_ctrl|di_tg_ctrl_n|vout.$206.Metal4 VDD.$696.Metal2 0.000269586f
Cred_3382 di_tg_ctrl|di_tg_ctrl_n|vout.$206.Metal4 VDD.$703.Metal2 0.0263395f
Cred_3383 di_tg_ctrl|di_tg_ctrl_n|vout.$206.Metal4 VDD.$704.Metal2 0.00874404f
Cred_3384 di_tg_ctrl|di_tg_ctrl_n|vout.$206.Metal4 VDD.$705.Metal2 0.0087408f
Cred_3385 di_tg_ctrl|di_tg_ctrl_n|vout.$206.Metal4 VDD.$706.Metal2 0.0145586f
Cred_3386 di_tg_ctrl|di_tg_ctrl_n|vout.$206.Metal4 VDD.$707.Metal2 0.013649f
Cred_3387 di_tg_ctrl|di_tg_ctrl_n|vout.$206.Metal4 VDD.$708.Metal2 0.0135618f
Cred_3388 di_tg_ctrl|di_tg_ctrl_n|vout.$206.Metal4 VDD.$709.Metal2 0.0122762f
Cred_3389 di_tg_ctrl|di_tg_ctrl_n|vout.$206.Metal4 VDD.$710.Metal2 0.00909284f
Cred_3390 di_tg_ctrl|di_tg_ctrl_n|vout.$206.Metal4 VDD.$711.Metal2 0.00911451f
Cred_3391 di_tg_ctrl|di_tg_ctrl_n|vout.$206.Metal4 VDD.$712.Metal2 0.0113038f
Cred_3392 di_tg_ctrl|di_tg_ctrl_n|vout.$206.Metal4 VDD.$713.Metal2 0.00906755f
Cred_3393 di_tg_ctrl|di_tg_ctrl_n|vout.$206.Metal4 VDD.$714.Metal2 0.0236517f
Cred_3394 di_tg_ctrl|di_tg_ctrl_n|vout.$206.Metal4 VDD.$734.Metal2 0.00060528f
Cred_3395 di_tg_ctrl|di_tg_ctrl_n|vout.$206.Metal4 VDD.$738.Metal2 0.00114546f
Cred_3396 di_tg_ctrl|di_tg_ctrl_n|vout.$206.Metal4 VDD.$746.Metal2 0.000633419f
Cred_3397 di_tg_ctrl|di_tg_ctrl_n|vout.$206.Metal4 VDD.$754.Metal2 1.62673e-05f
Cred_3398 di_tg_ctrl|di_tg_ctrl_n|vout.$206.Metal4 VDD.$762.Metal2 5.34006e-05f
Cred_3399 di_tg_ctrl|di_tg_ctrl_n|vout.$206.Metal4 VDD.$766.Metal2 5.54696e-05f
Cred_3400 di_tg_ctrl|di_tg_ctrl_n|vout.$206.Metal4 VDD.$774.Metal2 2.57087e-05f
Cred_3401 di_tg_ctrl|di_tg_ctrl_n|vout.$206.Metal4 VDD.$782.Metal2 3.60164e-05f
Cred_3402 di_tg_ctrl|di_tg_ctrl_n|vout.$206.Metal4 VDD.$790.Metal2 0.000130214f
Cred_3403 di_tg_ctrl|di_tg_ctrl_n|vout.$206.Metal4 VDD.$798.Metal2 5.82127e-05f
Cred_3404 di_tg_ctrl|di_tg_ctrl_n|vout.$206.Metal4 VDD.$802.Metal2 2.02479e-05f
Cred_3405 di_tg_ctrl|di_tg_ctrl_n|vout.$206.Metal4 VDD.$864.Metal3 2.15562e-06f
Cred_3406 di_tg_ctrl|di_tg_ctrl_n|vout.$206.Metal4 VDD.$868.Metal3 0.000653211f
Cred_3407 di_tg_ctrl|di_tg_ctrl_n|vout.$206.Metal4 VDD.$874.Metal3 0.00822126f
Cred_3408 di_tg_ctrl|di_tg_ctrl_n|vout.$206.Metal4 VDD.$878.Metal3 0.00813188f
Cred_3409 di_tg_ctrl|di_tg_ctrl_n|vout.$206.Metal4 VDD.$882.Metal3 0.0129566f
Cred_3410 di_tg_ctrl|di_tg_ctrl_n|vout.$206.Metal4 VDD.$888.Metal3 0.0160325f
Cred_3411 di_tg_ctrl|di_tg_ctrl_n|vout.$206.Metal4 VDD.$892.Metal3 0.0139132f
Cred_3412 di_tg_ctrl|di_tg_ctrl_n|vout.$206.Metal4 VDD.$896.Metal3 0.0288571f
Cred_3413 di_tg_ctrl|di_tg_ctrl_n|vout.$206.Metal4 VDD.$902.Metal3 0.0199659f
Cred_3414 di_tg_ctrl|di_tg_ctrl_n|vout.$206.Metal4 VDD.$906.Metal3 0.00461603f
Cred_3415 di_tg_ctrl|di_tg_ctrl_n|vout.$206.Metal4 VDD.P0.nSD 0.00512137f
Cred_3416 di_tg_ctrl|di_tg_ctrl_n|vout.$206.Metal4 VDD.P10.pSD 0.00155299f
Cred_3417 di_tg_ctrl|di_tg_ctrl_n|vout.$206.Metal4 VDD.P11.pSD 1.83161e-06f
Cred_3418 di_tg_ctrl|di_tg_ctrl_n|vout.$206.Metal4 VDD.P3.GatPoly 1.37607e-07f
Cred_3419 di_tg_ctrl|di_tg_ctrl_n|vout.$206.Metal4 VDD.P7.pSD 0.00101949f
Cred_3420 di_tg_ctrl|di_tg_ctrl_n|vout.$206.Metal4 VSS.$114.Metal1 0.000171881f
Cred_3421 di_tg_ctrl|di_tg_ctrl_n|vout.$206.Metal4 VSS.$127.Metal1 0.00073299f
Cred_3422 di_tg_ctrl|di_tg_ctrl_n|vout.$206.Metal4 VSS.$129.Metal1 0.00317409f
Cred_3423 di_tg_ctrl|di_tg_ctrl_n|vout.$206.Metal4 VSS.$132.Metal1 1.83522e-06f
Cred_3424 di_tg_ctrl|di_tg_ctrl_n|vout.$206.Metal4 VSS.$134.Metal1 8.55023e-05f
Cred_3425 di_tg_ctrl|di_tg_ctrl_n|vout.$206.Metal4 VSS.$155.Metal1 0.000730627f
Cred_3426 di_tg_ctrl|di_tg_ctrl_n|vout.$206.Metal4 VSS.$156.Metal1 0.000762876f
Cred_3427 di_tg_ctrl|di_tg_ctrl_n|vout.$206.Metal4 VSS.$220.Metal1 0.000315282f
Cred_3428 di_tg_ctrl|di_tg_ctrl_n|vout.$206.Metal4 VSS.$311.Metal2 0.00906419f
Cred_3429 di_tg_ctrl|di_tg_ctrl_n|vout.$206.Metal4 VSS.$350.Metal2 0.00049705f
Cred_3430 di_tg_ctrl|di_tg_ctrl_n|vout.$206.Metal4 VSS.$354.Metal2 6.84119e-06f
Cred_3431 di_tg_ctrl|di_tg_ctrl_n|vout.$206.Metal4 VSS.$359.Metal2 0.0145775f
Cred_3432 di_tg_ctrl|di_tg_ctrl_n|vout.$206.Metal4 VSS.$368.Metal2 0.000303943f
Cred_3433 di_tg_ctrl|di_tg_ctrl_n|vout.$206.Metal4 VSS.$372.Metal2 5.74983e-05f
Cred_3434 di_tg_ctrl|di_tg_ctrl_n|vout.$206.Metal4 VSS.$376.Metal2 2.34151e-06f
Cred_3435 di_tg_ctrl|di_tg_ctrl_n|vout.$206.Metal4 VSS.$496.Metal3 0.00111552f
Cred_3436 di_tg_ctrl|di_tg_ctrl_n|vout.$206.Metal4 VSS.$502.Metal3 0.0018634f
Cred_3437 di_tg_ctrl|di_tg_ctrl_n|vout.$206.Metal4 VSS.$510.Metal3 0.00029204f
Cred_3438 di_tg_ctrl|di_tg_ctrl_n|vout.$206.Metal4 VSS.$78.Metal1 0.00291654f
Cred_3439 di_tg_ctrl|di_tg_ctrl_n|vout.$206.Metal4 VSS.$87.Metal1 0.0011866f
Cred_3440 di_tg_ctrl|di_tg_ctrl_n|vout.$206.Metal4 VSS.P0.pSD 0.000781828f
Cred_3441 di_tg_ctrl|di_tg_ctrl_n|vout.$206.Metal4 VSS.P10.nSD 1.94777e-07f
Cred_3442 di_tg_ctrl|di_tg_ctrl_n|vout.$206.Metal4 VSS.P11.nSD 1.94777e-07f
Cred_3443 di_tg_ctrl|di_tg_ctrl_n|vout.$206.Metal4 VSS.P2.GatPoly 4.15631e-06f
Cred_3444 di_tg_ctrl|di_tg_ctrl_n|vout.$206.Metal4 VSS.P6.nSD 3.02547e-05f
Cred_3445 di_tg_ctrl|di_tg_ctrl_n|vout.$206.Metal4 VSS.P7.nSD 4.54088e-05f
Cred_3446 di_tg_ctrl|di_tg_ctrl_n|vout.$209.Metal4 VSS 0.0500625f
Cred_3447 di_tg_ctrl|di_tg_ctrl_n|vout.$209.Metal4 v_b 0.0161863f
Cred_3448 di_tg_ctrl|di_tg_ctrl_n|vout.$209.Metal4 v_b.$161.Metal2 0.00463967f
Cred_3449 di_tg_ctrl|di_tg_ctrl_n|vout.$209.Metal4 v_b.$195.Metal2 0.0100666f
Cred_3450 di_tg_ctrl|di_tg_ctrl_n|vout.$209.Metal4 v_b.P0.nSD 1.62078e-07f
Cred_3451 di_tg_ctrl|di_tg_ctrl_n|vout.$209.Metal4 v_b.P0.pSD 3.38238e-05f
Cred_3452 di_tg_ctrl|di_tg_ctrl_n|vout.$209.Metal4 v_b.P1.pSD 0.00565106f
Cred_3453 di_tg_ctrl|di_tg_ctrl_n|vout.$209.Metal4 v_b.P3.nSD 1.59195e-05f
Cred_3454 di_tg_ctrl|di_tg_ctrl_n|vout.$209.Metal4 v_b.P3.pSD 0.00714918f
Cred_3455 di_tg_ctrl|di_tg_ctrl_n|vout.$209.Metal4 v_b.P5.pSD 0.0042906f
Cred_3456 di_tg_ctrl|di_tg_ctrl_n|vout.$209.Metal4 v_c.$136.Metal1 1.26334e-06f
Cred_3457 di_tg_ctrl|di_tg_ctrl_n|vout.$209.Metal4 v_c.$172.Metal1 1.16575e-06f
Cred_3458 di_tg_ctrl|di_tg_ctrl_n|vout.$209.Metal4 v_c.$208.Metal1 2.29031e-05f
Cred_3459 di_tg_ctrl|di_tg_ctrl_n|vout.$209.Metal4 v_c.$322.Metal2 2.62829e-10f
Cred_3460 di_tg_ctrl|di_tg_ctrl_n|vout.$209.Metal4 v_c.$324.Metal2 5.27766e-10f
Cred_3461 di_tg_ctrl|di_tg_ctrl_n|vout.$209.Metal4 v_c.$326.Metal2 7.96934e-10f
Cred_3462 di_tg_ctrl|di_tg_ctrl_n|vout.$209.Metal4 v_c.$330.Metal2 2.69128e-05f
Cred_3463 di_tg_ctrl|di_tg_ctrl_n|vout.$209.Metal4 v_c.$332.Metal2 5.40605e-05f
Cred_3464 di_tg_ctrl|di_tg_ctrl_n|vout.$209.Metal4 v_c.$334.Metal2 3.91163e-05f
Cred_3465 di_tg_ctrl|di_tg_ctrl_n|vout.$209.Metal4 v_c.$362.Metal2 7.97007e-05f
Cred_3466 di_tg_ctrl|di_tg_ctrl_n|vout.$209.Metal4 v_c.$364.Metal2 0.000160058f
Cred_3467 di_tg_ctrl|di_tg_ctrl_n|vout.$209.Metal4 v_c.$366.Metal2 9.09615e-05f
Cred_3468 di_tg_ctrl|di_tg_ctrl_n|vout.$209.Metal4 v_c.$386.Metal2 5.33387e-08f
Cred_3469 di_tg_ctrl|di_tg_ctrl_n|vout.$209.Metal4 v_c.$388.Metal2 1.07105e-07f
Cred_3470 di_tg_ctrl|di_tg_ctrl_n|vout.$209.Metal4 v_c.$390.Metal2 1.6173e-07f
Cred_3471 di_tg_ctrl|di_tg_ctrl_n|vout.$209.Metal4 v_c.$394.Metal2 6.96106e-05f
Cred_3472 di_tg_ctrl|di_tg_ctrl_n|vout.$209.Metal4 v_c.$396.Metal2 0.000140126f
Cred_3473 di_tg_ctrl|di_tg_ctrl_n|vout.$209.Metal4 v_c.$398.Metal2 0.000283475f
Cred_3474 di_tg_ctrl|di_tg_ctrl_n|vout.$209.Metal4 v_c.$459.Metal3 1.128e-05f
Cred_3475 di_tg_ctrl|di_tg_ctrl_n|vout.$209.Metal4 v_c.$464.Metal3 3.27808e-08f
Cred_3476 di_tg_ctrl|di_tg_ctrl_n|vout.$209.Metal4 v_c.$468.Metal3 0.00335674f
Cred_3477 di_tg_ctrl|di_tg_ctrl_n|vout.$209.Metal4 v_c.$472.Metal3 0.00368827f
Cred_3478 di_tg_ctrl|di_tg_ctrl_n|vout.$209.Metal4 v_c.$476.Metal3 9.85338e-06f
Cred_3479 di_tg_ctrl|di_tg_ctrl_n|vout.$209.Metal4 v_c.$485.Metal3 0.0099405f
Cred_3480 di_tg_ctrl|di_tg_ctrl_n|vout.$209.Metal4 v_c.$489.Metal3 0.0102465f
Cred_3481 di_tg_ctrl|di_tg_ctrl_n|vout.$209.Metal4 v_c.$493.Metal3 0.000236923f
Cred_3482 di_tg_ctrl|di_tg_ctrl_n|vout.$209.Metal4 v_c.$498.Metal3 6.65256e-06f
Cred_3483 di_tg_ctrl|di_tg_ctrl_n|vout.$209.Metal4 v_c.$502.Metal3 0.00870221f
Cred_3484 di_tg_ctrl|di_tg_ctrl_n|vout.$209.Metal4 v_c.$506.Metal3 0.0129911f
Cred_3485 di_tg_ctrl|di_tg_ctrl_n|vout.$209.Metal4 v_c.P0.pSD 3.65902e-07f
Cred_3486 di_tg_ctrl|di_tg_ctrl_n|vout.$209.Metal4 v_c.P2.pSD 3.37638e-07f
Cred_3487 di_tg_ctrl|di_tg_ctrl_n|vout.$209.Metal4 v_c.P4.pSD 2.2194e-05f
Cred_3488 di_tg_ctrl|di_tg_ctrl_n|vout.$209.Metal4 VDD.$382.Metal1 1.35525e-09f
Cred_3489 di_tg_ctrl|di_tg_ctrl_n|vout.$209.Metal4 VDD.$477.Metal1 1.1111e-08f
Cred_3490 di_tg_ctrl|di_tg_ctrl_n|vout.$209.Metal4 VDD.$484.Metal1 2.45965e-07f
Cred_3491 di_tg_ctrl|di_tg_ctrl_n|vout.$209.Metal4 VDD.$495.Metal1 1.87396e-07f
Cred_3492 di_tg_ctrl|di_tg_ctrl_n|vout.$209.Metal4 VDD.$511.Metal1 1.15772e-05f
Cred_3493 di_tg_ctrl|di_tg_ctrl_n|vout.$209.Metal4 VDD.$519.Metal1 1.75368e-05f
Cred_3494 di_tg_ctrl|di_tg_ctrl_n|vout.$209.Metal4 VDD.$526.Metal1 3.95606e-07f
Cred_3495 di_tg_ctrl|di_tg_ctrl_n|vout.$209.Metal4 VDD.$798.Metal2 2.42522e-06f
Cred_3496 di_tg_ctrl|di_tg_ctrl_n|vout.$209.Metal4 VDD.$802.Metal2 9.02524e-06f
Cred_3497 di_tg_ctrl|di_tg_ctrl_n|vout.$209.Metal4 VDD.$810.Metal2 5.15478e-05f
Cred_3498 di_tg_ctrl|di_tg_ctrl_n|vout.$209.Metal4 VDD.$814.Metal2 4.96721e-05f
Cred_3499 di_tg_ctrl|di_tg_ctrl_n|vout.$209.Metal4 VDD.$822.Metal2 0.000128063f
Cred_3500 di_tg_ctrl|di_tg_ctrl_n|vout.$209.Metal4 VDD.$826.Metal2 0.000152548f
Cred_3501 di_tg_ctrl|di_tg_ctrl_n|vout.$209.Metal4 VDD.$902.Metal3 0.00126863f
Cred_3502 di_tg_ctrl|di_tg_ctrl_n|vout.$209.Metal4 VDD.$906.Metal3 0.0117771f
Cred_3503 di_tg_ctrl|di_tg_ctrl_n|vout.$209.Metal4 VDD.$912.Metal3 0.0204472f
Cred_3504 di_tg_ctrl|di_tg_ctrl_n|vout.$209.Metal4 VDD.$918.Metal3 0.00717317f
Cred_3505 di_tg_ctrl|di_tg_ctrl_n|vout.$209.Metal4 VDD.P0.nSD 8.33937e-08f
Cred_3506 di_tg_ctrl|di_tg_ctrl_n|vout.$21.GatPoly VSS 0.0122645f
Cred_3507 di_tg_ctrl|di_tg_ctrl_n|vout.$21.GatPoly v_b.$161.Metal2 0.00447204f
Cred_3508 di_tg_ctrl|di_tg_ctrl_n|vout.$21.GatPoly v_b.$195.Metal2 0.00841494f
Cred_3509 di_tg_ctrl|di_tg_ctrl_n|vout.$21.GatPoly v_b.P3.nSD 3.71969e-05f
Cred_3510 di_tg_ctrl|di_tg_ctrl_n|vout.$21.GatPoly v_b.P3.pSD 0.0185386f
Cred_3511 di_tg_ctrl|di_tg_ctrl_n|vout.$21.GatPoly v_b.P5.pSD 0.00801322f
Cred_3512 di_tg_ctrl|di_tg_ctrl_n|vout.$21.GatPoly v_c.$171.Metal1 0.000312706f
Cred_3513 di_tg_ctrl|di_tg_ctrl_n|vout.$21.GatPoly v_c.$172.Metal1 0.00343879f
Cred_3514 di_tg_ctrl|di_tg_ctrl_n|vout.$21.GatPoly v_c.$207.Metal1 0.00224706f
Cred_3515 di_tg_ctrl|di_tg_ctrl_n|vout.$21.GatPoly v_c.$208.Metal1 0.01847f
Cred_3516 di_tg_ctrl|di_tg_ctrl_n|vout.$21.GatPoly v_c.$364.Metal2 5.20367e-05f
Cred_3517 di_tg_ctrl|di_tg_ctrl_n|vout.$21.GatPoly v_c.$366.Metal2 0.00142779f
Cred_3518 di_tg_ctrl|di_tg_ctrl_n|vout.$21.GatPoly v_c.$396.Metal2 0.000279493f
Cred_3519 di_tg_ctrl|di_tg_ctrl_n|vout.$21.GatPoly v_c.$398.Metal2 0.00983162f
Cred_3520 di_tg_ctrl|di_tg_ctrl_n|vout.$21.GatPoly v_c.$489.Metal3 0.000504101f
Cred_3521 di_tg_ctrl|di_tg_ctrl_n|vout.$21.GatPoly v_c.$506.Metal3 0.00580196f
Cred_3522 di_tg_ctrl|di_tg_ctrl_n|vout.$21.GatPoly v_c.P2.pSD 0.0010715f
Cred_3523 di_tg_ctrl|di_tg_ctrl_n|vout.$21.GatPoly v_c.P4.pSD 0.00549006f
Cred_3524 di_tg_ctrl|di_tg_ctrl_n|vout.$21.GatPoly VDD.$499.Metal1 0.000325518f
Cred_3525 di_tg_ctrl|di_tg_ctrl_n|vout.$21.GatPoly VDD.$507.Metal1 0.00301369f
Cred_3526 di_tg_ctrl|di_tg_ctrl_n|vout.$21.GatPoly VDD.$511.Metal1 0.00434976f
Cred_3527 di_tg_ctrl|di_tg_ctrl_n|vout.$21.GatPoly VDD.$519.Metal1 0.00181294f
Cred_3528 di_tg_ctrl|di_tg_ctrl_n|vout.$21.GatPoly VDD.$810.Metal2 1.80565e-06f
Cred_3529 di_tg_ctrl|di_tg_ctrl_n|vout.$21.GatPoly VDD.$814.Metal2 6.72523e-06f
Cred_3530 di_tg_ctrl|di_tg_ctrl_n|vout.$21.GatPoly VDD.$822.Metal2 1.35561e-05f
Cred_3531 di_tg_ctrl|di_tg_ctrl_n|vout.$21.GatPoly VDD.$826.Metal2 2.8976e-06f
Cred_3532 di_tg_ctrl|di_tg_ctrl_n|vout.$21.GatPoly VDD.$912.Metal3 1.92041e-08f
Cred_3533 di_tg_ctrl|di_tg_ctrl_n|vout.$21.GatPoly VDD.P0.nSD 3.19904e-06f
Cred_3534 di_tg_ctrl|di_tg_ctrl_n|vout.$3.GatPoly VSS 0.0406782f
Cred_3535 di_tg_ctrl|di_tg_ctrl_n|vout.$3.GatPoly v_a.$148.Metal2 0.000963153f
Cred_3536 di_tg_ctrl|di_tg_ctrl_n|vout.$3.GatPoly v_a.$182.Metal2 0.000963153f
Cred_3537 di_tg_ctrl|di_tg_ctrl_n|vout.$3.GatPoly v_a.P1.nSD 0.00178374f
Cred_3538 di_tg_ctrl|di_tg_ctrl_n|vout.$3.GatPoly v_a.P1.pSD 3.06527e-05f
Cred_3539 di_tg_ctrl|di_tg_ctrl_n|vout.$3.GatPoly v_c.$220.Metal2 1.87241e-07f
Cred_3540 di_tg_ctrl|di_tg_ctrl_n|vout.$3.GatPoly v_c.$411.Metal3 2.33532e-05f
Cred_3541 di_tg_ctrl|di_tg_ctrl_n|vout.$3.GatPoly v_c.$425.Metal3 0.000634263f
Cred_3542 di_tg_ctrl|di_tg_ctrl_n|vout.$3.GatPoly v_c.P6.nSD 0.000271294f
Cred_3543 di_tg_ctrl|di_tg_ctrl_n|vout.$3.GatPoly v_c.P8.nSD 0.000809904f
Cred_3544 di_tg_ctrl|di_tg_ctrl_n|vout.$3.GatPoly VSS.$175.Metal1 0.000614815f
Cred_3545 di_tg_ctrl|di_tg_ctrl_n|vout.$3.GatPoly VSS.$181.Metal1 0.00307875f
Cred_3546 di_tg_ctrl|di_tg_ctrl_n|vout.$3.GatPoly VSS.$185.Metal1 0.000715836f
Cred_3547 di_tg_ctrl|di_tg_ctrl_n|vout.$3.GatPoly VSS.$392.Metal2 7.17919e-06f
Cred_3548 di_tg_ctrl|di_tg_ctrl_n|vout.$3.GatPoly VSS.$400.Metal2 2.43694e-06f
Cred_3549 di_tg_ctrl|di_tg_ctrl_n|vout.$3.GatPoly VSS.$518.Metal3 1.95388e-08f
Cred_3550 di_tg_ctrl|di_tg_ctrl_n|vout.$3.GatPoly VSS.P0.pSD 5.66131e-07f
Cred_3551 di_tg_ctrl|di_tg_ctrl_n|vout.$6.GatPoly VSS 0.0536731f
Cred_3552 di_tg_ctrl|di_tg_ctrl_n|vout.$6.GatPoly v_a.$148.Metal2 0.000128829f
Cred_3553 di_tg_ctrl|di_tg_ctrl_n|vout.$6.GatPoly v_a.$182.Metal2 0.00146835f
Cred_3554 di_tg_ctrl|di_tg_ctrl_n|vout.$6.GatPoly v_a.P1.nSD 0.000239032f
Cred_3555 di_tg_ctrl|di_tg_ctrl_n|vout.$6.GatPoly v_a.P1.pSD 4.10004e-06f
Cred_3556 di_tg_ctrl|di_tg_ctrl_n|vout.$6.GatPoly v_a.P3.nSD 0.00121153f
Cred_3557 di_tg_ctrl|di_tg_ctrl_n|vout.$6.GatPoly v_c.$284.Metal2 8.66173e-08f
Cred_3558 di_tg_ctrl|di_tg_ctrl_n|vout.$6.GatPoly v_c.$425.Metal3 0.00137879f
Cred_3559 di_tg_ctrl|di_tg_ctrl_n|vout.$6.GatPoly v_c.$446.Metal3 1.08032e-05f
Cred_3560 di_tg_ctrl|di_tg_ctrl_n|vout.$6.GatPoly v_c.$459.Metal3 1.2765e-05f
Cred_3561 di_tg_ctrl|di_tg_ctrl_n|vout.$6.GatPoly v_c.P10.nSD 0.000101669f
Cred_3562 di_tg_ctrl|di_tg_ctrl_n|vout.$6.GatPoly v_c.P8.nSD 0.00220478f
Cred_3563 di_tg_ctrl|di_tg_ctrl_n|vout.$6.GatPoly VSS.$129.Metal1 3.72806e-06f
Cred_3564 di_tg_ctrl|di_tg_ctrl_n|vout.$6.GatPoly VSS.$181.Metal1 0.000921677f
Cred_3565 di_tg_ctrl|di_tg_ctrl_n|vout.$6.GatPoly VSS.$185.Metal1 0.0053102f
Cred_3566 di_tg_ctrl|di_tg_ctrl_n|vout.$6.GatPoly VSS.$195.Metal1 0.000772458f
Cred_3567 di_tg_ctrl|di_tg_ctrl_n|vout.$6.GatPoly VSS.$220.Metal1 7.58276e-06f
Cred_3568 di_tg_ctrl|di_tg_ctrl_n|vout.$6.GatPoly VSS.$392.Metal2 2.53594e-06f
Cred_3569 di_tg_ctrl|di_tg_ctrl_n|vout.$6.GatPoly VSS.$400.Metal2 6.30661e-06f
Cred_3570 di_tg_ctrl|di_tg_ctrl_n|vout.$6.GatPoly VSS.$404.Metal2 5.9582e-06f
Cred_3571 di_tg_ctrl|di_tg_ctrl_n|vout.$6.GatPoly VSS.$518.Metal3 2.03326e-08f
Cred_3572 di_tg_ctrl|di_tg_ctrl_n|vout.$6.GatPoly VSS.$87.Metal1 7.86516e-07f
Cred_3573 di_tg_ctrl|di_tg_ctrl_n|vout.$6.GatPoly VSS.P0.pSD 5.59771e-06f
Cred_3574 di_tg_ctrl|di_tg_ctrl_n|vout.$61.Metal1 VSS 0.0297003f
Cred_3575 di_tg_ctrl|di_tg_ctrl_n|vout.$61.Metal1 v_a 1.75135e-07f
Cred_3576 di_tg_ctrl|di_tg_ctrl_n|vout.$61.Metal1 v_a.$148.Metal2 0.00961582f
Cred_3577 di_tg_ctrl|di_tg_ctrl_n|vout.$61.Metal1 v_a.$182.Metal2 0.000217201f
Cred_3578 di_tg_ctrl|di_tg_ctrl_n|vout.$61.Metal1 v_a.P0.nSD 0.00996344f
Cred_3579 di_tg_ctrl|di_tg_ctrl_n|vout.$61.Metal1 v_a.P1.nSD 0.000905156f
Cred_3580 di_tg_ctrl|di_tg_ctrl_n|vout.$61.Metal1 v_a.P1.pSD 6.9125e-06f
Cred_3581 di_tg_ctrl|di_tg_ctrl_n|vout.$61.Metal1 v_c.$220.Metal2 9.98091e-06f
Cred_3582 di_tg_ctrl|di_tg_ctrl_n|vout.$61.Metal1 v_c.$411.Metal3 0.00124485f
Cred_3583 di_tg_ctrl|di_tg_ctrl_n|vout.$61.Metal1 v_c.$425.Metal3 0.00743686f
Cred_3584 di_tg_ctrl|di_tg_ctrl_n|vout.$61.Metal1 v_c.P6.nSD 0.0140994f
Cred_3585 di_tg_ctrl|di_tg_ctrl_n|vout.$61.Metal1 VSS.$129.Metal1 0.00136943f
Cred_3586 di_tg_ctrl|di_tg_ctrl_n|vout.$61.Metal1 VSS.$132.Metal1 0.00871225f
Cred_3587 di_tg_ctrl|di_tg_ctrl_n|vout.$61.Metal1 VSS.$134.Metal1 0.000117933f
Cred_3588 di_tg_ctrl|di_tg_ctrl_n|vout.$61.Metal1 VSS.$147.Metal1 0.000158573f
Cred_3589 di_tg_ctrl|di_tg_ctrl_n|vout.$61.Metal1 VSS.$165.Metal1 0.0127389f
Cred_3590 di_tg_ctrl|di_tg_ctrl_n|vout.$61.Metal1 VSS.$175.Metal1 0.0275612f
Cred_3591 di_tg_ctrl|di_tg_ctrl_n|vout.$61.Metal1 VSS.$181.Metal1 0.00445392f
Cred_3592 di_tg_ctrl|di_tg_ctrl_n|vout.$61.Metal1 VSS.$220.Metal1 0.00104153f
Cred_3593 di_tg_ctrl|di_tg_ctrl_n|vout.$61.Metal1 VSS.$311.Metal2 2.09161e-05f
Cred_3594 di_tg_ctrl|di_tg_ctrl_n|vout.$61.Metal1 VSS.$368.Metal2 9.09654e-07f
Cred_3595 di_tg_ctrl|di_tg_ctrl_n|vout.$61.Metal1 VSS.$376.Metal2 0.000166592f
Cred_3596 di_tg_ctrl|di_tg_ctrl_n|vout.$61.Metal1 VSS.$384.Metal2 0.000411051f
Cred_3597 di_tg_ctrl|di_tg_ctrl_n|vout.$61.Metal1 VSS.$392.Metal2 7.17447e-06f
Cred_3598 di_tg_ctrl|di_tg_ctrl_n|vout.$61.Metal1 VSS.$78.Metal1 5.11313e-07f
Cred_3599 di_tg_ctrl|di_tg_ctrl_n|vout.$61.Metal1 VSS.$87.Metal1 0.000288911f
Cred_3600 di_tg_ctrl|di_tg_ctrl_n|vout.$61.Metal1 VSS.P0.pSD 0.000887115f
Cred_3601 di_tg_ctrl|di_tg_ctrl_n|vout.$61.Metal1 VSS.P2.GatPoly 6.78544e-10f
Cred_3602 di_tg_ctrl|di_tg_ctrl_n|vout.$61.Metal1 VSS.P3.GatPoly 0.000521626f
Cred_3603 di_tg_ctrl|di_tg_ctrl_n|vout.$61.Metal1 VSS.P6.nSD 5.3041e-09f
Cred_3604 di_tg_ctrl|di_tg_ctrl_n|vout.$61.Metal1 VSS.P7.nSD 6.7591e-09f
Cred_3605 di_tg_ctrl|di_tg_ctrl_n|vout.$65.Metal1 VSS 0.00722939f
Cred_3606 di_tg_ctrl|di_tg_ctrl_n|vout.$65.Metal1 v_a.$148.Metal2 0.0059668f
Cred_3607 di_tg_ctrl|di_tg_ctrl_n|vout.$65.Metal1 v_a.$182.Metal2 0.0059668f
Cred_3608 di_tg_ctrl|di_tg_ctrl_n|vout.$65.Metal1 v_a.P1.nSD 0.0148829f
Cred_3609 di_tg_ctrl|di_tg_ctrl_n|vout.$65.Metal1 v_a.P1.pSD 0.000189896f
Cred_3610 di_tg_ctrl|di_tg_ctrl_n|vout.$65.Metal1 v_c.$220.Metal2 3.17913e-06f
Cred_3611 di_tg_ctrl|di_tg_ctrl_n|vout.$65.Metal1 v_c.$411.Metal3 0.00039651f
Cred_3612 di_tg_ctrl|di_tg_ctrl_n|vout.$65.Metal1 v_c.$425.Metal3 0.00238336f
Cred_3613 di_tg_ctrl|di_tg_ctrl_n|vout.$65.Metal1 v_c.P6.nSD 0.00448684f
Cred_3614 di_tg_ctrl|di_tg_ctrl_n|vout.$65.Metal1 v_c.P8.nSD 5.21163e-06f
Cred_3615 di_tg_ctrl|di_tg_ctrl_n|vout.$65.Metal1 VSS.$129.Metal1 0.000485806f
Cred_3616 di_tg_ctrl|di_tg_ctrl_n|vout.$65.Metal1 VSS.$165.Metal1 0.000244005f
Cred_3617 di_tg_ctrl|di_tg_ctrl_n|vout.$65.Metal1 VSS.$175.Metal1 0.00737335f
Cred_3618 di_tg_ctrl|di_tg_ctrl_n|vout.$65.Metal1 VSS.$181.Metal1 0.0244463f
Cred_3619 di_tg_ctrl|di_tg_ctrl_n|vout.$65.Metal1 VSS.$185.Metal1 1.42818e-06f
Cred_3620 di_tg_ctrl|di_tg_ctrl_n|vout.$65.Metal1 VSS.$220.Metal1 0.000465801f
Cred_3621 di_tg_ctrl|di_tg_ctrl_n|vout.$65.Metal1 VSS.$384.Metal2 1.88176e-06f
Cred_3622 di_tg_ctrl|di_tg_ctrl_n|vout.$65.Metal1 VSS.$392.Metal2 1.69905e-05f
Cred_3623 di_tg_ctrl|di_tg_ctrl_n|vout.$65.Metal1 VSS.$400.Metal2 9.56209e-06f
Cred_3624 di_tg_ctrl|di_tg_ctrl_n|vout.$65.Metal1 VSS.$518.Metal3 7.66667e-08f
Cred_3625 di_tg_ctrl|di_tg_ctrl_n|vout.$65.Metal1 VSS.$87.Metal1 0.000102492f
Cred_3626 di_tg_ctrl|di_tg_ctrl_n|vout.$65.Metal1 VSS.P0.pSD 0.000339687f
Cred_3627 di_tg_ctrl|di_tg_ctrl_n|vout.$67.Metal1 VSS 0.0137088f
Cred_3628 di_tg_ctrl|di_tg_ctrl_n|vout.$67.Metal1 v_a.$148.Metal2 9.78847e-05f
Cred_3629 di_tg_ctrl|di_tg_ctrl_n|vout.$67.Metal1 v_a.$182.Metal2 9.78847e-05f
Cred_3630 di_tg_ctrl|di_tg_ctrl_n|vout.$67.Metal1 v_a.P1.nSD 0.000126669f
Cred_3631 di_tg_ctrl|di_tg_ctrl_n|vout.$67.Metal1 v_a.P1.pSD 3.11522e-06f
Cred_3632 di_tg_ctrl|di_tg_ctrl_n|vout.$67.Metal1 v_c.$425.Metal3 0.00773245f
Cred_3633 di_tg_ctrl|di_tg_ctrl_n|vout.$67.Metal1 v_c.P8.nSD 0.0152997f
Cred_3634 di_tg_ctrl|di_tg_ctrl_n|vout.$67.Metal1 VSS.$129.Metal1 0.000921662f
Cred_3635 di_tg_ctrl|di_tg_ctrl_n|vout.$67.Metal1 VSS.$181.Metal1 0.00901045f
Cred_3636 di_tg_ctrl|di_tg_ctrl_n|vout.$67.Metal1 VSS.$185.Metal1 0.0205431f
Cred_3637 di_tg_ctrl|di_tg_ctrl_n|vout.$67.Metal1 VSS.$195.Metal1 0.000265139f
Cred_3638 di_tg_ctrl|di_tg_ctrl_n|vout.$67.Metal1 VSS.$220.Metal1 0.00137054f
Cred_3639 di_tg_ctrl|di_tg_ctrl_n|vout.$67.Metal1 VSS.$392.Metal2 8.4668e-05f
Cred_3640 di_tg_ctrl|di_tg_ctrl_n|vout.$67.Metal1 VSS.$400.Metal2 8.5015e-05f
Cred_3641 di_tg_ctrl|di_tg_ctrl_n|vout.$67.Metal1 VSS.$404.Metal2 2.0451e-06f
Cred_3642 di_tg_ctrl|di_tg_ctrl_n|vout.$67.Metal1 VSS.$518.Metal3 6.7885e-07f
Cred_3643 di_tg_ctrl|di_tg_ctrl_n|vout.$67.Metal1 VSS.$87.Metal1 0.000194445f
Cred_3644 di_tg_ctrl|di_tg_ctrl_n|vout.$67.Metal1 VSS.P0.pSD 0.000751573f
Cred_3645 di_tg_ctrl|di_tg_ctrl_n|vout.$70.Metal1 VSS 0.0431321f
Cred_3646 di_tg_ctrl|di_tg_ctrl_n|vout.$70.Metal1 v_a.$182.Metal2 0.0218547f
Cred_3647 di_tg_ctrl|di_tg_ctrl_n|vout.$70.Metal1 v_a.P3.nSD 0.0159741f
Cred_3648 di_tg_ctrl|di_tg_ctrl_n|vout.$70.Metal1 v_a.P5.nSD 0.00933032f
Cred_3649 di_tg_ctrl|di_tg_ctrl_n|vout.$70.Metal1 v_a.P5.pSD 0.000235963f
Cred_3650 di_tg_ctrl|di_tg_ctrl_n|vout.$70.Metal1 v_c.$284.Metal2 1.62336e-05f
Cred_3651 di_tg_ctrl|di_tg_ctrl_n|vout.$70.Metal1 v_c.$425.Metal3 0.00938197f
Cred_3652 di_tg_ctrl|di_tg_ctrl_n|vout.$70.Metal1 v_c.$446.Metal3 0.0020247f
Cred_3653 di_tg_ctrl|di_tg_ctrl_n|vout.$70.Metal1 v_c.$459.Metal3 0.00239237f
Cred_3654 di_tg_ctrl|di_tg_ctrl_n|vout.$70.Metal1 v_c.P10.nSD 0.0176505f
Cred_3655 di_tg_ctrl|di_tg_ctrl_n|vout.$70.Metal1 v_c.P8.nSD 0.00457441f
Cred_3656 di_tg_ctrl|di_tg_ctrl_n|vout.$70.Metal1 VSS.$129.Metal1 0.00101849f
Cred_3657 di_tg_ctrl|di_tg_ctrl_n|vout.$70.Metal1 VSS.$185.Metal1 0.0267505f
Cred_3658 di_tg_ctrl|di_tg_ctrl_n|vout.$70.Metal1 VSS.$195.Metal1 0.0346806f
Cred_3659 di_tg_ctrl|di_tg_ctrl_n|vout.$70.Metal1 VSS.$199.Metal1 0.0185565f
Cred_3660 di_tg_ctrl|di_tg_ctrl_n|vout.$70.Metal1 VSS.$209.Metal1 0.00132784f
Cred_3661 di_tg_ctrl|di_tg_ctrl_n|vout.$70.Metal1 VSS.$211.Metal1 0.0055246f
Cred_3662 di_tg_ctrl|di_tg_ctrl_n|vout.$70.Metal1 VSS.$220.Metal1 0.00481593f
Cred_3663 di_tg_ctrl|di_tg_ctrl_n|vout.$70.Metal1 VSS.$400.Metal2 1.41556e-05f
Cred_3664 di_tg_ctrl|di_tg_ctrl_n|vout.$70.Metal1 VSS.$404.Metal2 9.84036e-05f
Cred_3665 di_tg_ctrl|di_tg_ctrl_n|vout.$70.Metal1 VSS.$408.Metal2 0.00105397f
Cred_3666 di_tg_ctrl|di_tg_ctrl_n|vout.$70.Metal1 VSS.$416.Metal2 0.000430008f
Cred_3667 di_tg_ctrl|di_tg_ctrl_n|vout.$70.Metal1 VSS.$522.Metal3 1.11776e-05f
Cred_3668 di_tg_ctrl|di_tg_ctrl_n|vout.$70.Metal1 VSS.$530.Metal3 1.11776e-05f
Cred_3669 di_tg_ctrl|di_tg_ctrl_n|vout.$70.Metal1 VSS.$87.Metal1 0.000214873f
Cred_3670 di_tg_ctrl|di_tg_ctrl_n|vout.$70.Metal1 VSS.P0.pSD 0.00144338f
Cred_3671 di_tg_ctrl|di_tg_ctrl_n|vout.$77.Metal1 VSS 0.00216789f
Cred_3672 di_tg_ctrl|di_tg_ctrl_n|vout.$77.Metal1 v_b 2.01254e-08f
Cred_3673 di_tg_ctrl|di_tg_ctrl_n|vout.$77.Metal1 v_b.$161.Metal2 0.00581614f
Cred_3674 di_tg_ctrl|di_tg_ctrl_n|vout.$77.Metal1 v_b.$195.Metal2 6.67597e-09f
Cred_3675 di_tg_ctrl|di_tg_ctrl_n|vout.$77.Metal1 v_b.P0.nSD 4.25702e-05f
Cred_3676 di_tg_ctrl|di_tg_ctrl_n|vout.$77.Metal1 v_b.P0.pSD 0.0171083f
Cred_3677 di_tg_ctrl|di_tg_ctrl_n|vout.$77.Metal1 v_b.P1.pSD 1.25634e-08f
Cred_3678 di_tg_ctrl|di_tg_ctrl_n|vout.$77.Metal1 v_c.$135.Metal1 0.000849863f
Cred_3679 di_tg_ctrl|di_tg_ctrl_n|vout.$77.Metal1 v_c.$136.Metal1 0.0077368f
Cred_3680 di_tg_ctrl|di_tg_ctrl_n|vout.$77.Metal1 v_c.$322.Metal2 4.46685e-08f
Cred_3681 di_tg_ctrl|di_tg_ctrl_n|vout.$77.Metal1 v_c.$324.Metal2 8.96951e-08f
Cred_3682 di_tg_ctrl|di_tg_ctrl_n|vout.$77.Metal1 v_c.$326.Metal2 1.35441e-07f
Cred_3683 di_tg_ctrl|di_tg_ctrl_n|vout.$77.Metal1 v_c.$330.Metal2 3.1952e-10f
Cred_3684 di_tg_ctrl|di_tg_ctrl_n|vout.$77.Metal1 v_c.$332.Metal2 0.000117076f
Cred_3685 di_tg_ctrl|di_tg_ctrl_n|vout.$77.Metal1 v_c.$334.Metal2 0.00325417f
Cred_3686 di_tg_ctrl|di_tg_ctrl_n|vout.$77.Metal1 v_c.$459.Metal3 1.34718e-06f
Cred_3687 di_tg_ctrl|di_tg_ctrl_n|vout.$77.Metal1 v_c.$464.Metal3 5.57118e-06f
Cred_3688 di_tg_ctrl|di_tg_ctrl_n|vout.$77.Metal1 v_c.$468.Metal3 0.00232585f
Cred_3689 di_tg_ctrl|di_tg_ctrl_n|vout.$77.Metal1 v_c.$472.Metal3 0.000861749f
Cred_3690 di_tg_ctrl|di_tg_ctrl_n|vout.$77.Metal1 v_c.P0.pSD 0.00579319f
Cred_3691 di_tg_ctrl|di_tg_ctrl_n|vout.$77.Metal1 VDD.$382.Metal1 4.75e-05f
Cred_3692 di_tg_ctrl|di_tg_ctrl_n|vout.$77.Metal1 VDD.$477.Metal1 0.00654519f
Cred_3693 di_tg_ctrl|di_tg_ctrl_n|vout.$77.Metal1 VDD.$484.Metal1 0.0244873f
Cred_3694 di_tg_ctrl|di_tg_ctrl_n|vout.$77.Metal1 VDD.$495.Metal1 0.0303429f
Cred_3695 di_tg_ctrl|di_tg_ctrl_n|vout.$77.Metal1 VDD.$499.Metal1 8.28253e-05f
Cred_3696 di_tg_ctrl|di_tg_ctrl_n|vout.$77.Metal1 VDD.$526.Metal1 6.18838e-06f
Cred_3697 di_tg_ctrl|di_tg_ctrl_n|vout.$77.Metal1 VDD.$798.Metal2 0.000566579f
Cred_3698 di_tg_ctrl|di_tg_ctrl_n|vout.$77.Metal1 VDD.$802.Metal2 9.40686e-05f
Cred_3699 di_tg_ctrl|di_tg_ctrl_n|vout.$77.Metal1 VDD.$810.Metal2 8.88381e-08f
Cred_3700 di_tg_ctrl|di_tg_ctrl_n|vout.$77.Metal1 VDD.$902.Metal3 2.18555e-05f
Cred_3701 di_tg_ctrl|di_tg_ctrl_n|vout.$77.Metal1 VDD.$906.Metal3 4.78529e-06f
Cred_3702 di_tg_ctrl|di_tg_ctrl_n|vout.$77.Metal1 VDD.P0.nSD 0.000751954f
Cred_3703 di_tg_ctrl|di_tg_ctrl_n|vout.$79.Metal1 VSS 0.000878133f
Cred_3704 di_tg_ctrl|di_tg_ctrl_n|vout.$79.Metal1 v_b.$161.Metal2 0.000765141f
Cred_3705 di_tg_ctrl|di_tg_ctrl_n|vout.$79.Metal1 v_b.P0.nSD 1.30661e-06f
Cred_3706 di_tg_ctrl|di_tg_ctrl_n|vout.$79.Metal1 v_b.P0.pSD 0.000406438f
Cred_3707 di_tg_ctrl|di_tg_ctrl_n|vout.$79.Metal1 v_b.P1.pSD 0.00217246f
Cred_3708 di_tg_ctrl|di_tg_ctrl_n|vout.$79.Metal1 v_c.$135.Metal1 0.000297111f
Cred_3709 di_tg_ctrl|di_tg_ctrl_n|vout.$79.Metal1 v_c.$136.Metal1 0.00650686f
Cred_3710 di_tg_ctrl|di_tg_ctrl_n|vout.$79.Metal1 v_c.$322.Metal2 8.87067e-09f
Cred_3711 di_tg_ctrl|di_tg_ctrl_n|vout.$79.Metal1 v_c.$324.Metal2 1.78125e-08f
Cred_3712 di_tg_ctrl|di_tg_ctrl_n|vout.$79.Metal1 v_c.$326.Metal2 2.68971e-08f
Cred_3713 di_tg_ctrl|di_tg_ctrl_n|vout.$79.Metal1 v_c.$332.Metal2 9.84635e-05f
Cred_3714 di_tg_ctrl|di_tg_ctrl_n|vout.$79.Metal1 v_c.$334.Metal2 0.00253493f
Cred_3715 di_tg_ctrl|di_tg_ctrl_n|vout.$79.Metal1 v_c.$464.Metal3 1.10637e-06f
Cred_3716 di_tg_ctrl|di_tg_ctrl_n|vout.$79.Metal1 v_c.$468.Metal3 0.00228398f
Cred_3717 di_tg_ctrl|di_tg_ctrl_n|vout.$79.Metal1 v_c.$472.Metal3 0.000415824f
Cred_3718 di_tg_ctrl|di_tg_ctrl_n|vout.$79.Metal1 v_c.P0.pSD 0.00537308f
Cred_3719 di_tg_ctrl|di_tg_ctrl_n|vout.$79.Metal1 VDD.$484.Metal1 0.00156368f
Cred_3720 di_tg_ctrl|di_tg_ctrl_n|vout.$79.Metal1 VDD.$495.Metal1 0.028521f
Cred_3721 di_tg_ctrl|di_tg_ctrl_n|vout.$79.Metal1 VDD.$499.Metal1 0.00321303f
Cred_3722 di_tg_ctrl|di_tg_ctrl_n|vout.$79.Metal1 VDD.$798.Metal2 1.20591e-05f
Cred_3723 di_tg_ctrl|di_tg_ctrl_n|vout.$79.Metal1 VDD.$802.Metal2 4.78633e-05f
Cred_3724 di_tg_ctrl|di_tg_ctrl_n|vout.$79.Metal1 VDD.$810.Metal2 3.65588e-05f
Cred_3725 di_tg_ctrl|di_tg_ctrl_n|vout.$79.Metal1 VDD.$906.Metal3 2.9312e-07f
Cred_3726 di_tg_ctrl|di_tg_ctrl_n|vout.$79.Metal1 VDD.P0.nSD 7.5998e-06f
Cred_3727 di_tg_ctrl|di_tg_ctrl_n|vout.$81.Metal1 VSS 0.000937936f
Cred_3728 di_tg_ctrl|di_tg_ctrl_n|vout.$81.Metal1 v_b.$161.Metal2 0.00729595f
Cred_3729 di_tg_ctrl|di_tg_ctrl_n|vout.$81.Metal1 v_b.P1.pSD 0.0200378f
Cred_3730 di_tg_ctrl|di_tg_ctrl_n|vout.$81.Metal1 v_c.$172.Metal1 0.00371994f
Cred_3731 di_tg_ctrl|di_tg_ctrl_n|vout.$81.Metal1 v_c.$322.Metal2 1.98534e-08f
Cred_3732 di_tg_ctrl|di_tg_ctrl_n|vout.$81.Metal1 v_c.$324.Metal2 3.9866e-08f
Cred_3733 di_tg_ctrl|di_tg_ctrl_n|vout.$81.Metal1 v_c.$326.Metal2 6.01982e-08f
Cred_3734 di_tg_ctrl|di_tg_ctrl_n|vout.$81.Metal1 v_c.$364.Metal2 5.62912e-05f
Cred_3735 di_tg_ctrl|di_tg_ctrl_n|vout.$81.Metal1 v_c.$366.Metal2 0.00143628f
Cred_3736 di_tg_ctrl|di_tg_ctrl_n|vout.$81.Metal1 v_c.$464.Metal3 2.47617e-06f
Cred_3737 di_tg_ctrl|di_tg_ctrl_n|vout.$81.Metal1 v_c.$468.Metal3 7.50809e-06f
Cred_3738 di_tg_ctrl|di_tg_ctrl_n|vout.$81.Metal1 v_c.$485.Metal3 0.00160654f
Cred_3739 di_tg_ctrl|di_tg_ctrl_n|vout.$81.Metal1 v_c.$489.Metal3 0.000243856f
Cred_3740 di_tg_ctrl|di_tg_ctrl_n|vout.$81.Metal1 v_c.P2.pSD 0.00285084f
Cred_3741 di_tg_ctrl|di_tg_ctrl_n|vout.$81.Metal1 VDD.$495.Metal1 0.00404718f
Cred_3742 di_tg_ctrl|di_tg_ctrl_n|vout.$81.Metal1 VDD.$499.Metal1 0.03977f
Cred_3743 di_tg_ctrl|di_tg_ctrl_n|vout.$81.Metal1 VDD.$507.Metal1 0.00497656f
Cred_3744 di_tg_ctrl|di_tg_ctrl_n|vout.$81.Metal1 VDD.$802.Metal2 8.19694e-05f
Cred_3745 di_tg_ctrl|di_tg_ctrl_n|vout.$81.Metal1 VDD.$810.Metal2 9.61571e-05f
Cred_3746 di_tg_ctrl|di_tg_ctrl_n|vout.$81.Metal1 VDD.$814.Metal2 2.7605e-05f
Cred_3747 di_tg_ctrl|di_tg_ctrl_n|vout.$81.Metal1 VDD.$906.Metal3 6.57213e-07f
Cred_3748 di_tg_ctrl|di_tg_ctrl_n|vout.$81.Metal1 VDD.P0.nSD 8.42805e-06f
Cred_3749 di_tg_ctrl|di_tg_ctrl_n|vout.$84.Metal1 VSS 0.00163547f
Cred_3750 di_tg_ctrl|di_tg_ctrl_n|vout.$84.Metal1 v_b.$161.Metal2 0.000653809f
Cred_3751 di_tg_ctrl|di_tg_ctrl_n|vout.$84.Metal1 v_b.$195.Metal2 0.000653809f
Cred_3752 di_tg_ctrl|di_tg_ctrl_n|vout.$84.Metal1 v_b.P1.pSD 0.000605159f
Cred_3753 di_tg_ctrl|di_tg_ctrl_n|vout.$84.Metal1 v_b.P3.nSD 5.43817e-06f
Cred_3754 di_tg_ctrl|di_tg_ctrl_n|vout.$84.Metal1 v_b.P3.pSD 0.00392251f
Cred_3755 di_tg_ctrl|di_tg_ctrl_n|vout.$84.Metal1 v_c.$171.Metal1 0.000358474f
Cred_3756 di_tg_ctrl|di_tg_ctrl_n|vout.$84.Metal1 v_c.$172.Metal1 0.0117547f
Cred_3757 di_tg_ctrl|di_tg_ctrl_n|vout.$84.Metal1 v_c.$354.Metal2 7.49016e-08f
Cred_3758 di_tg_ctrl|di_tg_ctrl_n|vout.$84.Metal1 v_c.$356.Metal2 1.50404e-07f
Cred_3759 di_tg_ctrl|di_tg_ctrl_n|vout.$84.Metal1 v_c.$358.Metal2 2.27112e-07f
Cred_3760 di_tg_ctrl|di_tg_ctrl_n|vout.$84.Metal1 v_c.$364.Metal2 0.000177876f
Cred_3761 di_tg_ctrl|di_tg_ctrl_n|vout.$84.Metal1 v_c.$366.Metal2 0.00464216f
Cred_3762 di_tg_ctrl|di_tg_ctrl_n|vout.$84.Metal1 v_c.$481.Metal3 9.34194e-06f
Cred_3763 di_tg_ctrl|di_tg_ctrl_n|vout.$84.Metal1 v_c.$485.Metal3 0.00293541f
Cred_3764 di_tg_ctrl|di_tg_ctrl_n|vout.$84.Metal1 v_c.$489.Metal3 0.000847372f
Cred_3765 di_tg_ctrl|di_tg_ctrl_n|vout.$84.Metal1 v_c.P2.pSD 0.00862604f
Cred_3766 di_tg_ctrl|di_tg_ctrl_n|vout.$84.Metal1 VDD.$499.Metal1 0.02114f
Cred_3767 di_tg_ctrl|di_tg_ctrl_n|vout.$84.Metal1 VDD.$507.Metal1 0.0286571f
Cred_3768 di_tg_ctrl|di_tg_ctrl_n|vout.$84.Metal1 VDD.$511.Metal1 9.82271e-05f
Cred_3769 di_tg_ctrl|di_tg_ctrl_n|vout.$84.Metal1 VDD.$810.Metal2 7.44396e-05f
Cred_3770 di_tg_ctrl|di_tg_ctrl_n|vout.$84.Metal1 VDD.$814.Metal2 0.000366381f
Cred_3771 di_tg_ctrl|di_tg_ctrl_n|vout.$84.Metal1 VDD.$822.Metal2 2.06135e-07f
Cred_3772 di_tg_ctrl|di_tg_ctrl_n|vout.$84.Metal1 VDD.$912.Metal3 1.65275e-09f
Cred_3773 di_tg_ctrl|di_tg_ctrl_n|vout.$84.Metal1 VDD.P0.nSD 4.42201e-05f
Cred_3774 di_tg_ctrl|di_tg_ctrl_n|vout.$86.Metal1 VSS 0.00150384f
Cred_3775 di_tg_ctrl|di_tg_ctrl_n|vout.$86.Metal1 v_b.$161.Metal2 0.00375558f
Cred_3776 di_tg_ctrl|di_tg_ctrl_n|vout.$86.Metal1 v_b.$195.Metal2 0.00375558f
Cred_3777 di_tg_ctrl|di_tg_ctrl_n|vout.$86.Metal1 v_b.P3.nSD 3.12377e-05f
Cred_3778 di_tg_ctrl|di_tg_ctrl_n|vout.$86.Metal1 v_b.P3.pSD 0.0203613f
Cred_3779 di_tg_ctrl|di_tg_ctrl_n|vout.$86.Metal1 v_c.$171.Metal1 0.00012404f
Cred_3780 di_tg_ctrl|di_tg_ctrl_n|vout.$86.Metal1 v_c.$172.Metal1 0.00136518f
Cred_3781 di_tg_ctrl|di_tg_ctrl_n|vout.$86.Metal1 v_c.$354.Metal2 8.59527e-09f
Cred_3782 di_tg_ctrl|di_tg_ctrl_n|vout.$86.Metal1 v_c.$356.Metal2 1.72595e-08f
Cred_3783 di_tg_ctrl|di_tg_ctrl_n|vout.$86.Metal1 v_c.$358.Metal2 2.6062e-08f
Cred_3784 di_tg_ctrl|di_tg_ctrl_n|vout.$86.Metal1 v_c.$364.Metal2 2.06582e-05f
Cred_3785 di_tg_ctrl|di_tg_ctrl_n|vout.$86.Metal1 v_c.$366.Metal2 0.000576169f
Cred_3786 di_tg_ctrl|di_tg_ctrl_n|vout.$86.Metal1 v_c.$481.Metal3 1.07203e-06f
Cred_3787 di_tg_ctrl|di_tg_ctrl_n|vout.$86.Metal1 v_c.$485.Metal3 3.25053e-06f
Cred_3788 di_tg_ctrl|di_tg_ctrl_n|vout.$86.Metal1 v_c.$489.Metal3 0.000201847f
Cred_3789 di_tg_ctrl|di_tg_ctrl_n|vout.$86.Metal1 v_c.P2.pSD 0.000428103f
Cred_3790 di_tg_ctrl|di_tg_ctrl_n|vout.$86.Metal1 VDD.$499.Metal1 0.000591425f
Cred_3791 di_tg_ctrl|di_tg_ctrl_n|vout.$86.Metal1 VDD.$507.Metal1 0.0286975f
Cred_3792 di_tg_ctrl|di_tg_ctrl_n|vout.$86.Metal1 VDD.$511.Metal1 0.00407051f
Cred_3793 di_tg_ctrl|di_tg_ctrl_n|vout.$86.Metal1 VDD.$810.Metal2 3.28064e-06f
Cred_3794 di_tg_ctrl|di_tg_ctrl_n|vout.$86.Metal1 VDD.$814.Metal2 3.25303e-05f
Cred_3795 di_tg_ctrl|di_tg_ctrl_n|vout.$86.Metal1 VDD.$822.Metal2 5.31194e-07f
Cred_3796 di_tg_ctrl|di_tg_ctrl_n|vout.$86.Metal1 VDD.$912.Metal3 4.259e-09f
Cred_3797 di_tg_ctrl|di_tg_ctrl_n|vout.$86.Metal1 VDD.P0.nSD 1.94883e-06f
Cred_3798 di_tg_ctrl|di_tg_ctrl_n|vout.$88.Metal1 VSS 0.0011627f
Cred_3799 di_tg_ctrl|di_tg_ctrl_n|vout.$88.Metal1 v_b 7.27652e-07f
Cred_3800 di_tg_ctrl|di_tg_ctrl_n|vout.$88.Metal1 v_b.$161.Metal2 0.000268263f
Cred_3801 di_tg_ctrl|di_tg_ctrl_n|vout.$88.Metal1 v_b.$195.Metal2 0.000559269f
Cred_3802 di_tg_ctrl|di_tg_ctrl_n|vout.$88.Metal1 v_b.P3.nSD 2.23132e-06f
Cred_3803 di_tg_ctrl|di_tg_ctrl_n|vout.$88.Metal1 v_b.P3.pSD 0.00213325f
Cred_3804 di_tg_ctrl|di_tg_ctrl_n|vout.$88.Metal1 v_b.P5.pSD 0.000505024f
Cred_3805 di_tg_ctrl|di_tg_ctrl_n|vout.$88.Metal1 v_c.$207.Metal1 0.000297111f
Cred_3806 di_tg_ctrl|di_tg_ctrl_n|vout.$88.Metal1 v_c.$208.Metal1 0.00651785f
Cred_3807 di_tg_ctrl|di_tg_ctrl_n|vout.$88.Metal1 v_c.$362.Metal2 1.0302e-09f
Cred_3808 di_tg_ctrl|di_tg_ctrl_n|vout.$88.Metal1 v_c.$364.Metal2 2.06866e-09f
Cred_3809 di_tg_ctrl|di_tg_ctrl_n|vout.$88.Metal1 v_c.$366.Metal2 1.0302e-09f
Cred_3810 di_tg_ctrl|di_tg_ctrl_n|vout.$88.Metal1 v_c.$386.Metal2 1.56051e-07f
Cred_3811 di_tg_ctrl|di_tg_ctrl_n|vout.$88.Metal1 v_c.$388.Metal2 3.13353e-07f
Cred_3812 di_tg_ctrl|di_tg_ctrl_n|vout.$88.Metal1 v_c.$390.Metal2 4.73167e-07f
Cred_3813 di_tg_ctrl|di_tg_ctrl_n|vout.$88.Metal1 v_c.$394.Metal2 6.34212e-09f
Cred_3814 di_tg_ctrl|di_tg_ctrl_n|vout.$88.Metal1 v_c.$396.Metal2 9.86426e-05f
Cred_3815 di_tg_ctrl|di_tg_ctrl_n|vout.$88.Metal1 v_c.$398.Metal2 0.00270813f
Cred_3816 di_tg_ctrl|di_tg_ctrl_n|vout.$88.Metal1 v_c.$485.Metal3 1.28489e-07f
Cred_3817 di_tg_ctrl|di_tg_ctrl_n|vout.$88.Metal1 v_c.$489.Metal3 1.28489e-07f
Cred_3818 di_tg_ctrl|di_tg_ctrl_n|vout.$88.Metal1 v_c.$493.Metal3 1.92185e-06f
Cred_3819 di_tg_ctrl|di_tg_ctrl_n|vout.$88.Metal1 v_c.$498.Metal3 1.94631e-05f
Cred_3820 di_tg_ctrl|di_tg_ctrl_n|vout.$88.Metal1 v_c.$502.Metal3 0.00234044f
Cred_3821 di_tg_ctrl|di_tg_ctrl_n|vout.$88.Metal1 v_c.$506.Metal3 0.000485369f
Cred_3822 di_tg_ctrl|di_tg_ctrl_n|vout.$88.Metal1 v_c.P4.pSD 0.00542476f
Cred_3823 di_tg_ctrl|di_tg_ctrl_n|vout.$88.Metal1 VDD.$382.Metal1 2.52866e-09f
Cred_3824 di_tg_ctrl|di_tg_ctrl_n|vout.$88.Metal1 VDD.$477.Metal1 1.32268e-09f
Cred_3825 di_tg_ctrl|di_tg_ctrl_n|vout.$88.Metal1 VDD.$507.Metal1 0.00320475f
Cred_3826 di_tg_ctrl|di_tg_ctrl_n|vout.$88.Metal1 VDD.$511.Metal1 0.0278057f
Cred_3827 di_tg_ctrl|di_tg_ctrl_n|vout.$88.Metal1 VDD.$519.Metal1 0.00236066f
Cred_3828 di_tg_ctrl|di_tg_ctrl_n|vout.$88.Metal1 VDD.$526.Metal1 7.81827e-07f
Cred_3829 di_tg_ctrl|di_tg_ctrl_n|vout.$88.Metal1 VDD.$810.Metal2 4.70484e-10f
Cred_3830 di_tg_ctrl|di_tg_ctrl_n|vout.$88.Metal1 VDD.$814.Metal2 1.40578e-07f
Cred_3831 di_tg_ctrl|di_tg_ctrl_n|vout.$88.Metal1 VDD.$822.Metal2 0.000227801f
Cred_3832 di_tg_ctrl|di_tg_ctrl_n|vout.$88.Metal1 VDD.$826.Metal2 0.000191684f
Cred_3833 di_tg_ctrl|di_tg_ctrl_n|vout.$88.Metal1 VDD.$906.Metal3 5.86801e-08f
Cred_3834 di_tg_ctrl|di_tg_ctrl_n|vout.$88.Metal1 VDD.$912.Metal3 2.63898e-05f
Cred_3835 di_tg_ctrl|di_tg_ctrl_n|vout.$88.Metal1 VDD.$918.Metal3 1.81922e-05f
Cred_3836 di_tg_ctrl|di_tg_ctrl_n|vout.$88.Metal1 VDD.P0.nSD 3.97733e-06f
Cred_3837 di_tg_ctrl|di_tg_ctrl_n|vout.$90.Metal1 VSS 0.00372283f
Cred_3838 di_tg_ctrl|di_tg_ctrl_n|vout.$90.Metal1 v_b 3.06396e-06f
Cred_3839 di_tg_ctrl|di_tg_ctrl_n|vout.$90.Metal1 v_b.$161.Metal2 3.85616e-06f
Cred_3840 di_tg_ctrl|di_tg_ctrl_n|vout.$90.Metal1 v_b.$195.Metal2 0.00674338f
Cred_3841 di_tg_ctrl|di_tg_ctrl_n|vout.$90.Metal1 v_b.P3.nSD 3.20743e-08f
Cred_3842 di_tg_ctrl|di_tg_ctrl_n|vout.$90.Metal1 v_b.P3.pSD 9.32115e-06f
Cred_3843 di_tg_ctrl|di_tg_ctrl_n|vout.$90.Metal1 v_b.P5.pSD 0.0168632f
Cred_3844 di_tg_ctrl|di_tg_ctrl_n|vout.$90.Metal1 v_c.$207.Metal1 0.000849863f
Cred_3845 di_tg_ctrl|di_tg_ctrl_n|vout.$90.Metal1 v_c.$208.Metal1 0.00774582f
Cred_3846 di_tg_ctrl|di_tg_ctrl_n|vout.$90.Metal1 v_c.$362.Metal2 4.32511e-09f
Cred_3847 di_tg_ctrl|di_tg_ctrl_n|vout.$90.Metal1 v_c.$364.Metal2 8.6849e-09f
Cred_3848 di_tg_ctrl|di_tg_ctrl_n|vout.$90.Metal1 v_c.$366.Metal2 4.32511e-09f
Cred_3849 di_tg_ctrl|di_tg_ctrl_n|vout.$90.Metal1 v_c.$386.Metal2 5.17105e-07f
Cred_3850 di_tg_ctrl|di_tg_ctrl_n|vout.$90.Metal1 v_c.$388.Metal2 1.03836e-06f
Cred_3851 di_tg_ctrl|di_tg_ctrl_n|vout.$90.Metal1 v_c.$390.Metal2 1.56793e-06f
Cred_3852 di_tg_ctrl|di_tg_ctrl_n|vout.$90.Metal1 v_c.$394.Metal2 2.66881e-08f
Cred_3853 di_tg_ctrl|di_tg_ctrl_n|vout.$90.Metal1 v_c.$396.Metal2 0.000117265f
Cred_3854 di_tg_ctrl|di_tg_ctrl_n|vout.$90.Metal1 v_c.$398.Metal2 0.00376992f
Cred_3855 di_tg_ctrl|di_tg_ctrl_n|vout.$90.Metal1 v_c.$485.Metal3 5.3944e-07f
Cred_3856 di_tg_ctrl|di_tg_ctrl_n|vout.$90.Metal1 v_c.$489.Metal3 5.3944e-07f
Cred_3857 di_tg_ctrl|di_tg_ctrl_n|vout.$90.Metal1 v_c.$493.Metal3 8.2185e-06f
Cred_3858 di_tg_ctrl|di_tg_ctrl_n|vout.$90.Metal1 v_c.$498.Metal3 6.44948e-05f
Cred_3859 di_tg_ctrl|di_tg_ctrl_n|vout.$90.Metal1 v_c.$502.Metal3 0.00247952f
Cred_3860 di_tg_ctrl|di_tg_ctrl_n|vout.$90.Metal1 v_c.$506.Metal3 0.0010899f
Cred_3861 di_tg_ctrl|di_tg_ctrl_n|vout.$90.Metal1 v_c.P4.pSD 0.00594116f
Cred_3862 di_tg_ctrl|di_tg_ctrl_n|vout.$90.Metal1 VDD.$382.Metal1 2.04645e-05f
Cred_3863 di_tg_ctrl|di_tg_ctrl_n|vout.$90.Metal1 VDD.$477.Metal1 1.07045e-05f
Cred_3864 di_tg_ctrl|di_tg_ctrl_n|vout.$90.Metal1 VDD.$507.Metal1 8.28253e-05f
Cred_3865 di_tg_ctrl|di_tg_ctrl_n|vout.$90.Metal1 VDD.$511.Metal1 0.0187958f
Cred_3866 di_tg_ctrl|di_tg_ctrl_n|vout.$90.Metal1 VDD.$519.Metal1 0.0362224f
Cred_3867 di_tg_ctrl|di_tg_ctrl_n|vout.$90.Metal1 VDD.$526.Metal1 0.00632734f
Cred_3868 di_tg_ctrl|di_tg_ctrl_n|vout.$90.Metal1 VDD.$810.Metal2 1.97524e-09f
Cred_3869 di_tg_ctrl|di_tg_ctrl_n|vout.$90.Metal1 VDD.$814.Metal2 9.28044e-08f
Cred_3870 di_tg_ctrl|di_tg_ctrl_n|vout.$90.Metal1 VDD.$822.Metal2 0.000716499f
Cred_3871 di_tg_ctrl|di_tg_ctrl_n|vout.$90.Metal1 VDD.$826.Metal2 0.00100522f
Cred_3872 di_tg_ctrl|di_tg_ctrl_n|vout.$90.Metal1 VDD.$906.Metal3 2.46358e-07f
Cred_3873 di_tg_ctrl|di_tg_ctrl_n|vout.$90.Metal1 VDD.$912.Metal3 0.000109439f
Cred_3874 di_tg_ctrl|di_tg_ctrl_n|vout.$90.Metal1 VDD.$918.Metal3 7.74734e-05f
Cred_3875 di_tg_ctrl|di_tg_ctrl_n|vout.$90.Metal1 VDD.P0.nSD 0.00116768f
Cred_3876 di_tg_ctrl|di_tg_ctrl_n|vout.P0.nSD VSS 0.0087797f
Cred_3877 di_tg_ctrl|di_tg_ctrl_n|vout.P0.nSD v_a 0.0172f
Cred_3878 di_tg_ctrl|di_tg_ctrl_n|vout.P0.nSD v_a.$148.Metal2 0.0138026f
Cred_3879 di_tg_ctrl|di_tg_ctrl_n|vout.P0.nSD v_a.$182.Metal2 4.38589e-05f
Cred_3880 di_tg_ctrl|di_tg_ctrl_n|vout.P0.nSD v_a.P0.nSD 1.2228e-05f
Cred_3881 di_tg_ctrl|di_tg_ctrl_n|vout.P0.nSD v_a.P0.pSD 0.00083159f
Cred_3882 di_tg_ctrl|di_tg_ctrl_n|vout.P0.nSD v_a.P1.nSD 3.64804e-07f
Cred_3883 di_tg_ctrl|di_tg_ctrl_n|vout.P0.nSD v_a.P1.pSD 0.000224518f
Cred_3884 di_tg_ctrl|di_tg_ctrl_n|vout.P0.nSD v_a.P3.pSD 6.00157e-05f
Cred_3885 di_tg_ctrl|di_tg_ctrl_n|vout.P0.nSD v_a.P5.pSD 3.83075e-05f
Cred_3886 di_tg_ctrl|di_tg_ctrl_n|vout.P0.nSD v_b 0.0141462f
Cred_3887 di_tg_ctrl|di_tg_ctrl_n|vout.P0.nSD v_b.$195.Metal2 7.81968e-05f
Cred_3888 di_tg_ctrl|di_tg_ctrl_n|vout.P0.nSD v_b.P0.pSD 2.5169e-05f
Cred_3889 di_tg_ctrl|di_tg_ctrl_n|vout.P0.nSD v_b.P1.pSD 2.73434e-05f
Cred_3890 di_tg_ctrl|di_tg_ctrl_n|vout.P0.nSD v_c.$129.Metal1 2.09044e-07f
Cred_3891 di_tg_ctrl|di_tg_ctrl_n|vout.P0.nSD v_c.$165.Metal1 1.97371e-07f
Cred_3892 di_tg_ctrl|di_tg_ctrl_n|vout.P0.nSD v_c.$220.Metal2 2.51592e-05f
Cred_3893 di_tg_ctrl|di_tg_ctrl_n|vout.P0.nSD v_c.$224.Metal2 1.06708e-05f
Cred_3894 di_tg_ctrl|di_tg_ctrl_n|vout.P0.nSD v_c.$226.Metal2 1.45624e-05f
Cred_3895 di_tg_ctrl|di_tg_ctrl_n|vout.P0.nSD v_c.$228.Metal2 0.000339417f
Cred_3896 di_tg_ctrl|di_tg_ctrl_n|vout.P0.nSD v_c.$23.Metal1 8.12012e-05f
Cred_3897 di_tg_ctrl|di_tg_ctrl_n|vout.P0.nSD v_c.$284.Metal2 4.19543e-06f
Cred_3898 di_tg_ctrl|di_tg_ctrl_n|vout.P0.nSD v_c.$288.Metal2 1.83742e-06f
Cred_3899 di_tg_ctrl|di_tg_ctrl_n|vout.P0.nSD v_c.$290.Metal2 2.49936e-06f
Cred_3900 di_tg_ctrl|di_tg_ctrl_n|vout.P0.nSD v_c.$292.Metal2 6.27594e-05f
Cred_3901 di_tg_ctrl|di_tg_ctrl_n|vout.P0.nSD v_c.$320.Metal2 4.35931e-06f
Cred_3902 di_tg_ctrl|di_tg_ctrl_n|vout.P0.nSD v_c.$322.Metal2 8.8646e-07f
Cred_3903 di_tg_ctrl|di_tg_ctrl_n|vout.P0.nSD v_c.$324.Metal2 1.18116e-06f
Cred_3904 di_tg_ctrl|di_tg_ctrl_n|vout.P0.nSD v_c.$326.Metal2 8.8646e-07f
Cred_3905 di_tg_ctrl|di_tg_ctrl_n|vout.P0.nSD v_c.$352.Metal2 4.11058e-06f
Cred_3906 di_tg_ctrl|di_tg_ctrl_n|vout.P0.nSD v_c.$354.Metal2 7.66011e-07f
Cred_3907 di_tg_ctrl|di_tg_ctrl_n|vout.P0.nSD v_c.$356.Metal2 1.02067e-06f
Cred_3908 di_tg_ctrl|di_tg_ctrl_n|vout.P0.nSD v_c.$358.Metal2 7.66011e-07f
Cred_3909 di_tg_ctrl|di_tg_ctrl_n|vout.P0.nSD v_c.$411.Metal3 0.00534013f
Cred_3910 di_tg_ctrl|di_tg_ctrl_n|vout.P0.nSD v_c.$415.Metal3 0.00640006f
Cred_3911 di_tg_ctrl|di_tg_ctrl_n|vout.P0.nSD v_c.$425.Metal3 0.00846657f
Cred_3912 di_tg_ctrl|di_tg_ctrl_n|vout.P0.nSD v_c.$446.Metal3 0.000881f
Cred_3913 di_tg_ctrl|di_tg_ctrl_n|vout.P0.nSD v_c.$450.Metal3 0.00105541f
Cred_3914 di_tg_ctrl|di_tg_ctrl_n|vout.P0.nSD v_c.$459.Metal3 0.000662421f
Cred_3915 di_tg_ctrl|di_tg_ctrl_n|vout.P0.nSD v_c.$464.Metal3 0.000406658f
Cred_3916 di_tg_ctrl|di_tg_ctrl_n|vout.P0.nSD v_c.$468.Metal3 0.000166464f
Cred_3917 di_tg_ctrl|di_tg_ctrl_n|vout.P0.nSD v_c.$476.Metal3 0.00041282f
Cred_3918 di_tg_ctrl|di_tg_ctrl_n|vout.P0.nSD v_c.$481.Metal3 0.000367085f
Cred_3919 di_tg_ctrl|di_tg_ctrl_n|vout.P0.nSD v_c.$485.Metal3 9.55391e-05f
Cred_3920 di_tg_ctrl|di_tg_ctrl_n|vout.P0.nSD v_c.$95.Metal1 1.54092e-05f
Cred_3921 di_tg_ctrl|di_tg_ctrl_n|vout.P0.nSD v_c.P0.nSD 2.93958e-06f
Cred_3922 di_tg_ctrl|di_tg_ctrl_n|vout.P0.nSD v_c.P0.pSD 4.02496e-09f
Cred_3923 di_tg_ctrl|di_tg_ctrl_n|vout.P0.nSD v_c.P10.nSD 1.04244e-05f
Cred_3924 di_tg_ctrl|di_tg_ctrl_n|vout.P0.nSD v_c.P10.pSD 1.16943e-05f
Cred_3925 di_tg_ctrl|di_tg_ctrl_n|vout.P0.nSD v_c.P2.nSD 2.39126e-06f
Cred_3926 di_tg_ctrl|di_tg_ctrl_n|vout.P0.nSD v_c.P2.pSD 3.80222e-09f
Cred_3927 di_tg_ctrl|di_tg_ctrl_n|vout.P0.nSD v_c.P6.nSD 8.26996e-05f
Cred_3928 di_tg_ctrl|di_tg_ctrl_n|vout.P0.nSD v_c.P6.pSD 6.1201e-05f
Cred_3929 di_tg_ctrl|di_tg_ctrl_n|vout.P0.nSD v_c.P8.nSD 9.77773e-06f
Cred_3930 di_tg_ctrl|di_tg_ctrl_n|vout.P0.nSD v_c.P8.pSD 0.000435889f
Cred_3931 di_tg_ctrl|di_tg_ctrl_n|vout.P0.nSD VDD.$215.Metal1 6.76601e-05f
Cred_3932 di_tg_ctrl|di_tg_ctrl_n|vout.P0.nSD VDD.$257.Metal1 7.33788e-05f
Cred_3933 di_tg_ctrl|di_tg_ctrl_n|vout.P0.nSD VDD.$279.Metal1 0.00242879f
Cred_3934 di_tg_ctrl|di_tg_ctrl_n|vout.P0.nSD VDD.$281.Metal1 0.00149367f
Cred_3935 di_tg_ctrl|di_tg_ctrl_n|vout.P0.nSD VDD.$283.Metal1 0.00148992f
Cred_3936 di_tg_ctrl|di_tg_ctrl_n|vout.P0.nSD VDD.$285.Metal1 0.00111796f
Cred_3937 di_tg_ctrl|di_tg_ctrl_n|vout.P0.nSD VDD.$286.Metal1 0.00110889f
Cred_3938 di_tg_ctrl|di_tg_ctrl_n|vout.P0.nSD VDD.$288.Metal1 0.00182545f
Cred_3939 di_tg_ctrl|di_tg_ctrl_n|vout.P0.nSD VDD.$29.Metal1 1.83224e-05f
Cred_3940 di_tg_ctrl|di_tg_ctrl_n|vout.P0.nSD VDD.$291.Metal1 0.00277314f
Cred_3941 di_tg_ctrl|di_tg_ctrl_n|vout.P0.nSD VDD.$298.Metal1 0.000219967f
Cred_3942 di_tg_ctrl|di_tg_ctrl_n|vout.P0.nSD VDD.$320.Metal1 0.00239421f
Cred_3943 di_tg_ctrl|di_tg_ctrl_n|vout.P0.nSD VDD.$322.Metal1 0.00140123f
Cred_3944 di_tg_ctrl|di_tg_ctrl_n|vout.P0.nSD VDD.$324.Metal1 0.00139775f
Cred_3945 di_tg_ctrl|di_tg_ctrl_n|vout.P0.nSD VDD.$326.Metal1 0.0010488f
Cred_3946 di_tg_ctrl|di_tg_ctrl_n|vout.P0.nSD VDD.$327.Metal1 0.0010403f
Cred_3947 di_tg_ctrl|di_tg_ctrl_n|vout.P0.nSD VDD.$329.Metal1 0.00171235f
Cred_3948 di_tg_ctrl|di_tg_ctrl_n|vout.P0.nSD VDD.$332.Metal1 0.00260115f
Cred_3949 di_tg_ctrl|di_tg_ctrl_n|vout.P0.nSD VDD.$339.Metal1 7.33788e-05f
Cred_3950 di_tg_ctrl|di_tg_ctrl_n|vout.P0.nSD VDD.$359.Metal1 5.95966e-05f
Cred_3951 di_tg_ctrl|di_tg_ctrl_n|vout.P0.nSD VDD.$378.Metal1 4.68034e-06f
Cred_3952 di_tg_ctrl|di_tg_ctrl_n|vout.P0.nSD VDD.$382.Metal1 0.00244144f
Cred_3953 di_tg_ctrl|di_tg_ctrl_n|vout.P0.nSD VDD.$405.Metal1 6.59888e-06f
Cred_3954 di_tg_ctrl|di_tg_ctrl_n|vout.P0.nSD VDD.$477.Metal1 1.14301e-06f
Cred_3955 di_tg_ctrl|di_tg_ctrl_n|vout.P0.nSD VDD.$526.Metal1 2.84688e-07f
Cred_3956 di_tg_ctrl|di_tg_ctrl_n|vout.P0.nSD VDD.$573.Metal2 3.18619e-05f
Cred_3957 di_tg_ctrl|di_tg_ctrl_n|vout.P0.nSD VDD.$606.Metal2 0.00345988f
Cred_3958 di_tg_ctrl|di_tg_ctrl_n|vout.P0.nSD VDD.$607.Metal2 0.00253505f
Cred_3959 di_tg_ctrl|di_tg_ctrl_n|vout.P0.nSD VDD.$608.Metal2 0.00255455f
Cred_3960 di_tg_ctrl|di_tg_ctrl_n|vout.P0.nSD VDD.$609.Metal2 0.00252098f
Cred_3961 di_tg_ctrl|di_tg_ctrl_n|vout.P0.nSD VDD.$610.Metal2 0.00250216f
Cred_3962 di_tg_ctrl|di_tg_ctrl_n|vout.P0.nSD VDD.$611.Metal2 0.00258021f
Cred_3963 di_tg_ctrl|di_tg_ctrl_n|vout.P0.nSD VDD.$612.Metal2 0.00262547f
Cred_3964 di_tg_ctrl|di_tg_ctrl_n|vout.P0.nSD VDD.$613.Metal2 0.00249204f
Cred_3965 di_tg_ctrl|di_tg_ctrl_n|vout.P0.nSD VDD.$614.Metal2 0.00248007f
Cred_3966 di_tg_ctrl|di_tg_ctrl_n|vout.P0.nSD VDD.$615.Metal2 0.00246004f
Cred_3967 di_tg_ctrl|di_tg_ctrl_n|vout.P0.nSD VDD.$616.Metal2 0.00246164f
Cred_3968 di_tg_ctrl|di_tg_ctrl_n|vout.P0.nSD VDD.$617.Metal2 0.00245063f
Cred_3969 di_tg_ctrl|di_tg_ctrl_n|vout.P0.nSD VDD.$618.Metal2 0.00244214f
Cred_3970 di_tg_ctrl|di_tg_ctrl_n|vout.P0.nSD VDD.$619.Metal2 0.00330542f
Cred_3971 di_tg_ctrl|di_tg_ctrl_n|vout.P0.nSD VDD.$620.Metal2 5.04149e-05f
Cred_3972 di_tg_ctrl|di_tg_ctrl_n|vout.P0.nSD VDD.$688.Metal2 0.000208518f
Cred_3973 di_tg_ctrl|di_tg_ctrl_n|vout.P0.nSD VDD.$696.Metal2 0.000208518f
Cred_3974 di_tg_ctrl|di_tg_ctrl_n|vout.P0.nSD VDD.$703.Metal2 0.0140869f
Cred_3975 di_tg_ctrl|di_tg_ctrl_n|vout.P0.nSD VDD.$704.Metal2 0.00360375f
Cred_3976 di_tg_ctrl|di_tg_ctrl_n|vout.P0.nSD VDD.$705.Metal2 0.00360124f
Cred_3977 di_tg_ctrl|di_tg_ctrl_n|vout.P0.nSD VDD.$706.Metal2 0.00379628f
Cred_3978 di_tg_ctrl|di_tg_ctrl_n|vout.P0.nSD VDD.$707.Metal2 0.00373435f
Cred_3979 di_tg_ctrl|di_tg_ctrl_n|vout.P0.nSD VDD.$708.Metal2 0.0047538f
Cred_3980 di_tg_ctrl|di_tg_ctrl_n|vout.P0.nSD VDD.$709.Metal2 0.0027744f
Cred_3981 di_tg_ctrl|di_tg_ctrl_n|vout.P0.nSD VDD.$710.Metal2 0.00263106f
Cred_3982 di_tg_ctrl|di_tg_ctrl_n|vout.P0.nSD VDD.$711.Metal2 0.00264782f
Cred_3983 di_tg_ctrl|di_tg_ctrl_n|vout.P0.nSD VDD.$712.Metal2 0.00306972f
Cred_3984 di_tg_ctrl|di_tg_ctrl_n|vout.P0.nSD VDD.$713.Metal2 0.0026115f
Cred_3985 di_tg_ctrl|di_tg_ctrl_n|vout.P0.nSD VDD.$714.Metal2 0.00393628f
Cred_3986 di_tg_ctrl|di_tg_ctrl_n|vout.P0.nSD VDD.$734.Metal2 2.35855e-05f
Cred_3987 di_tg_ctrl|di_tg_ctrl_n|vout.P0.nSD VDD.$738.Metal2 4.46344e-05f
Cred_3988 di_tg_ctrl|di_tg_ctrl_n|vout.P0.nSD VDD.$746.Metal2 2.4682e-05f
Cred_3989 di_tg_ctrl|di_tg_ctrl_n|vout.P0.nSD VDD.$754.Metal2 6.33876e-07f
Cred_3990 di_tg_ctrl|di_tg_ctrl_n|vout.P0.nSD VDD.$864.Metal3 1.66732e-06f
Cred_3991 di_tg_ctrl|di_tg_ctrl_n|vout.P0.nSD VDD.$868.Metal3 2.54532e-05f
Cred_3992 di_tg_ctrl|di_tg_ctrl_n|vout.P0.nSD VDD.$874.Metal3 0.000320352f
Cred_3993 di_tg_ctrl|di_tg_ctrl_n|vout.P0.nSD VDD.$878.Metal3 0.000316869f
Cred_3994 di_tg_ctrl|di_tg_ctrl_n|vout.P0.nSD VDD.$882.Metal3 0.000206511f
Cred_3995 di_tg_ctrl|di_tg_ctrl_n|vout.P0.nSD VDD.P0.nSD 0.000638015f
Cred_3996 di_tg_ctrl|di_tg_ctrl_n|vout.P0.nSD VDD.P10.pSD 0.00032854f
Cred_3997 di_tg_ctrl|di_tg_ctrl_n|vout.P0.nSD VDD.P11.pSD 1.14988e-06f
Cred_3998 di_tg_ctrl|di_tg_ctrl_n|vout.P0.nSD VDD.P3.GatPoly 5.36203e-09f
Cred_3999 di_tg_ctrl|di_tg_ctrl_n|vout.P0.nSD VDD.P7.pSD 0.000138178f
Cred_4000 di_tg_ctrl|di_tg_ctrl_n|vout.P0.nSD VSS.$114.Metal1 0.00343905f
Cred_4001 di_tg_ctrl|di_tg_ctrl_n|vout.P0.nSD VSS.$127.Metal1 0.0146556f
Cred_4002 di_tg_ctrl|di_tg_ctrl_n|vout.P0.nSD VSS.$129.Metal1 0.016171f
Cred_4003 di_tg_ctrl|di_tg_ctrl_n|vout.P0.nSD VSS.$132.Metal1 1.4195e-06f
Cred_4004 di_tg_ctrl|di_tg_ctrl_n|vout.P0.nSD VSS.$134.Metal1 0.00171075f
Cred_4005 di_tg_ctrl|di_tg_ctrl_n|vout.P0.nSD VSS.$155.Metal1 0.0145471f
Cred_4006 di_tg_ctrl|di_tg_ctrl_n|vout.P0.nSD VSS.$156.Metal1 0.0146361f
Cred_4007 di_tg_ctrl|di_tg_ctrl_n|vout.P0.nSD VSS.$220.Metal1 0.000215243f
Cred_4008 di_tg_ctrl|di_tg_ctrl_n|vout.P0.nSD VSS.$311.Metal2 0.0440418f
Cred_4009 di_tg_ctrl|di_tg_ctrl_n|vout.P0.nSD VSS.$350.Metal2 0.00389362f
Cred_4010 di_tg_ctrl|di_tg_ctrl_n|vout.P0.nSD VSS.$354.Metal2 1.90818e-05f
Cred_4011 di_tg_ctrl|di_tg_ctrl_n|vout.P0.nSD VSS.$359.Metal2 0.0455078f
Cred_4012 di_tg_ctrl|di_tg_ctrl_n|vout.P0.nSD VSS.$368.Metal2 0.000234596f
Cred_4013 di_tg_ctrl|di_tg_ctrl_n|vout.P0.nSD VSS.$372.Metal2 4.38379e-05f
Cred_4014 di_tg_ctrl|di_tg_ctrl_n|vout.P0.nSD VSS.$376.Metal2 1.57208e-06f
Cred_4015 di_tg_ctrl|di_tg_ctrl_n|vout.P0.nSD VSS.$496.Metal3 0.00113964f
Cred_4016 di_tg_ctrl|di_tg_ctrl_n|vout.P0.nSD VSS.$502.Metal3 0.00151725f
Cred_4017 di_tg_ctrl|di_tg_ctrl_n|vout.P0.nSD VSS.$510.Metal3 0.000196074f
Cred_4018 di_tg_ctrl|di_tg_ctrl_n|vout.P0.nSD VSS.$78.Metal1 0.0574519f
Cred_4019 di_tg_ctrl|di_tg_ctrl_n|vout.P0.nSD VSS.$87.Metal1 0.000849082f
Cred_4020 di_tg_ctrl|di_tg_ctrl_n|vout.P0.nSD VSS.P0.pSD 0.000548893f
Cred_4021 di_tg_ctrl|di_tg_ctrl_n|vout.P0.nSD VSS.P10.nSD 3.88931e-06f
Cred_4022 di_tg_ctrl|di_tg_ctrl_n|vout.P0.nSD VSS.P11.nSD 3.88931e-06f
Cred_4023 di_tg_ctrl|di_tg_ctrl_n|vout.P0.nSD VSS.P2.GatPoly 8.22225e-05f
Cred_4024 di_tg_ctrl|di_tg_ctrl_n|vout.P0.nSD VSS.P6.nSD 0.000595976f
Cred_4025 di_tg_ctrl|di_tg_ctrl_n|vout.P0.nSD VSS.P7.nSD 0.000902695f
Cred_4026 di_tg_ctrl|di_tg_ctrl_n|vout.P0.pSD VSS 0.0299061f
Cred_4027 di_tg_ctrl|di_tg_ctrl_n|vout.P0.pSD v_a 0.0889314f
Cred_4028 di_tg_ctrl|di_tg_ctrl_n|vout.P0.pSD v_a.$148.Metal2 0.0715907f
Cred_4029 di_tg_ctrl|di_tg_ctrl_n|vout.P0.pSD v_a.$182.Metal2 0.000227669f
Cred_4030 di_tg_ctrl|di_tg_ctrl_n|vout.P0.pSD v_a.P0.nSD 6.34749e-05f
Cred_4031 di_tg_ctrl|di_tg_ctrl_n|vout.P0.pSD v_a.P0.pSD 0.00431673f
Cred_4032 di_tg_ctrl|di_tg_ctrl_n|vout.P0.pSD v_a.P1.nSD 1.89367e-06f
Cred_4033 di_tg_ctrl|di_tg_ctrl_n|vout.P0.pSD v_a.P1.pSD 0.00116546f
Cred_4034 di_tg_ctrl|di_tg_ctrl_n|vout.P0.pSD v_a.P3.pSD 0.000311538f
Cred_4035 di_tg_ctrl|di_tg_ctrl_n|vout.P0.pSD v_a.P5.pSD 0.000198852f
Cred_4036 di_tg_ctrl|di_tg_ctrl_n|vout.P0.pSD v_b 0.0951393f
Cred_4037 di_tg_ctrl|di_tg_ctrl_n|vout.P0.pSD v_b.$195.Metal2 0.000405915f
Cred_4038 di_tg_ctrl|di_tg_ctrl_n|vout.P0.pSD v_b.P0.pSD 0.000130651f
Cred_4039 di_tg_ctrl|di_tg_ctrl_n|vout.P0.pSD v_b.P1.pSD 0.000141938f
Cred_4040 di_tg_ctrl|di_tg_ctrl_n|vout.P0.pSD v_c.$129.Metal1 1.08513e-06f
Cred_4041 di_tg_ctrl|di_tg_ctrl_n|vout.P0.pSD v_c.$165.Metal1 1.02454e-06f
Cred_4042 di_tg_ctrl|di_tg_ctrl_n|vout.P0.pSD v_c.$220.Metal2 0.000135343f
Cred_4043 di_tg_ctrl|di_tg_ctrl_n|vout.P0.pSD v_c.$224.Metal2 6.13612e-05f
Cred_4044 di_tg_ctrl|di_tg_ctrl_n|vout.P0.pSD v_c.$226.Metal2 8.38274e-05f
Cred_4045 di_tg_ctrl|di_tg_ctrl_n|vout.P0.pSD v_c.$228.Metal2 0.0027631f
Cred_4046 di_tg_ctrl|di_tg_ctrl_n|vout.P0.pSD v_c.$23.Metal1 0.000674551f
Cred_4047 di_tg_ctrl|di_tg_ctrl_n|vout.P0.pSD v_c.$284.Metal2 2.17782e-05f
Cred_4048 di_tg_ctrl|di_tg_ctrl_n|vout.P0.pSD v_c.$288.Metal2 9.53794e-06f
Cred_4049 di_tg_ctrl|di_tg_ctrl_n|vout.P0.pSD v_c.$290.Metal2 1.2974e-05f
Cred_4050 di_tg_ctrl|di_tg_ctrl_n|vout.P0.pSD v_c.$292.Metal2 0.000603404f
Cred_4051 di_tg_ctrl|di_tg_ctrl_n|vout.P0.pSD v_c.$320.Metal2 2.26289e-05f
Cred_4052 di_tg_ctrl|di_tg_ctrl_n|vout.P0.pSD v_c.$322.Metal2 4.60156e-06f
Cred_4053 di_tg_ctrl|di_tg_ctrl_n|vout.P0.pSD v_c.$324.Metal2 6.13132e-06f
Cred_4054 di_tg_ctrl|di_tg_ctrl_n|vout.P0.pSD v_c.$326.Metal2 4.60156e-06f
Cred_4055 di_tg_ctrl|di_tg_ctrl_n|vout.P0.pSD v_c.$352.Metal2 2.13378e-05f
Cred_4056 di_tg_ctrl|di_tg_ctrl_n|vout.P0.pSD v_c.$354.Metal2 3.97632e-06f
Cred_4057 di_tg_ctrl|di_tg_ctrl_n|vout.P0.pSD v_c.$356.Metal2 5.29822e-06f
Cred_4058 di_tg_ctrl|di_tg_ctrl_n|vout.P0.pSD v_c.$358.Metal2 3.97632e-06f
Cred_4059 di_tg_ctrl|di_tg_ctrl_n|vout.P0.pSD v_c.$411.Metal3 0.029464f
Cred_4060 di_tg_ctrl|di_tg_ctrl_n|vout.P0.pSD v_c.$415.Metal3 0.0446221f
Cred_4061 di_tg_ctrl|di_tg_ctrl_n|vout.P0.pSD v_c.$425.Metal3 0.0459705f
Cred_4062 di_tg_ctrl|di_tg_ctrl_n|vout.P0.pSD v_c.$446.Metal3 0.00457322f
Cred_4063 di_tg_ctrl|di_tg_ctrl_n|vout.P0.pSD v_c.$450.Metal3 0.00797371f
Cred_4064 di_tg_ctrl|di_tg_ctrl_n|vout.P0.pSD v_c.$459.Metal3 0.00343859f
Cred_4065 di_tg_ctrl|di_tg_ctrl_n|vout.P0.pSD v_c.$464.Metal3 0.00211093f
Cred_4066 di_tg_ctrl|di_tg_ctrl_n|vout.P0.pSD v_c.$468.Metal3 0.000864106f
Cred_4067 di_tg_ctrl|di_tg_ctrl_n|vout.P0.pSD v_c.$476.Metal3 0.00214292f
Cred_4068 di_tg_ctrl|di_tg_ctrl_n|vout.P0.pSD v_c.$481.Metal3 0.00190552f
Cred_4069 di_tg_ctrl|di_tg_ctrl_n|vout.P0.pSD v_c.$485.Metal3 0.000495937f
Cred_4070 di_tg_ctrl|di_tg_ctrl_n|vout.P0.pSD v_c.$95.Metal1 0.000151393f
Cred_4071 di_tg_ctrl|di_tg_ctrl_n|vout.P0.pSD v_c.P0.nSD 1.52592e-05f
Cred_4072 di_tg_ctrl|di_tg_ctrl_n|vout.P0.pSD v_c.P0.pSD 2.08933e-08f
Cred_4073 di_tg_ctrl|di_tg_ctrl_n|vout.P0.pSD v_c.P10.nSD 5.41124e-05f
Cred_4074 di_tg_ctrl|di_tg_ctrl_n|vout.P0.pSD v_c.P10.pSD 0.00011513f
Cred_4075 di_tg_ctrl|di_tg_ctrl_n|vout.P0.pSD v_c.P2.nSD 1.24129e-05f
Cred_4076 di_tg_ctrl|di_tg_ctrl_n|vout.P0.pSD v_c.P2.pSD 1.97371e-08f
Cred_4077 di_tg_ctrl|di_tg_ctrl_n|vout.P0.pSD v_c.P6.nSD 0.000394982f
Cred_4078 di_tg_ctrl|di_tg_ctrl_n|vout.P0.pSD v_c.P6.pSD 0.000509998f
Cred_4079 di_tg_ctrl|di_tg_ctrl_n|vout.P0.pSD v_c.P8.nSD 5.07556e-05f
Cred_4080 di_tg_ctrl|di_tg_ctrl_n|vout.P0.pSD v_c.P8.pSD 0.00314349f
Cred_4081 di_tg_ctrl|di_tg_ctrl_n|vout.P0.pSD VDD.$215.Metal1 0.000351219f
Cred_4082 di_tg_ctrl|di_tg_ctrl_n|vout.P0.pSD VDD.$257.Metal1 0.00235804f
Cred_4083 di_tg_ctrl|di_tg_ctrl_n|vout.P0.pSD VDD.$279.Metal1 0.0812295f
Cred_4084 di_tg_ctrl|di_tg_ctrl_n|vout.P0.pSD VDD.$281.Metal1 0.0496365f
Cred_4085 di_tg_ctrl|di_tg_ctrl_n|vout.P0.pSD VDD.$283.Metal1 0.0495875f
Cred_4086 di_tg_ctrl|di_tg_ctrl_n|vout.P0.pSD VDD.$285.Metal1 0.0373347f
Cred_4087 di_tg_ctrl|di_tg_ctrl_n|vout.P0.pSD VDD.$286.Metal1 0.0372063f
Cred_4088 di_tg_ctrl|di_tg_ctrl_n|vout.P0.pSD VDD.$288.Metal1 0.0616839f
Cred_4089 di_tg_ctrl|di_tg_ctrl_n|vout.P0.pSD VDD.$29.Metal1 9.51105e-05f
Cred_4090 di_tg_ctrl|di_tg_ctrl_n|vout.P0.pSD VDD.$291.Metal1 0.0950849f
Cred_4091 di_tg_ctrl|di_tg_ctrl_n|vout.P0.pSD VDD.$298.Metal1 0.00705546f
Cred_4092 di_tg_ctrl|di_tg_ctrl_n|vout.P0.pSD VDD.$320.Metal1 0.0786643f
Cred_4093 di_tg_ctrl|di_tg_ctrl_n|vout.P0.pSD VDD.$322.Metal1 0.0465647f
Cred_4094 di_tg_ctrl|di_tg_ctrl_n|vout.P0.pSD VDD.$324.Metal1 0.0465199f
Cred_4095 di_tg_ctrl|di_tg_ctrl_n|vout.P0.pSD VDD.$326.Metal1 0.0350251f
Cred_4096 di_tg_ctrl|di_tg_ctrl_n|vout.P0.pSD VDD.$327.Metal1 0.0349047f
Cred_4097 di_tg_ctrl|di_tg_ctrl_n|vout.P0.pSD VDD.$329.Metal1 0.0578621f
Cred_4098 di_tg_ctrl|di_tg_ctrl_n|vout.P0.pSD VDD.$332.Metal1 0.0891876f
Cred_4099 di_tg_ctrl|di_tg_ctrl_n|vout.P0.pSD VDD.$339.Metal1 0.00235804f
Cred_4100 di_tg_ctrl|di_tg_ctrl_n|vout.P0.pSD VDD.$359.Metal1 0.00056982f
Cred_4101 di_tg_ctrl|di_tg_ctrl_n|vout.P0.pSD VDD.$378.Metal1 2.42953e-05f
Cred_4102 di_tg_ctrl|di_tg_ctrl_n|vout.P0.pSD VDD.$382.Metal1 0.0126734f
Cred_4103 di_tg_ctrl|di_tg_ctrl_n|vout.P0.pSD VDD.$405.Metal1 3.42544e-05f
Cred_4104 di_tg_ctrl|di_tg_ctrl_n|vout.P0.pSD VDD.$477.Metal1 5.93328e-06f
Cred_4105 di_tg_ctrl|di_tg_ctrl_n|vout.P0.pSD VDD.$526.Metal1 1.4778e-06f
Cred_4106 di_tg_ctrl|di_tg_ctrl_n|vout.P0.pSD VDD.$573.Metal2 0.000165393f
Cred_4107 di_tg_ctrl|di_tg_ctrl_n|vout.P0.pSD VDD.$606.Metal2 0.0454644f
Cred_4108 di_tg_ctrl|di_tg_ctrl_n|vout.P0.pSD VDD.$607.Metal2 0.0334384f
Cred_4109 di_tg_ctrl|di_tg_ctrl_n|vout.P0.pSD VDD.$608.Metal2 0.0339823f
Cred_4110 di_tg_ctrl|di_tg_ctrl_n|vout.P0.pSD VDD.$609.Metal2 0.0340128f
Cred_4111 di_tg_ctrl|di_tg_ctrl_n|vout.P0.pSD VDD.$610.Metal2 0.0344984f
Cred_4112 di_tg_ctrl|di_tg_ctrl_n|vout.P0.pSD VDD.$611.Metal2 0.0351606f
Cred_4113 di_tg_ctrl|di_tg_ctrl_n|vout.P0.pSD VDD.$612.Metal2 0.0360708f
Cred_4114 di_tg_ctrl|di_tg_ctrl_n|vout.P0.pSD VDD.$613.Metal2 0.0350889f
Cred_4115 di_tg_ctrl|di_tg_ctrl_n|vout.P0.pSD VDD.$614.Metal2 0.0354314f
Cred_4116 di_tg_ctrl|di_tg_ctrl_n|vout.P0.pSD VDD.$615.Metal2 0.0353937f
Cred_4117 di_tg_ctrl|di_tg_ctrl_n|vout.P0.pSD VDD.$616.Metal2 0.0359711f
Cred_4118 di_tg_ctrl|di_tg_ctrl_n|vout.P0.pSD VDD.$617.Metal2 0.0359969f
Cred_4119 di_tg_ctrl|di_tg_ctrl_n|vout.P0.pSD VDD.$618.Metal2 0.0359834f
Cred_4120 di_tg_ctrl|di_tg_ctrl_n|vout.P0.pSD VDD.$619.Metal2 0.0490855f
Cred_4121 di_tg_ctrl|di_tg_ctrl_n|vout.P0.pSD VDD.$620.Metal2 0.0002617f
Cred_4122 di_tg_ctrl|di_tg_ctrl_n|vout.P0.pSD VDD.$688.Metal2 0.00504882f
Cred_4123 di_tg_ctrl|di_tg_ctrl_n|vout.P0.pSD VDD.$696.Metal2 0.00504882f
Cred_4124 di_tg_ctrl|di_tg_ctrl_n|vout.P0.pSD VDD.$703.Metal2 0.140409f
Cred_4125 di_tg_ctrl|di_tg_ctrl_n|vout.P0.pSD VDD.$704.Metal2 0.0390481f
Cred_4126 di_tg_ctrl|di_tg_ctrl_n|vout.P0.pSD VDD.$705.Metal2 0.0397523f
Cred_4127 di_tg_ctrl|di_tg_ctrl_n|vout.P0.pSD VDD.$706.Metal2 0.0408413f
Cred_4128 di_tg_ctrl|di_tg_ctrl_n|vout.P0.pSD VDD.$707.Metal2 0.0409051f
Cred_4129 di_tg_ctrl|di_tg_ctrl_n|vout.P0.pSD VDD.$708.Metal2 0.0468753f
Cred_4130 di_tg_ctrl|di_tg_ctrl_n|vout.P0.pSD VDD.$709.Metal2 0.0369228f
Cred_4131 di_tg_ctrl|di_tg_ctrl_n|vout.P0.pSD VDD.$710.Metal2 0.0362639f
Cred_4132 di_tg_ctrl|di_tg_ctrl_n|vout.P0.pSD VDD.$711.Metal2 0.0369863f
Cred_4133 di_tg_ctrl|di_tg_ctrl_n|vout.P0.pSD VDD.$712.Metal2 0.0391849f
Cred_4134 di_tg_ctrl|di_tg_ctrl_n|vout.P0.pSD VDD.$713.Metal2 0.0368443f
Cred_4135 di_tg_ctrl|di_tg_ctrl_n|vout.P0.pSD VDD.$714.Metal2 0.0518978f
Cred_4136 di_tg_ctrl|di_tg_ctrl_n|vout.P0.pSD VDD.$734.Metal2 0.000122431f
Cred_4137 di_tg_ctrl|di_tg_ctrl_n|vout.P0.pSD VDD.$738.Metal2 0.000231694f
Cred_4138 di_tg_ctrl|di_tg_ctrl_n|vout.P0.pSD VDD.$746.Metal2 0.000128123f
Cred_4139 di_tg_ctrl|di_tg_ctrl_n|vout.P0.pSD VDD.$754.Metal2 3.29041e-06f
Cred_4140 di_tg_ctrl|di_tg_ctrl_n|vout.P0.pSD VDD.$864.Metal3 4.03345e-05f
Cred_4141 di_tg_ctrl|di_tg_ctrl_n|vout.P0.pSD VDD.$868.Metal3 0.000132126f
Cred_4142 di_tg_ctrl|di_tg_ctrl_n|vout.P0.pSD VDD.$874.Metal3 0.00166293f
Cred_4143 di_tg_ctrl|di_tg_ctrl_n|vout.P0.pSD VDD.$878.Metal3 0.00164485f
Cred_4144 di_tg_ctrl|di_tg_ctrl_n|vout.P0.pSD VDD.$882.Metal3 0.00107199f
Cred_4145 di_tg_ctrl|di_tg_ctrl_n|vout.P0.pSD VDD.P0.nSD 0.00332451f
Cred_4146 di_tg_ctrl|di_tg_ctrl_n|vout.P0.pSD VDD.P10.pSD 0.00455809f
Cred_4147 di_tg_ctrl|di_tg_ctrl_n|vout.P0.pSD VDD.P11.pSD 1.09285e-05f
Cred_4148 di_tg_ctrl|di_tg_ctrl_n|vout.P0.pSD VDD.P3.GatPoly 2.7834e-08f
Cred_4149 di_tg_ctrl|di_tg_ctrl_n|vout.P0.pSD VDD.P7.pSD 0.00369616f
Cred_4150 di_tg_ctrl|di_tg_ctrl_n|vout.P0.pSD VSS.$114.Metal1 0.000690115f
Cred_4151 di_tg_ctrl|di_tg_ctrl_n|vout.P0.pSD VSS.$127.Metal1 0.002943f
Cred_4152 di_tg_ctrl|di_tg_ctrl_n|vout.P0.pSD VSS.$129.Metal1 0.0115311f
Cred_4153 di_tg_ctrl|di_tg_ctrl_n|vout.P0.pSD VSS.$132.Metal1 7.36852e-06f
Cred_4154 di_tg_ctrl|di_tg_ctrl_n|vout.P0.pSD VSS.$134.Metal1 0.000343297f
Cred_4155 di_tg_ctrl|di_tg_ctrl_n|vout.P0.pSD VSS.$155.Metal1 0.00293352f
Cred_4156 di_tg_ctrl|di_tg_ctrl_n|vout.P0.pSD VSS.$156.Metal1 0.00305619f
Cred_4157 di_tg_ctrl|di_tg_ctrl_n|vout.P0.pSD VSS.$220.Metal1 0.00111731f
Cred_4158 di_tg_ctrl|di_tg_ctrl_n|vout.P0.pSD VSS.$311.Metal2 0.0363933f
Cred_4159 di_tg_ctrl|di_tg_ctrl_n|vout.P0.pSD VSS.$350.Metal2 0.00199569f
Cred_4160 di_tg_ctrl|di_tg_ctrl_n|vout.P0.pSD VSS.$354.Metal2 2.74678e-05f
Cred_4161 di_tg_ctrl|di_tg_ctrl_n|vout.P0.pSD VSS.$359.Metal2 0.0563083f
Cred_4162 di_tg_ctrl|di_tg_ctrl_n|vout.P0.pSD VSS.$368.Metal2 0.00121777f
Cred_4163 di_tg_ctrl|di_tg_ctrl_n|vout.P0.pSD VSS.$372.Metal2 0.00022756f
Cred_4164 di_tg_ctrl|di_tg_ctrl_n|vout.P0.pSD VSS.$376.Metal2 8.16055e-06f
Cred_4165 di_tg_ctrl|di_tg_ctrl_n|vout.P0.pSD VSS.$496.Metal3 0.00447888f
Cred_4166 di_tg_ctrl|di_tg_ctrl_n|vout.P0.pSD VSS.$502.Metal3 0.00716034f
Cred_4167 di_tg_ctrl|di_tg_ctrl_n|vout.P0.pSD VSS.$510.Metal3 0.00101781f
Cred_4168 di_tg_ctrl|di_tg_ctrl_n|vout.P0.pSD VSS.$78.Metal1 0.0117101f
Cred_4169 di_tg_ctrl|di_tg_ctrl_n|vout.P0.pSD VSS.$87.Metal1 0.00440753f
Cred_4170 di_tg_ctrl|di_tg_ctrl_n|vout.P0.pSD VSS.P0.pSD 0.0028152f
Cred_4171 di_tg_ctrl|di_tg_ctrl_n|vout.P0.pSD VSS.P10.nSD 7.82042e-07f
Cred_4172 di_tg_ctrl|di_tg_ctrl_n|vout.P0.pSD VSS.P11.nSD 7.82042e-07f
Cred_4173 di_tg_ctrl|di_tg_ctrl_n|vout.P0.pSD VSS.P2.GatPoly 1.66879e-05f
Cred_4174 di_tg_ctrl|di_tg_ctrl_n|vout.P0.pSD VSS.P6.nSD 0.000121475f
Cred_4175 di_tg_ctrl|di_tg_ctrl_n|vout.P0.pSD VSS.P7.nSD 0.000182319f
Cred_4176 di_tg_ctrl|di_tg_ctrl_n|vout.P1.GatPoly VSS 0.0128857f
Cred_4177 di_tg_ctrl|di_tg_ctrl_n|vout.P1.GatPoly v_a.$148.Metal2 0.00401816f
Cred_4178 di_tg_ctrl|di_tg_ctrl_n|vout.P1.GatPoly v_a.$182.Metal2 0.00401816f
Cred_4179 di_tg_ctrl|di_tg_ctrl_n|vout.P1.GatPoly v_a.P1.nSD 0.00450125f
Cred_4180 di_tg_ctrl|di_tg_ctrl_n|vout.P1.GatPoly v_a.P1.pSD 0.000127879f
Cred_4181 di_tg_ctrl|di_tg_ctrl_n|vout.P1.GatPoly v_c.$220.Metal2 5.60863e-06f
Cred_4182 di_tg_ctrl|di_tg_ctrl_n|vout.P1.GatPoly v_c.$411.Metal3 0.000699524f
Cred_4183 di_tg_ctrl|di_tg_ctrl_n|vout.P1.GatPoly v_c.$425.Metal3 0.00417904f
Cred_4184 di_tg_ctrl|di_tg_ctrl_n|vout.P1.GatPoly v_c.P6.nSD 0.00606353f
Cred_4185 di_tg_ctrl|di_tg_ctrl_n|vout.P1.GatPoly VSS.$129.Metal1 0.000854254f
Cred_4186 di_tg_ctrl|di_tg_ctrl_n|vout.P1.GatPoly VSS.$220.Metal1 0.000783915f
Cred_4187 di_tg_ctrl|di_tg_ctrl_n|vout.P1.GatPoly VSS.$87.Metal1 0.000180224f
Cred_4188 di_tg_ctrl|di_tg_ctrl_n|vout.P1.GatPoly VSS.P0.pSD 0.000574977f
Cred_4189 di_tg_ctrl|di_tg_ctrl_n|vout.P1.GatPoly VSS.P3.GatPoly 0.00203485f
Cred_4190 di_tg_ctrl|di_tg_ctrl_n|vout.P10.GatPoly v_b 0.00190169f
Cred_4191 di_tg_ctrl|di_tg_ctrl_n|vout.P10.GatPoly v_b.$161.Metal2 0.0148999f
Cred_4192 di_tg_ctrl|di_tg_ctrl_n|vout.P10.GatPoly v_b.$195.Metal2 0.0155307f
Cred_4193 di_tg_ctrl|di_tg_ctrl_n|vout.P10.GatPoly v_b.P3.nSD 0.000123933f
Cred_4194 di_tg_ctrl|di_tg_ctrl_n|vout.P10.GatPoly v_b.P3.pSD 0.0332388f
Cred_4195 di_tg_ctrl|di_tg_ctrl_n|vout.P10.GatPoly v_c.$201.Metal1 0.0273961f
Cred_4196 di_tg_ctrl|di_tg_ctrl_n|vout.P10.GatPoly v_c.$203.Metal1 0.00787425f
Cred_4197 di_tg_ctrl|di_tg_ctrl_n|vout.P10.GatPoly v_c.$205.Metal1 0.00786109f
Cred_4198 di_tg_ctrl|di_tg_ctrl_n|vout.P10.GatPoly v_c.$207.Metal1 0.00591403f
Cred_4199 di_tg_ctrl|di_tg_ctrl_n|vout.P10.GatPoly v_c.$208.Metal1 0.0131158f
Cred_4200 di_tg_ctrl|di_tg_ctrl_n|vout.P10.GatPoly v_c.$384.Metal2 0.00167914f
Cred_4201 di_tg_ctrl|di_tg_ctrl_n|vout.P10.GatPoly v_c.$386.Metal2 2.26676e-06f
Cred_4202 di_tg_ctrl|di_tg_ctrl_n|vout.P10.GatPoly v_c.$388.Metal2 3.95746e-05f
Cred_4203 di_tg_ctrl|di_tg_ctrl_n|vout.P10.GatPoly v_c.$390.Metal2 1.97047e-05f
Cred_4204 di_tg_ctrl|di_tg_ctrl_n|vout.P10.GatPoly v_c.$392.Metal2 3.34227e-05f
Cred_4205 di_tg_ctrl|di_tg_ctrl_n|vout.P10.GatPoly v_c.$394.Metal2 9.91131e-06f
Cred_4206 di_tg_ctrl|di_tg_ctrl_n|vout.P10.GatPoly v_c.$396.Metal2 0.000146759f
Cred_4207 di_tg_ctrl|di_tg_ctrl_n|vout.P10.GatPoly v_c.$398.Metal2 0.00126302f
Cred_4208 di_tg_ctrl|di_tg_ctrl_n|vout.P10.GatPoly v_c.$493.Metal3 0.0022536f
Cred_4209 di_tg_ctrl|di_tg_ctrl_n|vout.P10.GatPoly v_c.$498.Metal3 0.000853563f
Cred_4210 di_tg_ctrl|di_tg_ctrl_n|vout.P10.GatPoly v_c.$506.Metal3 0.000127007f
Cred_4211 di_tg_ctrl|di_tg_ctrl_n|vout.P10.GatPoly v_c.P4.pSD 0.00180054f
Cred_4212 di_tg_ctrl|di_tg_ctrl_n|vout.P10.GatPoly VDD.$382.Metal1 0.000342136f
Cred_4213 di_tg_ctrl|di_tg_ctrl_n|vout.P10.GatPoly VDD.$477.Metal1 0.000178963f
Cred_4214 di_tg_ctrl|di_tg_ctrl_n|vout.P10.GatPoly VDD.$526.Metal1 0.000347932f
Cred_4215 di_tg_ctrl|di_tg_ctrl_n|vout.P10.GatPoly VDD.P0.nSD 0.00312492f
Cred_4216 di_tg_ctrl|di_tg_ctrl_n|vout.P11.GatPoly VSS 0.00239687f
Cred_4217 di_tg_ctrl|di_tg_ctrl_n|vout.P11.GatPoly v_b 0.00246658f
Cred_4218 di_tg_ctrl|di_tg_ctrl_n|vout.P11.GatPoly v_b.$195.Metal2 0.0347511f
Cred_4219 di_tg_ctrl|di_tg_ctrl_n|vout.P11.GatPoly v_b.P5.pSD 0.0330689f
Cred_4220 di_tg_ctrl|di_tg_ctrl_n|vout.P11.GatPoly v_c.$201.Metal1 0.0257983f
Cred_4221 di_tg_ctrl|di_tg_ctrl_n|vout.P11.GatPoly v_c.$203.Metal1 0.00787425f
Cred_4222 di_tg_ctrl|di_tg_ctrl_n|vout.P11.GatPoly v_c.$205.Metal1 0.00786109f
Cred_4223 di_tg_ctrl|di_tg_ctrl_n|vout.P11.GatPoly v_c.$207.Metal1 0.00598293f
Cred_4224 di_tg_ctrl|di_tg_ctrl_n|vout.P11.GatPoly v_c.$208.Metal1 0.0133674f
Cred_4225 di_tg_ctrl|di_tg_ctrl_n|vout.P11.GatPoly v_c.$384.Metal2 0.00162505f
Cred_4226 di_tg_ctrl|di_tg_ctrl_n|vout.P11.GatPoly v_c.$386.Metal2 2.26676e-06f
Cred_4227 di_tg_ctrl|di_tg_ctrl_n|vout.P11.GatPoly v_c.$388.Metal2 3.95746e-05f
Cred_4228 di_tg_ctrl|di_tg_ctrl_n|vout.P11.GatPoly v_c.$390.Metal2 1.97047e-05f
Cred_4229 di_tg_ctrl|di_tg_ctrl_n|vout.P11.GatPoly v_c.$392.Metal2 3.34227e-05f
Cred_4230 di_tg_ctrl|di_tg_ctrl_n|vout.P11.GatPoly v_c.$394.Metal2 9.91131e-06f
Cred_4231 di_tg_ctrl|di_tg_ctrl_n|vout.P11.GatPoly v_c.$396.Metal2 0.000150567f
Cred_4232 di_tg_ctrl|di_tg_ctrl_n|vout.P11.GatPoly v_c.$398.Metal2 0.00136247f
Cred_4233 di_tg_ctrl|di_tg_ctrl_n|vout.P11.GatPoly v_c.$493.Metal3 0.00225271f
Cred_4234 di_tg_ctrl|di_tg_ctrl_n|vout.P11.GatPoly v_c.$498.Metal3 0.000851561f
Cred_4235 di_tg_ctrl|di_tg_ctrl_n|vout.P11.GatPoly v_c.$506.Metal3 0.000172128f
Cred_4236 di_tg_ctrl|di_tg_ctrl_n|vout.P11.GatPoly v_c.P4.pSD 0.00181235f
Cred_4237 di_tg_ctrl|di_tg_ctrl_n|vout.P11.GatPoly VDD.$382.Metal1 0.000945194f
Cred_4238 di_tg_ctrl|di_tg_ctrl_n|vout.P11.GatPoly VDD.$477.Metal1 0.000494407f
Cred_4239 di_tg_ctrl|di_tg_ctrl_n|vout.P11.GatPoly VDD.$507.Metal1 6.71567e-06f
Cred_4240 di_tg_ctrl|di_tg_ctrl_n|vout.P11.GatPoly VDD.$511.Metal1 0.000112575f
Cred_4241 di_tg_ctrl|di_tg_ctrl_n|vout.P11.GatPoly VDD.$519.Metal1 7.72315e-05f
Cred_4242 di_tg_ctrl|di_tg_ctrl_n|vout.P11.GatPoly VDD.$526.Metal1 0.00114987f
Cred_4243 di_tg_ctrl|di_tg_ctrl_n|vout.P11.GatPoly VDD.$814.Metal2 7.20321e-09f
Cred_4244 di_tg_ctrl|di_tg_ctrl_n|vout.P11.GatPoly VDD.$822.Metal2 3.86869e-07f
Cred_4245 di_tg_ctrl|di_tg_ctrl_n|vout.P11.GatPoly VDD.$826.Metal2 1.23438e-07f
Cred_4246 di_tg_ctrl|di_tg_ctrl_n|vout.P11.GatPoly VDD.$912.Metal3 5.77537e-11f
Cred_4247 di_tg_ctrl|di_tg_ctrl_n|vout.P11.GatPoly VDD.P0.nSD 0.00943121f
Cred_4248 di_tg_ctrl|di_tg_ctrl_n|vout.P2.GatPoly VSS 0.0147086f
Cred_4249 di_tg_ctrl|di_tg_ctrl_n|vout.P2.GatPoly v_a.$148.Metal2 0.00389838f
Cred_4250 di_tg_ctrl|di_tg_ctrl_n|vout.P2.GatPoly v_a.$182.Metal2 0.00389838f
Cred_4251 di_tg_ctrl|di_tg_ctrl_n|vout.P2.GatPoly v_a.P1.nSD 0.00427977f
Cred_4252 di_tg_ctrl|di_tg_ctrl_n|vout.P2.GatPoly v_a.P1.pSD 0.000124067f
Cred_4253 di_tg_ctrl|di_tg_ctrl_n|vout.P2.GatPoly v_c.$425.Metal3 0.00522249f
Cred_4254 di_tg_ctrl|di_tg_ctrl_n|vout.P2.GatPoly v_c.P8.nSD 0.00649095f
Cred_4255 di_tg_ctrl|di_tg_ctrl_n|vout.P2.GatPoly VSS.$129.Metal1 0.000711595f
Cred_4256 di_tg_ctrl|di_tg_ctrl_n|vout.P2.GatPoly VSS.$181.Metal1 0.000143925f
Cred_4257 di_tg_ctrl|di_tg_ctrl_n|vout.P2.GatPoly VSS.$185.Metal1 0.000116323f
Cred_4258 di_tg_ctrl|di_tg_ctrl_n|vout.P2.GatPoly VSS.$220.Metal1 0.000857053f
Cred_4259 di_tg_ctrl|di_tg_ctrl_n|vout.P2.GatPoly VSS.$392.Metal2 3.96003e-07f
Cred_4260 di_tg_ctrl|di_tg_ctrl_n|vout.P2.GatPoly VSS.$400.Metal2 3.96003e-07f
Cred_4261 di_tg_ctrl|di_tg_ctrl_n|vout.P2.GatPoly VSS.$518.Metal3 3.17506e-09f
Cred_4262 di_tg_ctrl|di_tg_ctrl_n|vout.P2.GatPoly VSS.$87.Metal1 0.000150127f
Cred_4263 di_tg_ctrl|di_tg_ctrl_n|vout.P2.GatPoly VSS.P0.pSD 0.000536875f
Cred_4264 di_tg_ctrl|di_tg_ctrl_n|vout.P2.GatPoly VSS.P3.GatPoly 0.001728f
Cred_4265 di_tg_ctrl|di_tg_ctrl_n|vout.P3.GatPoly VSS 0.0134859f
Cred_4266 di_tg_ctrl|di_tg_ctrl_n|vout.P3.GatPoly v_a.$182.Metal2 0.0082325f
Cred_4267 di_tg_ctrl|di_tg_ctrl_n|vout.P3.GatPoly v_a.P3.nSD 0.00449935f
Cred_4268 di_tg_ctrl|di_tg_ctrl_n|vout.P3.GatPoly v_c.$284.Metal2 4.69177e-09f
Cred_4269 di_tg_ctrl|di_tg_ctrl_n|vout.P3.GatPoly v_c.$425.Metal3 0.0049373f
Cred_4270 di_tg_ctrl|di_tg_ctrl_n|vout.P3.GatPoly v_c.$446.Metal3 5.85171e-07f
Cred_4271 di_tg_ctrl|di_tg_ctrl_n|vout.P3.GatPoly v_c.$459.Metal3 6.91435e-07f
Cred_4272 di_tg_ctrl|di_tg_ctrl_n|vout.P3.GatPoly v_c.P10.nSD 5.50709e-06f
Cred_4273 di_tg_ctrl|di_tg_ctrl_n|vout.P3.GatPoly v_c.P8.nSD 0.00602131f
Cred_4274 di_tg_ctrl|di_tg_ctrl_n|vout.P3.GatPoly VSS.$129.Metal1 0.000541094f
Cred_4275 di_tg_ctrl|di_tg_ctrl_n|vout.P3.GatPoly VSS.$185.Metal1 2.70011e-05f
Cred_4276 di_tg_ctrl|di_tg_ctrl_n|vout.P3.GatPoly VSS.$195.Metal1 2.99852e-05f
Cred_4277 di_tg_ctrl|di_tg_ctrl_n|vout.P3.GatPoly VSS.$220.Metal1 0.00110057f
Cred_4278 di_tg_ctrl|di_tg_ctrl_n|vout.P3.GatPoly VSS.$400.Metal2 2.28471e-08f
Cred_4279 di_tg_ctrl|di_tg_ctrl_n|vout.P3.GatPoly VSS.$404.Metal2 2.31285e-07f
Cred_4280 di_tg_ctrl|di_tg_ctrl_n|vout.P3.GatPoly VSS.$87.Metal1 0.000114156f
Cred_4281 di_tg_ctrl|di_tg_ctrl_n|vout.P3.GatPoly VSS.P0.pSD 0.000503557f
Cred_4282 di_tg_ctrl|di_tg_ctrl_n|vout.P3.GatPoly VSS.P3.GatPoly 0.00150156f
Cred_4283 di_tg_ctrl|di_tg_ctrl_n|vout.P4.GatPoly VSS 0.0134859f
Cred_4284 di_tg_ctrl|di_tg_ctrl_n|vout.P4.GatPoly v_a.$182.Metal2 0.00794709f
Cred_4285 di_tg_ctrl|di_tg_ctrl_n|vout.P4.GatPoly v_a.P3.nSD 0.00424171f
Cred_4286 di_tg_ctrl|di_tg_ctrl_n|vout.P4.GatPoly v_c.$284.Metal2 7.06855e-06f
Cred_4287 di_tg_ctrl|di_tg_ctrl_n|vout.P4.GatPoly v_c.$425.Metal3 0.00310804f
Cred_4288 di_tg_ctrl|di_tg_ctrl_n|vout.P4.GatPoly v_c.$446.Metal3 0.000881609f
Cred_4289 di_tg_ctrl|di_tg_ctrl_n|vout.P4.GatPoly v_c.$459.Metal3 0.0010417f
Cred_4290 di_tg_ctrl|di_tg_ctrl_n|vout.P4.GatPoly v_c.P10.nSD 0.00623364f
Cred_4291 di_tg_ctrl|di_tg_ctrl_n|vout.P4.GatPoly v_c.P8.nSD 5.49471e-06f
Cred_4292 di_tg_ctrl|di_tg_ctrl_n|vout.P4.GatPoly VSS.$129.Metal1 0.000397807f
Cred_4293 di_tg_ctrl|di_tg_ctrl_n|vout.P4.GatPoly VSS.$185.Metal1 2.70011e-05f
Cred_4294 di_tg_ctrl|di_tg_ctrl_n|vout.P4.GatPoly VSS.$195.Metal1 2.99852e-05f
Cred_4295 di_tg_ctrl|di_tg_ctrl_n|vout.P4.GatPoly VSS.$220.Metal1 0.00145683f
Cred_4296 di_tg_ctrl|di_tg_ctrl_n|vout.P4.GatPoly VSS.$400.Metal2 2.28471e-08f
Cred_4297 di_tg_ctrl|di_tg_ctrl_n|vout.P4.GatPoly VSS.$404.Metal2 2.31285e-07f
Cred_4298 di_tg_ctrl|di_tg_ctrl_n|vout.P4.GatPoly VSS.$87.Metal1 8.39263e-05f
Cred_4299 di_tg_ctrl|di_tg_ctrl_n|vout.P4.GatPoly VSS.P0.pSD 0.000454884f
Cred_4300 di_tg_ctrl|di_tg_ctrl_n|vout.P4.GatPoly VSS.P3.GatPoly 0.0013276f
Cred_4301 di_tg_ctrl|di_tg_ctrl_n|vout.P5.GatPoly VSS 0.0201187f
Cred_4302 di_tg_ctrl|di_tg_ctrl_n|vout.P5.GatPoly v_a.$182.Metal2 0.00833016f
Cred_4303 di_tg_ctrl|di_tg_ctrl_n|vout.P5.GatPoly v_a.P3.nSD 1.85225e-06f
Cred_4304 di_tg_ctrl|di_tg_ctrl_n|vout.P5.GatPoly v_a.P5.nSD 0.00515208f
Cred_4305 di_tg_ctrl|di_tg_ctrl_n|vout.P5.GatPoly v_a.P5.pSD 0.000221347f
Cred_4306 di_tg_ctrl|di_tg_ctrl_n|vout.P5.GatPoly v_c.$284.Metal2 7.92125e-06f
Cred_4307 di_tg_ctrl|di_tg_ctrl_n|vout.P5.GatPoly v_c.$425.Metal3 0.00347922f
Cred_4308 di_tg_ctrl|di_tg_ctrl_n|vout.P5.GatPoly v_c.$446.Metal3 0.000987961f
Cred_4309 di_tg_ctrl|di_tg_ctrl_n|vout.P5.GatPoly v_c.$459.Metal3 0.00116737f
Cred_4310 di_tg_ctrl|di_tg_ctrl_n|vout.P5.GatPoly v_c.P10.nSD 0.00723214f
Cred_4311 di_tg_ctrl|di_tg_ctrl_n|vout.P5.GatPoly VSS.$129.Metal1 0.000571994f
Cred_4312 di_tg_ctrl|di_tg_ctrl_n|vout.P5.GatPoly VSS.$185.Metal1 5.54017e-06f
Cred_4313 di_tg_ctrl|di_tg_ctrl_n|vout.P5.GatPoly VSS.$195.Metal1 0.000305333f
Cred_4314 di_tg_ctrl|di_tg_ctrl_n|vout.P5.GatPoly VSS.$199.Metal1 0.000144207f
Cred_4315 di_tg_ctrl|di_tg_ctrl_n|vout.P5.GatPoly VSS.$209.Metal1 2.99564e-06f
Cred_4316 di_tg_ctrl|di_tg_ctrl_n|vout.P5.GatPoly VSS.$211.Metal1 1.24636e-05f
Cred_4317 di_tg_ctrl|di_tg_ctrl_n|vout.P5.GatPoly VSS.$220.Metal1 0.00294171f
Cred_4318 di_tg_ctrl|di_tg_ctrl_n|vout.P5.GatPoly VSS.$400.Metal2 4.68784e-09f
Cred_4319 di_tg_ctrl|di_tg_ctrl_n|vout.P5.GatPoly VSS.$404.Metal2 4.24185e-08f
Cred_4320 di_tg_ctrl|di_tg_ctrl_n|vout.P5.GatPoly VSS.$408.Metal2 2.10562e-06f
Cred_4321 di_tg_ctrl|di_tg_ctrl_n|vout.P5.GatPoly VSS.$416.Metal2 8.88525e-07f
Cred_4322 di_tg_ctrl|di_tg_ctrl_n|vout.P5.GatPoly VSS.$522.Metal3 2.30446e-08f
Cred_4323 di_tg_ctrl|di_tg_ctrl_n|vout.P5.GatPoly VSS.$530.Metal3 2.30446e-08f
Cred_4324 di_tg_ctrl|di_tg_ctrl_n|vout.P5.GatPoly VSS.$87.Metal1 0.000120675f
Cred_4325 di_tg_ctrl|di_tg_ctrl_n|vout.P5.GatPoly VSS.P0.pSD 0.000717189f
Cred_4326 di_tg_ctrl|di_tg_ctrl_n|vout.P5.GatPoly VSS.P3.GatPoly 0.00127455f
Cred_4327 di_tg_ctrl|di_tg_ctrl_n|vout.P6.GatPoly VSS 0.000175773f
Cred_4328 di_tg_ctrl|di_tg_ctrl_n|vout.P6.GatPoly v_b 0.00813723f
Cred_4329 di_tg_ctrl|di_tg_ctrl_n|vout.P6.GatPoly v_b.$161.Metal2 0.0220764f
Cred_4330 di_tg_ctrl|di_tg_ctrl_n|vout.P6.GatPoly v_b.$195.Metal2 0.00269927f
Cred_4331 di_tg_ctrl|di_tg_ctrl_n|vout.P6.GatPoly v_b.P0.nSD 0.000161585f
Cred_4332 di_tg_ctrl|di_tg_ctrl_n|vout.P6.GatPoly v_b.P0.pSD 0.0350386f
Cred_4333 di_tg_ctrl|di_tg_ctrl_n|vout.P6.GatPoly v_c.$129.Metal1 0.0265209f
Cred_4334 di_tg_ctrl|di_tg_ctrl_n|vout.P6.GatPoly v_c.$131.Metal1 0.00787425f
Cred_4335 di_tg_ctrl|di_tg_ctrl_n|vout.P6.GatPoly v_c.$133.Metal1 0.00786109f
Cred_4336 di_tg_ctrl|di_tg_ctrl_n|vout.P6.GatPoly v_c.$135.Metal1 0.00598293f
Cred_4337 di_tg_ctrl|di_tg_ctrl_n|vout.P6.GatPoly v_c.$136.Metal1 0.0133718f
Cred_4338 di_tg_ctrl|di_tg_ctrl_n|vout.P6.GatPoly v_c.$320.Metal2 0.00164951f
Cred_4339 di_tg_ctrl|di_tg_ctrl_n|vout.P6.GatPoly v_c.$322.Metal2 2.26676e-06f
Cred_4340 di_tg_ctrl|di_tg_ctrl_n|vout.P6.GatPoly v_c.$324.Metal2 3.95746e-05f
Cred_4341 di_tg_ctrl|di_tg_ctrl_n|vout.P6.GatPoly v_c.$326.Metal2 1.97047e-05f
Cred_4342 di_tg_ctrl|di_tg_ctrl_n|vout.P6.GatPoly v_c.$328.Metal2 3.34227e-05f
Cred_4343 di_tg_ctrl|di_tg_ctrl_n|vout.P6.GatPoly v_c.$330.Metal2 9.91131e-06f
Cred_4344 di_tg_ctrl|di_tg_ctrl_n|vout.P6.GatPoly v_c.$332.Metal2 0.000150633f
Cred_4345 di_tg_ctrl|di_tg_ctrl_n|vout.P6.GatPoly v_c.$334.Metal2 0.00136413f
Cred_4346 di_tg_ctrl|di_tg_ctrl_n|vout.P6.GatPoly v_c.$459.Metal3 0.00225311f
Cred_4347 di_tg_ctrl|di_tg_ctrl_n|vout.P6.GatPoly v_c.$464.Metal3 0.000852466f
Cred_4348 di_tg_ctrl|di_tg_ctrl_n|vout.P6.GatPoly v_c.$472.Metal3 0.000172353f
Cred_4349 di_tg_ctrl|di_tg_ctrl_n|vout.P6.GatPoly v_c.P0.pSD 0.00183791f
Cred_4350 di_tg_ctrl|di_tg_ctrl_n|vout.P6.GatPoly VDD.$382.Metal1 0.00160723f
Cred_4351 di_tg_ctrl|di_tg_ctrl_n|vout.P6.GatPoly VDD.$477.Metal1 0.000840702f
Cred_4352 di_tg_ctrl|di_tg_ctrl_n|vout.P6.GatPoly VDD.$484.Metal1 5.20049e-05f
Cred_4353 di_tg_ctrl|di_tg_ctrl_n|vout.P6.GatPoly VDD.$495.Metal1 0.000137312f
Cred_4354 di_tg_ctrl|di_tg_ctrl_n|vout.P6.GatPoly VDD.$499.Metal1 6.71567e-06f
Cred_4355 di_tg_ctrl|di_tg_ctrl_n|vout.P6.GatPoly VDD.$526.Metal1 0.000531312f
Cred_4356 di_tg_ctrl|di_tg_ctrl_n|vout.P6.GatPoly VDD.$798.Metal2 4.01061e-07f
Cred_4357 di_tg_ctrl|di_tg_ctrl_n|vout.P6.GatPoly VDD.$802.Metal2 4.7292e-07f
Cred_4358 di_tg_ctrl|di_tg_ctrl_n|vout.P6.GatPoly VDD.$810.Metal2 7.20321e-09f
Cred_4359 di_tg_ctrl|di_tg_ctrl_n|vout.P6.GatPoly VDD.$906.Metal3 5.77537e-11f
Cred_4360 di_tg_ctrl|di_tg_ctrl_n|vout.P6.GatPoly VDD.P0.nSD 0.00848525f
Cred_4361 di_tg_ctrl|di_tg_ctrl_n|vout.P7.GatPoly v_b 0.00190169f
Cred_4362 di_tg_ctrl|di_tg_ctrl_n|vout.P7.GatPoly v_b.$161.Metal2 0.030398f
Cred_4363 di_tg_ctrl|di_tg_ctrl_n|vout.P7.GatPoly v_b.$195.Metal2 0.000630827f
Cred_4364 di_tg_ctrl|di_tg_ctrl_n|vout.P7.GatPoly v_b.P1.pSD 0.0327646f
Cred_4365 di_tg_ctrl|di_tg_ctrl_n|vout.P7.GatPoly v_c.$129.Metal1 0.0273961f
Cred_4366 di_tg_ctrl|di_tg_ctrl_n|vout.P7.GatPoly v_c.$131.Metal1 0.00787425f
Cred_4367 di_tg_ctrl|di_tg_ctrl_n|vout.P7.GatPoly v_c.$133.Metal1 0.00786109f
Cred_4368 di_tg_ctrl|di_tg_ctrl_n|vout.P7.GatPoly v_c.$135.Metal1 0.00591403f
Cred_4369 di_tg_ctrl|di_tg_ctrl_n|vout.P7.GatPoly v_c.$136.Metal1 0.0131158f
Cred_4370 di_tg_ctrl|di_tg_ctrl_n|vout.P7.GatPoly v_c.$320.Metal2 0.00167914f
Cred_4371 di_tg_ctrl|di_tg_ctrl_n|vout.P7.GatPoly v_c.$322.Metal2 2.26676e-06f
Cred_4372 di_tg_ctrl|di_tg_ctrl_n|vout.P7.GatPoly v_c.$324.Metal2 3.95746e-05f
Cred_4373 di_tg_ctrl|di_tg_ctrl_n|vout.P7.GatPoly v_c.$326.Metal2 1.97047e-05f
Cred_4374 di_tg_ctrl|di_tg_ctrl_n|vout.P7.GatPoly v_c.$328.Metal2 3.34227e-05f
Cred_4375 di_tg_ctrl|di_tg_ctrl_n|vout.P7.GatPoly v_c.$330.Metal2 9.91131e-06f
Cred_4376 di_tg_ctrl|di_tg_ctrl_n|vout.P7.GatPoly v_c.$332.Metal2 0.000146759f
Cred_4377 di_tg_ctrl|di_tg_ctrl_n|vout.P7.GatPoly v_c.$334.Metal2 0.00126302f
Cred_4378 di_tg_ctrl|di_tg_ctrl_n|vout.P7.GatPoly v_c.$459.Metal3 0.0022536f
Cred_4379 di_tg_ctrl|di_tg_ctrl_n|vout.P7.GatPoly v_c.$464.Metal3 0.000853563f
Cred_4380 di_tg_ctrl|di_tg_ctrl_n|vout.P7.GatPoly v_c.$472.Metal3 0.000127007f
Cred_4381 di_tg_ctrl|di_tg_ctrl_n|vout.P7.GatPoly v_c.P0.pSD 0.00180054f
Cred_4382 di_tg_ctrl|di_tg_ctrl_n|vout.P7.GatPoly VDD.$382.Metal1 0.000516342f
Cred_4383 di_tg_ctrl|di_tg_ctrl_n|vout.P7.GatPoly VDD.$477.Metal1 0.000270085f
Cred_4384 di_tg_ctrl|di_tg_ctrl_n|vout.P7.GatPoly VDD.$526.Metal1 0.000208993f
Cred_4385 di_tg_ctrl|di_tg_ctrl_n|vout.P7.GatPoly VDD.P0.nSD 0.00299853f
Cred_4386 di_tg_ctrl|di_tg_ctrl_n|vout.P8.GatPoly VSS 2.03641e-05f
Cred_4387 di_tg_ctrl|di_tg_ctrl_n|vout.P8.GatPoly v_b 0.00190169f
Cred_4388 di_tg_ctrl|di_tg_ctrl_n|vout.P8.GatPoly v_b.$161.Metal2 0.0299547f
Cred_4389 di_tg_ctrl|di_tg_ctrl_n|vout.P8.GatPoly v_b.$195.Metal2 0.000630827f
Cred_4390 di_tg_ctrl|di_tg_ctrl_n|vout.P8.GatPoly v_b.P1.pSD 0.032893f
Cred_4391 di_tg_ctrl|di_tg_ctrl_n|vout.P8.GatPoly v_c.$165.Metal1 0.0273961f
Cred_4392 di_tg_ctrl|di_tg_ctrl_n|vout.P8.GatPoly v_c.$167.Metal1 0.00787425f
Cred_4393 di_tg_ctrl|di_tg_ctrl_n|vout.P8.GatPoly v_c.$169.Metal1 0.00786109f
Cred_4394 di_tg_ctrl|di_tg_ctrl_n|vout.P8.GatPoly v_c.$171.Metal1 0.00591403f
Cred_4395 di_tg_ctrl|di_tg_ctrl_n|vout.P8.GatPoly v_c.$172.Metal1 0.0132303f
Cred_4396 di_tg_ctrl|di_tg_ctrl_n|vout.P8.GatPoly v_c.$352.Metal2 0.00167914f
Cred_4397 di_tg_ctrl|di_tg_ctrl_n|vout.P8.GatPoly v_c.$354.Metal2 2.26676e-06f
Cred_4398 di_tg_ctrl|di_tg_ctrl_n|vout.P8.GatPoly v_c.$356.Metal2 3.95746e-05f
Cred_4399 di_tg_ctrl|di_tg_ctrl_n|vout.P8.GatPoly v_c.$358.Metal2 1.97047e-05f
Cred_4400 di_tg_ctrl|di_tg_ctrl_n|vout.P8.GatPoly v_c.$360.Metal2 3.34227e-05f
Cred_4401 di_tg_ctrl|di_tg_ctrl_n|vout.P8.GatPoly v_c.$362.Metal2 9.91131e-06f
Cred_4402 di_tg_ctrl|di_tg_ctrl_n|vout.P8.GatPoly v_c.$364.Metal2 0.000148493f
Cred_4403 di_tg_ctrl|di_tg_ctrl_n|vout.P8.GatPoly v_c.$366.Metal2 0.00131059f
Cred_4404 di_tg_ctrl|di_tg_ctrl_n|vout.P8.GatPoly v_c.$476.Metal3 0.0022536f
Cred_4405 di_tg_ctrl|di_tg_ctrl_n|vout.P8.GatPoly v_c.$481.Metal3 0.000853563f
Cred_4406 di_tg_ctrl|di_tg_ctrl_n|vout.P8.GatPoly v_c.$489.Metal3 0.000143801f
Cred_4407 di_tg_ctrl|di_tg_ctrl_n|vout.P8.GatPoly v_c.P2.pSD 0.00183624f
Cred_4408 di_tg_ctrl|di_tg_ctrl_n|vout.P8.GatPoly VDD.$382.Metal1 0.000457204f
Cred_4409 di_tg_ctrl|di_tg_ctrl_n|vout.P8.GatPoly VDD.$477.Metal1 0.000239152f
Cred_4410 di_tg_ctrl|di_tg_ctrl_n|vout.P8.GatPoly VDD.$495.Metal1 4.75777e-06f
Cred_4411 di_tg_ctrl|di_tg_ctrl_n|vout.P8.GatPoly VDD.$499.Metal1 9.30868e-06f
Cred_4412 di_tg_ctrl|di_tg_ctrl_n|vout.P8.GatPoly VDD.$526.Metal1 0.000224907f
Cred_4413 di_tg_ctrl|di_tg_ctrl_n|vout.P8.GatPoly VDD.$802.Metal2 9.98446e-09f
Cred_4414 di_tg_ctrl|di_tg_ctrl_n|vout.P8.GatPoly VDD.$810.Metal2 9.98446e-09f
Cred_4415 di_tg_ctrl|di_tg_ctrl_n|vout.P8.GatPoly VDD.$906.Metal3 8.00532e-11f
Cred_4416 di_tg_ctrl|di_tg_ctrl_n|vout.P8.GatPoly VDD.P0.nSD 0.00291063f
Cred_4417 di_tg_ctrl|di_tg_ctrl_n|vout.P9.GatPoly VSS 0.000139177f
Cred_4418 di_tg_ctrl|di_tg_ctrl_n|vout.P9.GatPoly v_b 0.00190169f
Cred_4419 di_tg_ctrl|di_tg_ctrl_n|vout.P9.GatPoly v_b.$161.Metal2 0.0147296f
Cred_4420 di_tg_ctrl|di_tg_ctrl_n|vout.P9.GatPoly v_b.$195.Metal2 0.0153605f
Cred_4421 di_tg_ctrl|di_tg_ctrl_n|vout.P9.GatPoly v_b.P3.nSD 0.000122516f
Cred_4422 di_tg_ctrl|di_tg_ctrl_n|vout.P9.GatPoly v_b.P3.pSD 0.0335543f
Cred_4423 di_tg_ctrl|di_tg_ctrl_n|vout.P9.GatPoly v_c.$165.Metal1 0.0277422f
Cred_4424 di_tg_ctrl|di_tg_ctrl_n|vout.P9.GatPoly v_c.$167.Metal1 0.00787425f
Cred_4425 di_tg_ctrl|di_tg_ctrl_n|vout.P9.GatPoly v_c.$169.Metal1 0.00786109f
Cred_4426 di_tg_ctrl|di_tg_ctrl_n|vout.P9.GatPoly v_c.$171.Metal1 0.00594007f
Cred_4427 di_tg_ctrl|di_tg_ctrl_n|vout.P9.GatPoly v_c.$172.Metal1 0.0134022f
Cred_4428 di_tg_ctrl|di_tg_ctrl_n|vout.P9.GatPoly v_c.$352.Metal2 0.00169086f
Cred_4429 di_tg_ctrl|di_tg_ctrl_n|vout.P9.GatPoly v_c.$354.Metal2 2.26676e-06f
Cred_4430 di_tg_ctrl|di_tg_ctrl_n|vout.P9.GatPoly v_c.$356.Metal2 3.95746e-05f
Cred_4431 di_tg_ctrl|di_tg_ctrl_n|vout.P9.GatPoly v_c.$358.Metal2 1.97047e-05f
Cred_4432 di_tg_ctrl|di_tg_ctrl_n|vout.P9.GatPoly v_c.$360.Metal2 3.34227e-05f
Cred_4433 di_tg_ctrl|di_tg_ctrl_n|vout.P9.GatPoly v_c.$362.Metal2 9.91131e-06f
Cred_4434 di_tg_ctrl|di_tg_ctrl_n|vout.P9.GatPoly v_c.$364.Metal2 0.000151093f
Cred_4435 di_tg_ctrl|di_tg_ctrl_n|vout.P9.GatPoly v_c.$366.Metal2 0.00138193f
Cred_4436 di_tg_ctrl|di_tg_ctrl_n|vout.P9.GatPoly v_c.$476.Metal3 0.00225379f
Cred_4437 di_tg_ctrl|di_tg_ctrl_n|vout.P9.GatPoly v_c.$481.Metal3 0.000853996f
Cred_4438 di_tg_ctrl|di_tg_ctrl_n|vout.P9.GatPoly v_c.$489.Metal3 0.000168989f
Cred_4439 di_tg_ctrl|di_tg_ctrl_n|vout.P9.GatPoly v_c.P2.pSD 0.00190128f
Cred_4440 di_tg_ctrl|di_tg_ctrl_n|vout.P9.GatPoly VDD.$382.Metal1 0.000389585f
Cred_4441 di_tg_ctrl|di_tg_ctrl_n|vout.P9.GatPoly VDD.$477.Metal1 0.000203782f
Cred_4442 di_tg_ctrl|di_tg_ctrl_n|vout.P9.GatPoly VDD.$499.Metal1 2.71093e-05f
Cred_4443 di_tg_ctrl|di_tg_ctrl_n|vout.P9.GatPoly VDD.$507.Metal1 8.82796e-05f
Cred_4444 di_tg_ctrl|di_tg_ctrl_n|vout.P9.GatPoly VDD.$511.Metal1 1.18937e-05f
Cred_4445 di_tg_ctrl|di_tg_ctrl_n|vout.P9.GatPoly VDD.$526.Metal1 0.000275461f
Cred_4446 di_tg_ctrl|di_tg_ctrl_n|vout.P9.GatPoly VDD.$810.Metal2 1.50375e-07f
Cred_4447 di_tg_ctrl|di_tg_ctrl_n|vout.P9.GatPoly VDD.$814.Metal2 3.85567e-07f
Cred_4448 di_tg_ctrl|di_tg_ctrl_n|vout.P9.GatPoly VDD.$822.Metal2 2.49597e-08f
Cred_4449 di_tg_ctrl|di_tg_ctrl_n|vout.P9.GatPoly VDD.$912.Metal3 2.00122e-10f
Cred_4450 di_tg_ctrl|di_tg_ctrl_n|vout.P9.GatPoly VDD.P0.nSD 0.00296315f
Cred_4451 VSS v_a 0.11298f
Cred_4452 VSS v_a.$148.Metal2 0.0993251f
Cred_4453 VSS v_a.$182.Metal2 0.109867f
Cred_4454 VSS v_a.P0.nSD 0.00977955f
Cred_4455 VSS v_a.P1.nSD 0.00230876f
Cred_4456 VSS v_a.P1.pSD 0.000534409f
Cred_4457 VSS v_a.P3.nSD 0.00216909f
Cred_4458 VSS v_a.P5.nSD 0.0111458f
Cred_4459 VSS v_a.P5.pSD 0.00158856f
Cred_4460 VSS v_b 0.118682f
Cred_4461 VSS v_b.$161.Metal2 0.109931f
Cred_4462 VSS v_b.$195.Metal2 0.37476f
Cred_4463 VSS v_b.P0.nSD 0.0111415f
Cred_4464 VSS v_b.P0.pSD 0.00158724f
Cred_4465 VSS v_b.P1.nSD 0.00217327f
Cred_4466 VSS v_b.P3.nSD 0.00231325f
Cred_4467 VSS v_b.P3.pSD 0.000535599f
Cred_4468 VSS v_b.P5.nSD 0.011651f
Cred_4469 VSS v_b.P5.pSD 0.0481647f
Cred_4470 VSS v_c 0.057946f
Cred_4471 VSS v_c.$201.Metal1 7.40565e-06f
Cred_4472 VSS v_c.$220.Metal2 1.77261e-05f
Cred_4473 VSS v_c.$284.Metal2 5.47331e-05f
Cred_4474 VSS v_c.$384.Metal2 0.000152088f
Cred_4475 VSS v_c.$411.Metal3 0.00221085f
Cred_4476 VSS v_c.$425.Metal3 0.0496704f
Cred_4477 VSS v_c.$446.Metal3 0.00682647f
Cred_4478 VSS v_c.$459.Metal3 0.0474077f
Cred_4479 VSS v_c.$476.Metal3 0.0128557f
Cred_4480 VSS v_c.$493.Metal3 0.0577713f
Cred_4481 VSS v_c.$498.Metal3 0.00694173f
Cred_4482 VSS v_c.P0.nSD 0.0028307f
Cred_4483 VSS v_c.P10.nSD 0.00297176f
Cred_4484 VSS v_c.P2.nSD 0.00274177f
Cred_4485 VSS v_c.P4.nSD 0.00299721f
Cred_4486 VSS v_c.P4.pSD 1.43485e-07f
Cred_4487 VSS v_c.P6.nSD 0.00290928f
Cred_4488 VSS v_c.P8.nSD 0.00273842f
Cred_4489 VSS VDD 0.0457401f
Cred_4490 VSS VDD.$105.Metal1 0.0510641f
Cred_4491 VSS VDD.$113.Metal1 0.0510613f
Cred_4492 VSS VDD.$185.Metal1 0.0563269f
Cred_4493 VSS VDD.$215.Metal1 0.0267496f
Cred_4494 VSS VDD.$218.Metal1 0.0499038f
Cred_4495 VSS VDD.$257.Metal1 0.0510494f
Cred_4496 VSS VDD.$29.Metal1 0.180973f
Cred_4497 VSS VDD.$298.Metal1 0.0510521f
Cred_4498 VSS VDD.$320.Metal1 7.6363e-05f
Cred_4499 VSS VDD.$33.Metal1 0.0383042f
Cred_4500 VSS VDD.$339.Metal1 0.0510486f
Cred_4501 VSS VDD.$359.Metal1 7.6363e-05f
Cred_4502 VSS VDD.$378.Metal1 0.0465383f
Cred_4503 VSS VDD.$382.Metal1 0.0719434f
Cred_4504 VSS VDD.$405.Metal1 0.0451658f
Cred_4505 VSS VDD.$414.Metal1 0.0333883f
Cred_4506 VSS VDD.$418.Metal1 0.0202829f
Cred_4507 VSS VDD.$422.Metal1 0.0202868f
Cred_4508 VSS VDD.$426.Metal1 0.0423361f
Cred_4509 VSS VDD.$434.Metal1 0.0423242f
Cred_4510 VSS VDD.$438.Metal1 0.0202868f
Cred_4511 VSS VDD.$442.Metal1 0.0202829f
Cred_4512 VSS VDD.$446.Metal1 0.0333883f
Cred_4513 VSS VDD.$453.Metal1 0.0418783f
Cred_4514 VSS VDD.$477.Metal1 0.0256407f
Cred_4515 VSS VDD.$484.Metal1 0.0577898f
Cred_4516 VSS VDD.$495.Metal1 0.0397536f
Cred_4517 VSS VDD.$499.Metal1 0.0423361f
Cred_4518 VSS VDD.$507.Metal1 0.0423242f
Cred_4519 VSS VDD.$51.Metal1 0.000162844f
Cred_4520 VSS VDD.$511.Metal1 0.030385f
Cred_4521 VSS VDD.$519.Metal1 0.043865f
Cred_4522 VSS VDD.$526.Metal1 0.258337f
Cred_4523 VSS VDD.$552.Metal2 0.0535766f
Cred_4524 VSS VDD.$554.Metal2 0.0451851f
Cred_4525 VSS VDD.$562.Metal2 0.0422198f
Cred_4526 VSS VDD.$563.Metal2 0.0128281f
Cred_4527 VSS VDD.$564.Metal2 0.0128281f
Cred_4528 VSS VDD.$565.Metal2 0.0128281f
Cred_4529 VSS VDD.$566.Metal2 0.0128281f
Cred_4530 VSS VDD.$567.Metal2 0.0128281f
Cred_4531 VSS VDD.$568.Metal2 0.0128281f
Cred_4532 VSS VDD.$569.Metal2 0.0128281f
Cred_4533 VSS VDD.$570.Metal2 0.0128281f
Cred_4534 VSS VDD.$571.Metal2 0.0128281f
Cred_4535 VSS VDD.$572.Metal2 0.0128281f
Cred_4536 VSS VDD.$573.Metal2 0.0263961f
Cred_4537 VSS VDD.$574.Metal2 0.0254383f
Cred_4538 VSS VDD.$597.Metal2 0.0292644f
Cred_4539 VSS VDD.$606.Metal2 0.0120026f
Cred_4540 VSS VDD.$620.Metal2 0.0137191f
Cred_4541 VSS VDD.$621.Metal2 0.0288026f
Cred_4542 VSS VDD.$643.Metal2 0.0311879f
Cred_4543 VSS VDD.$651.Metal2 0.0332635f
Cred_4544 VSS VDD.$688.Metal2 0.0288026f
Cred_4545 VSS VDD.$696.Metal2 0.0285997f
Cred_4546 VSS VDD.$703.Metal2 0.0118095f
Cred_4547 VSS VDD.$714.Metal2 0.00211087f
Cred_4548 VSS VDD.$734.Metal2 0.0231538f
Cred_4549 VSS VDD.$738.Metal2 0.0264026f
Cred_4550 VSS VDD.$746.Metal2 0.0331598f
Cred_4551 VSS VDD.$754.Metal2 0.0285755f
Cred_4552 VSS VDD.$762.Metal2 0.0216276f
Cred_4553 VSS VDD.$766.Metal2 0.0216275f
Cred_4554 VSS VDD.$774.Metal2 0.0285755f
Cred_4555 VSS VDD.$782.Metal2 0.0313554f
Cred_4556 VSS VDD.$790.Metal2 0.0315273f
Cred_4557 VSS VDD.$798.Metal2 0.0215788f
Cred_4558 VSS VDD.$802.Metal2 0.0215438f
Cred_4559 VSS VDD.$810.Metal2 0.0216276f
Cred_4560 VSS VDD.$814.Metal2 0.0216275f
Cred_4561 VSS VDD.$822.Metal2 0.0215623f
Cred_4562 VSS VDD.$826.Metal2 0.108116f
Cred_4563 VSS VDD.$840.Metal3 0.0275078f
Cred_4564 VSS VDD.$844.Metal3 0.0384502f
Cred_4565 VSS VDD.$852.Metal3 0.0442201f
Cred_4566 VSS VDD.$856.Metal3 0.0442862f
Cred_4567 VSS VDD.$864.Metal3 0.0384465f
Cred_4568 VSS VDD.$868.Metal3 0.036221f
Cred_4569 VSS VDD.$874.Metal3 0.0363023f
Cred_4570 VSS VDD.$878.Metal3 0.0257667f
Cred_4571 VSS VDD.$882.Metal3 0.0321303f
Cred_4572 VSS VDD.$888.Metal3 0.0321303f
Cred_4573 VSS VDD.$892.Metal3 0.0257667f
Cred_4574 VSS VDD.$896.Metal3 0.0346645f
Cred_4575 VSS VDD.$90.Metal1 0.000162844f
Cred_4576 VSS VDD.$902.Metal3 0.0345846f
Cred_4577 VSS VDD.$906.Metal3 0.0321303f
Cred_4578 VSS VDD.$912.Metal3 0.0384938f
Cred_4579 VSS VDD.$918.Metal3 0.101823f
Cred_4580 VSS VDD.P0.GatPoly 0.00312382f
Cred_4581 VSS VDD.P0.nSD 0.387465f
Cred_4582 VSS VDD.P0.pSD 3.10431e-06f
Cred_4583 VSS VDD.P1.GatPoly 0.000551129f
Cred_4584 VSS VDD.P1.pSD 3.10431e-06f
Cred_4585 VSS VDD.P10.pSD 1.54483e-06f
Cred_4586 VSS VDD.P11.pSD 1.54483e-06f
Cred_4587 VSS VDD.P2.GatPoly 0.000551129f
Cred_4588 VSS VDD.P3.GatPoly 0.000551485f
Cred_4589 VSS VSS 0.0479614f
Cred_4590 VSS VSS.$114.Metal1 0.0943756f
Cred_4591 VSS VSS.$127.Metal1 0.0196315f
Cred_4592 VSS VSS.$129.Metal1 0.140785f
Cred_4593 VSS VSS.$132.Metal1 0.0890129f
Cred_4594 VSS VSS.$134.Metal1 0.0886045f
Cred_4595 VSS VSS.$147.Metal1 0.0789612f
Cred_4596 VSS VSS.$155.Metal1 0.0120433f
Cred_4597 VSS VSS.$156.Metal1 0.0121257f
Cred_4598 VSS VSS.$165.Metal1 0.0920128f
Cred_4599 VSS VSS.$175.Metal1 0.0579298f
Cred_4600 VSS VSS.$181.Metal1 0.0458659f
Cred_4601 VSS VSS.$185.Metal1 0.0632176f
Cred_4602 VSS VSS.$195.Metal1 0.0529494f
Cred_4603 VSS VSS.$199.Metal1 0.0563684f
Cred_4604 VSS VSS.$209.Metal1 0.0669897f
Cred_4605 VSS VSS.$211.Metal1 0.11527f
Cred_4606 VSS VSS.$220.Metal1 0.263095f
Cred_4607 VSS VSS.$231.Metal1 0.0960379f
Cred_4608 VSS VSS.$241.Metal1 0.0634658f
Cred_4609 VSS VSS.$245.Metal1 0.0631891f
Cred_4610 VSS VSS.$255.Metal1 0.418473f
Cred_4611 VSS VSS.$284.Metal2 0.126878f
Cred_4612 VSS VSS.$286.Metal2 0.0404539f
Cred_4613 VSS VSS.$292.Metal2 0.0220962f
Cred_4614 VSS VSS.$303.Metal2 0.0267332f
Cred_4615 VSS VSS.$307.Metal2 0.0239676f
Cred_4616 VSS VSS.$311.Metal2 0.0580003f
Cred_4617 VSS VSS.$321.Metal2 0.0315859f
Cred_4618 VSS VSS.$329.Metal2 0.0284733f
Cred_4619 VSS VSS.$33.Metal1 0.225497f
Cred_4620 VSS VSS.$339.Metal2 0.0299962f
Cred_4621 VSS VSS.$350.Metal2 0.0262044f
Cred_4622 VSS VSS.$354.Metal2 0.0239676f
Cred_4623 VSS VSS.$359.Metal2 0.0345436f
Cred_4624 VSS VSS.$368.Metal2 0.0236538f
Cred_4625 VSS VSS.$372.Metal2 0.0195285f
Cred_4626 VSS VSS.$376.Metal2 0.0539798f
Cred_4627 VSS VSS.$384.Metal2 0.0357751f
Cred_4628 VSS VSS.$392.Metal2 0.03213f
Cred_4629 VSS VSS.$400.Metal2 0.0239874f
Cred_4630 VSS VSS.$404.Metal2 0.016089f
Cred_4631 VSS VSS.$408.Metal2 0.0243409f
Cred_4632 VSS VSS.$416.Metal2 0.0461758f
Cred_4633 VSS VSS.$42.Metal1 0.0968244f
Cred_4634 VSS VSS.$424.Metal2 0.0358801f
Cred_4635 VSS VSS.$428.Metal2 0.0317341f
Cred_4636 VSS VSS.$436.Metal2 0.0242714f
Cred_4637 VSS VSS.$440.Metal2 0.0160314f
Cred_4638 VSS VSS.$444.Metal2 0.0161993f
Cred_4639 VSS VSS.$448.Metal2 0.0162005f
Cred_4640 VSS VSS.$452.Metal2 0.168084f
Cred_4641 VSS VSS.$474.Metal3 0.0310926f
Cred_4642 VSS VSS.$478.Metal3 0.0376989f
Cred_4643 VSS VSS.$484.Metal3 0.0370568f
Cred_4644 VSS VSS.$488.Metal3 0.0492822f
Cred_4645 VSS VSS.$496.Metal3 0.0582744f
Cred_4646 VSS VSS.$5.Metal1 0.160671f
Cred_4647 VSS VSS.$502.Metal3 0.0554862f
Cred_4648 VSS VSS.$510.Metal3 0.0601767f
Cred_4649 VSS VSS.$518.Metal3 0.0418679f
Cred_4650 VSS VSS.$522.Metal3 0.0432362f
Cred_4651 VSS VSS.$530.Metal3 0.0637689f
Cred_4652 VSS VSS.$536.Metal3 0.0433467f
Cred_4653 VSS VSS.$540.Metal3 0.0417688f
Cred_4654 VSS VSS.$548.Metal3 0.159024f
Cred_4655 VSS VSS.$61.Metal1 0.0899397f
Cred_4656 VSS VSS.$74.Metal1 0.0643319f
Cred_4657 VSS VSS.$78.Metal1 0.284597f
Cred_4658 VSS VSS.$87.Metal1 0.176793f
Cred_4659 VSS VSS.$94.Metal1 0.0748166f
Cred_4660 VSS VSS.P0.GatPoly 0.0330019f
Cred_4661 VSS VSS.P0.nSD 0.000325632f
Cred_4662 VSS VSS.P0.pSD 0.216014f
Cred_4663 VSS VSS.P1.GatPoly 0.0315314f
Cred_4664 VSS VSS.P1.nSD 0.000325632f
Cred_4665 VSS VSS.P10.nSD 8.5174e-07f
Cred_4666 VSS VSS.P11.nSD 8.5174e-07f
Cred_4667 VSS VSS.P2.GatPoly 0.0315374f
Cred_4668 VSS VSS.P3.GatPoly 0.0314358f
Cred_4669 VSS VSS.P3.nSD 0.00108838f
Cred_4670 VSS VSS.P5.nSD 0.000911674f
Cred_4671 VSS VSS.P6.nSD 0.000909037f
Cred_4672 VSS VSS.P7.nSD 0.00108507f
Cred_4673 v_a v_b 0.350257f
Cred_4674 v_a v_b.$161.Metal2 9.09489e-06f
Cred_4675 v_a v_b.$195.Metal2 1.97048e-06f
Cred_4676 v_a v_b.P0.nSD 6.65685e-08f
Cred_4677 v_a v_b.P0.pSD 2.41697e-07f
Cred_4678 v_a v_c.$220.Metal2 5.43832e-05f
Cred_4679 v_a v_c.$411.Metal3 0.00678282f
Cred_4680 v_a v_c.$415.Metal3 1.42692e-05f
Cred_4681 v_a v_c.$425.Metal3 0.0404865f
Cred_4682 v_a v_c.$459.Metal3 0.0319008f
Cred_4683 v_a v_c.P6.nSD 0.00018293f
Cred_4684 v_a v_c.P6.pSD 4.92979e-06f
Cred_4685 v_a VDD.$215.Metal1 0.00036445f
Cred_4686 v_a VDD.$29.Metal1 0.00143767f
Cred_4687 v_a VDD.$320.Metal1 5.44663e-05f
Cred_4688 v_a VDD.$359.Metal1 5.44663e-05f
Cred_4689 v_a VDD.$378.Metal1 6.49717e-06f
Cred_4690 v_a VDD.$382.Metal1 0.00339925f
Cred_4691 v_a VDD.$405.Metal1 8.89279e-06f
Cred_4692 v_a VDD.$477.Metal1 1.3042e-05f
Cred_4693 v_a VDD.$51.Metal1 7.84008e-06f
Cred_4694 v_a VDD.$526.Metal1 3.24835e-06f
Cred_4695 v_a VDD.$562.Metal2 0.00121246f
Cred_4696 v_a VDD.$606.Metal2 0.00107518f
Cred_4697 v_a VDD.$703.Metal2 0.00842317f
Cred_4698 v_a VDD.$90.Metal1 7.84008e-06f
Cred_4699 v_a VDD.P0.nSD 0.0086801f
Cred_4700 v_a VDD.P0.pSD 1.58606e-07f
Cred_4701 v_a VDD.P1.pSD 1.58606e-07f
Cred_4702 v_a VDD.P10.pSD 1.10186e-06f
Cred_4703 v_a VDD.P11.pSD 1.10186e-06f
Cred_4704 v_a VSS 0.000810742f
Cred_4705 v_a VSS.$129.Metal1 0.000936328f
Cred_4706 v_a VSS.$165.Metal1 8.16795e-08f
Cred_4707 v_a VSS.$220.Metal1 7.50908e-05f
Cred_4708 v_a VSS.$284.Metal2 0.0375934f
Cred_4709 v_a VSS.$286.Metal2 1.36797e-06f
Cred_4710 v_a VSS.$292.Metal2 5.20975e-06f
Cred_4711 v_a VSS.$311.Metal2 0.0352063f
Cred_4712 v_a VSS.$33.Metal1 0.00256589f
Cred_4713 v_a VSS.$359.Metal2 0.0212987f
Cred_4714 v_a VSS.$376.Metal2 2.53367e-05f
Cred_4715 v_a VSS.$384.Metal2 1.01873e-05f
Cred_4716 v_a VSS.$474.Metal3 0.00246363f
Cred_4717 v_a VSS.$478.Metal3 0.000649775f
Cred_4718 v_a VSS.$5.Metal1 0.000220548f
Cred_4719 v_a VSS.$510.Metal3 8.16795e-08f
Cred_4720 v_a VSS.$78.Metal1 0.000792985f
Cred_4721 v_a VSS.$87.Metal1 0.000636791f
Cred_4722 v_a VSS.P0.nSD 1.1229e-05f
Cred_4723 v_a VSS.P0.pSD 0.000773769f
Cred_4724 v_a VSS.P1.GatPoly 6.50878e-07f
Cred_4725 v_a VSS.P1.nSD 1.1229e-05f
Cred_4726 v_a VSS.P2.GatPoly 3.94284e-07f
Cred_4727 v_a VSS.P3.nSD 6.46096e-06f
Cred_4728 v_a VSS.P5.nSD 5.12175e-06f
Cred_4729 v_a VSS.P6.nSD 3.10426e-06f
Cred_4730 v_a VSS.P7.nSD 3.91906e-06f
Cred_4731 v_a.$148.Metal2 v_b 0.0560021f
Cred_4732 v_a.$148.Metal2 v_b.$161.Metal2 0.0103136f
Cred_4733 v_a.$148.Metal2 v_b.$195.Metal2 0.00346916f
Cred_4734 v_a.$148.Metal2 v_b.P0.nSD 0.000318096f
Cred_4735 v_a.$148.Metal2 v_b.P0.pSD 0.0010026f
Cred_4736 v_a.$148.Metal2 v_c.$21.Metal1 0.0616882f
Cred_4737 v_a.$148.Metal2 v_c.$220.Metal2 0.0970883f
Cred_4738 v_a.$148.Metal2 v_c.$224.Metal2 0.0681683f
Cred_4739 v_a.$148.Metal2 v_c.$226.Metal2 0.0419999f
Cred_4740 v_a.$148.Metal2 v_c.$228.Metal2 0.252631f
Cred_4741 v_a.$148.Metal2 v_c.$23.Metal1 0.154758f
Cred_4742 v_a.$148.Metal2 v_c.$411.Metal3 0.0870709f
Cred_4743 v_a.$148.Metal2 v_c.$415.Metal3 0.148098f
Cred_4744 v_a.$148.Metal2 v_c.$425.Metal3 0.534441f
Cred_4745 v_a.$148.Metal2 v_c.$459.Metal3 0.00538092f
Cred_4746 v_a.$148.Metal2 v_c.P6.nSD 0.0955363f
Cred_4747 v_a.$148.Metal2 v_c.P6.pSD 0.0749414f
Cred_4748 v_a.$148.Metal2 v_c.P8.nSD 0.0301637f
Cred_4749 v_a.$148.Metal2 v_c.P8.pSD 0.139941f
Cred_4750 v_a.$148.Metal2 VDD.$215.Metal1 0.000201504f
Cred_4751 v_a.$148.Metal2 VDD.$29.Metal1 5.45675e-05f
Cred_4752 v_a.$148.Metal2 VDD.$320.Metal1 0.000201051f
Cred_4753 v_a.$148.Metal2 VDD.$359.Metal1 0.000201051f
Cred_4754 v_a.$148.Metal2 VDD.$378.Metal1 0.0116093f
Cred_4755 v_a.$148.Metal2 VDD.$382.Metal1 0.106424f
Cred_4756 v_a.$148.Metal2 VDD.$405.Metal1 0.0158899f
Cred_4757 v_a.$148.Metal2 VDD.$414.Metal1 0.000644656f
Cred_4758 v_a.$148.Metal2 VDD.$418.Metal1 9.32224e-07f
Cred_4759 v_a.$148.Metal2 VDD.$477.Metal1 0.00180814f
Cred_4760 v_a.$148.Metal2 VDD.$526.Metal1 0.000450353f
Cred_4761 v_a.$148.Metal2 VDD.$703.Metal2 0.0492807f
Cred_4762 v_a.$148.Metal2 VDD.$704.Metal2 0.0126872f
Cred_4763 v_a.$148.Metal2 VDD.$705.Metal2 0.0120029f
Cred_4764 v_a.$148.Metal2 VDD.$706.Metal2 0.0114099f
Cred_4765 v_a.$148.Metal2 VDD.$707.Metal2 0.0108998f
Cred_4766 v_a.$148.Metal2 VDD.$708.Metal2 0.0104657f
Cred_4767 v_a.$148.Metal2 VDD.$709.Metal2 0.010102f
Cred_4768 v_a.$148.Metal2 VDD.$710.Metal2 0.0098044f
Cred_4769 v_a.$148.Metal2 VDD.$711.Metal2 0.0095697f
Cred_4770 v_a.$148.Metal2 VDD.$712.Metal2 0.00939544f
Cred_4771 v_a.$148.Metal2 VDD.$713.Metal2 0.00927992f
Cred_4772 v_a.$148.Metal2 VDD.$714.Metal2 0.0122991f
Cred_4773 v_a.$148.Metal2 VDD.$746.Metal2 0.000465636f
Cred_4774 v_a.$148.Metal2 VDD.$754.Metal2 0.000465636f
Cred_4775 v_a.$148.Metal2 VDD.$878.Metal3 3.73337e-06f
Cred_4776 v_a.$148.Metal2 VDD.P0.nSD 0.0429348f
Cred_4777 v_a.$148.Metal2 VDD.P10.pSD 3.85435e-06f
Cred_4778 v_a.$148.Metal2 VDD.P11.pSD 3.85435e-06f
Cred_4779 v_a.$148.Metal2 VSS.$127.Metal1 0.00183359f
Cred_4780 v_a.$148.Metal2 VSS.$129.Metal1 0.0476537f
Cred_4781 v_a.$148.Metal2 VSS.$132.Metal1 0.00100552f
Cred_4782 v_a.$148.Metal2 VSS.$155.Metal1 0.00661601f
Cred_4783 v_a.$148.Metal2 VSS.$156.Metal1 0.00666337f
Cred_4784 v_a.$148.Metal2 VSS.$165.Metal1 0.000682859f
Cred_4785 v_a.$148.Metal2 VSS.$175.Metal1 0.00043406f
Cred_4786 v_a.$148.Metal2 VSS.$220.Metal1 0.023505f
Cred_4787 v_a.$148.Metal2 VSS.$311.Metal2 0.0019322f
Cred_4788 v_a.$148.Metal2 VSS.$359.Metal2 0.0492456f
Cred_4789 v_a.$148.Metal2 VSS.$376.Metal2 0.00497246f
Cred_4790 v_a.$148.Metal2 VSS.$384.Metal2 0.0041932f
Cred_4791 v_a.$148.Metal2 VSS.$510.Metal3 2.05255e-05f
Cred_4792 v_a.$148.Metal2 VSS.$78.Metal1 4.36792e-05f
Cred_4793 v_a.$148.Metal2 VSS.$87.Metal1 0.00978528f
Cred_4794 v_a.$148.Metal2 VSS.P0.pSD 0.0212476f
Cred_4795 v_a.$148.Metal2 VSS.P2.GatPoly 5.75878e-08f
Cred_4796 v_a.$148.Metal2 VSS.P6.nSD 4.53105e-07f
Cred_4797 v_a.$148.Metal2 VSS.P7.nSD 5.72713e-07f
Cred_4798 v_a.$182.Metal2 v_b 0.035537f
Cred_4799 v_a.$182.Metal2 v_b.$161.Metal2 0.1392f
Cred_4800 v_a.$182.Metal2 v_b.$195.Metal2 0.0252092f
Cred_4801 v_a.$182.Metal2 v_b.P0.nSD 0.00355326f
Cred_4802 v_a.$182.Metal2 v_b.P0.pSD 0.0365038f
Cred_4803 v_a.$182.Metal2 v_b.P1.nSD 0.000195469f
Cred_4804 v_a.$182.Metal2 v_b.P1.pSD 0.000593731f
Cred_4805 v_a.$182.Metal2 v_b.P3.nSD 0.000179065f
Cred_4806 v_a.$182.Metal2 v_b.P3.pSD 0.000570921f
Cred_4807 v_a.$182.Metal2 v_b.P5.nSD 0.000115009f
Cred_4808 v_a.$182.Metal2 v_b.P5.pSD 0.000349338f
Cred_4809 v_a.$182.Metal2 v_c.$21.Metal1 0.0199092f
Cred_4810 v_a.$182.Metal2 v_c.$220.Metal2 0.0317246f
Cred_4811 v_a.$182.Metal2 v_c.$224.Metal2 0.0222648f
Cred_4812 v_a.$182.Metal2 v_c.$226.Metal2 0.0137157f
Cred_4813 v_a.$182.Metal2 v_c.$228.Metal2 0.0825574f
Cred_4814 v_a.$182.Metal2 v_c.$23.Metal1 0.0505282f
Cred_4815 v_a.$182.Metal2 v_c.$284.Metal2 0.123624f
Cred_4816 v_a.$182.Metal2 v_c.$288.Metal2 0.086244f
Cred_4817 v_a.$182.Metal2 v_c.$290.Metal2 0.0531417f
Cred_4818 v_a.$182.Metal2 v_c.$292.Metal2 0.319297f
Cred_4819 v_a.$182.Metal2 v_c.$411.Metal3 0.0266004f
Cred_4820 v_a.$182.Metal2 v_c.$415.Metal3 0.0475014f
Cred_4821 v_a.$182.Metal2 v_c.$425.Metal3 1.10196f
Cred_4822 v_a.$182.Metal2 v_c.$446.Metal3 0.118323f
Cred_4823 v_a.$182.Metal2 v_c.$450.Metal3 0.187757f
Cred_4824 v_a.$182.Metal2 v_c.$459.Metal3 0.0845866f
Cred_4825 v_a.$182.Metal2 v_c.$93.Metal1 0.0761684f
Cred_4826 v_a.$182.Metal2 v_c.$95.Metal1 0.194017f
Cred_4827 v_a.$182.Metal2 v_c.P0.nSD 1.95816e-05f
Cred_4828 v_a.$182.Metal2 v_c.P10.nSD 0.120357f
Cred_4829 v_a.$182.Metal2 v_c.P10.pSD 0.0946538f
Cred_4830 v_a.$182.Metal2 v_c.P6.nSD 0.0310189f
Cred_4831 v_a.$182.Metal2 v_c.P6.pSD 0.0244719f
Cred_4832 v_a.$182.Metal2 v_c.P8.nSD 0.0919373f
Cred_4833 v_a.$182.Metal2 v_c.P8.pSD 0.425151f
Cred_4834 v_a.$182.Metal2 VDD.$382.Metal1 0.0609075f
Cred_4835 v_a.$182.Metal2 VDD.$442.Metal1 8.39311e-07f
Cred_4836 v_a.$182.Metal2 VDD.$446.Metal1 0.000672319f
Cred_4837 v_a.$182.Metal2 VDD.$477.Metal1 0.0417662f
Cred_4838 v_a.$182.Metal2 VDD.$526.Metal1 0.00282285f
Cred_4839 v_a.$182.Metal2 VDD.$774.Metal2 0.000419227f
Cred_4840 v_a.$182.Metal2 VDD.$782.Metal2 0.000419227f
Cred_4841 v_a.$182.Metal2 VDD.$892.Metal3 3.36127e-06f
Cred_4842 v_a.$182.Metal2 VDD.P0.nSD 0.112806f
Cred_4843 v_a.$182.Metal2 VSS.$129.Metal1 0.0226612f
Cred_4844 v_a.$182.Metal2 VSS.$199.Metal1 0.000941805f
Cred_4845 v_a.$182.Metal2 VSS.$209.Metal1 0.000107705f
Cred_4846 v_a.$182.Metal2 VSS.$211.Metal1 0.011569f
Cred_4847 v_a.$182.Metal2 VSS.$220.Metal1 0.0904126f
Cred_4848 v_a.$182.Metal2 VSS.$408.Metal2 0.000775036f
Cred_4849 v_a.$182.Metal2 VSS.$416.Metal2 0.000775866f
Cred_4850 v_a.$182.Metal2 VSS.$522.Metal3 3.0578e-06f
Cred_4851 v_a.$182.Metal2 VSS.$530.Metal3 3.0578e-06f
Cred_4852 v_a.$182.Metal2 VSS.$87.Metal1 0.00478088f
Cred_4853 v_a.$182.Metal2 VSS.P0.pSD 0.0234539f
Cred_4854 v_a.P0.nSD v_b.$161.Metal2 9.97335e-05f
Cred_4855 v_a.P0.nSD v_b.P0.nSD 8.47912e-06f
Cred_4856 v_a.P0.nSD v_b.P0.pSD 2.65042e-06f
Cred_4857 v_a.P0.nSD v_c.$220.Metal2 2.47154e-05f
Cred_4858 v_a.P0.nSD v_c.$411.Metal3 0.00308258f
Cred_4859 v_a.P0.nSD v_c.$425.Metal3 0.0184157f
Cred_4860 v_a.P0.nSD v_c.P6.nSD 0.0288385f
Cred_4861 v_a.P0.nSD VSS.$127.Metal1 0.00166008f
Cred_4862 v_a.P0.nSD VSS.$129.Metal1 0.00466668f
Cred_4863 v_a.P0.nSD VSS.$132.Metal1 0.000910369f
Cred_4864 v_a.P0.nSD VSS.$155.Metal1 0.00595613f
Cred_4865 v_a.P0.nSD VSS.$156.Metal1 0.0059216f
Cred_4866 v_a.P0.nSD VSS.$165.Metal1 0.00059966f
Cred_4867 v_a.P0.nSD VSS.$175.Metal1 0.000392988f
Cred_4868 v_a.P0.nSD VSS.$220.Metal1 0.00105821f
Cred_4869 v_a.P0.nSD VSS.$359.Metal2 0.00270109f
Cred_4870 v_a.P0.nSD VSS.$384.Metal2 0.000106559f
Cred_4871 v_a.P0.nSD VSS.$87.Metal1 0.000468761f
Cred_4872 v_a.P0.nSD VSS.P0.pSD 0.00109166f
Cred_4873 v_a.P0.pSD v_b 0.00945368f
Cred_4874 v_a.P0.pSD v_b.$161.Metal2 0.000301122f
Cred_4875 v_a.P0.pSD v_b.$195.Metal2 0.0010836f
Cred_4876 v_a.P0.pSD v_b.P0.nSD 2.20401e-06f
Cred_4877 v_a.P0.pSD v_b.P0.pSD 0.000117001f
Cred_4878 v_a.P0.pSD v_c.$21.Metal1 0.0650454f
Cred_4879 v_a.P0.pSD v_c.$220.Metal2 0.0180899f
Cred_4880 v_a.P0.pSD v_c.$224.Metal2 0.0188842f
Cred_4881 v_a.P0.pSD v_c.$226.Metal2 0.0148813f
Cred_4882 v_a.P0.pSD v_c.$228.Metal2 0.171404f
Cred_4883 v_a.P0.pSD v_c.$23.Metal1 0.170806f
Cred_4884 v_a.P0.pSD v_c.$411.Metal3 0.00788714f
Cred_4885 v_a.P0.pSD v_c.$415.Metal3 0.101993f
Cred_4886 v_a.P0.pSD v_c.$425.Metal3 0.000560105f
Cred_4887 v_a.P0.pSD v_c.P6.nSD 2.52506e-06f
Cred_4888 v_a.P0.pSD v_c.P6.pSD 0.0804104f
Cred_4889 v_a.P0.pSD VDD.$320.Metal1 5.48786e-05f
Cred_4890 v_a.P0.pSD VDD.$359.Metal1 5.48786e-05f
Cred_4891 v_a.P0.pSD VDD.$378.Metal1 0.0223843f
Cred_4892 v_a.P0.pSD VDD.$382.Metal1 0.059393f
Cred_4893 v_a.P0.pSD VDD.$405.Metal1 0.0306378f
Cred_4894 v_a.P0.pSD VDD.$414.Metal1 0.00242836f
Cred_4895 v_a.P0.pSD VDD.$418.Metal1 1.02468e-06f
Cred_4896 v_a.P0.pSD VDD.$477.Metal1 0.000154945f
Cred_4897 v_a.P0.pSD VDD.$526.Metal1 3.8592e-05f
Cred_4898 v_a.P0.pSD VDD.$703.Metal2 0.0160082f
Cred_4899 v_a.P0.pSD VDD.$704.Metal2 0.00667192f
Cred_4900 v_a.P0.pSD VDD.$705.Metal2 0.00735622f
Cred_4901 v_a.P0.pSD VDD.$706.Metal2 0.00794917f
Cred_4902 v_a.P0.pSD VDD.$707.Metal2 0.00845928f
Cred_4903 v_a.P0.pSD VDD.$708.Metal2 0.00889344f
Cred_4904 v_a.P0.pSD VDD.$709.Metal2 0.00925714f
Cred_4905 v_a.P0.pSD VDD.$710.Metal2 0.0095547f
Cred_4906 v_a.P0.pSD VDD.$711.Metal2 0.0097894f
Cred_4907 v_a.P0.pSD VDD.$712.Metal2 0.00996366f
Cred_4908 v_a.P0.pSD VDD.$713.Metal2 0.0100792f
Cred_4909 v_a.P0.pSD VDD.$714.Metal2 0.0135188f
Cred_4910 v_a.P0.pSD VDD.$746.Metal2 0.000511817f
Cred_4911 v_a.P0.pSD VDD.$754.Metal2 0.000511817f
Cred_4912 v_a.P0.pSD VDD.$878.Metal3 4.10363e-06f
Cred_4913 v_a.P0.pSD VDD.P0.nSD 0.0365184f
Cred_4914 v_a.P0.pSD VDD.P10.pSD 1.03635e-06f
Cred_4915 v_a.P0.pSD VDD.P11.pSD 1.03635e-06f
Cred_4916 v_a.P1.nSD v_b 0.000116722f
Cred_4917 v_a.P1.nSD v_b.$161.Metal2 0.000179065f
Cred_4918 v_a.P1.nSD v_b.$195.Metal2 3.87189e-05f
Cred_4919 v_a.P1.nSD v_b.P0.nSD 1.34015e-05f
Cred_4920 v_a.P1.nSD v_b.P0.pSD 7.28701e-06f
Cred_4921 v_a.P1.nSD v_c.$21.Metal1 0.000165598f
Cred_4922 v_a.P1.nSD v_c.$220.Metal2 0.000288716f
Cred_4923 v_a.P1.nSD v_c.$224.Metal2 0.000185191f
Cred_4924 v_a.P1.nSD v_c.$226.Metal2 0.000114082f
Cred_4925 v_a.P1.nSD v_c.$228.Metal2 0.000686685f
Cred_4926 v_a.P1.nSD v_c.$23.Metal1 0.000420277f
Cred_4927 v_a.P1.nSD v_c.$411.Metal3 0.00331956f
Cred_4928 v_a.P1.nSD v_c.$415.Metal3 0.000395101f
Cred_4929 v_a.P1.nSD v_c.$425.Metal3 0.0426156f
Cred_4930 v_a.P1.nSD v_c.P6.nSD 0.0283812f
Cred_4931 v_a.P1.nSD v_c.P6.pSD 0.000203549f
Cred_4932 v_a.P1.nSD v_c.P8.nSD 0.0279039f
Cred_4933 v_a.P1.nSD v_c.P8.pSD 0.00116398f
Cred_4934 v_a.P1.nSD VDD.$382.Metal1 0.000135026f
Cred_4935 v_a.P1.nSD VDD.$477.Metal1 7.76331e-06f
Cred_4936 v_a.P1.nSD VDD.$526.Metal1 1.9336e-06f
Cred_4937 v_a.P1.nSD VDD.P0.nSD 8.5558e-05f
Cred_4938 v_a.P1.nSD VSS.$129.Metal1 0.00153579f
Cred_4939 v_a.P1.nSD VSS.$220.Metal1 0.00184903f
Cred_4940 v_a.P1.nSD VSS.$87.Metal1 0.000324009f
Cred_4941 v_a.P1.nSD VSS.P0.pSD 0.00115778f
Cred_4942 v_a.P1.pSD v_b 0.00839227f
Cred_4943 v_a.P1.pSD v_b.$161.Metal2 0.000570921f
Cred_4944 v_a.P1.pSD v_b.$195.Metal2 0.00278387f
Cred_4945 v_a.P1.pSD v_b.P0.nSD 7.38912e-06f
Cred_4946 v_a.P1.pSD v_b.P0.pSD 0.000184068f
Cred_4947 v_a.P1.pSD v_c.$21.Metal1 0.0638794f
Cred_4948 v_a.P1.pSD v_c.$220.Metal2 0.0188906f
Cred_4949 v_a.P1.pSD v_c.$224.Metal2 0.0193984f
Cred_4950 v_a.P1.pSD v_c.$226.Metal2 0.0151591f
Cred_4951 v_a.P1.pSD v_c.$228.Metal2 0.17209f
Cred_4952 v_a.P1.pSD v_c.$23.Metal1 0.170375f
Cred_4953 v_a.P1.pSD v_c.$411.Metal3 0.00953609f
Cred_4954 v_a.P1.pSD v_c.$415.Metal3 0.0987307f
Cred_4955 v_a.P1.pSD v_c.$425.Metal3 0.323124f
Cred_4956 v_a.P1.pSD v_c.P6.nSD 0.0010158f
Cred_4957 v_a.P1.pSD v_c.P6.pSD 0.07977f
Cred_4958 v_a.P1.pSD v_c.P8.nSD 0.000959971f
Cred_4959 v_a.P1.pSD v_c.P8.pSD 0.33749f
Cred_4960 v_a.P1.pSD VDD.$382.Metal1 0.00561519f
Cred_4961 v_a.P1.pSD VDD.$477.Metal1 0.000325945f
Cred_4962 v_a.P1.pSD VDD.$526.Metal1 8.1183e-05f
Cred_4963 v_a.P1.pSD VDD.P0.nSD 0.00362593f
Cred_4964 v_a.P1.pSD VSS.$129.Metal1 0.000262727f
Cred_4965 v_a.P1.pSD VSS.$220.Metal1 0.000313797f
Cred_4966 v_a.P1.pSD VSS.$87.Metal1 5.54281e-05f
Cred_4967 v_a.P1.pSD VSS.P0.pSD 0.000194704f
Cred_4968 v_a.P3.nSD v_b 7.33579e-05f
Cred_4969 v_a.P3.nSD v_b.$161.Metal2 0.000195469f
Cred_4970 v_a.P3.nSD v_b.$195.Metal2 2.43342e-05f
Cred_4971 v_a.P3.nSD v_b.P0.nSD 1.66183e-05f
Cred_4972 v_a.P3.nSD v_b.P0.pSD 5.19459e-06f
Cred_4973 v_a.P3.nSD v_c.$284.Metal2 2.86939e-05f
Cred_4974 v_a.P3.nSD v_c.$425.Metal3 0.034116f
Cred_4975 v_a.P3.nSD v_c.$446.Metal3 0.00357879f
Cred_4976 v_a.P3.nSD v_c.$459.Metal3 0.00422868f
Cred_4977 v_a.P3.nSD v_c.P10.nSD 0.0260728f
Cred_4978 v_a.P3.nSD v_c.P8.nSD 0.0279129f
Cred_4979 v_a.P3.nSD VSS.$129.Metal1 0.000918905f
Cred_4980 v_a.P3.nSD VSS.$220.Metal1 0.00248197f
Cred_4981 v_a.P3.nSD VSS.$87.Metal1 0.000193863f
Cred_4982 v_a.P3.nSD VSS.P0.pSD 0.000951755f
Cred_4983 v_a.P3.pSD v_b 0.00822635f
Cred_4984 v_a.P3.pSD v_b.$161.Metal2 0.000593731f
Cred_4985 v_a.P3.pSD v_b.$195.Metal2 0.00272883f
Cred_4986 v_a.P3.pSD v_b.P0.nSD 4.34571e-06f
Cred_4987 v_a.P3.pSD v_b.P0.pSD 0.000230694f
Cred_4988 v_a.P3.pSD v_c.$284.Metal2 0.0178864f
Cred_4989 v_a.P3.pSD v_c.$288.Metal2 0.0186694f
Cred_4990 v_a.P3.pSD v_c.$290.Metal2 0.0147268f
Cred_4991 v_a.P3.pSD v_c.$292.Metal2 0.168925f
Cred_4992 v_a.P3.pSD v_c.$425.Metal3 0.308622f
Cred_4993 v_a.P3.pSD v_c.$446.Metal3 0.00909624f
Cred_4994 v_a.P3.pSD v_c.$450.Metal3 0.100926f
Cred_4995 v_a.P3.pSD v_c.$459.Metal3 0.00105261f
Cred_4996 v_a.P3.pSD v_c.$93.Metal1 0.0604592f
Cred_4997 v_a.P3.pSD v_c.$95.Metal1 0.16423f
Cred_4998 v_a.P3.pSD v_c.P10.nSD 1.88453e-05f
Cred_4999 v_a.P3.pSD v_c.P10.pSD 0.0786767f
Cred_5000 v_a.P3.pSD v_c.P8.pSD 0.334707f
Cred_5001 v_a.P3.pSD VDD.$382.Metal1 0.0036896f
Cred_5002 v_a.P3.pSD VDD.$477.Metal1 0.000448898f
Cred_5003 v_a.P3.pSD VDD.$526.Metal1 0.000111807f
Cred_5004 v_a.P3.pSD VDD.P0.nSD 0.00429875f
Cred_5005 v_a.P5.nSD v_b 0.00024301f
Cred_5006 v_a.P5.nSD v_b.$161.Metal2 0.00355326f
Cred_5007 v_a.P5.nSD v_b.$195.Metal2 0.000443159f
Cred_5008 v_a.P5.nSD v_b.P0.nSD 0.000222216f
Cred_5009 v_a.P5.nSD v_b.P0.pSD 0.00031612f
Cred_5010 v_a.P5.nSD v_b.P1.nSD 1.66183e-05f
Cred_5011 v_a.P5.nSD v_b.P1.pSD 4.34571e-06f
Cred_5012 v_a.P5.nSD v_b.P3.nSD 1.34015e-05f
Cred_5013 v_a.P5.nSD v_b.P3.pSD 7.38912e-06f
Cred_5014 v_a.P5.nSD v_b.P5.nSD 9.77785e-06f
Cred_5015 v_a.P5.nSD v_b.P5.pSD 2.55692e-06f
Cred_5016 v_a.P5.nSD v_c.$284.Metal2 0.000478534f
Cred_5017 v_a.P5.nSD v_c.$288.Metal2 0.000298834f
Cred_5018 v_a.P5.nSD v_c.$290.Metal2 0.000184084f
Cred_5019 v_a.P5.nSD v_c.$292.Metal2 0.00110783f
Cred_5020 v_a.P5.nSD v_c.$425.Metal3 0.0159888f
Cred_5021 v_a.P5.nSD v_c.$446.Metal3 0.00470346f
Cred_5022 v_a.P5.nSD v_c.$450.Metal3 0.00063384f
Cred_5023 v_a.P5.nSD v_c.$459.Metal3 0.00546888f
Cred_5024 v_a.P5.nSD v_c.$93.Metal1 0.00027316f
Cred_5025 v_a.P5.nSD v_c.$95.Metal1 0.000685583f
Cred_5026 v_a.P5.nSD v_c.P0.nSD 1.66478e-06f
Cred_5027 v_a.P5.nSD v_c.P10.nSD 0.0302953f
Cred_5028 v_a.P5.nSD v_c.P10.pSD 0.00032879f
Cred_5029 v_a.P5.nSD VDD.$382.Metal1 0.000154512f
Cred_5030 v_a.P5.nSD VDD.$442.Metal1 6.14319e-09f
Cred_5031 v_a.P5.nSD VDD.$446.Metal1 4.92092e-06f
Cred_5032 v_a.P5.nSD VDD.$477.Metal1 0.000277177f
Cred_5033 v_a.P5.nSD VDD.$526.Metal1 1.35571e-05f
Cred_5034 v_a.P5.nSD VDD.$774.Metal2 3.06846e-06f
Cred_5035 v_a.P5.nSD VDD.$782.Metal2 3.06846e-06f
Cred_5036 v_a.P5.nSD VDD.$892.Metal3 2.46022e-08f
Cred_5037 v_a.P5.nSD VDD.P0.nSD 0.000545804f
Cred_5038 v_a.P5.nSD VSS.$129.Metal1 0.000545899f
Cred_5039 v_a.P5.nSD VSS.$199.Metal1 0.000918991f
Cred_5040 v_a.P5.nSD VSS.$209.Metal1 0.000105727f
Cred_5041 v_a.P5.nSD VSS.$211.Metal1 0.00871134f
Cred_5042 v_a.P5.nSD VSS.$220.Metal1 0.0130066f
Cred_5043 v_a.P5.nSD VSS.$408.Metal2 7.31174e-05f
Cred_5044 v_a.P5.nSD VSS.$416.Metal2 7.39328e-05f
Cred_5045 v_a.P5.nSD VSS.$522.Metal3 2.88475e-07f
Cred_5046 v_a.P5.nSD VSS.$530.Metal3 2.88475e-07f
Cred_5047 v_a.P5.nSD VSS.$87.Metal1 0.000115169f
Cred_5048 v_a.P5.nSD VSS.P0.pSD 0.00176192f
Cred_5049 v_a.P5.pSD v_b 0.0127783f
Cred_5050 v_a.P5.pSD v_b.$161.Metal2 0.0365038f
Cred_5051 v_a.P5.pSD v_b.$195.Metal2 0.0059024f
Cred_5052 v_a.P5.pSD v_b.P0.nSD 0.00031612f
Cred_5053 v_a.P5.pSD v_b.P0.pSD 0.0304584f
Cred_5054 v_a.P5.pSD v_b.P1.nSD 5.19459e-06f
Cred_5055 v_a.P5.pSD v_b.P1.pSD 0.000230694f
Cred_5056 v_a.P5.pSD v_b.P3.nSD 7.28701e-06f
Cred_5057 v_a.P5.pSD v_b.P3.pSD 0.000184068f
Cred_5058 v_a.P5.pSD v_b.P5.nSD 3.05638e-06f
Cred_5059 v_a.P5.pSD v_b.P5.pSD 0.000135735f
Cred_5060 v_a.P5.pSD v_c.$284.Metal2 0.0238493f
Cred_5061 v_a.P5.pSD v_c.$288.Metal2 0.0228814f
Cred_5062 v_a.P5.pSD v_c.$290.Metal2 0.0172979f
Cred_5063 v_a.P5.pSD v_c.$292.Metal2 0.184698f
Cred_5064 v_a.P5.pSD v_c.$425.Metal3 0.0117493f
Cred_5065 v_a.P5.pSD v_c.$446.Metal3 0.0125945f
Cred_5066 v_a.P5.pSD v_c.$450.Metal3 0.105503f
Cred_5067 v_a.P5.pSD v_c.$459.Metal3 0.00397476f
Cred_5068 v_a.P5.pSD v_c.$93.Metal1 0.0684038f
Cred_5069 v_a.P5.pSD v_c.$95.Metal1 0.179974f
Cred_5070 v_a.P5.pSD v_c.P0.nSD 5.2038e-07f
Cred_5071 v_a.P5.pSD v_c.P10.nSD 0.00165895f
Cred_5072 v_a.P5.pSD v_c.P10.pSD 0.0830774f
Cred_5073 v_a.P5.pSD VDD.$382.Metal1 0.0154463f
Cred_5074 v_a.P5.pSD VDD.$442.Metal1 1.11145e-06f
Cred_5075 v_a.P5.pSD VDD.$446.Metal1 0.00271636f
Cred_5076 v_a.P5.pSD VDD.$477.Metal1 0.0696516f
Cred_5077 v_a.P5.pSD VDD.$526.Metal1 0.0017643f
Cred_5078 v_a.P5.pSD VDD.$774.Metal2 0.000555157f
Cred_5079 v_a.P5.pSD VDD.$782.Metal2 0.000555157f
Cred_5080 v_a.P5.pSD VDD.$892.Metal3 4.45113e-06f
Cred_5081 v_a.P5.pSD VDD.P0.nSD 0.0880553f
Cred_5082 v_a.P5.pSD VSS.$129.Metal1 0.000109375f
Cred_5083 v_a.P5.pSD VSS.$199.Metal1 2.50285e-05f
Cred_5084 v_a.P5.pSD VSS.$209.Metal1 2.86226e-06f
Cred_5085 v_a.P5.pSD VSS.$211.Metal1 0.000307447f
Cred_5086 v_a.P5.pSD VSS.$220.Metal1 0.00138957f
Cred_5087 v_a.P5.pSD VSS.$408.Metal2 2.05966e-05f
Cred_5088 v_a.P5.pSD VSS.$416.Metal2 2.06186e-05f
Cred_5089 v_a.P5.pSD VSS.$522.Metal3 8.12611e-08f
Cred_5090 v_a.P5.pSD VSS.$530.Metal3 8.12611e-08f
Cred_5091 v_a.P5.pSD VSS.$87.Metal1 2.3075e-05f
Cred_5092 v_a.P5.pSD VSS.P0.pSD 0.000180033f
Cred_5093 v_b v_c 0.0260984f
Cred_5094 v_b v_c.$129.Metal1 0.000102328f
Cred_5095 v_b v_c.$165.Metal1 9.62943e-05f
Cred_5096 v_b v_c.$201.Metal1 0.000137914f
Cred_5097 v_b v_c.$21.Metal1 6.90507e-06f
Cred_5098 v_b v_c.$220.Metal2 0.00145447f
Cred_5099 v_b v_c.$224.Metal2 0.000418266f
Cred_5100 v_b v_c.$226.Metal2 3.26793e-05f
Cred_5101 v_b v_c.$228.Metal2 0.00126278f
Cred_5102 v_b v_c.$23.Metal1 0.00029629f
Cred_5103 v_b v_c.$284.Metal2 0.00147751f
Cred_5104 v_b v_c.$288.Metal2 0.000418053f
Cred_5105 v_b v_c.$290.Metal2 3.25385e-05f
Cred_5106 v_b v_c.$292.Metal2 0.00127819f
Cred_5107 v_b v_c.$320.Metal2 0.00220884f
Cred_5108 v_b v_c.$330.Metal2 7.55799e-05f
Cred_5109 v_b v_c.$332.Metal2 0.000151766f
Cred_5110 v_b v_c.$334.Metal2 7.55799e-05f
Cred_5111 v_b v_c.$352.Metal2 0.0020801f
Cred_5112 v_b v_c.$362.Metal2 7.59573e-05f
Cred_5113 v_b v_c.$364.Metal2 0.000152524f
Cred_5114 v_b v_c.$366.Metal2 7.59573e-05f
Cred_5115 v_b v_c.$384.Metal2 0.0030713f
Cred_5116 v_b v_c.$394.Metal2 7.55799e-05f
Cred_5117 v_b v_c.$396.Metal2 0.000151766f
Cred_5118 v_b v_c.$398.Metal2 7.55799e-05f
Cred_5119 v_b v_c.$411.Metal3 0.0623607f
Cred_5120 v_b v_c.$415.Metal3 0.0181484f
Cred_5121 v_b v_c.$425.Metal3 0.136005f
Cred_5122 v_b v_c.$446.Metal3 0.065202f
Cred_5123 v_b v_c.$450.Metal3 0.0183399f
Cred_5124 v_b v_c.$459.Metal3 0.0622523f
Cred_5125 v_b v_c.$464.Metal3 0.0521609f
Cred_5126 v_b v_c.$468.Metal3 0.00942654f
Cred_5127 v_b v_c.$472.Metal3 0.00942654f
Cred_5128 v_b v_c.$476.Metal3 0.0378615f
Cred_5129 v_b v_c.$481.Metal3 0.043561f
Cred_5130 v_b v_c.$485.Metal3 0.00947361f
Cred_5131 v_b v_c.$489.Metal3 0.00947361f
Cred_5132 v_b v_c.$493.Metal3 0.0484836f
Cred_5133 v_b v_c.$498.Metal3 0.0579623f
Cred_5134 v_b v_c.$502.Metal3 0.00942654f
Cred_5135 v_b v_c.$506.Metal3 0.00942654f
Cred_5136 v_b v_c.$93.Metal1 6.90507e-06f
Cred_5137 v_b v_c.$95.Metal1 0.00029997f
Cred_5138 v_b v_c.P0.pSD 1.94162e-06f
Cred_5139 v_b v_c.P10.nSD 0.000176023f
Cred_5140 v_b v_c.P10.pSD 0.000222911f
Cred_5141 v_b v_c.P2.pSD 1.82657e-06f
Cred_5142 v_b v_c.P4.pSD 2.62079e-06f
Cred_5143 v_b v_c.P6.nSD 0.000105413f
Cred_5144 v_b v_c.P6.pSD 0.000220177f
Cred_5145 v_b v_c.P8.pSD 0.00966648f
Cred_5146 v_b VDD.$215.Metal1 7.5418e-05f
Cred_5147 v_b VDD.$29.Metal1 0.000297943f
Cred_5148 v_b VDD.$320.Metal1 0.000213803f
Cred_5149 v_b VDD.$359.Metal1 0.000213803f
Cred_5150 v_b VDD.$378.Metal1 7.50255e-06f
Cred_5151 v_b VDD.$382.Metal1 0.00789372f
Cred_5152 v_b VDD.$405.Metal1 1.02689e-05f
Cred_5153 v_b VDD.$477.Metal1 0.00541512f
Cred_5154 v_b VDD.$51.Metal1 0.00020957f
Cred_5155 v_b VDD.$519.Metal1 1.54656e-06f
Cred_5156 v_b VDD.$526.Metal1 0.010629f
Cred_5157 v_b VDD.$562.Metal2 0.0433797f
Cred_5158 v_b VDD.$569.Metal2 0.0907398f
Cred_5159 v_b VDD.$606.Metal2 0.0364151f
Cred_5160 v_b VDD.$607.Metal2 0.0299246f
Cred_5161 v_b VDD.$608.Metal2 0.00912336f
Cred_5162 v_b VDD.$614.Metal2 0.050726f
Cred_5163 v_b VDD.$615.Metal2 0.0527914f
Cred_5164 v_b VDD.$703.Metal2 0.0443355f
Cred_5165 v_b VDD.$709.Metal2 0.0523892f
Cred_5166 v_b VDD.$826.Metal2 0.000347266f
Cred_5167 v_b VDD.$90.Metal1 0.00020957f
Cred_5168 v_b VDD.$918.Metal3 0.00332339f
Cred_5169 v_b VDD.P0.nSD 0.0284135f
Cred_5170 v_b VDD.P0.pSD 3.98288e-06f
Cred_5171 v_b VDD.P1.pSD 0.00281141f
Cred_5172 v_b VDD.P10.pSD 0.00281149f
Cred_5173 v_b VDD.P11.pSD 4.06145e-06f
Cred_5174 v_b VDD.P3.pSD 0.00280743f
Cred_5175 v_b VDD.P7.pSD 0.00280743f
Cred_5176 v_b VSS.$211.Metal1 0.000655044f
Cred_5177 v_b VSS.$220.Metal1 0.0021301f
Cred_5178 v_b VSS.$255.Metal1 0.00363423f
Cred_5179 v_b VSS.$452.Metal2 0.000147828f
Cred_5180 v_b VSS.$548.Metal3 1.06351e-05f
Cred_5181 v_b VSS.P0.pSD 0.00169115f
Cred_5182 v_b.$161.Metal2 v_c.$129.Metal1 0.0839568f
Cred_5183 v_b.$161.Metal2 v_c.$131.Metal1 0.0461686f
Cred_5184 v_b.$161.Metal2 v_c.$133.Metal1 0.0439249f
Cred_5185 v_b.$161.Metal2 v_c.$135.Metal1 0.0324586f
Cred_5186 v_b.$161.Metal2 v_c.$136.Metal1 0.125847f
Cred_5187 v_b.$161.Metal2 v_c.$165.Metal1 0.0652266f
Cred_5188 v_b.$161.Metal2 v_c.$167.Metal1 0.0350046f
Cred_5189 v_b.$161.Metal2 v_c.$169.Metal1 0.0344708f
Cred_5190 v_b.$161.Metal2 v_c.$171.Metal1 0.0246452f
Cred_5191 v_b.$161.Metal2 v_c.$172.Metal1 0.0954925f
Cred_5192 v_b.$161.Metal2 v_c.$201.Metal1 0.0208755f
Cred_5193 v_b.$161.Metal2 v_c.$203.Metal1 0.0109728f
Cred_5194 v_b.$161.Metal2 v_c.$205.Metal1 0.0104015f
Cred_5195 v_b.$161.Metal2 v_c.$207.Metal1 0.00758999f
Cred_5196 v_b.$161.Metal2 v_c.$208.Metal1 0.0308591f
Cred_5197 v_b.$161.Metal2 v_c.$284.Metal2 4.3564e-05f
Cred_5198 v_b.$161.Metal2 v_c.$320.Metal2 0.198809f
Cred_5199 v_b.$161.Metal2 v_c.$322.Metal2 0.0536583f
Cred_5200 v_b.$161.Metal2 v_c.$324.Metal2 0.0510325f
Cred_5201 v_b.$161.Metal2 v_c.$326.Metal2 0.0484065f
Cred_5202 v_b.$161.Metal2 v_c.$328.Metal2 0.0461835f
Cred_5203 v_b.$161.Metal2 v_c.$330.Metal2 0.0438039f
Cred_5204 v_b.$161.Metal2 v_c.$332.Metal2 0.0443458f
Cred_5205 v_b.$161.Metal2 v_c.$334.Metal2 0.200815f
Cred_5206 v_b.$161.Metal2 v_c.$352.Metal2 0.154214f
Cred_5207 v_b.$161.Metal2 v_c.$354.Metal2 0.0416996f
Cred_5208 v_b.$161.Metal2 v_c.$356.Metal2 0.0396575f
Cred_5209 v_b.$161.Metal2 v_c.$358.Metal2 0.037348f
Cred_5210 v_b.$161.Metal2 v_c.$360.Metal2 0.0358842f
Cred_5211 v_b.$161.Metal2 v_c.$362.Metal2 0.0348951f
Cred_5212 v_b.$161.Metal2 v_c.$364.Metal2 0.0341931f
Cred_5213 v_b.$161.Metal2 v_c.$366.Metal2 0.155213f
Cred_5214 v_b.$161.Metal2 v_c.$384.Metal2 0.050921f
Cred_5215 v_b.$161.Metal2 v_c.$386.Metal2 0.0137153f
Cred_5216 v_b.$161.Metal2 v_c.$388.Metal2 0.0130407f
Cred_5217 v_b.$161.Metal2 v_c.$390.Metal2 0.0123719f
Cred_5218 v_b.$161.Metal2 v_c.$392.Metal2 0.0118006f
Cred_5219 v_b.$161.Metal2 v_c.$394.Metal2 0.0113178f
Cred_5220 v_b.$161.Metal2 v_c.$396.Metal2 0.0113172f
Cred_5221 v_b.$161.Metal2 v_c.$398.Metal2 0.0510754f
Cred_5222 v_b.$161.Metal2 v_c.$425.Metal3 0.0191344f
Cred_5223 v_b.$161.Metal2 v_c.$446.Metal3 0.00543342f
Cred_5224 v_b.$161.Metal2 v_c.$459.Metal3 0.391462f
Cred_5225 v_b.$161.Metal2 v_c.$464.Metal3 0.0526172f
Cred_5226 v_b.$161.Metal2 v_c.$468.Metal3 0.0326836f
Cred_5227 v_b.$161.Metal2 v_c.$472.Metal3 0.0520497f
Cred_5228 v_b.$161.Metal2 v_c.$476.Metal3 0.284272f
Cred_5229 v_b.$161.Metal2 v_c.$481.Metal3 0.0414919f
Cred_5230 v_b.$161.Metal2 v_c.$485.Metal3 0.0260998f
Cred_5231 v_b.$161.Metal2 v_c.$489.Metal3 0.0412758f
Cred_5232 v_b.$161.Metal2 v_c.$493.Metal3 0.0916246f
Cred_5233 v_b.$161.Metal2 v_c.$498.Metal3 0.0135408f
Cred_5234 v_b.$161.Metal2 v_c.$502.Metal3 0.008595f
Cred_5235 v_b.$161.Metal2 v_c.$506.Metal3 0.0135111f
Cred_5236 v_b.$161.Metal2 v_c.P0.nSD 0.121615f
Cred_5237 v_b.$161.Metal2 v_c.P0.pSD 0.0280309f
Cred_5238 v_b.$161.Metal2 v_c.P10.nSD 0.000134523f
Cred_5239 v_b.$161.Metal2 v_c.P2.nSD 0.0918026f
Cred_5240 v_b.$161.Metal2 v_c.P2.pSD 0.0212903f
Cred_5241 v_b.$161.Metal2 v_c.P4.nSD 0.0292468f
Cred_5242 v_b.$161.Metal2 v_c.P4.pSD 0.00690858f
Cred_5243 v_b.$161.Metal2 VDD.$382.Metal1 0.0240263f
Cred_5244 v_b.$161.Metal2 VDD.$477.Metal1 0.0428431f
Cred_5245 v_b.$161.Metal2 VDD.$484.Metal1 0.000451019f
Cred_5246 v_b.$161.Metal2 VDD.$495.Metal1 0.000214535f
Cred_5247 v_b.$161.Metal2 VDD.$526.Metal1 0.0084008f
Cred_5248 v_b.$161.Metal2 VDD.$798.Metal2 0.00084758f
Cred_5249 v_b.$161.Metal2 VDD.$802.Metal2 7.46287e-07f
Cred_5250 v_b.$161.Metal2 VDD.P0.nSD 0.144644f
Cred_5251 v_b.$161.Metal2 VSS.$211.Metal1 0.0116459f
Cred_5252 v_b.$161.Metal2 VSS.$220.Metal1 0.0972604f
Cred_5253 v_b.$161.Metal2 VSS.$231.Metal1 0.000969262f
Cred_5254 v_b.$161.Metal2 VSS.$255.Metal1 0.0139171f
Cred_5255 v_b.$161.Metal2 VSS.$424.Metal2 4.25693e-07f
Cred_5256 v_b.$161.Metal2 VSS.$428.Metal2 0.000776029f
Cred_5257 v_b.$161.Metal2 VSS.$436.Metal2 0.000774987f
Cred_5258 v_b.$161.Metal2 VSS.$452.Metal2 0.000566102f
Cred_5259 v_b.$161.Metal2 VSS.$536.Metal3 6.21367e-06f
Cred_5260 v_b.$161.Metal2 VSS.$548.Metal3 4.07267e-05f
Cred_5261 v_b.$161.Metal2 VSS.P0.pSD 0.0317854f
Cred_5262 v_b.$195.Metal2 v_c 0.142584f
Cred_5263 v_b.$195.Metal2 v_c.$129.Metal1 3.56851e-05f
Cred_5264 v_b.$195.Metal2 v_c.$165.Metal1 0.0211247f
Cred_5265 v_b.$195.Metal2 v_c.$167.Metal1 0.0118608f
Cred_5266 v_b.$195.Metal2 v_c.$169.Metal1 0.0114431f
Cred_5267 v_b.$195.Metal2 v_c.$171.Metal1 0.00844792f
Cred_5268 v_b.$195.Metal2 v_c.$172.Metal1 0.0332031f
Cred_5269 v_b.$195.Metal2 v_c.$201.Metal1 0.0658311f
Cred_5270 v_b.$195.Metal2 v_c.$203.Metal1 0.0353457f
Cred_5271 v_b.$195.Metal2 v_c.$205.Metal1 0.0340376f
Cred_5272 v_b.$195.Metal2 v_c.$207.Metal1 0.0248374f
Cred_5273 v_b.$195.Metal2 v_c.$208.Metal1 0.0955041f
Cred_5274 v_b.$195.Metal2 v_c.$21.Metal1 2.29054e-06f
Cred_5275 v_b.$195.Metal2 v_c.$220.Metal2 0.000452862f
Cred_5276 v_b.$195.Metal2 v_c.$224.Metal2 0.00013171f
Cred_5277 v_b.$195.Metal2 v_c.$226.Metal2 6.18025e-06f
Cred_5278 v_b.$195.Metal2 v_c.$228.Metal2 0.000416566f
Cred_5279 v_b.$195.Metal2 v_c.$23.Metal1 9.82849e-05f
Cred_5280 v_b.$195.Metal2 v_c.$284.Metal2 0.000495447f
Cred_5281 v_b.$195.Metal2 v_c.$288.Metal2 0.000138676f
Cred_5282 v_b.$195.Metal2 v_c.$290.Metal2 1.07936e-05f
Cred_5283 v_b.$195.Metal2 v_c.$292.Metal2 0.000423999f
Cred_5284 v_b.$195.Metal2 v_c.$320.Metal2 0.000769869f
Cred_5285 v_b.$195.Metal2 v_c.$330.Metal2 2.50713e-05f
Cred_5286 v_b.$195.Metal2 v_c.$332.Metal2 5.03435e-05f
Cred_5287 v_b.$195.Metal2 v_c.$334.Metal2 2.50713e-05f
Cred_5288 v_b.$195.Metal2 v_c.$352.Metal2 0.0514592f
Cred_5289 v_b.$195.Metal2 v_c.$354.Metal2 0.0137133f
Cred_5290 v_b.$195.Metal2 v_c.$356.Metal2 0.0130413f
Cred_5291 v_b.$195.Metal2 v_c.$358.Metal2 0.0126288f
Cred_5292 v_b.$195.Metal2 v_c.$360.Metal2 0.0118057f
Cred_5293 v_b.$195.Metal2 v_c.$362.Metal2 0.0113467f
Cred_5294 v_b.$195.Metal2 v_c.$364.Metal2 0.0116287f
Cred_5295 v_b.$195.Metal2 v_c.$366.Metal2 0.0519297f
Cred_5296 v_b.$195.Metal2 v_c.$384.Metal2 0.170093f
Cred_5297 v_b.$195.Metal2 v_c.$386.Metal2 0.0414039f
Cred_5298 v_b.$195.Metal2 v_c.$388.Metal2 0.0393751f
Cred_5299 v_b.$195.Metal2 v_c.$390.Metal2 0.0373486f
Cred_5300 v_b.$195.Metal2 v_c.$392.Metal2 0.0356343f
Cred_5301 v_b.$195.Metal2 v_c.$394.Metal2 0.0341985f
Cred_5302 v_b.$195.Metal2 v_c.$396.Metal2 0.0342503f
Cred_5303 v_b.$195.Metal2 v_c.$398.Metal2 0.154648f
Cred_5304 v_b.$195.Metal2 v_c.$411.Metal3 0.0122409f
Cred_5305 v_b.$195.Metal2 v_c.$415.Metal3 0.00573072f
Cred_5306 v_b.$195.Metal2 v_c.$425.Metal3 0.0457658f
Cred_5307 v_b.$195.Metal2 v_c.$446.Metal3 0.0230209f
Cred_5308 v_b.$195.Metal2 v_c.$450.Metal3 0.00608369f
Cred_5309 v_b.$195.Metal2 v_c.$459.Metal3 0.0215578f
Cred_5310 v_b.$195.Metal2 v_c.$464.Metal3 0.019472f
Cred_5311 v_b.$195.Metal2 v_c.$468.Metal3 0.00312696f
Cred_5312 v_b.$195.Metal2 v_c.$472.Metal3 0.00312696f
Cred_5313 v_b.$195.Metal2 v_c.$476.Metal3 0.107327f
Cred_5314 v_b.$195.Metal2 v_c.$481.Metal3 0.0316155f
Cred_5315 v_b.$195.Metal2 v_c.$485.Metal3 0.0111916f
Cred_5316 v_b.$195.Metal2 v_c.$489.Metal3 0.0163339f
Cred_5317 v_b.$195.Metal2 v_c.$493.Metal3 0.350867f
Cred_5318 v_b.$195.Metal2 v_c.$498.Metal3 0.0807669f
Cred_5319 v_b.$195.Metal2 v_c.$502.Metal3 0.0283662f
Cred_5320 v_b.$195.Metal2 v_c.$506.Metal3 0.0435856f
Cred_5321 v_b.$195.Metal2 v_c.$93.Metal1 2.29054e-06f
Cred_5322 v_b.$195.Metal2 v_c.$95.Metal1 9.95057e-05f
Cred_5323 v_b.$195.Metal2 v_c.P0.pSD 6.77272e-07f
Cred_5324 v_b.$195.Metal2 v_c.P10.nSD 5.90854e-05f
Cred_5325 v_b.$195.Metal2 v_c.P10.pSD 7.39439e-05f
Cred_5326 v_b.$195.Metal2 v_c.P2.nSD 0.0302963f
Cred_5327 v_b.$195.Metal2 v_c.P2.pSD 0.00733391f
Cred_5328 v_b.$195.Metal2 v_c.P4.nSD 0.0914984f
Cred_5329 v_b.$195.Metal2 v_c.P4.pSD 0.0213098f
Cred_5330 v_b.$195.Metal2 v_c.P6.nSD 3.1958e-05f
Cred_5331 v_b.$195.Metal2 v_c.P6.pSD 7.30369e-05f
Cred_5332 v_b.$195.Metal2 v_c.P8.pSD 0.0033358f
Cred_5333 v_b.$195.Metal2 VDD.$382.Metal1 0.0151951f
Cred_5334 v_b.$195.Metal2 VDD.$477.Metal1 0.00910064f
Cred_5335 v_b.$195.Metal2 VDD.$519.Metal1 0.000771919f
Cred_5336 v_b.$195.Metal2 VDD.$526.Metal1 0.075569f
Cred_5337 v_b.$195.Metal2 VDD.$826.Metal2 0.00721918f
Cred_5338 v_b.$195.Metal2 VDD.$918.Metal3 0.00515252f
Cred_5339 v_b.$195.Metal2 VDD.P0.nSD 0.218412f
Cred_5340 v_b.$195.Metal2 VSS.$211.Metal1 0.00021729f
Cred_5341 v_b.$195.Metal2 VSS.$220.Metal1 0.0426797f
Cred_5342 v_b.$195.Metal2 VSS.$255.Metal1 0.0574778f
Cred_5343 v_b.$195.Metal2 VSS.$452.Metal2 0.020491f
Cred_5344 v_b.$195.Metal2 VSS.$548.Metal3 0.0015294f
Cred_5345 v_b.$195.Metal2 VSS.P0.pSD 0.0519183f
Cred_5346 v_b.P0.nSD v_c.$129.Metal1 0.000296417f
Cred_5347 v_b.P0.nSD v_c.$131.Metal1 0.000157058f
Cred_5348 v_b.P0.nSD v_c.$133.Metal1 0.000151668f
Cred_5349 v_b.P0.nSD v_c.$135.Metal1 0.000110674f
Cred_5350 v_b.P0.nSD v_c.$136.Metal1 0.000440264f
Cred_5351 v_b.P0.nSD v_c.$284.Metal2 4.52065e-07f
Cred_5352 v_b.P0.nSD v_c.$320.Metal2 0.000709956f
Cred_5353 v_b.P0.nSD v_c.$322.Metal2 0.000187965f
Cred_5354 v_b.P0.nSD v_c.$324.Metal2 0.000178757f
Cred_5355 v_b.P0.nSD v_c.$326.Metal2 0.000169566f
Cred_5356 v_b.P0.nSD v_c.$328.Metal2 0.000161734f
Cred_5357 v_b.P0.nSD v_c.$330.Metal2 0.000155115f
Cred_5358 v_b.P0.nSD v_c.$332.Metal2 0.000155344f
Cred_5359 v_b.P0.nSD v_c.$334.Metal2 0.000703611f
Cred_5360 v_b.P0.nSD v_c.$425.Metal3 0.000198559f
Cred_5361 v_b.P0.nSD v_c.$446.Metal3 5.63828e-05f
Cred_5362 v_b.P0.nSD v_c.$459.Metal3 0.0261286f
Cred_5363 v_b.P0.nSD v_c.$464.Metal3 0.000193114f
Cred_5364 v_b.P0.nSD v_c.$468.Metal3 0.000122236f
Cred_5365 v_b.P0.nSD v_c.$472.Metal3 0.000189755f
Cred_5366 v_b.P0.nSD v_c.P0.nSD 0.0302569f
Cred_5367 v_b.P0.nSD v_c.P0.pSD 9.87164e-05f
Cred_5368 v_b.P0.nSD v_c.P10.nSD 2.85753e-06f
Cred_5369 v_b.P0.nSD VDD.$382.Metal1 0.00010796f
Cred_5370 v_b.P0.nSD VDD.$477.Metal1 0.000278068f
Cred_5371 v_b.P0.nSD VDD.$484.Metal1 3.30116e-06f
Cred_5372 v_b.P0.nSD VDD.$495.Metal1 1.57025e-06f
Cred_5373 v_b.P0.nSD VDD.$526.Metal1 2.07866e-05f
Cred_5374 v_b.P0.nSD VDD.$798.Metal2 6.20372e-06f
Cred_5375 v_b.P0.nSD VDD.$802.Metal2 5.46232e-09f
Cred_5376 v_b.P0.nSD VDD.P0.nSD 0.000589061f
Cred_5377 v_b.P0.nSD VSS.$211.Metal1 0.00879094f
Cred_5378 v_b.P0.nSD VSS.$220.Metal1 0.0131509f
Cred_5379 v_b.P0.nSD VSS.$231.Metal1 0.000945944f
Cred_5380 v_b.P0.nSD VSS.$255.Metal1 0.000326251f
Cred_5381 v_b.P0.nSD VSS.$424.Metal2 4.17873e-07f
Cred_5382 v_b.P0.nSD VSS.$428.Metal2 7.4136e-05f
Cred_5383 v_b.P0.nSD VSS.$436.Metal2 7.31128e-05f
Cred_5384 v_b.P0.nSD VSS.$452.Metal2 1.32708e-05f
Cred_5385 v_b.P0.nSD VSS.$536.Metal3 5.86202e-07f
Cred_5386 v_b.P0.nSD VSS.$548.Metal3 9.54731e-07f
Cred_5387 v_b.P0.nSD VSS.P0.pSD 0.00194185f
Cred_5388 v_b.P0.pSD v_c.$129.Metal1 0.069819f
Cred_5389 v_b.P0.pSD v_c.$131.Metal1 0.0411889f
Cred_5390 v_b.P0.pSD v_c.$133.Metal1 0.0419622f
Cred_5391 v_b.P0.pSD v_c.$135.Metal1 0.032043f
Cred_5392 v_b.P0.pSD v_c.$136.Metal1 0.134675f
Cred_5393 v_b.P0.pSD v_c.$284.Metal2 1.15771e-06f
Cred_5394 v_b.P0.pSD v_c.$320.Metal2 0.0451876f
Cred_5395 v_b.P0.pSD v_c.$322.Metal2 0.0176566f
Cred_5396 v_b.P0.pSD v_c.$324.Metal2 0.0192564f
Cred_5397 v_b.P0.pSD v_c.$326.Metal2 0.0203478f
Cred_5398 v_b.P0.pSD v_c.$328.Metal2 0.0214278f
Cred_5399 v_b.P0.pSD v_c.$330.Metal2 0.0222217f
Cred_5400 v_b.P0.pSD v_c.$332.Metal2 0.0246747f
Cred_5401 v_b.P0.pSD v_c.$334.Metal2 0.133647f
Cred_5402 v_b.P0.pSD v_c.$425.Metal3 0.000508498f
Cred_5403 v_b.P0.pSD v_c.$446.Metal3 0.000144393f
Cred_5404 v_b.P0.pSD v_c.$459.Metal3 0.0188725f
Cred_5405 v_b.P0.pSD v_c.$464.Metal3 0.0117002f
Cred_5406 v_b.P0.pSD v_c.$468.Metal3 0.0115895f
Cred_5407 v_b.P0.pSD v_c.$472.Metal3 0.0343656f
Cred_5408 v_b.P0.pSD v_c.P0.nSD 0.00160541f
Cred_5409 v_b.P0.pSD v_c.P0.pSD 0.0256041f
Cred_5410 v_b.P0.pSD v_c.P10.nSD 3.57495e-06f
Cred_5411 v_b.P0.pSD VDD.$382.Metal1 0.0136105f
Cred_5412 v_b.P0.pSD VDD.$477.Metal1 0.0693344f
Cred_5413 v_b.P0.pSD VDD.$484.Metal1 0.00182685f
Cred_5414 v_b.P0.pSD VDD.$495.Metal1 0.000868972f
Cred_5415 v_b.P0.pSD VDD.$526.Metal1 0.00202131f
Cred_5416 v_b.P0.pSD VDD.$798.Metal2 0.00112896f
Cred_5417 v_b.P0.pSD VDD.$802.Metal2 3.02283e-06f
Cred_5418 v_b.P0.pSD VDD.P0.nSD 0.0891613f
Cred_5419 v_b.P0.pSD VSS.$211.Metal1 0.000309491f
Cred_5420 v_b.P0.pSD VSS.$220.Metal1 0.00141849f
Cred_5421 v_b.P0.pSD VSS.$231.Metal1 2.57581e-05f
Cred_5422 v_b.P0.pSD VSS.$255.Metal1 6.53788e-05f
Cred_5423 v_b.P0.pSD VSS.$424.Metal2 1.13128e-08f
Cred_5424 v_b.P0.pSD VSS.$428.Metal2 2.0623e-05f
Cred_5425 v_b.P0.pSD VSS.$436.Metal2 2.05953e-05f
Cred_5426 v_b.P0.pSD VSS.$452.Metal2 2.65939e-06f
Cred_5427 v_b.P0.pSD VSS.$536.Metal3 1.65128e-07f
Cred_5428 v_b.P0.pSD VSS.$548.Metal3 1.91323e-07f
Cred_5429 v_b.P0.pSD VSS.P0.pSD 0.000216019f
Cred_5430 v_b.P1.nSD v_c.$459.Metal3 0.0216253f
Cred_5431 v_b.P1.nSD v_c.$476.Metal3 0.0214365f
Cred_5432 v_b.P1.nSD v_c.P0.nSD 0.0279147f
Cred_5433 v_b.P1.nSD v_c.P2.nSD 0.0276512f
Cred_5434 v_b.P1.nSD VSS.$220.Metal1 0.00278514f
Cred_5435 v_b.P1.nSD VSS.$255.Metal1 0.000562423f
Cred_5436 v_b.P1.nSD VSS.$452.Metal2 2.28775e-05f
Cred_5437 v_b.P1.nSD VSS.$548.Metal3 1.64586e-06f
Cred_5438 v_b.P1.nSD VSS.P0.pSD 0.00128414f
Cred_5439 v_b.P1.pSD v_c.$129.Metal1 0.063706f
Cred_5440 v_b.P1.pSD v_c.$131.Metal1 0.0404028f
Cred_5441 v_b.P1.pSD v_c.$133.Metal1 0.0401435f
Cred_5442 v_b.P1.pSD v_c.$135.Metal1 0.0314611f
Cred_5443 v_b.P1.pSD v_c.$136.Metal1 0.126282f
Cred_5444 v_b.P1.pSD v_c.$165.Metal1 0.0646083f
Cred_5445 v_b.P1.pSD v_c.$167.Metal1 0.0378423f
Cred_5446 v_b.P1.pSD v_c.$169.Metal1 0.0398299f
Cred_5447 v_b.P1.pSD v_c.$171.Metal1 0.0293937f
Cred_5448 v_b.P1.pSD v_c.$172.Metal1 0.119471f
Cred_5449 v_b.P1.pSD v_c.$320.Metal2 0.0347596f
Cred_5450 v_b.P1.pSD v_c.$322.Metal2 0.0147173f
Cred_5451 v_b.P1.pSD v_c.$324.Metal2 0.0164258f
Cred_5452 v_b.P1.pSD v_c.$326.Metal2 0.017623f
Cred_5453 v_b.P1.pSD v_c.$328.Metal2 0.0187944f
Cred_5454 v_b.P1.pSD v_c.$330.Metal2 0.0192458f
Cred_5455 v_b.P1.pSD v_c.$332.Metal2 0.0220471f
Cred_5456 v_b.P1.pSD v_c.$334.Metal2 0.121266f
Cred_5457 v_b.P1.pSD v_c.$352.Metal2 0.0348021f
Cred_5458 v_b.P1.pSD v_c.$354.Metal2 0.0147205f
Cred_5459 v_b.P1.pSD v_c.$356.Metal2 0.0164203f
Cred_5460 v_b.P1.pSD v_c.$358.Metal2 0.0172504f
Cred_5461 v_b.P1.pSD v_c.$360.Metal2 0.0187801f
Cred_5462 v_b.P1.pSD v_c.$362.Metal2 0.0200595f
Cred_5463 v_b.P1.pSD v_c.$364.Metal2 0.0215347f
Cred_5464 v_b.P1.pSD v_c.$366.Metal2 0.119118f
Cred_5465 v_b.P1.pSD v_c.$459.Metal3 0.00615378f
Cred_5466 v_b.P1.pSD v_c.$464.Metal3 0.00884036f
Cred_5467 v_b.P1.pSD v_c.$468.Metal3 0.00908832f
Cred_5468 v_b.P1.pSD v_c.$472.Metal3 0.0288612f
Cred_5469 v_b.P1.pSD v_c.$476.Metal3 0.00615465f
Cred_5470 v_b.P1.pSD v_c.$481.Metal3 0.00932553f
Cred_5471 v_b.P1.pSD v_c.$485.Metal3 0.00999281f
Cred_5472 v_b.P1.pSD v_c.$489.Metal3 0.0308249f
Cred_5473 v_b.P1.pSD v_c.P0.pSD 0.0238217f
Cred_5474 v_b.P1.pSD v_c.P2.pSD 0.0226032f
Cred_5475 v_b.P1.pSD VDD.$382.Metal1 0.00104606f
Cred_5476 v_b.P1.pSD VDD.$477.Metal1 0.000547165f
Cred_5477 v_b.P1.pSD VDD.$526.Metal1 0.000514573f
Cred_5478 v_b.P1.pSD VDD.P0.nSD 0.00665935f
Cred_5479 v_b.P3.nSD v_c.$165.Metal1 0.000175421f
Cred_5480 v_b.P3.nSD v_c.$167.Metal1 9.86544e-05f
Cred_5481 v_b.P3.nSD v_c.$169.Metal1 9.51801e-05f
Cred_5482 v_b.P3.nSD v_c.$171.Metal1 7.0267e-05f
Cred_5483 v_b.P3.nSD v_c.$172.Metal1 0.000276172f
Cred_5484 v_b.P3.nSD v_c.$201.Metal1 0.000173635f
Cred_5485 v_b.P3.nSD v_c.$203.Metal1 9.12678e-05f
Cred_5486 v_b.P3.nSD v_c.$205.Metal1 8.6516e-05f
Cred_5487 v_b.P3.nSD v_c.$207.Metal1 6.3131e-05f
Cred_5488 v_b.P3.nSD v_c.$208.Metal1 0.000256676f
Cred_5489 v_b.P3.nSD v_c.$352.Metal2 0.000421821f
Cred_5490 v_b.P3.nSD v_c.$354.Metal2 0.000114063f
Cred_5491 v_b.P3.nSD v_c.$356.Metal2 0.000108473f
Cred_5492 v_b.P3.nSD v_c.$358.Metal2 0.000105042f
Cred_5493 v_b.P3.nSD v_c.$360.Metal2 9.81959e-05f
Cred_5494 v_b.P3.nSD v_c.$362.Metal2 9.41686e-05f
Cred_5495 v_b.P3.nSD v_c.$364.Metal2 9.63027e-05f
Cred_5496 v_b.P3.nSD v_c.$366.Metal2 0.000431725f
Cred_5497 v_b.P3.nSD v_c.$384.Metal2 0.000423544f
Cred_5498 v_b.P3.nSD v_c.$386.Metal2 0.000114079f
Cred_5499 v_b.P3.nSD v_c.$388.Metal2 0.000108468f
Cred_5500 v_b.P3.nSD v_c.$390.Metal2 0.000102906f
Cred_5501 v_b.P3.nSD v_c.$392.Metal2 9.81534e-05f
Cred_5502 v_b.P3.nSD v_c.$394.Metal2 9.41377e-05f
Cred_5503 v_b.P3.nSD v_c.$396.Metal2 9.41329e-05f
Cred_5504 v_b.P3.nSD v_c.$398.Metal2 0.000424828f
Cred_5505 v_b.P3.nSD v_c.$476.Metal3 0.0224107f
Cred_5506 v_b.P3.nSD v_c.$481.Metal3 0.000110422f
Cred_5507 v_b.P3.nSD v_c.$485.Metal3 6.69492e-05f
Cred_5508 v_b.P3.nSD v_c.$489.Metal3 0.000109721f
Cred_5509 v_b.P3.nSD v_c.$493.Metal3 0.0211758f
Cred_5510 v_b.P3.nSD v_c.$498.Metal3 0.000112628f
Cred_5511 v_b.P3.nSD v_c.$502.Metal3 7.14903e-05f
Cred_5512 v_b.P3.nSD v_c.$506.Metal3 0.00011238f
Cred_5513 v_b.P3.nSD v_c.P2.nSD 0.0281669f
Cred_5514 v_b.P3.nSD v_c.P2.pSD 6.09956e-05f
Cred_5515 v_b.P3.nSD v_c.P4.nSD 0.0262387f
Cred_5516 v_b.P3.nSD v_c.P4.pSD 5.74633e-05f
Cred_5517 v_b.P3.nSD VDD.$382.Metal1 2.18491e-05f
Cred_5518 v_b.P3.nSD VDD.$477.Metal1 1.14287e-05f
Cred_5519 v_b.P3.nSD VDD.$526.Metal1 1.9117e-05f
Cred_5520 v_b.P3.nSD VDD.P0.nSD 0.000184156f
Cred_5521 v_b.P3.nSD VSS.$220.Metal1 0.00217984f
Cred_5522 v_b.P3.nSD VSS.$255.Metal1 0.000895465f
Cred_5523 v_b.P3.nSD VSS.$452.Metal2 3.64245e-05f
Cred_5524 v_b.P3.nSD VSS.$548.Metal3 2.62046e-06f
Cred_5525 v_b.P3.nSD VSS.P0.pSD 0.0016529f
Cred_5526 v_b.P3.pSD v_c.$165.Metal1 0.0635453f
Cred_5527 v_b.P3.pSD v_c.$167.Metal1 0.0399521f
Cred_5528 v_b.P3.pSD v_c.$169.Metal1 0.0407656f
Cred_5529 v_b.P3.pSD v_c.$171.Metal1 0.0315453f
Cred_5530 v_b.P3.pSD v_c.$172.Metal1 0.131449f
Cred_5531 v_b.P3.pSD v_c.$201.Metal1 0.0628411f
Cred_5532 v_b.P3.pSD v_c.$203.Metal1 0.036935f
Cred_5533 v_b.P3.pSD v_c.$205.Metal1 0.0370449f
Cred_5534 v_b.P3.pSD v_c.$207.Metal1 0.0283419f
Cred_5535 v_b.P3.pSD v_c.$208.Metal1 0.121787f
Cred_5536 v_b.P3.pSD v_c.$352.Metal2 0.0363593f
Cred_5537 v_b.P3.pSD v_c.$354.Metal2 0.0151531f
Cred_5538 v_b.P3.pSD v_c.$356.Metal2 0.0168346f
Cred_5539 v_b.P3.pSD v_c.$358.Metal2 0.0183893f
Cred_5540 v_b.P3.pSD v_c.$360.Metal2 0.0191679f
Cred_5541 v_b.P3.pSD v_c.$362.Metal2 0.0200192f
Cred_5542 v_b.P3.pSD v_c.$364.Metal2 0.0229066f
Cred_5543 v_b.P3.pSD v_c.$366.Metal2 0.124664f
Cred_5544 v_b.P3.pSD v_c.$384.Metal2 0.0365248f
Cred_5545 v_b.P3.pSD v_c.$386.Metal2 0.0151542f
Cred_5546 v_b.P3.pSD v_c.$388.Metal2 0.0168209f
Cred_5547 v_b.P3.pSD v_c.$390.Metal2 0.0180056f
Cred_5548 v_b.P3.pSD v_c.$392.Metal2 0.0191492f
Cred_5549 v_b.P3.pSD v_c.$394.Metal2 0.0200085f
Cred_5550 v_b.P3.pSD v_c.$396.Metal2 0.0223398f
Cred_5551 v_b.P3.pSD v_c.$398.Metal2 0.121859f
Cred_5552 v_b.P3.pSD v_c.$476.Metal3 0.00912857f
Cred_5553 v_b.P3.pSD v_c.$481.Metal3 0.00926286f
Cred_5554 v_b.P3.pSD v_c.$485.Metal3 0.00971677f
Cred_5555 v_b.P3.pSD v_c.$489.Metal3 0.0301559f
Cred_5556 v_b.P3.pSD v_c.$493.Metal3 0.00907143f
Cred_5557 v_b.P3.pSD v_c.$498.Metal3 0.00945564f
Cred_5558 v_b.P3.pSD v_c.$502.Metal3 0.00996286f
Cred_5559 v_b.P3.pSD v_c.$506.Metal3 0.0307709f
Cred_5560 v_b.P3.pSD v_c.P2.nSD 0.00096419f
Cred_5561 v_b.P3.pSD v_c.P2.pSD 0.0249015f
Cred_5562 v_b.P3.pSD v_c.P4.nSD 0.000930791f
Cred_5563 v_b.P3.pSD v_c.P4.pSD 0.0231079f
Cred_5564 v_b.P3.pSD VDD.$382.Metal1 0.000873677f
Cred_5565 v_b.P3.pSD VDD.$477.Metal1 0.000456998f
Cred_5566 v_b.P3.pSD VDD.$526.Metal1 0.000743735f
Cred_5567 v_b.P3.pSD VDD.P0.nSD 0.00729663f
Cred_5568 v_b.P3.pSD VSS.$220.Metal1 0.000377299f
Cred_5569 v_b.P3.pSD VSS.$255.Metal1 0.000158222f
Cred_5570 v_b.P3.pSD VSS.$452.Metal2 6.43594e-06f
Cred_5571 v_b.P3.pSD VSS.$548.Metal3 4.63016e-07f
Cred_5572 v_b.P3.pSD VSS.P0.pSD 0.000287504f
Cred_5573 v_b.P5.nSD v_c.$493.Metal3 0.0222329f
Cred_5574 v_b.P5.nSD v_c.P4.nSD 0.0285916f
Cred_5575 v_b.P5.nSD VSS.$220.Metal1 0.00376988f
Cred_5576 v_b.P5.nSD VSS.$255.Metal1 0.0123626f
Cred_5577 v_b.P5.nSD VSS.$452.Metal2 0.000578928f
Cred_5578 v_b.P5.nSD VSS.$548.Metal3 3.98576e-05f
Cred_5579 v_b.P5.nSD VSS.P0.pSD 0.00676742f
Cred_5580 v_b.P5.pSD v_c.$201.Metal1 0.064852f
Cred_5581 v_b.P5.pSD v_c.$203.Metal1 0.039859f
Cred_5582 v_b.P5.pSD v_c.$205.Metal1 0.0408933f
Cred_5583 v_b.P5.pSD v_c.$207.Metal1 0.0312992f
Cred_5584 v_b.P5.pSD v_c.$208.Metal1 0.124237f
Cred_5585 v_b.P5.pSD v_c.$384.Metal2 0.0344505f
Cred_5586 v_b.P5.pSD v_c.$386.Metal2 0.0145651f
Cred_5587 v_b.P5.pSD v_c.$388.Metal2 0.0162556f
Cred_5588 v_b.P5.pSD v_c.$390.Metal2 0.0174383f
Cred_5589 v_b.P5.pSD v_c.$392.Metal2 0.0185966f
Cred_5590 v_b.P5.pSD v_c.$394.Metal2 0.0194523f
Cred_5591 v_b.P5.pSD v_c.$396.Metal2 0.0218169f
Cred_5592 v_b.P5.pSD v_c.$398.Metal2 0.119893f
Cred_5593 v_b.P5.pSD v_c.$493.Metal3 0.00931219f
Cred_5594 v_b.P5.pSD v_c.$498.Metal3 0.00908178f
Cred_5595 v_b.P5.pSD v_c.$502.Metal3 0.00961498f
Cred_5596 v_b.P5.pSD v_c.$506.Metal3 0.0296516f
Cred_5597 v_b.P5.pSD v_c.P4.pSD 0.0235018f
Cred_5598 v_b.P5.pSD VDD.$382.Metal1 0.00363234f
Cred_5599 v_b.P5.pSD VDD.$477.Metal1 0.00189998f
Cred_5600 v_b.P5.pSD VDD.$519.Metal1 0.00264378f
Cred_5601 v_b.P5.pSD VDD.$526.Metal1 0.0640961f
Cred_5602 v_b.P5.pSD VDD.$826.Metal2 0.00103184f
Cred_5603 v_b.P5.pSD VDD.P0.nSD 0.0906656f
Cred_5604 v_c VSS.$220.Metal1 0.000906883f
Cred_5605 v_c VSS.$255.Metal1 0.00506762f
Cred_5606 v_c VSS.$452.Metal2 0.00098143f
Cred_5607 v_c VSS.$548.Metal3 0.018438f
Cred_5608 v_c VSS.P0.pSD 0.00220466f
Cred_5609 v_c.$129.Metal1 VDD.$382.Metal1 0.00124337f
Cred_5610 v_c.$129.Metal1 VDD.$477.Metal1 0.000650572f
Cred_5611 v_c.$129.Metal1 VDD.$526.Metal1 0.000450706f
Cred_5612 v_c.$129.Metal1 VDD.P0.nSD 0.00684658f
Cred_5613 v_c.$165.Metal1 VDD.$382.Metal1 0.000879333f
Cred_5614 v_c.$165.Metal1 VDD.$477.Metal1 0.000459957f
Cred_5615 v_c.$165.Metal1 VDD.$526.Metal1 0.000621744f
Cred_5616 v_c.$165.Metal1 VDD.P0.nSD 0.00668793f
Cred_5617 v_c.$201.Metal1 VDD.$382.Metal1 0.000751541f
Cred_5618 v_c.$201.Metal1 VDD.$477.Metal1 0.000393112f
Cred_5619 v_c.$201.Metal1 VDD.$526.Metal1 0.000843226f
Cred_5620 v_c.$201.Metal1 VDD.P0.nSD 0.00719826f
Cred_5621 v_c.$21.Metal1 VDD.$382.Metal1 0.0061579f
Cred_5622 v_c.$21.Metal1 VDD.$477.Metal1 0.000225714f
Cred_5623 v_c.$21.Metal1 VDD.$526.Metal1 5.62183e-05f
Cred_5624 v_c.$21.Metal1 VDD.P0.nSD 0.00273079f
Cred_5625 v_c.$220.Metal2 VDD.$320.Metal1 4.39242e-08f
Cred_5626 v_c.$220.Metal2 VDD.$359.Metal1 4.39242e-08f
Cred_5627 v_c.$220.Metal2 VDD.$378.Metal1 3.28773e-07f
Cred_5628 v_c.$220.Metal2 VDD.$382.Metal1 0.000234238f
Cred_5629 v_c.$220.Metal2 VDD.$405.Metal1 4.49997e-07f
Cred_5630 v_c.$220.Metal2 VDD.$477.Metal1 7.8703e-06f
Cred_5631 v_c.$220.Metal2 VDD.$526.Metal1 1.96025e-06f
Cred_5632 v_c.$220.Metal2 VDD.$703.Metal2 6.79284e-06f
Cred_5633 v_c.$220.Metal2 VDD.P0.nSD 9.68805e-05f
Cred_5634 v_c.$220.Metal2 VDD.P10.pSD 8.88592e-10f
Cred_5635 v_c.$220.Metal2 VDD.P11.pSD 8.88592e-10f
Cred_5636 v_c.$220.Metal2 VSS.$129.Metal1 8.3436e-06f
Cred_5637 v_c.$220.Metal2 VSS.$220.Metal1 4.69683e-06f
Cred_5638 v_c.$220.Metal2 VSS.$87.Metal1 1.61695e-06f
Cred_5639 v_c.$220.Metal2 VSS.P0.pSD 4.1179e-06f
Cred_5640 v_c.$224.Metal2 VDD.$382.Metal1 2.02218e-05f
Cred_5641 v_c.$224.Metal2 VDD.$477.Metal1 7.41215e-07f
Cred_5642 v_c.$224.Metal2 VDD.$526.Metal1 1.84614e-07f
Cred_5643 v_c.$224.Metal2 VDD.P0.nSD 8.96756e-06f
Cred_5644 v_c.$228.Metal2 VDD.$382.Metal1 0.000109752f
Cred_5645 v_c.$228.Metal2 VDD.$477.Metal1 3.99623e-06f
Cred_5646 v_c.$228.Metal2 VDD.$526.Metal1 9.95339e-07f
Cred_5647 v_c.$228.Metal2 VDD.$708.Metal2 0.000150254f
Cred_5648 v_c.$228.Metal2 VDD.$709.Metal2 0.000332181f
Cred_5649 v_c.$228.Metal2 VDD.$710.Metal2 0.000399717f
Cred_5650 v_c.$228.Metal2 VDD.$711.Metal2 0.00045081f
Cred_5651 v_c.$228.Metal2 VDD.$712.Metal2 0.000487474f
Cred_5652 v_c.$228.Metal2 VDD.$713.Metal2 0.000511149f
Cred_5653 v_c.$228.Metal2 VDD.$714.Metal2 0.000688513f
Cred_5654 v_c.$228.Metal2 VDD.P0.nSD 4.84022e-05f
Cred_5655 v_c.$23.Metal1 VDD.$382.Metal1 2.34183e-05f
Cred_5656 v_c.$23.Metal1 VDD.$477.Metal1 8.52693e-07f
Cred_5657 v_c.$23.Metal1 VDD.$526.Metal1 2.12379e-07f
Cred_5658 v_c.$23.Metal1 VDD.$708.Metal2 3.40259e-05f
Cred_5659 v_c.$23.Metal1 VDD.$709.Metal2 7.89583e-05f
Cred_5660 v_c.$23.Metal1 VDD.$710.Metal2 9.87618e-05f
Cred_5661 v_c.$23.Metal1 VDD.$711.Metal2 0.000114773f
Cred_5662 v_c.$23.Metal1 VDD.$712.Metal2 0.000126855f
Cred_5663 v_c.$23.Metal1 VDD.$713.Metal2 0.000134937f
Cred_5664 v_c.$23.Metal1 VDD.$714.Metal2 0.000183053f
Cred_5665 v_c.$23.Metal1 VDD.P0.nSD 1.03278e-05f
Cred_5666 v_c.$284.Metal2 VDD.$382.Metal1 0.000127096f
Cred_5667 v_c.$284.Metal2 VDD.$477.Metal1 3.12543e-05f
Cred_5668 v_c.$284.Metal2 VDD.$526.Metal1 6.40063e-06f
Cred_5669 v_c.$284.Metal2 VDD.P0.nSD 0.000221081f
Cred_5670 v_c.$284.Metal2 VSS.$129.Metal1 2.72579e-06f
Cred_5671 v_c.$284.Metal2 VSS.$199.Metal1 1.24077e-10f
Cred_5672 v_c.$284.Metal2 VSS.$211.Metal1 5.86831e-06f
Cred_5673 v_c.$284.Metal2 VSS.$220.Metal1 3.32997e-05f
Cred_5674 v_c.$284.Metal2 VSS.$408.Metal2 3.10123e-08f
Cred_5675 v_c.$284.Metal2 VSS.$416.Metal2 6.25847e-08f
Cred_5676 v_c.$284.Metal2 VSS.$522.Metal3 1.93782e-06f
Cred_5677 v_c.$284.Metal2 VSS.$530.Metal3 2.13516e-05f
Cred_5678 v_c.$284.Metal2 VSS.$87.Metal1 5.75066e-07f
Cred_5679 v_c.$284.Metal2 VSS.P0.pSD 4.16434e-06f
Cred_5680 v_c.$288.Metal2 VDD.$382.Metal1 1.09231e-05f
Cred_5681 v_c.$288.Metal2 VDD.$477.Metal1 1.91342e-06f
Cred_5682 v_c.$288.Metal2 VDD.$526.Metal1 4.76574e-07f
Cred_5683 v_c.$288.Metal2 VDD.P0.nSD 1.6802e-05f
Cred_5684 v_c.$292.Metal2 VDD.$382.Metal1 5.91683e-05f
Cred_5685 v_c.$292.Metal2 VDD.$477.Metal1 1.01011e-05f
Cred_5686 v_c.$292.Metal2 VDD.$526.Metal1 2.51589e-06f
Cred_5687 v_c.$292.Metal2 VDD.P0.nSD 8.92597e-05f
Cred_5688 v_c.$320.Metal2 VDD.$382.Metal1 6.0098e-05f
Cred_5689 v_c.$320.Metal2 VDD.$477.Metal1 3.5458e-05f
Cred_5690 v_c.$320.Metal2 VDD.$526.Metal1 1.76043e-05f
Cred_5691 v_c.$320.Metal2 VDD.P0.nSD 0.000302439f
Cred_5692 v_c.$352.Metal2 VDD.$382.Metal1 0.000141314f
Cred_5693 v_c.$352.Metal2 VDD.$477.Metal1 7.39176e-05f
Cred_5694 v_c.$352.Metal2 VDD.$526.Metal1 9.99177e-05f
Cred_5695 v_c.$352.Metal2 VDD.P0.nSD 0.00107479f
Cred_5696 v_c.$384.Metal2 VDD.$382.Metal1 2.54438e-05f
Cred_5697 v_c.$384.Metal2 VDD.$477.Metal1 1.3309e-05f
Cred_5698 v_c.$384.Metal2 VDD.$526.Metal1 2.85478e-05f
Cred_5699 v_c.$384.Metal2 VDD.P0.nSD 0.0002437f
Cred_5700 v_c.$411.Metal3 VDD.$320.Metal1 5.47835e-06f
Cred_5701 v_c.$411.Metal3 VDD.$359.Metal1 5.47835e-06f
Cred_5702 v_c.$411.Metal3 VDD.$378.Metal1 4.10055e-05f
Cred_5703 v_c.$411.Metal3 VDD.$382.Metal1 0.00302053f
Cred_5704 v_c.$411.Metal3 VDD.$405.Metal1 5.61249e-05f
Cred_5705 v_c.$411.Metal3 VDD.$477.Metal1 2.14707e-05f
Cred_5706 v_c.$411.Metal3 VDD.$526.Metal1 5.34768e-06f
Cred_5707 v_c.$411.Metal3 VDD.$703.Metal2 0.000847222f
Cred_5708 v_c.$411.Metal3 VDD.P0.nSD 0.000467046f
Cred_5709 v_c.$411.Metal3 VDD.P10.pSD 1.10828e-07f
Cred_5710 v_c.$411.Metal3 VDD.P11.pSD 1.10828e-07f
Cred_5711 v_c.$411.Metal3 VSS.$129.Metal1 0.00104064f
Cred_5712 v_c.$411.Metal3 VSS.$220.Metal1 0.000585802f
Cred_5713 v_c.$411.Metal3 VSS.$87.Metal1 0.000201671f
Cred_5714 v_c.$411.Metal3 VSS.P0.pSD 0.000513596f
Cred_5715 v_c.$415.Metal3 VDD.$382.Metal1 0.00368795f
Cred_5716 v_c.$415.Metal3 VDD.$477.Metal1 0.000134283f
Cred_5717 v_c.$415.Metal3 VDD.$526.Metal1 3.34459e-05f
Cred_5718 v_c.$415.Metal3 VDD.$708.Metal2 0.002707f
Cred_5719 v_c.$415.Metal3 VDD.$709.Metal2 0.00429546f
Cred_5720 v_c.$415.Metal3 VDD.$710.Metal2 0.00419257f
Cred_5721 v_c.$415.Metal3 VDD.$711.Metal2 0.00411259f
Cred_5722 v_c.$415.Metal3 VDD.$712.Metal2 0.00405393f
Cred_5723 v_c.$415.Metal3 VDD.$713.Metal2 0.00401544f
Cred_5724 v_c.$415.Metal3 VDD.$714.Metal2 0.00526352f
Cred_5725 v_c.$415.Metal3 VDD.P0.nSD 0.00162644f
Cred_5726 v_c.$425.Metal3 VDD.$320.Metal1 9.90156e-07f
Cred_5727 v_c.$425.Metal3 VDD.$359.Metal1 9.90156e-07f
Cred_5728 v_c.$425.Metal3 VDD.$378.Metal1 7.41133e-06f
Cred_5729 v_c.$425.Metal3 VDD.$382.Metal1 0.0260401f
Cred_5730 v_c.$425.Metal3 VDD.$405.Metal1 1.0144e-05f
Cred_5731 v_c.$425.Metal3 VDD.$477.Metal1 0.00472729f
Cred_5732 v_c.$425.Metal3 VDD.$526.Metal1 0.000717597f
Cred_5733 v_c.$425.Metal3 VDD.$703.Metal2 0.000153127f
Cred_5734 v_c.$425.Metal3 VDD.P0.nSD 0.0272706f
Cred_5735 v_c.$425.Metal3 VDD.P10.pSD 2.0031e-08f
Cred_5736 v_c.$425.Metal3 VDD.P11.pSD 2.0031e-08f
Cred_5737 v_c.$425.Metal3 VSS.$129.Metal1 0.0101998f
Cred_5738 v_c.$425.Metal3 VSS.$199.Metal1 5.44979e-08f
Cred_5739 v_c.$425.Metal3 VSS.$211.Metal1 0.00257751f
Cred_5740 v_c.$425.Metal3 VSS.$220.Metal1 0.0237916f
Cred_5741 v_c.$425.Metal3 VSS.$408.Metal2 1.36214e-05f
Cred_5742 v_c.$425.Metal3 VSS.$416.Metal2 2.74888e-05f
Cred_5743 v_c.$425.Metal3 VSS.$522.Metal3 0.000851143f
Cred_5744 v_c.$425.Metal3 VSS.$530.Metal3 0.00937818f
Cred_5745 v_c.$425.Metal3 VSS.$87.Metal1 0.00204508f
Cred_5746 v_c.$425.Metal3 VSS.P0.pSD 0.00748937f
Cred_5747 v_c.$446.Metal3 VDD.$382.Metal1 0.00170248f
Cred_5748 v_c.$446.Metal3 VDD.$477.Metal1 0.00141957f
Cred_5749 v_c.$446.Metal3 VDD.$526.Metal1 0.000180973f
Cred_5750 v_c.$446.Metal3 VDD.P0.nSD 0.0058092f
Cred_5751 v_c.$446.Metal3 VSS.$129.Metal1 0.000339969f
Cred_5752 v_c.$446.Metal3 VSS.$199.Metal1 1.54752e-08f
Cred_5753 v_c.$446.Metal3 VSS.$211.Metal1 0.000731912f
Cred_5754 v_c.$446.Metal3 VSS.$220.Metal1 0.00415324f
Cred_5755 v_c.$446.Metal3 VSS.$408.Metal2 3.86794e-06f
Cred_5756 v_c.$446.Metal3 VSS.$416.Metal2 7.80574e-06f
Cred_5757 v_c.$446.Metal3 VSS.$522.Metal3 0.000241691f
Cred_5758 v_c.$446.Metal3 VSS.$530.Metal3 0.00266303f
Cred_5759 v_c.$446.Metal3 VSS.$87.Metal1 7.17238e-05f
Cred_5760 v_c.$446.Metal3 VSS.P0.pSD 0.000519388f
Cred_5761 v_c.$450.Metal3 VDD.$382.Metal1 0.0019882f
Cred_5762 v_c.$450.Metal3 VDD.$477.Metal1 0.000339424f
Cred_5763 v_c.$450.Metal3 VDD.$526.Metal1 8.454e-05f
Cred_5764 v_c.$450.Metal3 VDD.P0.nSD 0.00299935f
Cred_5765 v_c.$459.Metal3 VDD.$382.Metal1 0.00556031f
Cred_5766 v_c.$459.Metal3 VDD.$477.Metal1 0.00542834f
Cred_5767 v_c.$459.Metal3 VDD.$526.Metal1 0.00091029f
Cred_5768 v_c.$459.Metal3 VDD.P0.nSD 0.0228341f
Cred_5769 v_c.$459.Metal3 VSS.$129.Metal1 0.000401705f
Cred_5770 v_c.$459.Metal3 VSS.$199.Metal1 1.82855e-08f
Cred_5771 v_c.$459.Metal3 VSS.$211.Metal1 0.00506429f
Cred_5772 v_c.$459.Metal3 VSS.$220.Metal1 0.0291621f
Cred_5773 v_c.$459.Metal3 VSS.$255.Metal1 0.00116468f
Cred_5774 v_c.$459.Metal3 VSS.$408.Metal2 4.57034e-06f
Cred_5775 v_c.$459.Metal3 VSS.$416.Metal2 9.22322e-06f
Cred_5776 v_c.$459.Metal3 VSS.$424.Metal2 9.05281e-05f
Cred_5777 v_c.$459.Metal3 VSS.$428.Metal2 6.76563e-05f
Cred_5778 v_c.$459.Metal3 VSS.$452.Metal2 4.73754e-05f
Cred_5779 v_c.$459.Metal3 VSS.$522.Metal3 0.000285581f
Cred_5780 v_c.$459.Metal3 VSS.$530.Metal3 0.0112682f
Cred_5781 v_c.$459.Metal3 VSS.$536.Metal3 0.00843828f
Cred_5782 v_c.$459.Metal3 VSS.$548.Metal3 3.4083e-06f
Cred_5783 v_c.$459.Metal3 VSS.$87.Metal1 8.47485e-05f
Cred_5784 v_c.$459.Metal3 VSS.P0.pSD 0.00423258f
Cred_5785 v_c.$464.Metal3 VDD.$382.Metal1 0.000824626f
Cred_5786 v_c.$464.Metal3 VDD.$477.Metal1 0.000614929f
Cred_5787 v_c.$464.Metal3 VDD.$526.Metal1 0.000107796f
Cred_5788 v_c.$464.Metal3 VDD.P0.nSD 0.00323834f
Cred_5789 v_c.$468.Metal3 VDD.$382.Metal1 0.000762652f
Cred_5790 v_c.$468.Metal3 VDD.$477.Metal1 0.000398924f
Cred_5791 v_c.$468.Metal3 VDD.$526.Metal1 0.000275754f
Cred_5792 v_c.$468.Metal3 VDD.P0.nSD 0.00419452f
Cred_5793 v_c.$476.Metal3 VDD.$382.Metal1 0.00077981f
Cred_5794 v_c.$476.Metal3 VDD.$477.Metal1 0.000407899f
Cred_5795 v_c.$476.Metal3 VDD.$526.Metal1 0.000505992f
Cred_5796 v_c.$476.Metal3 VDD.P0.nSD 0.00566953f
Cred_5797 v_c.$476.Metal3 VSS.$220.Metal1 0.00599347f
Cred_5798 v_c.$476.Metal3 VSS.$255.Metal1 0.00195676f
Cred_5799 v_c.$476.Metal3 VSS.$452.Metal2 7.95942e-05f
Cred_5800 v_c.$476.Metal3 VSS.$548.Metal3 5.72619e-06f
Cred_5801 v_c.$476.Metal3 VSS.P0.pSD 0.00388442f
Cred_5802 v_c.$481.Metal3 VDD.$382.Metal1 5.48955e-06f
Cred_5803 v_c.$481.Metal3 VDD.$477.Metal1 2.87144e-06f
Cred_5804 v_c.$481.Metal3 VDD.$526.Metal1 3.88146e-06f
Cred_5805 v_c.$481.Metal3 VDD.P0.nSD 4.17518e-05f
Cred_5806 v_c.$485.Metal3 VDD.$382.Metal1 0.000525229f
Cred_5807 v_c.$485.Metal3 VDD.$477.Metal1 0.000274734f
Cred_5808 v_c.$485.Metal3 VDD.$526.Metal1 0.000336459f
Cred_5809 v_c.$485.Metal3 VDD.P0.nSD 0.00379359f
Cred_5810 v_c.$493.Metal3 VDD.$382.Metal1 0.000737078f
Cred_5811 v_c.$493.Metal3 VDD.$477.Metal1 0.000385547f
Cred_5812 v_c.$493.Metal3 VDD.$526.Metal1 0.00100359f
Cred_5813 v_c.$493.Metal3 VDD.P0.nSD 0.00770883f
Cred_5814 v_c.$493.Metal3 VSS.$220.Metal1 0.00586416f
Cred_5815 v_c.$493.Metal3 VSS.$255.Metal1 0.00650332f
Cred_5816 v_c.$493.Metal3 VSS.$452.Metal2 0.000519247f
Cred_5817 v_c.$493.Metal3 VSS.$548.Metal3 0.00730713f
Cred_5818 v_c.$493.Metal3 VSS.P0.pSD 0.00688032f
Cred_5819 v_c.$498.Metal3 VDD.$382.Metal1 9.41703e-07f
Cred_5820 v_c.$498.Metal3 VDD.$477.Metal1 4.92581e-07f
Cred_5821 v_c.$498.Metal3 VDD.$526.Metal1 1.05659e-06f
Cred_5822 v_c.$498.Metal3 VDD.P0.nSD 9.01963e-06f
Cred_5823 v_c.$502.Metal3 VDD.$382.Metal1 0.000507696f
Cred_5824 v_c.$502.Metal3 VDD.$477.Metal1 0.000265563f
Cred_5825 v_c.$502.Metal3 VDD.$526.Metal1 0.000554985f
Cred_5826 v_c.$502.Metal3 VDD.P0.nSD 0.00480075f
Cred_5827 v_c.$93.Metal1 VDD.$382.Metal1 0.00332629f
Cred_5828 v_c.$93.Metal1 VDD.$477.Metal1 0.000582672f
Cred_5829 v_c.$93.Metal1 VDD.$526.Metal1 0.000145126f
Cred_5830 v_c.$93.Metal1 VDD.P0.nSD 0.00511653f
Cred_5831 v_c.$95.Metal1 VDD.$382.Metal1 1.2625e-05f
Cred_5832 v_c.$95.Metal1 VDD.$477.Metal1 2.15532e-06f
Cred_5833 v_c.$95.Metal1 VDD.$526.Metal1 5.36825e-07f
Cred_5834 v_c.$95.Metal1 VDD.P0.nSD 1.90457e-05f
Cred_5835 v_c.P0.nSD VSS.$211.Metal1 3.20874e-05f
Cred_5836 v_c.P0.nSD VSS.$220.Metal1 0.00384165f
Cred_5837 v_c.P0.nSD VSS.$255.Metal1 0.000491444f
Cred_5838 v_c.P0.nSD VSS.$452.Metal2 1.99903e-05f
Cred_5839 v_c.P0.nSD VSS.$548.Metal3 1.43815e-06f
Cred_5840 v_c.P0.nSD VSS.P0.pSD 0.00125676f
Cred_5841 v_c.P0.pSD VDD.$382.Metal1 0.000576617f
Cred_5842 v_c.P0.pSD VDD.$477.Metal1 0.000301618f
Cred_5843 v_c.P0.pSD VDD.$526.Metal1 0.000210987f
Cred_5844 v_c.P0.pSD VDD.P0.nSD 0.00318912f
Cred_5845 v_c.P10.nSD VDD.$382.Metal1 2.15485e-05f
Cred_5846 v_c.P10.nSD VDD.$477.Metal1 1.88953e-05f
Cred_5847 v_c.P10.nSD VDD.$526.Metal1 1.94404e-06f
Cred_5848 v_c.P10.nSD VDD.P0.nSD 6.5508e-05f
Cred_5849 v_c.P10.nSD VSS.$129.Metal1 0.000829509f
Cred_5850 v_c.P10.nSD VSS.$199.Metal1 3.27372e-10f
Cred_5851 v_c.P10.nSD VSS.$211.Metal1 4.75088e-05f
Cred_5852 v_c.P10.nSD VSS.$220.Metal1 0.00371666f
Cred_5853 v_c.P10.nSD VSS.$408.Metal2 8.18245e-08f
Cred_5854 v_c.P10.nSD VSS.$416.Metal2 1.65127e-07f
Cred_5855 v_c.P10.nSD VSS.$522.Metal3 5.11286e-06f
Cred_5856 v_c.P10.nSD VSS.$530.Metal3 5.63352e-05f
Cred_5857 v_c.P10.nSD VSS.$87.Metal1 0.000175003f
Cred_5858 v_c.P10.nSD VSS.P0.pSD 0.000997368f
Cred_5859 v_c.P10.pSD VDD.$382.Metal1 0.00156889f
Cred_5860 v_c.P10.pSD VDD.$477.Metal1 0.000271968f
Cred_5861 v_c.P10.pSD VDD.$526.Metal1 6.77389e-05f
Cred_5862 v_c.P10.pSD VDD.P0.nSD 0.00239426f
Cred_5863 v_c.P2.nSD VSS.$220.Metal1 0.00313981f
Cred_5864 v_c.P2.nSD VSS.$255.Metal1 0.00102509f
Cred_5865 v_c.P2.nSD VSS.$452.Metal2 4.16971e-05f
Cred_5866 v_c.P2.nSD VSS.$548.Metal3 2.99979e-06f
Cred_5867 v_c.P2.nSD VSS.P0.pSD 0.00203494f
Cred_5868 v_c.P2.pSD VDD.$382.Metal1 0.000433069f
Cred_5869 v_c.P2.pSD VDD.$477.Metal1 0.000226528f
Cred_5870 v_c.P2.pSD VDD.$526.Metal1 0.000306208f
Cred_5871 v_c.P2.pSD VDD.P0.nSD 0.00329379f
Cred_5872 v_c.P4.nSD VSS.$220.Metal1 0.00220593f
Cred_5873 v_c.P4.nSD VSS.$255.Metal1 0.00130525f
Cred_5874 v_c.P4.nSD VSS.$452.Metal2 5.30931e-05f
Cred_5875 v_c.P4.nSD VSS.$548.Metal3 3.81964e-06f
Cred_5876 v_c.P4.nSD VSS.P0.pSD 0.00207527f
Cred_5877 v_c.P4.pSD VDD.$382.Metal1 0.000351345f
Cred_5878 v_c.P4.pSD VDD.$477.Metal1 0.000183779f
Cred_5879 v_c.P4.pSD VDD.$526.Metal1 0.000391098f
Cred_5880 v_c.P4.pSD VDD.P0.nSD 0.00335203f
Cred_5881 v_c.P6.nSD VDD.$320.Metal1 4.46381e-09f
Cred_5882 v_c.P6.nSD VDD.$359.Metal1 4.46381e-09f
Cred_5883 v_c.P6.nSD VDD.$378.Metal1 3.34116e-08f
Cred_5884 v_c.P6.nSD VDD.$382.Metal1 2.9824e-05f
Cred_5885 v_c.P6.nSD VDD.$405.Metal1 4.57311e-08f
Cred_5886 v_c.P6.nSD VDD.$477.Metal1 5.77876e-07f
Cred_5887 v_c.P6.nSD VDD.$526.Metal1 1.43931e-07f
Cred_5888 v_c.P6.nSD VDD.$703.Metal2 6.90325e-07f
Cred_5889 v_c.P6.nSD VDD.P0.nSD 7.34224e-06f
Cred_5890 v_c.P6.nSD VDD.P10.pSD 9.03034e-11f
Cred_5891 v_c.P6.nSD VDD.P11.pSD 9.03034e-11f
Cred_5892 v_c.P6.nSD VSS.$129.Metal1 0.00218834f
Cred_5893 v_c.P6.nSD VSS.$220.Metal1 0.00171389f
Cred_5894 v_c.P6.nSD VSS.$87.Metal1 0.000458445f
Cred_5895 v_c.P6.nSD VSS.P0.pSD 0.0013591f
Cred_5896 v_c.P6.pSD VDD.$382.Metal1 0.00287797f
Cred_5897 v_c.P6.pSD VDD.$477.Metal1 0.000107007f
Cred_5898 v_c.P6.pSD VDD.$526.Metal1 2.66521e-05f
Cred_5899 v_c.P6.pSD VDD.$708.Metal2 2.49755e-05f
Cred_5900 v_c.P6.pSD VDD.$709.Metal2 5.86625e-05f
Cred_5901 v_c.P6.pSD VDD.$710.Metal2 7.42095e-05f
Cred_5902 v_c.P6.pSD VDD.$711.Metal2 8.70876e-05f
Cred_5903 v_c.P6.pSD VDD.$712.Metal2 9.70041e-05f
Cred_5904 v_c.P6.pSD VDD.$713.Metal2 0.000103739f
Cred_5905 v_c.P6.pSD VDD.$714.Metal2 0.000141116f
Cred_5906 v_c.P6.pSD VDD.P0.nSD 0.00129155f
Cred_5907 v_c.P8.nSD VSS.$129.Metal1 0.00145152f
Cred_5908 v_c.P8.nSD VSS.$220.Metal1 0.00295235f
Cred_5909 v_c.P8.nSD VSS.$87.Metal1 0.00030623f
Cred_5910 v_c.P8.nSD VSS.P0.pSD 0.00135063f
Cred_5911 v_c.P8.pSD VDD.$382.Metal1 0.0203537f
Cred_5912 v_c.P8.pSD VDD.$477.Metal1 0.00194052f
Cred_5913 v_c.P8.pSD VDD.$526.Metal1 0.000483323f
Cred_5914 v_c.P8.pSD VDD.P0.nSD 0.0195488f
Cred_5915 VDD.$215.Metal1 VSS.$129.Metal1 0.0011639f
Cred_5916 VDD.$215.Metal1 VSS.$220.Metal1 0.000155892f
Cred_5917 VDD.$215.Metal1 VSS.$284.Metal2 7.74285e-06f
Cred_5918 VDD.$215.Metal1 VSS.$311.Metal2 2.85026e-05f
Cred_5919 VDD.$215.Metal1 VSS.$33.Metal1 0.0013568f
Cred_5920 VDD.$215.Metal1 VSS.$5.Metal1 0.000238682f
Cred_5921 VDD.$215.Metal1 VSS.$78.Metal1 0.00122796f
Cred_5922 VDD.$215.Metal1 VSS.$87.Metal1 0.00918029f
Cred_5923 VDD.$215.Metal1 VSS.P0.nSD 3.08249e-06f
Cred_5924 VDD.$215.Metal1 VSS.P0.pSD 0.00216965f
Cred_5925 VDD.$215.Metal1 VSS.P1.GatPoly 5.3721e-07f
Cred_5926 VDD.$215.Metal1 VSS.P1.nSD 3.08249e-06f
Cred_5927 VDD.$215.Metal1 VSS.P2.GatPoly 4.81475e-07f
Cred_5928 VDD.$215.Metal1 VSS.P3.nSD 5.18094e-06f
Cred_5929 VDD.$215.Metal1 VSS.P5.nSD 4.61479e-06f
Cred_5930 VDD.$215.Metal1 VSS.P6.nSD 4.15107e-06f
Cred_5931 VDD.$215.Metal1 VSS.P7.nSD 4.62836e-06f
Cred_5932 VDD.$29.Metal1 VSS.$129.Metal1 0.000315184f
Cred_5933 VDD.$29.Metal1 VSS.$220.Metal1 4.22158e-05f
Cred_5934 VDD.$29.Metal1 VSS.$284.Metal2 1.39908e-05f
Cred_5935 VDD.$29.Metal1 VSS.$311.Metal2 1.21543e-05f
Cred_5936 VDD.$29.Metal1 VSS.$33.Metal1 0.0023172f
Cred_5937 VDD.$29.Metal1 VSS.$5.Metal1 0.000400605f
Cred_5938 VDD.$29.Metal1 VSS.$78.Metal1 0.000475782f
Cred_5939 VDD.$29.Metal1 VSS.$87.Metal1 0.00564435f
Cred_5940 VDD.$29.Metal1 VSS.P0.nSD 5.58989e-06f
Cred_5941 VDD.$29.Metal1 VSS.P0.pSD 0.00233313f
Cred_5942 VDD.$29.Metal1 VSS.P1.GatPoly 3.04024e-07f
Cred_5943 VDD.$29.Metal1 VSS.P1.nSD 5.58989e-06f
Cred_5944 VDD.$29.Metal1 VSS.P2.GatPoly 1.30384e-07f
Cred_5945 VDD.$29.Metal1 VSS.P3.nSD 2.97491e-06f
Cred_5946 VDD.$29.Metal1 VSS.P5.nSD 2.5688e-06f
Cred_5947 VDD.$29.Metal1 VSS.P6.nSD 1.12411e-06f
Cred_5948 VDD.$29.Metal1 VSS.P7.nSD 1.25336e-06f
Cred_5949 VDD.$320.Metal1 VSS.$129.Metal1 1.39843e-07f
Cred_5950 VDD.$320.Metal1 VSS.$156.Metal1 8.11088e-07f
Cred_5951 VDD.$320.Metal1 VSS.$359.Metal2 0.000210582f
Cred_5952 VDD.$359.Metal1 VSS.$129.Metal1 1.39843e-07f
Cred_5953 VDD.$359.Metal1 VSS.$156.Metal1 8.11088e-07f
Cred_5954 VDD.$359.Metal1 VSS.$359.Metal2 0.000210582f
Cred_5955 VDD.$382.Metal1 VSS.$129.Metal1 0.060115f
Cred_5956 VDD.$382.Metal1 VSS.$147.Metal1 0.00035711f
Cred_5957 VDD.$382.Metal1 VSS.$165.Metal1 0.00166329f
Cred_5958 VDD.$382.Metal1 VSS.$199.Metal1 0.000164758f
Cred_5959 VDD.$382.Metal1 VSS.$209.Metal1 0.000405629f
Cred_5960 VDD.$382.Metal1 VSS.$211.Metal1 0.000215426f
Cred_5961 VDD.$382.Metal1 VSS.$220.Metal1 0.0456273f
Cred_5962 VDD.$382.Metal1 VSS.$231.Metal1 0.000179871f
Cred_5963 VDD.$382.Metal1 VSS.$255.Metal1 0.00238133f
Cred_5964 VDD.$382.Metal1 VSS.$284.Metal2 2.02039e-05f
Cred_5965 VDD.$382.Metal1 VSS.$311.Metal2 0.000117115f
Cred_5966 VDD.$382.Metal1 VSS.$33.Metal1 0.00354037f
Cred_5967 VDD.$382.Metal1 VSS.$376.Metal2 4.53731e-06f
Cred_5968 VDD.$382.Metal1 VSS.$416.Metal2 1.27061e-06f
Cred_5969 VDD.$382.Metal1 VSS.$424.Metal2 1.15446e-06f
Cred_5970 VDD.$382.Metal1 VSS.$428.Metal2 1.38716e-06f
Cred_5971 VDD.$382.Metal1 VSS.$452.Metal2 9.63121e-05f
Cred_5972 VDD.$382.Metal1 VSS.$5.Metal1 0.000622806f
Cred_5973 VDD.$382.Metal1 VSS.$548.Metal3 6.92489e-06f
Cred_5974 VDD.$382.Metal1 VSS.$78.Metal1 0.00458449f
Cred_5975 VDD.$382.Metal1 VSS.$87.Metal1 0.0514558f
Cred_5976 VDD.$382.Metal1 VSS.P0.nSD 8.04332e-06f
Cred_5977 VDD.$382.Metal1 VSS.P0.pSD 0.0360953f
Cred_5978 VDD.$382.Metal1 VSS.P1.GatPoly 1.40177e-06f
Cred_5979 VDD.$382.Metal1 VSS.P1.nSD 8.04332e-06f
Cred_5980 VDD.$382.Metal1 VSS.P2.GatPoly 2.78405e-06f
Cred_5981 VDD.$382.Metal1 VSS.P3.nSD 1.35189e-05f
Cred_5982 VDD.$382.Metal1 VSS.P5.nSD 1.20416e-05f
Cred_5983 VDD.$382.Metal1 VSS.P6.nSD 2.35422e-05f
Cred_5984 VDD.$382.Metal1 VSS.P7.nSD 2.72235e-05f
Cred_5985 VDD.$477.Metal1 VSS.$129.Metal1 0.00113161f
Cred_5986 VDD.$477.Metal1 VSS.$147.Metal1 2.19973e-06f
Cred_5987 VDD.$477.Metal1 VSS.$165.Metal1 1.65356e-05f
Cred_5988 VDD.$477.Metal1 VSS.$199.Metal1 5.32539e-05f
Cred_5989 VDD.$477.Metal1 VSS.$209.Metal1 0.000149185f
Cred_5990 VDD.$477.Metal1 VSS.$211.Metal1 0.000112684f
Cred_5991 VDD.$477.Metal1 VSS.$220.Metal1 0.0102186f
Cred_5992 VDD.$477.Metal1 VSS.$231.Metal1 9.40858e-05f
Cred_5993 VDD.$477.Metal1 VSS.$255.Metal1 0.00124561f
Cred_5994 VDD.$477.Metal1 VSS.$376.Metal2 2.7949e-08f
Cred_5995 VDD.$477.Metal1 VSS.$416.Metal2 4.10693e-07f
Cred_5996 VDD.$477.Metal1 VSS.$424.Metal2 6.0387e-07f
Cred_5997 VDD.$477.Metal1 VSS.$428.Metal2 7.25588e-07f
Cred_5998 VDD.$477.Metal1 VSS.$452.Metal2 5.03784e-05f
Cred_5999 VDD.$477.Metal1 VSS.$548.Metal3 3.62223e-06f
Cred_6000 VDD.$477.Metal1 VSS.$87.Metal1 0.000238738f
Cred_6001 VDD.$477.Metal1 VSS.P0.pSD 0.00317861f
Cred_6002 VDD.$526.Metal1 VSS.$129.Metal1 0.000281849f
Cred_6003 VDD.$526.Metal1 VSS.$147.Metal1 5.47885e-07f
Cred_6004 VDD.$526.Metal1 VSS.$165.Metal1 4.1185e-06f
Cred_6005 VDD.$526.Metal1 VSS.$199.Metal1 1.32639e-05f
Cred_6006 VDD.$526.Metal1 VSS.$209.Metal1 3.71575e-05f
Cred_6007 VDD.$526.Metal1 VSS.$211.Metal1 3.96369e-05f
Cred_6008 VDD.$526.Metal1 VSS.$220.Metal1 0.00641521f
Cred_6009 VDD.$526.Metal1 VSS.$231.Metal1 3.56344e-05f
Cred_6010 VDD.$526.Metal1 VSS.$255.Metal1 0.00278975f
Cred_6011 VDD.$526.Metal1 VSS.$376.Metal2 6.96123e-09f
Cred_6012 VDD.$526.Metal1 VSS.$416.Metal2 1.02291e-07f
Cred_6013 VDD.$526.Metal1 VSS.$424.Metal2 2.12413e-07f
Cred_6014 VDD.$526.Metal1 VSS.$428.Metal2 2.74812e-07f
Cred_6015 VDD.$526.Metal1 VSS.$452.Metal2 0.000112498f
Cred_6016 VDD.$526.Metal1 VSS.$548.Metal3 8.08625e-06f
Cred_6017 VDD.$526.Metal1 VSS.$87.Metal1 5.94623e-05f
Cred_6018 VDD.$526.Metal1 VSS.P0.pSD 0.0040281f
Cred_6019 VDD.$563.Metal2 VSS 0.00185935f
Cred_6020 VDD.$563.Metal2 VSS.$284.Metal2 7.31119e-06f
Cred_6021 VDD.$563.Metal2 VSS.$286.Metal2 3.13728e-06f
Cred_6022 VDD.$563.Metal2 VSS.$474.Metal3 0.00131515f
Cred_6023 VDD.$563.Metal2 VSS.$5.Metal1 4.78451e-08f
Cred_6024 VDD.$606.Metal2 VSS.$311.Metal2 0.0226785f
Cred_6025 VDD.$606.Metal2 VSS.$78.Metal1 0.000504272f
Cred_6026 VDD.$606.Metal2 VSS.P1.GatPoly 6.63883e-07f
Cred_6027 VDD.$606.Metal2 VSS.P3.nSD 6.59439e-06f
Cred_6028 VDD.$606.Metal2 VSS.P5.nSD 5.23106e-06f
Cred_6029 VDD.$703.Metal2 VSS.$129.Metal1 2.16266e-05f
Cred_6030 VDD.$703.Metal2 VSS.$156.Metal1 0.000125434f
Cred_6031 VDD.$703.Metal2 VSS.$359.Metal2 0.0325663f
Cred_6032 VDD.P0.nSD VSS.$129.Metal1 0.0221834f
Cred_6033 VDD.P0.nSD VSS.$147.Metal1 3.16613e-05f
Cred_6034 VDD.P0.nSD VSS.$165.Metal1 0.000230512f
Cred_6035 VDD.P0.nSD VSS.$199.Metal1 0.000400144f
Cred_6036 VDD.P0.nSD VSS.$209.Metal1 0.00108306f
Cred_6037 VDD.P0.nSD VSS.$211.Metal1 0.000867633f
Cred_6038 VDD.P0.nSD VSS.$220.Metal1 0.103184f
Cred_6039 VDD.P0.nSD VSS.$231.Metal1 0.000748846f
Cred_6040 VDD.P0.nSD VSS.$255.Metal1 0.0220735f
Cred_6041 VDD.P0.nSD VSS.$284.Metal2 0.000121637f
Cred_6042 VDD.P0.nSD VSS.$311.Metal2 0.000232391f
Cred_6043 VDD.P0.nSD VSS.$33.Metal1 0.0202021f
Cred_6044 VDD.P0.nSD VSS.$376.Metal2 4.02277e-07f
Cred_6045 VDD.P0.nSD VSS.$416.Metal2 3.08591e-06f
Cred_6046 VDD.P0.nSD VSS.$424.Metal2 4.64962e-06f
Cred_6047 VDD.P0.nSD VSS.$428.Metal2 5.77509e-06f
Cred_6048 VDD.P0.nSD VSS.$452.Metal2 0.000891273f
Cred_6049 VDD.P0.nSD VSS.$5.Metal1 0.00349571f
Cred_6050 VDD.P0.nSD VSS.$548.Metal3 6.40721e-05f
Cred_6051 VDD.P0.nSD VSS.$78.Metal1 0.00948369f
Cred_6052 VDD.P0.nSD VSS.$87.Metal1 0.0860761f
Cred_6053 VDD.P0.nSD VSS.P0.nSD 4.85904e-05f
Cred_6054 VDD.P0.nSD VSS.P0.pSD 0.0694403f
Cred_6055 VDD.P0.nSD VSS.P1.GatPoly 4.72934e-06f
Cred_6056 VDD.P0.nSD VSS.P1.nSD 4.85904e-05f
Cred_6057 VDD.P0.nSD VSS.P2.GatPoly 3.57643e-06f
Cred_6058 VDD.P0.nSD VSS.P3.nSD 4.59246e-05f
Cred_6059 VDD.P0.nSD VSS.P5.nSD 4.03123e-05f
Cred_6060 VDD.P0.nSD VSS.P6.nSD 3.07202e-05f
Cred_6061 VDD.P0.nSD VSS.P7.nSD 3.44941e-05f
Cred_6062 VDD.P10.pSD VSS.$129.Metal1 2.82904e-09f
Cred_6063 VDD.P10.pSD VSS.$156.Metal1 1.64084e-08f
Cred_6064 VDD.P10.pSD VSS.$359.Metal2 4.2601e-06f
Cred_6065 VDD.P11.pSD VSS.$129.Metal1 2.82904e-09f
Cred_6066 VDD.P11.pSD VSS.$156.Metal1 1.64084e-08f
Cred_6067 VDD.P11.pSD VSS.$359.Metal2 4.2601e-06f
Rred_1 di_spdt_ctrl di_spdt_ctrl.P0.GatPoly 211.071900563
Rred_2 di_spdt_ctrl di_spdt_ctrl.P1.GatPoly 211.071900563
Rred_3 di_spdt_ctrl di_spdt_ctrl.P2.GatPoly 75.9099031854
Rred_4 di_spdt_ctrl di_spdt_ctrl.P3.GatPoly 75.9099031854
Rred_5 di_spdt_ctrl.P0.GatPoly di_spdt_ctrl.P1.GatPoly 3598.75949861
Rred_6 di_spdt_ctrl.P0.GatPoly di_spdt_ctrl.P2.GatPoly 91822.7071745
Rred_7 di_spdt_ctrl.P0.GatPoly di_spdt_ctrl.P3.GatPoly 91822.7071745
Rred_8 di_spdt_ctrl.P1.GatPoly di_spdt_ctrl.P2.GatPoly 91822.7071745
Rred_9 di_spdt_ctrl.P1.GatPoly di_spdt_ctrl.P3.GatPoly 91822.7071745
Rred_10 di_spdt_ctrl.P2.GatPoly di_spdt_ctrl.P3.GatPoly 364.402674168
Rred_11 di_tg_ctrl|di_tg_ctrl_n|vin|vout di_tg_ctrl|di_tg_ctrl_n|vin|vout.$17.GatPoly 84.9611874773
Rred_12 di_tg_ctrl|di_tg_ctrl_n|vin|vout di_tg_ctrl|di_tg_ctrl_n|vin|vout.$89.Metal1 160.640900692
Rred_13 di_tg_ctrl|di_tg_ctrl_n|vin|vout.$102.Metal1 di_tg_ctrl|di_tg_ctrl_n|vin|vout.$171.Metal2 59.3620713434
Rred_14 di_tg_ctrl|di_tg_ctrl_n|vin|vout.$102.Metal1 di_tg_ctrl|di_tg_ctrl_n|vin|vout.$173.Metal2 5.29580587355
Rred_15 di_tg_ctrl|di_tg_ctrl_n|vin|vout.$102.Metal1 di_tg_ctrl|di_tg_ctrl_n|vin|vout.$217.Metal3 527.797700058
Rred_16 di_tg_ctrl|di_tg_ctrl_n|vin|vout.$102.Metal1 di_tg_ctrl|di_tg_ctrl_n|vin|vout.$229.Metal4 9674.41880138
Rred_17 di_tg_ctrl|di_tg_ctrl_n|vin|vout.$102.Metal1 di_tg_ctrl|di_tg_ctrl_n|vin|vout.$26.GatPoly 13.812116934
Rred_18 di_tg_ctrl|di_tg_ctrl_n|vin|vout.$102.Metal1 di_tg_ctrl|di_tg_ctrl_n|vin|vout.$98.Metal1 0.362768213765
Rred_19 di_tg_ctrl|di_tg_ctrl_n|vin|vout.$102.Metal1 di_tg_ctrl|di_tg_ctrl_n|vin|vout.P5.GatPoly 160.640900692
Rred_20 di_tg_ctrl|di_tg_ctrl_n|vin|vout.$13.GatPoly di_tg_ctrl|di_tg_ctrl_n|vin|vout.$155.Metal2 231.881032883
Rred_21 di_tg_ctrl|di_tg_ctrl_n|vin|vout.$13.GatPoly di_tg_ctrl|di_tg_ctrl_n|vin|vout.$205.Metal3 5253.63842572
Rred_22 di_tg_ctrl|di_tg_ctrl_n|vin|vout.$13.GatPoly di_tg_ctrl|di_tg_ctrl_n|vin|vout.$80.Metal1 71.9069024808
Rred_23 di_tg_ctrl|di_tg_ctrl_n|vin|vout.$13.GatPoly di_tg_ctrl|di_tg_ctrl_n|vin|vout.$82.Metal1 8.40686660168
Rred_24 di_tg_ctrl|di_tg_ctrl_n|vin|vout.$13.GatPoly di_tg_ctrl|di_tg_ctrl_n|vin|vout.$9.GatPoly 38.0307617565
Rred_25 di_tg_ctrl|di_tg_ctrl_n|vin|vout.$13.GatPoly di_tg_ctrl|di_tg_ctrl_n|vin|vout.P10.GatPoly 171.230769231
Rred_26 di_tg_ctrl|di_tg_ctrl_n|vin|vout.$13.GatPoly di_tg_ctrl|di_tg_ctrl_n|vin|vout.P11.GatPoly 349.772014061
Rred_27 di_tg_ctrl|di_tg_ctrl_n|vin|vout.$13.GatPoly di_tg_ctrl|di_tg_ctrl_n|vin|vout.P9.GatPoly 593.858885441
Rred_28 di_tg_ctrl|di_tg_ctrl_n|vin|vout.$136.Metal2 di_tg_ctrl|di_tg_ctrl_n|vin|vout.$199.Metal3 22.5250950903
Rred_29 di_tg_ctrl|di_tg_ctrl_n|vin|vout.$136.Metal2 di_tg_ctrl|di_tg_ctrl_n|vin|vout.$225.Metal4 39.8821319798
Rred_30 di_tg_ctrl|di_tg_ctrl_n|vin|vout.$136.Metal2 di_tg_ctrl|di_tg_ctrl_n|vin|vout.P0.nSD 64.1326028439
Rred_31 di_tg_ctrl|di_tg_ctrl_n|vin|vout.$136.Metal2 di_tg_ctrl|di_tg_ctrl_n|vin|vout.P0.pSD 12.3547265151
Rred_32 di_tg_ctrl|di_tg_ctrl_n|vin|vout.$136.Metal2 di_tg_ctrl|di_tg_ctrl_n|vin|vout.P12.GatPoly 211.138438387
Rred_33 di_tg_ctrl|di_tg_ctrl_n|vin|vout.$136.Metal2 di_tg_ctrl|di_tg_ctrl_n|vin|vout.P13.GatPoly 211.138438387
Rred_34 di_tg_ctrl|di_tg_ctrl_n|vin|vout.$136.Metal2 di_tg_ctrl|di_tg_ctrl_n|vin|vout.P14.GatPoly 75.9338328498
Rred_35 di_tg_ctrl|di_tg_ctrl_n|vin|vout.$136.Metal2 di_tg_ctrl|di_tg_ctrl_n|vin|vout.P15.GatPoly 75.9338328498
Rred_36 di_tg_ctrl|di_tg_ctrl_n|vin|vout.$149.Metal2 di_tg_ctrl|di_tg_ctrl_n|vin|vout.$151.Metal2 0.1804
Rred_37 di_tg_ctrl|di_tg_ctrl_n|vin|vout.$149.Metal2 di_tg_ctrl|di_tg_ctrl_n|vin|vout.$199.Metal3 4.92652709787
Rred_38 di_tg_ctrl|di_tg_ctrl_n|vin|vout.$149.Metal2 di_tg_ctrl|di_tg_ctrl_n|vin|vout.$202.Metal3 9.40314772683
Rred_39 di_tg_ctrl|di_tg_ctrl_n|vin|vout.$149.Metal2 di_tg_ctrl|di_tg_ctrl_n|vin|vout.$4.GatPoly 579.310302222
Rred_40 di_tg_ctrl|di_tg_ctrl_n|vin|vout.$149.Metal2 di_tg_ctrl|di_tg_ctrl_n|vin|vout.$75.Metal1 4.37330990686
Rred_41 di_tg_ctrl|di_tg_ctrl_n|vin|vout.$149.Metal2 di_tg_ctrl|di_tg_ctrl_n|vin|vout.$77.Metal1 13.0762765958
Rred_42 di_tg_ctrl|di_tg_ctrl_n|vin|vout.$151.Metal2 di_tg_ctrl|di_tg_ctrl_n|vin|vout.$153.Metal2 0.1804
Rred_43 di_tg_ctrl|di_tg_ctrl_n|vin|vout.$151.Metal2 di_tg_ctrl|di_tg_ctrl_n|vin|vout.$202.Metal3 9
Rred_44 di_tg_ctrl|di_tg_ctrl_n|vin|vout.$151.Metal2 di_tg_ctrl|di_tg_ctrl_n|vin|vout.$77.Metal1 16.5584735124
Rred_45 di_tg_ctrl|di_tg_ctrl_n|vin|vout.$151.Metal2 di_tg_ctrl|di_tg_ctrl_n|vin|vout.$80.Metal1 20.3813394518
Rred_46 di_tg_ctrl|di_tg_ctrl_n|vin|vout.$151.Metal2 di_tg_ctrl|di_tg_ctrl_n|vin|vout.$9.GatPoly 1716.610141
Rred_47 di_tg_ctrl|di_tg_ctrl_n|vin|vout.$153.Metal2 di_tg_ctrl|di_tg_ctrl_n|vin|vout.$155.Metal2 0.180376474681
Rred_48 di_tg_ctrl|di_tg_ctrl_n|vin|vout.$153.Metal2 di_tg_ctrl|di_tg_ctrl_n|vin|vout.$202.Metal3 13.7250524829
Rred_49 di_tg_ctrl|di_tg_ctrl_n|vin|vout.$153.Metal2 di_tg_ctrl|di_tg_ctrl_n|vin|vout.$205.Metal3 27.7252160178
Rred_50 di_tg_ctrl|di_tg_ctrl_n|vin|vout.$153.Metal2 di_tg_ctrl|di_tg_ctrl_n|vin|vout.$80.Metal1 10.0511202186
Rred_51 di_tg_ctrl|di_tg_ctrl_n|vin|vout.$153.Metal2 di_tg_ctrl|di_tg_ctrl_n|vin|vout.$82.Metal1 87.5883333335
Rred_52 di_tg_ctrl|di_tg_ctrl_n|vin|vout.$155.Metal2 di_tg_ctrl|di_tg_ctrl_n|vin|vout.$202.Metal3 27.7252160178
Rred_53 di_tg_ctrl|di_tg_ctrl_n|vin|vout.$155.Metal2 di_tg_ctrl|di_tg_ctrl_n|vin|vout.$205.Metal3 3.65308543829
Rred_54 di_tg_ctrl|di_tg_ctrl_n|vin|vout.$155.Metal2 di_tg_ctrl|di_tg_ctrl_n|vin|vout.$82.Metal1 3.41121971298
Rred_55 di_tg_ctrl|di_tg_ctrl_n|vin|vout.$155.Metal2 di_tg_ctrl|di_tg_ctrl_n|vin|vout.P11.GatPoly 6904.30885605
Rred_56 di_tg_ctrl|di_tg_ctrl_n|vin|vout.$163.Metal2 di_tg_ctrl|di_tg_ctrl_n|vin|vout.$165.Metal2 0.18039473539
Rred_57 di_tg_ctrl|di_tg_ctrl_n|vin|vout.$163.Metal2 di_tg_ctrl|di_tg_ctrl_n|vin|vout.$17.GatPoly 3168.27462302
Rred_58 di_tg_ctrl|di_tg_ctrl_n|vin|vout.$163.Metal2 di_tg_ctrl|di_tg_ctrl_n|vin|vout.$209.Metal3 4.67534324968
Rred_59 di_tg_ctrl|di_tg_ctrl_n|vin|vout.$163.Metal2 di_tg_ctrl|di_tg_ctrl_n|vin|vout.$225.Metal4 485.411815761
Rred_60 di_tg_ctrl|di_tg_ctrl_n|vin|vout.$163.Metal2 di_tg_ctrl|di_tg_ctrl_n|vin|vout.$89.Metal1 5.29785766018
Rred_61 di_tg_ctrl|di_tg_ctrl_n|vin|vout.$163.Metal2 di_tg_ctrl|di_tg_ctrl_n|vin|vout.$93.Metal1 37.7758635821
Rred_62 di_tg_ctrl|di_tg_ctrl_n|vin|vout.$165.Metal2 di_tg_ctrl|di_tg_ctrl_n|vin|vout.$167.Metal2 0.1804
Rred_63 di_tg_ctrl|di_tg_ctrl_n|vin|vout.$165.Metal2 di_tg_ctrl|di_tg_ctrl_n|vin|vout.$17.GatPoly 4975.15540044
Rred_64 di_tg_ctrl|di_tg_ctrl_n|vin|vout.$165.Metal2 di_tg_ctrl|di_tg_ctrl_n|vin|vout.$209.Metal3 18.3537449082
Rred_65 di_tg_ctrl|di_tg_ctrl_n|vin|vout.$165.Metal2 di_tg_ctrl|di_tg_ctrl_n|vin|vout.$213.Metal3 18.3537449082
Rred_66 di_tg_ctrl|di_tg_ctrl_n|vin|vout.$165.Metal2 di_tg_ctrl|di_tg_ctrl_n|vin|vout.$225.Metal4 1905.4556852
Rred_67 di_tg_ctrl|di_tg_ctrl_n|vin|vout.$165.Metal2 di_tg_ctrl|di_tg_ctrl_n|vin|vout.$229.Metal4 1905.4556852
Rred_68 di_tg_ctrl|di_tg_ctrl_n|vin|vout.$165.Metal2 di_tg_ctrl|di_tg_ctrl_n|vin|vout.$89.Metal1 59.3620713434
Rred_69 di_tg_ctrl|di_tg_ctrl_n|vin|vout.$165.Metal2 di_tg_ctrl|di_tg_ctrl_n|vin|vout.$93.Metal1 10.7144155147
Rred_70 di_tg_ctrl|di_tg_ctrl_n|vin|vout.$167.Metal2 di_tg_ctrl|di_tg_ctrl_n|vin|vout.$169.Metal2 0.1804
Rred_71 di_tg_ctrl|di_tg_ctrl_n|vin|vout.$167.Metal2 di_tg_ctrl|di_tg_ctrl_n|vin|vout.$21.GatPoly 1716.610141
Rred_72 di_tg_ctrl|di_tg_ctrl_n|vin|vout.$167.Metal2 di_tg_ctrl|di_tg_ctrl_n|vin|vout.$213.Metal3 9
Rred_73 di_tg_ctrl|di_tg_ctrl_n|vin|vout.$167.Metal2 di_tg_ctrl|di_tg_ctrl_n|vin|vout.$93.Metal1 16.5584735124
Rred_74 di_tg_ctrl|di_tg_ctrl_n|vin|vout.$167.Metal2 di_tg_ctrl|di_tg_ctrl_n|vin|vout.$96.Metal1 20.3813394518
Rred_75 di_tg_ctrl|di_tg_ctrl_n|vin|vout.$169.Metal2 di_tg_ctrl|di_tg_ctrl_n|vin|vout.$171.Metal2 0.1804
Rred_76 di_tg_ctrl|di_tg_ctrl_n|vin|vout.$169.Metal2 di_tg_ctrl|di_tg_ctrl_n|vin|vout.$213.Metal3 18.3608
Rred_77 di_tg_ctrl|di_tg_ctrl_n|vin|vout.$169.Metal2 di_tg_ctrl|di_tg_ctrl_n|vin|vout.$217.Metal3 18.3608
Rred_78 di_tg_ctrl|di_tg_ctrl_n|vin|vout.$169.Metal2 di_tg_ctrl|di_tg_ctrl_n|vin|vout.$229.Metal4 916.00443459
Rred_79 di_tg_ctrl|di_tg_ctrl_n|vin|vout.$169.Metal2 di_tg_ctrl|di_tg_ctrl_n|vin|vout.$96.Metal1 10.0511202186
Rred_80 di_tg_ctrl|di_tg_ctrl_n|vin|vout.$169.Metal2 di_tg_ctrl|di_tg_ctrl_n|vin|vout.$98.Metal1 87.5883333335
Rred_81 di_tg_ctrl|di_tg_ctrl_n|vin|vout.$17.GatPoly di_tg_ctrl|di_tg_ctrl_n|vin|vout.$21.GatPoly 21.9492989844
Rred_82 di_tg_ctrl|di_tg_ctrl_n|vin|vout.$17.GatPoly di_tg_ctrl|di_tg_ctrl_n|vin|vout.$89.Metal1 13.812116934
Rred_83 di_tg_ctrl|di_tg_ctrl_n|vin|vout.$17.GatPoly di_tg_ctrl|di_tg_ctrl_n|vin|vout.$93.Metal1 17.2516301382
Rred_84 di_tg_ctrl|di_tg_ctrl_n|vin|vout.$17.GatPoly di_tg_ctrl|di_tg_ctrl_n|vin|vout.P1.GatPoly 45.1439599386
Rred_85 di_tg_ctrl|di_tg_ctrl_n|vin|vout.$17.GatPoly di_tg_ctrl|di_tg_ctrl_n|vin|vout.P2.GatPoly 405.217827404
Rred_86 di_tg_ctrl|di_tg_ctrl_n|vin|vout.$171.Metal2 di_tg_ctrl|di_tg_ctrl_n|vin|vout.$173.Metal2 0.18039473539
Rred_87 di_tg_ctrl|di_tg_ctrl_n|vin|vout.$171.Metal2 di_tg_ctrl|di_tg_ctrl_n|vin|vout.$217.Metal3 9
Rred_88 di_tg_ctrl|di_tg_ctrl_n|vin|vout.$171.Metal2 di_tg_ctrl|di_tg_ctrl_n|vin|vout.$26.GatPoly 4975.15540044
Rred_89 di_tg_ctrl|di_tg_ctrl_n|vin|vout.$171.Metal2 di_tg_ctrl|di_tg_ctrl_n|vin|vout.$98.Metal1 10.7144155147
Rred_90 di_tg_ctrl|di_tg_ctrl_n|vin|vout.$173.Metal2 di_tg_ctrl|di_tg_ctrl_n|vin|vout.$217.Metal3 5.01776877845
Rred_91 di_tg_ctrl|di_tg_ctrl_n|vin|vout.$173.Metal2 di_tg_ctrl|di_tg_ctrl_n|vin|vout.$229.Metal4 112.464729423
Rred_92 di_tg_ctrl|di_tg_ctrl_n|vin|vout.$173.Metal2 di_tg_ctrl|di_tg_ctrl_n|vin|vout.$26.GatPoly 3168.27462302
Rred_93 di_tg_ctrl|di_tg_ctrl_n|vin|vout.$173.Metal2 di_tg_ctrl|di_tg_ctrl_n|vin|vout.$98.Metal1 37.7758635821
Rred_94 di_tg_ctrl|di_tg_ctrl_n|vin|vout.$199.Metal3 di_tg_ctrl|di_tg_ctrl_n|vin|vout.$202.Metal3 0.555401374625
Rred_95 di_tg_ctrl|di_tg_ctrl_n|vin|vout.$199.Metal3 di_tg_ctrl|di_tg_ctrl_n|vin|vout.$225.Metal4 52.540999688
Rred_96 di_tg_ctrl|di_tg_ctrl_n|vin|vout.$199.Metal3 di_tg_ctrl|di_tg_ctrl_n|vin|vout.$4.GatPoly 12473.1233492
Rred_97 di_tg_ctrl|di_tg_ctrl_n|vin|vout.$199.Metal3 di_tg_ctrl|di_tg_ctrl_n|vin|vout.$75.Metal1 119.979883983
Rred_98 di_tg_ctrl|di_tg_ctrl_n|vin|vout.$199.Metal3 di_tg_ctrl|di_tg_ctrl_n|vin|vout.P0.nSD 81.2150632298
Rred_99 di_tg_ctrl|di_tg_ctrl_n|vin|vout.$199.Metal3 di_tg_ctrl|di_tg_ctrl_n|vin|vout.P0.pSD 15.6455507903
Rred_100 di_tg_ctrl|di_tg_ctrl_n|vin|vout.$202.Metal3 di_tg_ctrl|di_tg_ctrl_n|vin|vout.$205.Metal3 0.555736552179
Rred_101 di_tg_ctrl|di_tg_ctrl_n|vin|vout.$202.Metal3 di_tg_ctrl|di_tg_ctrl_n|vin|vout.$4.GatPoly 89044.3351818
Rred_102 di_tg_ctrl|di_tg_ctrl_n|vin|vout.$202.Metal3 di_tg_ctrl|di_tg_ctrl_n|vin|vout.$75.Metal1 790.309054999
Rred_103 di_tg_ctrl|di_tg_ctrl_n|vin|vout.$205.Metal3 di_tg_ctrl|di_tg_ctrl_n|vin|vout.$82.Metal1 110.222835093
Rred_104 di_tg_ctrl|di_tg_ctrl_n|vin|vout.$205.Metal3 di_tg_ctrl|di_tg_ctrl_n|vin|vout.P11.GatPoly 150517.835629
Rred_105 di_tg_ctrl|di_tg_ctrl_n|vin|vout.$209.Metal3 di_tg_ctrl|di_tg_ctrl_n|vin|vout.$213.Metal3 0.36774791179
Rred_106 di_tg_ctrl|di_tg_ctrl_n|vin|vout.$209.Metal3 di_tg_ctrl|di_tg_ctrl_n|vin|vout.$225.Metal4 4.66207446718
Rred_107 di_tg_ctrl|di_tg_ctrl_n|vin|vout.$209.Metal3 di_tg_ctrl|di_tg_ctrl_n|vin|vout.$229.Metal4 19.0026209553
Rred_108 di_tg_ctrl|di_tg_ctrl_n|vin|vout.$209.Metal3 di_tg_ctrl|di_tg_ctrl_n|vin|vout.$89.Metal1 492.33342869
Rred_109 di_tg_ctrl|di_tg_ctrl_n|vin|vout.$21.GatPoly di_tg_ctrl|di_tg_ctrl_n|vin|vout.$24.GatPoly 21.8444333333
Rred_110 di_tg_ctrl|di_tg_ctrl_n|vin|vout.$21.GatPoly di_tg_ctrl|di_tg_ctrl_n|vin|vout.$93.Metal1 17.2736224188
Rred_111 di_tg_ctrl|di_tg_ctrl_n|vin|vout.$21.GatPoly di_tg_ctrl|di_tg_ctrl_n|vin|vout.$96.Metal1 17.2199796994
Rred_112 di_tg_ctrl|di_tg_ctrl_n|vin|vout.$21.GatPoly di_tg_ctrl|di_tg_ctrl_n|vin|vout.P1.GatPoly 405.217827404
Rred_113 di_tg_ctrl|di_tg_ctrl_n|vin|vout.$21.GatPoly di_tg_ctrl|di_tg_ctrl_n|vin|vout.P2.GatPoly 45.1439599386
Rred_114 di_tg_ctrl|di_tg_ctrl_n|vin|vout.$21.GatPoly di_tg_ctrl|di_tg_ctrl_n|vin|vout.P3.GatPoly 134.427282051
Rred_115 di_tg_ctrl|di_tg_ctrl_n|vin|vout.$213.Metal3 di_tg_ctrl|di_tg_ctrl_n|vin|vout.$217.Metal3 0.368032035556
Rred_116 di_tg_ctrl|di_tg_ctrl_n|vin|vout.$213.Metal3 di_tg_ctrl|di_tg_ctrl_n|vin|vout.$225.Metal4 19.0026209553
Rred_117 di_tg_ctrl|di_tg_ctrl_n|vin|vout.$213.Metal3 di_tg_ctrl|di_tg_ctrl_n|vin|vout.$229.Metal4 6.1693181278
Rred_118 di_tg_ctrl|di_tg_ctrl_n|vin|vout.$217.Metal3 di_tg_ctrl|di_tg_ctrl_n|vin|vout.$229.Metal4 2.92153130042
Rred_119 di_tg_ctrl|di_tg_ctrl_n|vin|vout.$225.Metal4 di_tg_ctrl|di_tg_ctrl_n|vin|vout.$229.Metal4 0.758051540616
Rred_120 di_tg_ctrl|di_tg_ctrl_n|vin|vout.$225.Metal4 di_tg_ctrl|di_tg_ctrl_n|vin|vout.$89.Metal1 24562.0890145
Rred_121 di_tg_ctrl|di_tg_ctrl_n|vin|vout.$225.Metal4 di_tg_ctrl|di_tg_ctrl_n|vin|vout.P0.nSD 143.796501524
Rred_122 di_tg_ctrl|di_tg_ctrl_n|vin|vout.$225.Metal4 di_tg_ctrl|di_tg_ctrl_n|vin|vout.P0.pSD 27.7014555994
Rred_123 di_tg_ctrl|di_tg_ctrl_n|vin|vout.$24.GatPoly di_tg_ctrl|di_tg_ctrl_n|vin|vout.$26.GatPoly 8.255625
Rred_124 di_tg_ctrl|di_tg_ctrl_n|vin|vout.$24.GatPoly di_tg_ctrl|di_tg_ctrl_n|vin|vout.$96.Metal1 41.3025
Rred_125 di_tg_ctrl|di_tg_ctrl_n|vin|vout.$24.GatPoly di_tg_ctrl|di_tg_ctrl_n|vin|vout.$98.Metal1 15
Rred_126 di_tg_ctrl|di_tg_ctrl_n|vin|vout.$24.GatPoly di_tg_ctrl|di_tg_ctrl_n|vin|vout.P3.GatPoly 72.94084838
Rred_127 di_tg_ctrl|di_tg_ctrl_n|vin|vout.$24.GatPoly di_tg_ctrl|di_tg_ctrl_n|vin|vout.P4.GatPoly 152.411538462
Rred_128 di_tg_ctrl|di_tg_ctrl_n|vin|vout.$26.GatPoly di_tg_ctrl|di_tg_ctrl_n|vin|vout.$98.Metal1 30.4037274471
Rred_129 di_tg_ctrl|di_tg_ctrl_n|vin|vout.$26.GatPoly di_tg_ctrl|di_tg_ctrl_n|vin|vout.P4.GatPoly 50.8038461538
Rred_130 di_tg_ctrl|di_tg_ctrl_n|vin|vout.$26.GatPoly di_tg_ctrl|di_tg_ctrl_n|vin|vout.P5.GatPoly 84.9611874773
Rred_131 di_tg_ctrl|di_tg_ctrl_n|vin|vout.$4.GatPoly di_tg_ctrl|di_tg_ctrl_n|vin|vout.$6.GatPoly 10.9656296296
Rred_132 di_tg_ctrl|di_tg_ctrl_n|vin|vout.$4.GatPoly di_tg_ctrl|di_tg_ctrl_n|vin|vout.$75.Metal1 13.1332678338
Rred_133 di_tg_ctrl|di_tg_ctrl_n|vin|vout.$4.GatPoly di_tg_ctrl|di_tg_ctrl_n|vin|vout.P6.GatPoly 184.996975262
Rred_134 di_tg_ctrl|di_tg_ctrl_n|vin|vout.$6.GatPoly di_tg_ctrl|di_tg_ctrl_n|vin|vout.$75.Metal1 20.7333333333
Rred_135 di_tg_ctrl|di_tg_ctrl_n|vin|vout.$6.GatPoly di_tg_ctrl|di_tg_ctrl_n|vin|vout.$77.Metal1 32.2322960913
Rred_136 di_tg_ctrl|di_tg_ctrl_n|vin|vout.$6.GatPoly di_tg_ctrl|di_tg_ctrl_n|vin|vout.$9.GatPoly 17.1953950122
Rred_137 di_tg_ctrl|di_tg_ctrl_n|vin|vout.$6.GatPoly di_tg_ctrl|di_tg_ctrl_n|vin|vout.P7.GatPoly 171.230769231
Rred_138 di_tg_ctrl|di_tg_ctrl_n|vin|vout.$6.GatPoly di_tg_ctrl|di_tg_ctrl_n|vin|vout.P8.GatPoly 1484.56170513
Rred_139 di_tg_ctrl|di_tg_ctrl_n|vin|vout.$75.Metal1 di_tg_ctrl|di_tg_ctrl_n|vin|vout.$77.Metal1 0.178847486772
Rred_140 di_tg_ctrl|di_tg_ctrl_n|vin|vout.$77.Metal1 di_tg_ctrl|di_tg_ctrl_n|vin|vout.$80.Metal1 0.361795734713
Rred_141 di_tg_ctrl|di_tg_ctrl_n|vin|vout.$77.Metal1 di_tg_ctrl|di_tg_ctrl_n|vin|vout.$9.GatPoly 17.893858647
Rred_142 di_tg_ctrl|di_tg_ctrl_n|vin|vout.$77.Metal1 di_tg_ctrl|di_tg_ctrl_n|vin|vout.P8.GatPoly 3742.59253395
Rred_143 di_tg_ctrl|di_tg_ctrl_n|vin|vout.$80.Metal1 di_tg_ctrl|di_tg_ctrl_n|vin|vout.$82.Metal1 0.178245243196
Rred_144 di_tg_ctrl|di_tg_ctrl_n|vin|vout.$80.Metal1 di_tg_ctrl|di_tg_ctrl_n|vin|vout.$9.GatPoly 15.8680212252
Rred_145 di_tg_ctrl|di_tg_ctrl_n|vin|vout.$80.Metal1 di_tg_ctrl|di_tg_ctrl_n|vin|vout.P9.GatPoly 863.431298709
Rred_146 di_tg_ctrl|di_tg_ctrl_n|vin|vout.$82.Metal1 di_tg_ctrl|di_tg_ctrl_n|vin|vout.$9.GatPoly 95.8758699743
Rred_147 di_tg_ctrl|di_tg_ctrl_n|vin|vout.$82.Metal1 di_tg_ctrl|di_tg_ctrl_n|vin|vout.P11.GatPoly 449.09914894
Rred_148 di_tg_ctrl|di_tg_ctrl_n|vin|vout.$82.Metal1 di_tg_ctrl|di_tg_ctrl_n|vin|vout.P9.GatPoly 1497.12324061
Rred_149 di_tg_ctrl|di_tg_ctrl_n|vin|vout.$89.Metal1 di_tg_ctrl|di_tg_ctrl_n|vin|vout.$93.Metal1 0.362768213765
Rred_150 di_tg_ctrl|di_tg_ctrl_n|vin|vout.$9.GatPoly di_tg_ctrl|di_tg_ctrl_n|vin|vout.P8.GatPoly 206.475897793
Rred_151 di_tg_ctrl|di_tg_ctrl_n|vin|vout.$9.GatPoly di_tg_ctrl|di_tg_ctrl_n|vin|vout.P9.GatPoly 456.659220206
Rred_152 di_tg_ctrl|di_tg_ctrl_n|vin|vout.$93.Metal1 di_tg_ctrl|di_tg_ctrl_n|vin|vout.$96.Metal1 0.361795734713
Rred_153 di_tg_ctrl|di_tg_ctrl_n|vin|vout.$93.Metal1 di_tg_ctrl|di_tg_ctrl_n|vin|vout.P1.GatPoly 736.257692309
Rred_154 di_tg_ctrl|di_tg_ctrl_n|vin|vout.$93.Metal1 di_tg_ctrl|di_tg_ctrl_n|vin|vout.P2.GatPoly 736.257692309
Rred_155 di_tg_ctrl|di_tg_ctrl_n|vin|vout.$96.Metal1 di_tg_ctrl|di_tg_ctrl_n|vin|vout.$98.Metal1 0.178420679012
Rred_156 di_tg_ctrl|di_tg_ctrl_n|vin|vout.$96.Metal1 di_tg_ctrl|di_tg_ctrl_n|vin|vout.P3.GatPoly 254.169230769
Rred_157 di_tg_ctrl|di_tg_ctrl_n|vin|vout.P0.nSD di_tg_ctrl|di_tg_ctrl_n|vin|vout.P0.pSD 37.6564246257
Rred_158 di_tg_ctrl|di_tg_ctrl_n|vin|vout.P1.GatPoly di_tg_ctrl|di_tg_ctrl_n|vin|vout.P2.GatPoly 7480.94450594
Rred_159 di_tg_ctrl|di_tg_ctrl_n|vin|vout.P12.GatPoly di_tg_ctrl|di_tg_ctrl_n|vin|vout.P13.GatPoly 3596.20396212
Rred_160 di_tg_ctrl|di_tg_ctrl_n|vin|vout.P12.GatPoly di_tg_ctrl|di_tg_ctrl_n|vin|vout.P14.GatPoly 87415.5772682
Rred_161 di_tg_ctrl|di_tg_ctrl_n|vin|vout.P12.GatPoly di_tg_ctrl|di_tg_ctrl_n|vin|vout.P15.GatPoly 87415.5772682
Rred_162 di_tg_ctrl|di_tg_ctrl_n|vin|vout.P13.GatPoly di_tg_ctrl|di_tg_ctrl_n|vin|vout.P14.GatPoly 87415.5772682
Rred_163 di_tg_ctrl|di_tg_ctrl_n|vin|vout.P13.GatPoly di_tg_ctrl|di_tg_ctrl_n|vin|vout.P15.GatPoly 87415.5772682
Rred_164 di_tg_ctrl|di_tg_ctrl_n|vin|vout.P14.GatPoly di_tg_ctrl|di_tg_ctrl_n|vin|vout.P15.GatPoly 364.200059688
Rred_165 di_tg_ctrl|di_tg_ctrl_n|vout di_tg_ctrl|di_tg_ctrl_n|vout.$1.GatPoly 84.9611874773
Rred_166 di_tg_ctrl|di_tg_ctrl_n|vout di_tg_ctrl|di_tg_ctrl_n|vout.$61.Metal1 160.640900692
Rred_167 di_tg_ctrl|di_tg_ctrl_n|vout.$1.GatPoly di_tg_ctrl|di_tg_ctrl_n|vout.$128.Metal2 3168.27462302
Rred_168 di_tg_ctrl|di_tg_ctrl_n|vout.$1.GatPoly di_tg_ctrl|di_tg_ctrl_n|vout.$130.Metal2 4975.15540044
Rred_169 di_tg_ctrl|di_tg_ctrl_n|vout.$1.GatPoly di_tg_ctrl|di_tg_ctrl_n|vout.$3.GatPoly 8.255625
Rred_170 di_tg_ctrl|di_tg_ctrl_n|vout.$1.GatPoly di_tg_ctrl|di_tg_ctrl_n|vout.$61.Metal1 13.812116934
Rred_171 di_tg_ctrl|di_tg_ctrl_n|vout.$1.GatPoly di_tg_ctrl|di_tg_ctrl_n|vout.$65.Metal1 30.4037274471
Rred_172 di_tg_ctrl|di_tg_ctrl_n|vout.$1.GatPoly di_tg_ctrl|di_tg_ctrl_n|vout.P1.GatPoly 50.8038461538
Rred_173 di_tg_ctrl|di_tg_ctrl_n|vout.$10.GatPoly di_tg_ctrl|di_tg_ctrl_n|vout.$136.Metal2 197.196676572
Rred_174 di_tg_ctrl|di_tg_ctrl_n|vout.$10.GatPoly di_tg_ctrl|di_tg_ctrl_n|vout.$186.Metal3 4475.86226874
Rred_175 di_tg_ctrl|di_tg_ctrl_n|vout.$10.GatPoly di_tg_ctrl|di_tg_ctrl_n|vout.$6.GatPoly 21.9492989844
Rred_176 di_tg_ctrl|di_tg_ctrl_n|vout.$10.GatPoly di_tg_ctrl|di_tg_ctrl_n|vout.$70.Metal1 8.08323005506
Rred_177 di_tg_ctrl|di_tg_ctrl_n|vout.$10.GatPoly di_tg_ctrl|di_tg_ctrl_n|vout.P3.GatPoly 405.217827404
Rred_178 di_tg_ctrl|di_tg_ctrl_n|vout.$10.GatPoly di_tg_ctrl|di_tg_ctrl_n|vout.P4.GatPoly 45.1439599386
Rred_179 di_tg_ctrl|di_tg_ctrl_n|vout.$10.GatPoly di_tg_ctrl|di_tg_ctrl_n|vout.P5.GatPoly 83.9031298176
Rred_180 di_tg_ctrl|di_tg_ctrl_n|vout.$128.Metal2 di_tg_ctrl|di_tg_ctrl_n|vout.$130.Metal2 0.180371211445
Rred_181 di_tg_ctrl|di_tg_ctrl_n|vout.$128.Metal2 di_tg_ctrl|di_tg_ctrl_n|vout.$180.Metal3 5.56430714639
Rred_182 di_tg_ctrl|di_tg_ctrl_n|vout.$128.Metal2 di_tg_ctrl|di_tg_ctrl_n|vout.$183.Metal3 27.7252160178
Rred_183 di_tg_ctrl|di_tg_ctrl_n|vout.$128.Metal2 di_tg_ctrl|di_tg_ctrl_n|vout.$61.Metal1 5.29895684974
Rred_184 di_tg_ctrl|di_tg_ctrl_n|vout.$128.Metal2 di_tg_ctrl|di_tg_ctrl_n|vout.$65.Metal1 37.7758635821
Rred_185 di_tg_ctrl|di_tg_ctrl_n|vout.$130.Metal2 di_tg_ctrl|di_tg_ctrl_n|vout.$134.Metal2 0.368025439907
Rred_186 di_tg_ctrl|di_tg_ctrl_n|vout.$130.Metal2 di_tg_ctrl|di_tg_ctrl_n|vout.$180.Metal3 27.7252160178
Rred_187 di_tg_ctrl|di_tg_ctrl_n|vout.$130.Metal2 di_tg_ctrl|di_tg_ctrl_n|vout.$183.Metal3 7.85396030454
Rred_188 di_tg_ctrl|di_tg_ctrl_n|vout.$130.Metal2 di_tg_ctrl|di_tg_ctrl_n|vout.$61.Metal1 59.3620713434
Rred_189 di_tg_ctrl|di_tg_ctrl_n|vout.$130.Metal2 di_tg_ctrl|di_tg_ctrl_n|vout.$65.Metal1 10.1082952114
Rred_190 di_tg_ctrl|di_tg_ctrl_n|vout.$130.Metal2 di_tg_ctrl|di_tg_ctrl_n|vout.$67.Metal1 20.5048111973
Rred_191 di_tg_ctrl|di_tg_ctrl_n|vout.$134.Metal2 di_tg_ctrl|di_tg_ctrl_n|vout.$136.Metal2 0.180376474681
Rred_192 di_tg_ctrl|di_tg_ctrl_n|vout.$134.Metal2 di_tg_ctrl|di_tg_ctrl_n|vout.$183.Metal3 7.85396030454
Rred_193 di_tg_ctrl|di_tg_ctrl_n|vout.$134.Metal2 di_tg_ctrl|di_tg_ctrl_n|vout.$186.Metal3 27.7252160178
Rred_194 di_tg_ctrl|di_tg_ctrl_n|vout.$134.Metal2 di_tg_ctrl|di_tg_ctrl_n|vout.$6.GatPoly 1716.610141
Rred_195 di_tg_ctrl|di_tg_ctrl_n|vout.$134.Metal2 di_tg_ctrl|di_tg_ctrl_n|vout.$65.Metal1 178.684783291
Rred_196 di_tg_ctrl|di_tg_ctrl_n|vout.$134.Metal2 di_tg_ctrl|di_tg_ctrl_n|vout.$67.Metal1 10.2214444445
Rred_197 di_tg_ctrl|di_tg_ctrl_n|vout.$134.Metal2 di_tg_ctrl|di_tg_ctrl_n|vout.$70.Metal1 16.5584735124
Rred_198 di_tg_ctrl|di_tg_ctrl_n|vout.$136.Metal2 di_tg_ctrl|di_tg_ctrl_n|vout.$183.Metal3 27.7252160178
Rred_199 di_tg_ctrl|di_tg_ctrl_n|vout.$136.Metal2 di_tg_ctrl|di_tg_ctrl_n|vout.$186.Metal3 3.65311568297
Rred_200 di_tg_ctrl|di_tg_ctrl_n|vout.$136.Metal2 di_tg_ctrl|di_tg_ctrl_n|vout.$70.Metal1 3.42235565598
Rred_201 di_tg_ctrl|di_tg_ctrl_n|vout.$136.Metal2 di_tg_ctrl|di_tg_ctrl_n|vout.P5.GatPoly 2541.27510026
Rred_202 di_tg_ctrl|di_tg_ctrl_n|vout.$14.GatPoly di_tg_ctrl|di_tg_ctrl_n|vout.$17.GatPoly 17.1953950122
Rred_203 di_tg_ctrl|di_tg_ctrl_n|vout.$14.GatPoly di_tg_ctrl|di_tg_ctrl_n|vout.$77.Metal1 28.8380826051
Rred_204 di_tg_ctrl|di_tg_ctrl_n|vout.$14.GatPoly di_tg_ctrl|di_tg_ctrl_n|vout.$79.Metal1 18.3474918298
Rred_205 di_tg_ctrl|di_tg_ctrl_n|vout.$14.GatPoly di_tg_ctrl|di_tg_ctrl_n|vout.$81.Metal1 32.2322960913
Rred_206 di_tg_ctrl|di_tg_ctrl_n|vout.$14.GatPoly di_tg_ctrl|di_tg_ctrl_n|vout.P6.GatPoly 355.663870287
Rred_207 di_tg_ctrl|di_tg_ctrl_n|vout.$14.GatPoly di_tg_ctrl|di_tg_ctrl_n|vout.P7.GatPoly 171.230769231
Rred_208 di_tg_ctrl|di_tg_ctrl_n|vout.$14.GatPoly di_tg_ctrl|di_tg_ctrl_n|vout.P8.GatPoly 1484.56170513
Rred_209 di_tg_ctrl|di_tg_ctrl_n|vout.$144.Metal2 di_tg_ctrl|di_tg_ctrl_n|vout.$148.Metal2 0.368016826258
Rred_210 di_tg_ctrl|di_tg_ctrl_n|vout.$144.Metal2 di_tg_ctrl|di_tg_ctrl_n|vout.$192.Metal3 3.95410517628
Rred_211 di_tg_ctrl|di_tg_ctrl_n|vout.$144.Metal2 di_tg_ctrl|di_tg_ctrl_n|vout.$206.Metal4 117.74237666
Rred_212 di_tg_ctrl|di_tg_ctrl_n|vout.$144.Metal2 di_tg_ctrl|di_tg_ctrl_n|vout.$209.Metal4 774.596321885
Rred_213 di_tg_ctrl|di_tg_ctrl_n|vout.$144.Metal2 di_tg_ctrl|di_tg_ctrl_n|vout.$77.Metal1 6.15857392943
Rred_214 di_tg_ctrl|di_tg_ctrl_n|vout.$144.Metal2 di_tg_ctrl|di_tg_ctrl_n|vout.$79.Metal1 14.2033302725
Rred_215 di_tg_ctrl|di_tg_ctrl_n|vout.$144.Metal2 di_tg_ctrl|di_tg_ctrl_n|vout.$81.Metal1 26.6756641466
Rred_216 di_tg_ctrl|di_tg_ctrl_n|vout.$148.Metal2 di_tg_ctrl|di_tg_ctrl_n|vout.$152.Metal2 0.368025439907
Rred_217 di_tg_ctrl|di_tg_ctrl_n|vout.$148.Metal2 di_tg_ctrl|di_tg_ctrl_n|vout.$17.GatPoly 1716.610141
Rred_218 di_tg_ctrl|di_tg_ctrl_n|vout.$148.Metal2 di_tg_ctrl|di_tg_ctrl_n|vout.$192.Metal3 9.18021030141
Rred_219 di_tg_ctrl|di_tg_ctrl_n|vout.$148.Metal2 di_tg_ctrl|di_tg_ctrl_n|vout.$196.Metal3 9.18031773646
Rred_220 di_tg_ctrl|di_tg_ctrl_n|vout.$148.Metal2 di_tg_ctrl|di_tg_ctrl_n|vout.$209.Metal4 916.00443459
Rred_221 di_tg_ctrl|di_tg_ctrl_n|vout.$148.Metal2 di_tg_ctrl|di_tg_ctrl_n|vout.$79.Metal1 59.7026768994
Rred_222 di_tg_ctrl|di_tg_ctrl_n|vout.$148.Metal2 di_tg_ctrl|di_tg_ctrl_n|vout.$81.Metal1 10.21665522
Rred_223 di_tg_ctrl|di_tg_ctrl_n|vout.$148.Metal2 di_tg_ctrl|di_tg_ctrl_n|vout.$84.Metal1 10.2214444445
Rred_224 di_tg_ctrl|di_tg_ctrl_n|vout.$148.Metal2 di_tg_ctrl|di_tg_ctrl_n|vout.$86.Metal1 178.684783291
Rred_225 di_tg_ctrl|di_tg_ctrl_n|vout.$152.Metal2 di_tg_ctrl|di_tg_ctrl_n|vout.$196.Metal3 3.09177561096
Rred_226 di_tg_ctrl|di_tg_ctrl_n|vout.$152.Metal2 di_tg_ctrl|di_tg_ctrl_n|vout.$209.Metal4 48.3197549182
Rred_227 di_tg_ctrl|di_tg_ctrl_n|vout.$152.Metal2 di_tg_ctrl|di_tg_ctrl_n|vout.$84.Metal1 20.5048111973
Rred_228 di_tg_ctrl|di_tg_ctrl_n|vout.$152.Metal2 di_tg_ctrl|di_tg_ctrl_n|vout.$86.Metal1 12.1845991629
Rred_229 di_tg_ctrl|di_tg_ctrl_n|vout.$152.Metal2 di_tg_ctrl|di_tg_ctrl_n|vout.$88.Metal1 11.8908136098
Rred_230 di_tg_ctrl|di_tg_ctrl_n|vout.$152.Metal2 di_tg_ctrl|di_tg_ctrl_n|vout.$90.Metal1 6.61426001545
Rred_231 di_tg_ctrl|di_tg_ctrl_n|vout.$17.GatPoly di_tg_ctrl|di_tg_ctrl_n|vout.$21.GatPoly 38.0307617565
Rred_232 di_tg_ctrl|di_tg_ctrl_n|vout.$17.GatPoly di_tg_ctrl|di_tg_ctrl_n|vout.$81.Metal1 17.893858647
Rred_233 di_tg_ctrl|di_tg_ctrl_n|vout.$17.GatPoly di_tg_ctrl|di_tg_ctrl_n|vout.$84.Metal1 15.8680212252
Rred_234 di_tg_ctrl|di_tg_ctrl_n|vout.$17.GatPoly di_tg_ctrl|di_tg_ctrl_n|vout.$86.Metal1 95.8758699743
Rred_235 di_tg_ctrl|di_tg_ctrl_n|vout.$17.GatPoly di_tg_ctrl|di_tg_ctrl_n|vout.P8.GatPoly 206.475897793
Rred_236 di_tg_ctrl|di_tg_ctrl_n|vout.$17.GatPoly di_tg_ctrl|di_tg_ctrl_n|vout.P9.GatPoly 456.659220206
Rred_237 di_tg_ctrl|di_tg_ctrl_n|vout.$180.Metal3 di_tg_ctrl|di_tg_ctrl_n|vout.$183.Metal3 0.555736552179
Rred_238 di_tg_ctrl|di_tg_ctrl_n|vout.$180.Metal3 di_tg_ctrl|di_tg_ctrl_n|vout.$206.Metal4 20.0875321002
Rred_239 di_tg_ctrl|di_tg_ctrl_n|vout.$180.Metal3 di_tg_ctrl|di_tg_ctrl_n|vout.$61.Metal1 473.532989653
Rred_240 di_tg_ctrl|di_tg_ctrl_n|vout.$180.Metal3 di_tg_ctrl|di_tg_ctrl_n|vout.P0.nSD 29.9191618293
Rred_241 di_tg_ctrl|di_tg_ctrl_n|vout.$180.Metal3 di_tg_ctrl|di_tg_ctrl_n|vout.P0.pSD 5.76373085717
Rred_242 di_tg_ctrl|di_tg_ctrl_n|vout.$183.Metal3 di_tg_ctrl|di_tg_ctrl_n|vout.$186.Metal3 0.555736552179
Rred_243 di_tg_ctrl|di_tg_ctrl_n|vout.$183.Metal3 di_tg_ctrl|di_tg_ctrl_n|vout.$65.Metal1 8914.42932163
Rred_244 di_tg_ctrl|di_tg_ctrl_n|vout.$183.Metal3 di_tg_ctrl|di_tg_ctrl_n|vout.$67.Metal1 1022.9672992
Rred_245 di_tg_ctrl|di_tg_ctrl_n|vout.$186.Metal3 di_tg_ctrl|di_tg_ctrl_n|vout.$70.Metal1 110.739055712
Rred_246 di_tg_ctrl|di_tg_ctrl_n|vout.$186.Metal3 di_tg_ctrl|di_tg_ctrl_n|vout.P5.GatPoly 54864.2076373
Rred_247 di_tg_ctrl|di_tg_ctrl_n|vout.$192.Metal3 di_tg_ctrl|di_tg_ctrl_n|vout.$196.Metal3 0.368032035556
Rred_248 di_tg_ctrl|di_tg_ctrl_n|vout.$192.Metal3 di_tg_ctrl|di_tg_ctrl_n|vout.$206.Metal4 4.93068936086
Rred_249 di_tg_ctrl|di_tg_ctrl_n|vout.$192.Metal3 di_tg_ctrl|di_tg_ctrl_n|vout.$209.Metal4 6.21945438928
Rred_250 di_tg_ctrl|di_tg_ctrl_n|vout.$192.Metal3 di_tg_ctrl|di_tg_ctrl_n|vout.$77.Metal1 530.672045058
Rred_251 di_tg_ctrl|di_tg_ctrl_n|vout.$192.Metal3 di_tg_ctrl|di_tg_ctrl_n|vout.$79.Metal1 2978.51492292
Rred_252 di_tg_ctrl|di_tg_ctrl_n|vout.$192.Metal3 di_tg_ctrl|di_tg_ctrl_n|vout.$81.Metal1 1330.82581663
Rred_253 di_tg_ctrl|di_tg_ctrl_n|vout.$196.Metal3 di_tg_ctrl|di_tg_ctrl_n|vout.$209.Metal4 2.49274515405
Rred_254 di_tg_ctrl|di_tg_ctrl_n|vout.$196.Metal3 di_tg_ctrl|di_tg_ctrl_n|vout.$84.Metal1 1022.9672992
Rred_255 di_tg_ctrl|di_tg_ctrl_n|vout.$196.Metal3 di_tg_ctrl|di_tg_ctrl_n|vout.$86.Metal1 8914.42932163
Rred_256 di_tg_ctrl|di_tg_ctrl_n|vout.$196.Metal3 di_tg_ctrl|di_tg_ctrl_n|vout.$88.Metal1 613.910695388
Rred_257 di_tg_ctrl|di_tg_ctrl_n|vout.$196.Metal3 di_tg_ctrl|di_tg_ctrl_n|vout.$90.Metal1 150.311019344
Rred_258 di_tg_ctrl|di_tg_ctrl_n|vout.$206.Metal4 di_tg_ctrl|di_tg_ctrl_n|vout.$209.Metal4 0.555401718499
Rred_259 di_tg_ctrl|di_tg_ctrl_n|vout.$206.Metal4 di_tg_ctrl|di_tg_ctrl_n|vout.$77.Metal1 9822.89996167
Rred_260 di_tg_ctrl|di_tg_ctrl_n|vout.$206.Metal4 di_tg_ctrl|di_tg_ctrl_n|vout.P0.nSD 174.836677738
Rred_261 di_tg_ctrl|di_tg_ctrl_n|vout.$206.Metal4 di_tg_ctrl|di_tg_ctrl_n|vout.P0.pSD 33.6811425464
Rred_262 di_tg_ctrl|di_tg_ctrl_n|vout.$209.Metal4 di_tg_ctrl|di_tg_ctrl_n|vout.$77.Metal1 81568.2705287
Rred_263 di_tg_ctrl|di_tg_ctrl_n|vout.$209.Metal4 di_tg_ctrl|di_tg_ctrl_n|vout.$88.Metal1 6528.16041664
Rred_264 di_tg_ctrl|di_tg_ctrl_n|vout.$209.Metal4 di_tg_ctrl|di_tg_ctrl_n|vout.$90.Metal1 1554.94569335
Rred_265 di_tg_ctrl|di_tg_ctrl_n|vout.$21.GatPoly di_tg_ctrl|di_tg_ctrl_n|vout.$84.Metal1 71.9069024808
Rred_266 di_tg_ctrl|di_tg_ctrl_n|vout.$21.GatPoly di_tg_ctrl|di_tg_ctrl_n|vout.$86.Metal1 27.9042159324
Rred_267 di_tg_ctrl|di_tg_ctrl_n|vout.$21.GatPoly di_tg_ctrl|di_tg_ctrl_n|vout.$88.Metal1 18.3474918298
Rred_268 di_tg_ctrl|di_tg_ctrl_n|vout.$21.GatPoly di_tg_ctrl|di_tg_ctrl_n|vout.$90.Metal1 28.8380826051
Rred_269 di_tg_ctrl|di_tg_ctrl_n|vout.$21.GatPoly di_tg_ctrl|di_tg_ctrl_n|vout.P10.GatPoly 171.230769231
Rred_270 di_tg_ctrl|di_tg_ctrl_n|vout.$21.GatPoly di_tg_ctrl|di_tg_ctrl_n|vout.P11.GatPoly 355.663870287
Rred_271 di_tg_ctrl|di_tg_ctrl_n|vout.$21.GatPoly di_tg_ctrl|di_tg_ctrl_n|vout.P9.GatPoly 593.858885441
Rred_272 di_tg_ctrl|di_tg_ctrl_n|vout.$3.GatPoly di_tg_ctrl|di_tg_ctrl_n|vout.$6.GatPoly 21.8444333333
Rred_273 di_tg_ctrl|di_tg_ctrl_n|vout.$3.GatPoly di_tg_ctrl|di_tg_ctrl_n|vout.$65.Metal1 15
Rred_274 di_tg_ctrl|di_tg_ctrl_n|vout.$3.GatPoly di_tg_ctrl|di_tg_ctrl_n|vout.$67.Metal1 41.3025
Rred_275 di_tg_ctrl|di_tg_ctrl_n|vout.$3.GatPoly di_tg_ctrl|di_tg_ctrl_n|vout.P1.GatPoly 152.411538462
Rred_276 di_tg_ctrl|di_tg_ctrl_n|vout.$3.GatPoly di_tg_ctrl|di_tg_ctrl_n|vout.P2.GatPoly 72.94084838
Rred_277 di_tg_ctrl|di_tg_ctrl_n|vout.$6.GatPoly di_tg_ctrl|di_tg_ctrl_n|vout.$67.Metal1 17.2199796994
Rred_278 di_tg_ctrl|di_tg_ctrl_n|vout.$6.GatPoly di_tg_ctrl|di_tg_ctrl_n|vout.$70.Metal1 17.2736224188
Rred_279 di_tg_ctrl|di_tg_ctrl_n|vout.$6.GatPoly di_tg_ctrl|di_tg_ctrl_n|vout.P2.GatPoly 134.427282051
Rred_280 di_tg_ctrl|di_tg_ctrl_n|vout.$6.GatPoly di_tg_ctrl|di_tg_ctrl_n|vout.P3.GatPoly 45.1439599386
Rred_281 di_tg_ctrl|di_tg_ctrl_n|vout.$6.GatPoly di_tg_ctrl|di_tg_ctrl_n|vout.P4.GatPoly 405.217827404
Rred_282 di_tg_ctrl|di_tg_ctrl_n|vout.$61.Metal1 di_tg_ctrl|di_tg_ctrl_n|vout.$65.Metal1 0.362768213765
Rred_283 di_tg_ctrl|di_tg_ctrl_n|vout.$65.Metal1 di_tg_ctrl|di_tg_ctrl_n|vout.$67.Metal1 0.178417481464
Rred_284 di_tg_ctrl|di_tg_ctrl_n|vout.$67.Metal1 di_tg_ctrl|di_tg_ctrl_n|vout.$70.Metal1 0.361795734713
Rred_285 di_tg_ctrl|di_tg_ctrl_n|vout.$67.Metal1 di_tg_ctrl|di_tg_ctrl_n|vout.P2.GatPoly 254.169230769
Rred_286 di_tg_ctrl|di_tg_ctrl_n|vout.$70.Metal1 di_tg_ctrl|di_tg_ctrl_n|vout.P3.GatPoly 736.257692309
Rred_287 di_tg_ctrl|di_tg_ctrl_n|vout.$70.Metal1 di_tg_ctrl|di_tg_ctrl_n|vout.P4.GatPoly 736.257692309
Rred_288 di_tg_ctrl|di_tg_ctrl_n|vout.$70.Metal1 di_tg_ctrl|di_tg_ctrl_n|vout.P5.GatPoly 176.923878717
Rred_289 di_tg_ctrl|di_tg_ctrl_n|vout.$77.Metal1 di_tg_ctrl|di_tg_ctrl_n|vout.$79.Metal1 0.17882878213
Rred_290 di_tg_ctrl|di_tg_ctrl_n|vout.$77.Metal1 di_tg_ctrl|di_tg_ctrl_n|vout.P6.GatPoly 486.516345572
Rred_291 di_tg_ctrl|di_tg_ctrl_n|vout.$79.Metal1 di_tg_ctrl|di_tg_ctrl_n|vout.$81.Metal1 0.178840095718
Rred_292 di_tg_ctrl|di_tg_ctrl_n|vout.$79.Metal1 di_tg_ctrl|di_tg_ctrl_n|vout.P6.GatPoly 2689.8948173
Rred_293 di_tg_ctrl|di_tg_ctrl_n|vout.$81.Metal1 di_tg_ctrl|di_tg_ctrl_n|vout.$84.Metal1 0.361795734713
Rred_294 di_tg_ctrl|di_tg_ctrl_n|vout.$81.Metal1 di_tg_ctrl|di_tg_ctrl_n|vout.P8.GatPoly 3742.59253395
Rred_295 di_tg_ctrl|di_tg_ctrl_n|vout.$84.Metal1 di_tg_ctrl|di_tg_ctrl_n|vout.$86.Metal1 0.178242051933
Rred_296 di_tg_ctrl|di_tg_ctrl_n|vout.$84.Metal1 di_tg_ctrl|di_tg_ctrl_n|vout.P9.GatPoly 863.431298709
Rred_297 di_tg_ctrl|di_tg_ctrl_n|vout.$86.Metal1 di_tg_ctrl|di_tg_ctrl_n|vout.$88.Metal1 0.178847486772
Rred_298 di_tg_ctrl|di_tg_ctrl_n|vout.$86.Metal1 di_tg_ctrl|di_tg_ctrl_n|vout.P9.GatPoly 1497.12324061
Rred_299 di_tg_ctrl|di_tg_ctrl_n|vout.$88.Metal1 di_tg_ctrl|di_tg_ctrl_n|vout.$90.Metal1 0.178782034968
Rred_300 di_tg_ctrl|di_tg_ctrl_n|vout.$88.Metal1 di_tg_ctrl|di_tg_ctrl_n|vout.P11.GatPoly 2689.8948173
Rred_301 di_tg_ctrl|di_tg_ctrl_n|vout.$90.Metal1 di_tg_ctrl|di_tg_ctrl_n|vout.P11.GatPoly 486.516345572
Rred_302 di_tg_ctrl|di_tg_ctrl_n|vout.P0.nSD di_tg_ctrl|di_tg_ctrl_n|vout.P0.pSD 43.5451796244
Rred_303 di_tg_ctrl|di_tg_ctrl_n|vout.P3.GatPoly di_tg_ctrl|di_tg_ctrl_n|vout.P4.GatPoly 7480.94450594
Rred_304 v_a v_a.$148.Metal2 5.27652796841
Rred_305 v_a.$148.Metal2 v_a.$182.Metal2 0.183123238257
Rred_306 v_a.$148.Metal2 v_a.P0.nSD 10.7914879937
Rred_307 v_a.$148.Metal2 v_a.P0.pSD 2.82039210998
Rred_308 v_a.$148.Metal2 v_a.P1.nSD 22.0161789998
Rred_309 v_a.$148.Metal2 v_a.P1.pSD 5.75400330141
Rred_310 v_a.$182.Metal2 v_a.P1.nSD 22.0161789998
Rred_311 v_a.$182.Metal2 v_a.P1.pSD 5.75400330141
Rred_312 v_a.$182.Metal2 v_a.P3.nSD 10.7914879937
Rred_313 v_a.$182.Metal2 v_a.P3.pSD 2.82039210998
Rred_314 v_a.$182.Metal2 v_a.P5.nSD 11.3738836354
Rred_315 v_a.$182.Metal2 v_a.P5.pSD 3.13261286415
Rred_316 v_a.P1.nSD v_a.P1.pSD 691.780944107
Rred_317 v_a.P5.nSD v_a.P5.pSD 427.991941053
Rred_318 v_b v_b.$195.Metal2 6.41212273872
Rred_319 v_b.$161.Metal2 v_b.$195.Metal2 0.183123238257
Rred_320 v_b.$161.Metal2 v_b.P0.nSD 11.3738836354
Rred_321 v_b.$161.Metal2 v_b.P0.pSD 3.13261286415
Rred_322 v_b.$161.Metal2 v_b.P1.nSD 10.7914879937
Rred_323 v_b.$161.Metal2 v_b.P1.pSD 2.82039210998
Rred_324 v_b.$161.Metal2 v_b.P3.nSD 22.0161789998
Rred_325 v_b.$161.Metal2 v_b.P3.pSD 5.75400330141
Rred_326 v_b.$195.Metal2 v_b.P3.nSD 22.0161789998
Rred_327 v_b.$195.Metal2 v_b.P3.pSD 5.75400330141
Rred_328 v_b.$195.Metal2 v_b.P5.nSD 10.7914879937
Rred_329 v_b.$195.Metal2 v_b.P5.pSD 2.82039210998
Rred_330 v_b.P0.nSD v_b.P0.pSD 427.991941053
Rred_331 v_b.P3.nSD v_b.P3.pSD 691.780944107
Rred_332 v_c v_c.$493.Metal3 0.1738
Rred_333 v_c.$129.Metal1 v_c.$131.Metal1 0.380587953605
Rred_334 v_c.$129.Metal1 v_c.$320.Metal2 3.85279316473
Rred_335 v_c.$129.Metal1 v_c.$322.Metal2 653.919302103
Rred_336 v_c.$129.Metal1 v_c.$459.Metal3 367.850330546
Rred_337 v_c.$129.Metal1 v_c.$464.Metal3 156.351247393
Rred_338 v_c.$129.Metal1 v_c.P0.pSD 5.02090633063
Rred_339 v_c.$131.Metal1 v_c.$133.Metal1 0.377723728059
Rred_340 v_c.$131.Metal1 v_c.$320.Metal2 22.1667560035
Rred_341 v_c.$131.Metal1 v_c.$322.Metal2 9.13449534951
Rred_342 v_c.$131.Metal1 v_c.$324.Metal2 20.9354207047
Rred_343 v_c.$131.Metal1 v_c.P0.pSD 8.57099587643
Rred_344 v_c.$133.Metal1 v_c.$135.Metal1 0.381682896331
Rred_345 v_c.$133.Metal1 v_c.$324.Metal2 16.2050096923
Rred_346 v_c.$133.Metal1 v_c.$326.Metal2 10.5309757306
Rred_347 v_c.$133.Metal1 v_c.$328.Metal2 31.9902737945
Rred_348 v_c.$133.Metal1 v_c.P0.pSD 8.54749027394
Rred_349 v_c.$135.Metal1 v_c.$136.Metal1 0.186889833711
Rred_350 v_c.$135.Metal1 v_c.$326.Metal2 65.5800612787
Rred_351 v_c.$135.Metal1 v_c.$328.Metal2 12.7565634338
Rred_352 v_c.$135.Metal1 v_c.$330.Metal2 21.4073809524
Rred_353 v_c.$135.Metal1 v_c.P0.pSD 11.415314082
Rred_354 v_c.$136.Metal1 v_c.$330.Metal2 15.6639372822
Rred_355 v_c.$136.Metal1 v_c.$332.Metal2 9.95894340908
Rred_356 v_c.$136.Metal1 v_c.$334.Metal2 3.30620123555
Rred_357 v_c.$136.Metal1 v_c.$472.Metal3 35.3708671911
Rred_358 v_c.$136.Metal1 v_c.P0.pSD 2.98775409163
Rred_359 v_c.$165.Metal1 v_c.$167.Metal1 0.380587953605
Rred_360 v_c.$165.Metal1 v_c.$352.Metal2 3.85279316473
Rred_361 v_c.$165.Metal1 v_c.$354.Metal2 653.919302103
Rred_362 v_c.$165.Metal1 v_c.$476.Metal3 367.850330546
Rred_363 v_c.$165.Metal1 v_c.$481.Metal3 156.351247393
Rred_364 v_c.$165.Metal1 v_c.P2.pSD 5.02090633063
Rred_365 v_c.$167.Metal1 v_c.$169.Metal1 0.377723728059
Rred_366 v_c.$167.Metal1 v_c.$352.Metal2 22.1667560035
Rred_367 v_c.$167.Metal1 v_c.$354.Metal2 9.13449534951
Rred_368 v_c.$167.Metal1 v_c.$356.Metal2 20.9354207047
Rred_369 v_c.$167.Metal1 v_c.P2.pSD 8.57099587643
Rred_370 v_c.$169.Metal1 v_c.$171.Metal1 0.381682896331
Rred_371 v_c.$169.Metal1 v_c.$356.Metal2 16.2050096923
Rred_372 v_c.$169.Metal1 v_c.$358.Metal2 10.5309757306
Rred_373 v_c.$169.Metal1 v_c.$360.Metal2 31.9902737945
Rred_374 v_c.$169.Metal1 v_c.P2.pSD 8.54749027394
Rred_375 v_c.$171.Metal1 v_c.$172.Metal1 0.186889833711
Rred_376 v_c.$171.Metal1 v_c.$358.Metal2 65.5800612787
Rred_377 v_c.$171.Metal1 v_c.$360.Metal2 12.7565634338
Rred_378 v_c.$171.Metal1 v_c.$362.Metal2 21.4073809524
Rred_379 v_c.$171.Metal1 v_c.P2.pSD 11.415314082
Rred_380 v_c.$172.Metal1 v_c.$362.Metal2 15.6639372822
Rred_381 v_c.$172.Metal1 v_c.$364.Metal2 9.95894340908
Rred_382 v_c.$172.Metal1 v_c.$366.Metal2 3.30620123555
Rred_383 v_c.$172.Metal1 v_c.$489.Metal3 35.3708671911
Rred_384 v_c.$172.Metal1 v_c.P2.pSD 2.98775409163
Rred_385 v_c.$201.Metal1 v_c.$203.Metal1 0.380587953605
Rred_386 v_c.$201.Metal1 v_c.$384.Metal2 3.85279316473
Rred_387 v_c.$201.Metal1 v_c.$386.Metal2 653.919302103
Rred_388 v_c.$201.Metal1 v_c.$493.Metal3 367.850330546
Rred_389 v_c.$201.Metal1 v_c.$498.Metal3 156.351247393
Rred_390 v_c.$201.Metal1 v_c.P4.pSD 5.02090633063
Rred_391 v_c.$203.Metal1 v_c.$205.Metal1 0.377723728059
Rred_392 v_c.$203.Metal1 v_c.$384.Metal2 22.1667560035
Rred_393 v_c.$203.Metal1 v_c.$386.Metal2 9.13449534951
Rred_394 v_c.$203.Metal1 v_c.$388.Metal2 20.9354207047
Rred_395 v_c.$203.Metal1 v_c.P4.pSD 8.57099587643
Rred_396 v_c.$205.Metal1 v_c.$207.Metal1 0.381682896331
Rred_397 v_c.$205.Metal1 v_c.$388.Metal2 16.2050096923
Rred_398 v_c.$205.Metal1 v_c.$390.Metal2 10.5309757306
Rred_399 v_c.$205.Metal1 v_c.$392.Metal2 31.9902737945
Rred_400 v_c.$205.Metal1 v_c.P4.pSD 8.54749027394
Rred_401 v_c.$207.Metal1 v_c.$208.Metal1 0.186889833711
Rred_402 v_c.$207.Metal1 v_c.$390.Metal2 65.5800612787
Rred_403 v_c.$207.Metal1 v_c.$392.Metal2 12.7565634338
Rred_404 v_c.$207.Metal1 v_c.$394.Metal2 21.4073809524
Rred_405 v_c.$207.Metal1 v_c.P4.pSD 11.415314082
Rred_406 v_c.$208.Metal1 v_c.$394.Metal2 15.6639372822
Rred_407 v_c.$208.Metal1 v_c.$396.Metal2 9.95894340908
Rred_408 v_c.$208.Metal1 v_c.$398.Metal2 3.30620123555
Rred_409 v_c.$208.Metal1 v_c.$506.Metal3 35.3708671911
Rred_410 v_c.$208.Metal1 v_c.P4.pSD 2.98775409163
Rred_411 v_c.$21.Metal1 v_c.$220.Metal2 6.33650906128
Rred_412 v_c.$21.Metal1 v_c.$224.Metal2 8.48755283696
Rred_413 v_c.$21.Metal1 v_c.$226.Metal2 653.919302103
Rred_414 v_c.$21.Metal1 v_c.$23.Metal1 0.380587953605
Rred_415 v_c.$21.Metal1 v_c.$411.Metal3 979.990651107
Rred_416 v_c.$21.Metal1 v_c.P6.pSD 5.0249176968
Rred_417 v_c.$220.Metal2 v_c.$224.Metal2 0.350115178576
Rred_418 v_c.$220.Metal2 v_c.$411.Metal3 6.75999980527
Rred_419 v_c.$220.Metal2 v_c.$425.Metal3 59.2351277913
Rred_420 v_c.$220.Metal2 v_c.P6.nSD 13139.4607533
Rred_421 v_c.$220.Metal2 v_c.P6.pSD 312.054467843
Rred_422 v_c.$224.Metal2 v_c.$226.Metal2 0.171795809299
Rred_423 v_c.$224.Metal2 v_c.$228.Metal2 4580.45571151
Rred_424 v_c.$224.Metal2 v_c.$23.Metal1 22.1667560035
Rred_425 v_c.$224.Metal2 v_c.$411.Metal3 7.29494099486
Rred_426 v_c.$224.Metal2 v_c.$415.Metal3 36.7250760159
Rred_427 v_c.$224.Metal2 v_c.P6.pSD 1155.70047075
Rred_428 v_c.$226.Metal2 v_c.$228.Metal2 0.171796584217
Rred_429 v_c.$226.Metal2 v_c.$23.Metal1 9.13449534951
Rred_430 v_c.$226.Metal2 v_c.$411.Metal3 18.2892185628
Rred_431 v_c.$226.Metal2 v_c.$415.Metal3 18.2892185628
Rred_432 v_c.$226.Metal2 v_c.P6.pSD 59609.1460043
Rred_433 v_c.$228.Metal2 v_c.$23.Metal1 2.94009656778
Rred_434 v_c.$228.Metal2 v_c.$411.Metal3 36.7250760159
Rred_435 v_c.$228.Metal2 v_c.$415.Metal3 1.74343129416
Rred_436 v_c.$228.Metal2 v_c.P6.pSD 7.71668977509
Rred_437 v_c.$23.Metal1 v_c.$415.Metal3 11.202495865
Rred_438 v_c.$23.Metal1 v_c.P6.pSD 2.34918399287
Rred_439 v_c.$284.Metal2 v_c.$288.Metal2 0.350115178576
Rred_440 v_c.$284.Metal2 v_c.$425.Metal3 64.1747368246
Rred_441 v_c.$284.Metal2 v_c.$446.Metal3 6.94377008489
Rred_442 v_c.$284.Metal2 v_c.$459.Metal3 191.265882301
Rred_443 v_c.$284.Metal2 v_c.$93.Metal1 6.33650906128
Rred_444 v_c.$284.Metal2 v_c.P10.nSD 10683.2326931
Rred_445 v_c.$284.Metal2 v_c.P10.pSD 312.054467843
Rred_446 v_c.$288.Metal2 v_c.$290.Metal2 0.171795809299
Rred_447 v_c.$288.Metal2 v_c.$292.Metal2 4580.45571151
Rred_448 v_c.$288.Metal2 v_c.$446.Metal3 7.29494099486
Rred_449 v_c.$288.Metal2 v_c.$450.Metal3 36.7250760159
Rred_450 v_c.$288.Metal2 v_c.$93.Metal1 8.48755283696
Rred_451 v_c.$288.Metal2 v_c.$95.Metal1 22.1667560035
Rred_452 v_c.$288.Metal2 v_c.P10.pSD 1155.70047075
Rred_453 v_c.$290.Metal2 v_c.$292.Metal2 0.171796584217
Rred_454 v_c.$290.Metal2 v_c.$446.Metal3 18.2892185628
Rred_455 v_c.$290.Metal2 v_c.$450.Metal3 18.2892185628
Rred_456 v_c.$290.Metal2 v_c.$93.Metal1 653.919302103
Rred_457 v_c.$290.Metal2 v_c.$95.Metal1 9.13449534951
Rred_458 v_c.$290.Metal2 v_c.P10.pSD 59609.1460043
Rred_459 v_c.$292.Metal2 v_c.$446.Metal3 36.7250760159
Rred_460 v_c.$292.Metal2 v_c.$450.Metal3 1.74343129416
Rred_461 v_c.$292.Metal2 v_c.$95.Metal1 2.94009656778
Rred_462 v_c.$292.Metal2 v_c.P10.pSD 7.71668977509
Rred_463 v_c.$320.Metal2 v_c.$322.Metal2 0.171808748775
Rred_464 v_c.$320.Metal2 v_c.$459.Metal3 17.9117747301
Rred_465 v_c.$320.Metal2 v_c.$464.Metal3 3.90787634111
Rred_466 v_c.$320.Metal2 v_c.P0.pSD 267.156923058
Rred_467 v_c.$322.Metal2 v_c.$324.Metal2 0.171796584217
Rred_468 v_c.$322.Metal2 v_c.$326.Metal2 4580.45571151
Rred_469 v_c.$322.Metal2 v_c.$464.Metal3 12.1119512228
Rred_470 v_c.$322.Metal2 v_c.$468.Metal3 36.7250760159
Rred_471 v_c.$322.Metal2 v_c.P0.pSD 59609.1460043
Rred_472 v_c.$324.Metal2 v_c.$326.Metal2 0.171796584217
Rred_473 v_c.$324.Metal2 v_c.$464.Metal3 18.2892185628
Rred_474 v_c.$324.Metal2 v_c.$468.Metal3 18.2892185628
Rred_475 v_c.$324.Metal2 v_c.P0.pSD 1913.94243063
Rred_476 v_c.$326.Metal2 v_c.$328.Metal2 0.171804153568
Rred_477 v_c.$326.Metal2 v_c.$464.Metal3 36.7250760159
Rred_478 v_c.$326.Metal2 v_c.$468.Metal3 12.1119512228
Rred_479 v_c.$326.Metal2 v_c.P0.pSD 5881.92612918
Rred_480 v_c.$328.Metal2 v_c.$330.Metal2 0.17180952381
Rred_481 v_c.$328.Metal2 v_c.$468.Metal3 9
Rred_482 v_c.$328.Metal2 v_c.P0.pSD 2912.41521397
Rred_483 v_c.$330.Metal2 v_c.$332.Metal2 0.171796584217
Rred_484 v_c.$330.Metal2 v_c.$334.Metal2 4580.45571151
Rred_485 v_c.$330.Metal2 v_c.$468.Metal3 12.1119512228
Rred_486 v_c.$330.Metal2 v_c.$472.Metal3 36.7250760159
Rred_487 v_c.$332.Metal2 v_c.$334.Metal2 0.171661606325
Rred_488 v_c.$332.Metal2 v_c.$468.Metal3 18.2892185628
Rred_489 v_c.$332.Metal2 v_c.$472.Metal3 18.1472265446
Rred_490 v_c.$332.Metal2 v_c.P0.pSD 239.542066515
Rred_491 v_c.$334.Metal2 v_c.$468.Metal3 36.7250760159
Rred_492 v_c.$334.Metal2 v_c.$472.Metal3 2.31741938765
Rred_493 v_c.$334.Metal2 v_c.P0.pSD 15.1481517659
Rred_494 v_c.$352.Metal2 v_c.$354.Metal2 0.171808748775
Rred_495 v_c.$352.Metal2 v_c.$476.Metal3 17.9117747301
Rred_496 v_c.$352.Metal2 v_c.$481.Metal3 3.90787634111
Rred_497 v_c.$352.Metal2 v_c.P2.pSD 267.156923058
Rred_498 v_c.$354.Metal2 v_c.$356.Metal2 0.171796584217
Rred_499 v_c.$354.Metal2 v_c.$358.Metal2 4580.45571151
Rred_500 v_c.$354.Metal2 v_c.$481.Metal3 12.1119512228
Rred_501 v_c.$354.Metal2 v_c.$485.Metal3 36.7250760159
Rred_502 v_c.$354.Metal2 v_c.P2.pSD 59609.1460043
Rred_503 v_c.$356.Metal2 v_c.$358.Metal2 0.171796584217
Rred_504 v_c.$356.Metal2 v_c.$481.Metal3 18.2892185628
Rred_505 v_c.$356.Metal2 v_c.$485.Metal3 18.2892185628
Rred_506 v_c.$356.Metal2 v_c.P2.pSD 1913.94243063
Rred_507 v_c.$358.Metal2 v_c.$360.Metal2 0.171804153568
Rred_508 v_c.$358.Metal2 v_c.$481.Metal3 36.7250760159
Rred_509 v_c.$358.Metal2 v_c.$485.Metal3 12.1119512228
Rred_510 v_c.$358.Metal2 v_c.P2.pSD 5881.92612918
Rred_511 v_c.$360.Metal2 v_c.$362.Metal2 0.17180952381
Rred_512 v_c.$360.Metal2 v_c.$485.Metal3 9
Rred_513 v_c.$360.Metal2 v_c.P2.pSD 2912.41521397
Rred_514 v_c.$362.Metal2 v_c.$364.Metal2 0.171796584217
Rred_515 v_c.$362.Metal2 v_c.$366.Metal2 4580.45571151
Rred_516 v_c.$362.Metal2 v_c.$485.Metal3 12.1119512228
Rred_517 v_c.$362.Metal2 v_c.$489.Metal3 36.7250760159
Rred_518 v_c.$364.Metal2 v_c.$366.Metal2 0.171661606325
Rred_519 v_c.$364.Metal2 v_c.$485.Metal3 18.2892185628
Rred_520 v_c.$364.Metal2 v_c.$489.Metal3 18.1472265446
Rred_521 v_c.$364.Metal2 v_c.P2.pSD 239.542066515
Rred_522 v_c.$366.Metal2 v_c.$485.Metal3 36.7250760159
Rred_523 v_c.$366.Metal2 v_c.$489.Metal3 2.31741938765
Rred_524 v_c.$366.Metal2 v_c.P2.pSD 15.1481517659
Rred_525 v_c.$384.Metal2 v_c.$386.Metal2 0.171808748775
Rred_526 v_c.$384.Metal2 v_c.$493.Metal3 17.9117747301
Rred_527 v_c.$384.Metal2 v_c.$498.Metal3 3.90787634111
Rred_528 v_c.$384.Metal2 v_c.P4.pSD 267.156923058
Rred_529 v_c.$386.Metal2 v_c.$388.Metal2 0.171796584217
Rred_530 v_c.$386.Metal2 v_c.$390.Metal2 4580.45571151
Rred_531 v_c.$386.Metal2 v_c.$498.Metal3 12.1119512228
Rred_532 v_c.$386.Metal2 v_c.$502.Metal3 36.7250760159
Rred_533 v_c.$386.Metal2 v_c.P4.pSD 59609.1460043
Rred_534 v_c.$388.Metal2 v_c.$390.Metal2 0.171796584217
Rred_535 v_c.$388.Metal2 v_c.$498.Metal3 18.2892185628
Rred_536 v_c.$388.Metal2 v_c.$502.Metal3 18.2892185628
Rred_537 v_c.$388.Metal2 v_c.P4.pSD 1913.94243063
Rred_538 v_c.$390.Metal2 v_c.$392.Metal2 0.171804153568
Rred_539 v_c.$390.Metal2 v_c.$498.Metal3 36.7250760159
Rred_540 v_c.$390.Metal2 v_c.$502.Metal3 12.1119512228
Rred_541 v_c.$390.Metal2 v_c.P4.pSD 5881.92612918
Rred_542 v_c.$392.Metal2 v_c.$394.Metal2 0.17180952381
Rred_543 v_c.$392.Metal2 v_c.$502.Metal3 9
Rred_544 v_c.$392.Metal2 v_c.P4.pSD 2912.41521397
Rred_545 v_c.$394.Metal2 v_c.$396.Metal2 0.171796584217
Rred_546 v_c.$394.Metal2 v_c.$398.Metal2 4580.45571151
Rred_547 v_c.$394.Metal2 v_c.$502.Metal3 12.1119512228
Rred_548 v_c.$394.Metal2 v_c.$506.Metal3 36.7250760159
Rred_549 v_c.$396.Metal2 v_c.$398.Metal2 0.171661606325
Rred_550 v_c.$396.Metal2 v_c.$502.Metal3 18.2892185628
Rred_551 v_c.$396.Metal2 v_c.$506.Metal3 18.1472265446
Rred_552 v_c.$396.Metal2 v_c.P4.pSD 239.542066515
Rred_553 v_c.$398.Metal2 v_c.$502.Metal3 36.7250760159
Rred_554 v_c.$398.Metal2 v_c.$506.Metal3 2.31741938765
Rred_555 v_c.$398.Metal2 v_c.P4.pSD 15.1481517659
Rred_556 v_c.$411.Metal3 v_c.$415.Metal3 0.294453498367
Rred_557 v_c.$411.Metal3 v_c.$425.Metal3 0.474934091269
Rred_558 v_c.$411.Metal3 v_c.P6.nSD 105.34927644
Rred_559 v_c.$411.Metal3 v_c.P6.pSD 143680.337841
Rred_560 v_c.$415.Metal3 v_c.P6.pSD 15.7094054283
Rred_561 v_c.$425.Metal3 v_c.$446.Metal3 0.514538778807
Rred_562 v_c.$425.Metal3 v_c.$459.Metal3 0.43546119108
Rred_563 v_c.$425.Metal3 v_c.P10.nSD 24.3228597655
Rred_564 v_c.$425.Metal3 v_c.P6.nSD 17.6342972259
Rred_565 v_c.$425.Metal3 v_c.P8.nSD 14.9424370708
Rred_566 v_c.$425.Metal3 v_c.P8.pSD 2.80751540366
Rred_567 v_c.$446.Metal3 v_c.$450.Metal3 0.294453498367
Rred_568 v_c.$446.Metal3 v_c.$459.Metal3 1.53352734076
Rred_569 v_c.$446.Metal3 v_c.$93.Metal1 979.990651107
Rred_570 v_c.$446.Metal3 v_c.P10.nSD 85.6557856818
Rred_571 v_c.$446.Metal3 v_c.P10.pSD 143680.337841
Rred_572 v_c.$450.Metal3 v_c.$95.Metal1 11.202495865
Rred_573 v_c.$450.Metal3 v_c.P10.pSD 15.7094054283
Rred_574 v_c.$459.Metal3 v_c.$464.Metal3 0.392433596146
Rred_575 v_c.$459.Metal3 v_c.$476.Metal3 0.08976
Rred_576 v_c.$459.Metal3 v_c.P0.nSD 14.9424370708
Rred_577 v_c.$459.Metal3 v_c.P0.pSD 18985.799744
Rred_578 v_c.$459.Metal3 v_c.P10.nSD 72.4916604777
Rred_579 v_c.$464.Metal3 v_c.$468.Metal3 0.294453498367
Rred_580 v_c.$464.Metal3 v_c.P0.pSD 8418.01649392
Rred_581 v_c.$468.Metal3 v_c.$472.Metal3 0.294453498367
Rred_582 v_c.$472.Metal3 v_c.P0.pSD 124.949606526
Rred_583 v_c.$476.Metal3 v_c.$481.Metal3 0.392433596146
Rred_584 v_c.$476.Metal3 v_c.$493.Metal3 0.08976
Rred_585 v_c.$476.Metal3 v_c.P2.nSD 14.9424370708
Rred_586 v_c.$476.Metal3 v_c.P2.pSD 18985.799744
Rred_587 v_c.$481.Metal3 v_c.$485.Metal3 0.294453498367
Rred_588 v_c.$481.Metal3 v_c.P2.pSD 8418.01649392
Rred_589 v_c.$485.Metal3 v_c.$489.Metal3 0.294453498367
Rred_590 v_c.$489.Metal3 v_c.P2.pSD 124.949606526
Rred_591 v_c.$493.Metal3 v_c.$498.Metal3 0.392433596146
Rred_592 v_c.$493.Metal3 v_c.P4.nSD 14.9424370708
Rred_593 v_c.$493.Metal3 v_c.P4.pSD 18985.799744
Rred_594 v_c.$498.Metal3 v_c.$502.Metal3 0.294453498367
Rred_595 v_c.$498.Metal3 v_c.P4.pSD 8418.01649392
Rred_596 v_c.$502.Metal3 v_c.$506.Metal3 0.294453498367
Rred_597 v_c.$506.Metal3 v_c.P4.pSD 124.949606526
Rred_598 v_c.$93.Metal1 v_c.$95.Metal1 0.380587953605
Rred_599 v_c.$93.Metal1 v_c.P10.pSD 5.0249176968
Rred_600 v_c.$95.Metal1 v_c.P10.pSD 2.34918399287
Rred_601 VDD VDD.$552.Metal2 15.4168936585
Rred_602 VDD VDD.$554.Metal2 15.4168936585
Rred_603 VDD VDD.$840.Metal3 0.0618046136889
Rred_604 VDD.$100.Metal1 VDD.$102.Metal1 0.377874959862
Rred_605 VDD.$100.Metal1 VDD.$569.Metal2 20.7508366546
Rred_606 VDD.$100.Metal1 VDD.$570.Metal2 9.13539966392
Rred_607 VDD.$100.Metal1 VDD.$571.Metal2 22.388202951
Rred_608 VDD.$100.Metal1 VDD.$98.Metal1 0.380432005335
Rred_609 VDD.$100.Metal1 VDD.P1.pSD 8.57103899949
Rred_610 VDD.$102.Metal1 VDD.$570.Metal2 649.257885581
Rred_611 VDD.$102.Metal1 VDD.$571.Metal2 15.4236335282
Rred_612 VDD.$102.Metal1 VDD.$572.Metal2 9.18715616563
Rred_613 VDD.$102.Metal1 VDD.$573.Metal2 9.58934553755
Rred_614 VDD.$102.Metal1 VDD.P1.pSD 5.03147100162
Rred_615 VDD.$105.Metal1 VDD.$113.Metal1 0.0697021182856
Rred_616 VDD.$105.Metal1 VDD.$33.Metal1 0.0697692902273
Rred_617 VDD.$105.Metal1 VDD.$574.Metal2 4.68422960318
Rred_618 VDD.$105.Metal1 VDD.$597.Metal2 4.38496188699
Rred_619 VDD.$105.Metal1 VDD.$844.Metal3 1062.25078202
Rred_620 VDD.$105.Metal1 VDD.P0.nSD 8.73280354357
Rred_621 VDD.$113.Metal1 VDD.$185.Metal1 0.0697692902273
Rred_622 VDD.$113.Metal1 VDD.$597.Metal2 4.52745327144
Rred_623 VDD.$113.Metal1 VDD.$621.Metal2 4.52921396731
Rred_624 VDD.$113.Metal1 VDD.$844.Metal3 2299.30001576
Rred_625 VDD.$113.Metal1 VDD.$852.Metal3 2299.30001576
Rred_626 VDD.$113.Metal1 VDD.P0.nSD 8.73280354357
Rred_627 VDD.$125.Metal1 VDD.$139.Metal1 0.385940766875
Rred_628 VDD.$125.Metal1 VDD.$615.Metal2 21.0513145568
Rred_629 VDD.$125.Metal1 VDD.$616.Metal2 9
Rred_630 VDD.$125.Metal1 VDD.$617.Metal2 10.0114120534
Rred_631 VDD.$125.Metal1 VDD.$618.Metal2 10.8140411388
Rred_632 VDD.$125.Metal1 VDD.$619.Metal2 11.2874512273
Rred_633 VDD.$125.Metal1 VDD.P3.pSD 3.51667285081
Rred_634 VDD.$131.Metal1 VDD.$133.Metal1 0.380587953605
Rred_635 VDD.$131.Metal1 VDD.$606.Metal2 9.58257958965
Rred_636 VDD.$131.Metal1 VDD.$607.Metal2 9.1793269445
Rred_637 VDD.$131.Metal1 VDD.$608.Metal2 15.5360474609
Rred_638 VDD.$131.Metal1 VDD.$609.Metal2 653.919302103
Rred_639 VDD.$131.Metal1 VDD.P3.pSD 5.02509000547
Rred_640 VDD.$133.Metal1 VDD.$135.Metal1 0.377723728059
Rred_641 VDD.$133.Metal1 VDD.$608.Metal2 22.1667560035
Rred_642 VDD.$133.Metal1 VDD.$609.Metal2 9.13449534951
Rred_643 VDD.$133.Metal1 VDD.$610.Metal2 20.9354207047
Rred_644 VDD.$133.Metal1 VDD.P3.pSD 8.57099587643
Rred_645 VDD.$135.Metal1 VDD.$137.Metal1 0.381682896331
Rred_646 VDD.$135.Metal1 VDD.$610.Metal2 16.2050096923
Rred_647 VDD.$135.Metal1 VDD.$611.Metal2 10.5309757306
Rred_648 VDD.$135.Metal1 VDD.$612.Metal2 31.9902737945
Rred_649 VDD.$135.Metal1 VDD.P3.pSD 8.54749027394
Rred_650 VDD.$137.Metal1 VDD.$139.Metal1 0.378908730097
Rred_651 VDD.$137.Metal1 VDD.$611.Metal2 65.5800612787
Rred_652 VDD.$137.Metal1 VDD.$612.Metal2 12.7565634338
Rred_653 VDD.$137.Metal1 VDD.$613.Metal2 12.7926067357
Rred_654 VDD.$137.Metal1 VDD.$614.Metal2 68.529904295
Rred_655 VDD.$137.Metal1 VDD.P3.pSD 8.57731352064
Rred_656 VDD.$139.Metal1 VDD.$613.Metal2 31.757760527
Rred_657 VDD.$139.Metal1 VDD.$614.Metal2 10.4541785882
Rred_658 VDD.$139.Metal1 VDD.$615.Metal2 16.1507468455
Rred_659 VDD.$139.Metal1 VDD.P3.pSD 8.46137847645
Rred_660 VDD.$170.Metal1 VDD.$172.Metal1 0.380587953605
Rred_661 VDD.$170.Metal1 VDD.$606.Metal2 9.58257958965
Rred_662 VDD.$170.Metal1 VDD.$607.Metal2 9.1793269445
Rred_663 VDD.$170.Metal1 VDD.$608.Metal2 15.5360474609
Rred_664 VDD.$170.Metal1 VDD.$609.Metal2 653.919302103
Rred_665 VDD.$170.Metal1 VDD.P5.pSD 5.02509000547
Rred_666 VDD.$172.Metal1 VDD.$174.Metal1 0.377723728059
Rred_667 VDD.$172.Metal1 VDD.$608.Metal2 22.1667560035
Rred_668 VDD.$172.Metal1 VDD.$609.Metal2 9.13449534951
Rred_669 VDD.$172.Metal1 VDD.$610.Metal2 20.9354207047
Rred_670 VDD.$172.Metal1 VDD.P5.pSD 8.57099587643
Rred_671 VDD.$174.Metal1 VDD.$176.Metal1 0.381682896331
Rred_672 VDD.$174.Metal1 VDD.$610.Metal2 16.2050096923
Rred_673 VDD.$174.Metal1 VDD.$611.Metal2 10.5309757306
Rred_674 VDD.$174.Metal1 VDD.$612.Metal2 31.9902737945
Rred_675 VDD.$174.Metal1 VDD.P5.pSD 8.54749027394
Rred_676 VDD.$176.Metal1 VDD.$177.Metal1 0.186889833711
Rred_677 VDD.$176.Metal1 VDD.$611.Metal2 65.5800612787
Rred_678 VDD.$176.Metal1 VDD.$612.Metal2 12.7565634338
Rred_679 VDD.$176.Metal1 VDD.$613.Metal2 21.4073809524
Rred_680 VDD.$176.Metal1 VDD.P5.pSD 11.415314082
Rred_681 VDD.$177.Metal1 VDD.$179.Metal1 0.378342725478
Rred_682 VDD.$177.Metal1 VDD.$613.Metal2 15.6639372822
Rred_683 VDD.$177.Metal1 VDD.$614.Metal2 14.3820275964
Rred_684 VDD.$177.Metal1 VDD.$615.Metal2 162.515397989
Rred_685 VDD.$177.Metal1 VDD.P5.pSD 11.3902299793
Rred_686 VDD.$179.Metal1 VDD.$182.Metal1 0.5836897818
Rred_687 VDD.$179.Metal1 VDD.$614.Metal2 25.0023689215
Rred_688 VDD.$179.Metal1 VDD.$615.Metal2 9.56445844156
Rred_689 VDD.$179.Metal1 VDD.$616.Metal2 14.1111214102
Rred_690 VDD.$179.Metal1 VDD.$617.Metal2 34.5822472602
Rred_691 VDD.$179.Metal1 VDD.P5.pSD 6.90933999562
Rred_692 VDD.$182.Metal1 VDD.$616.Metal2 27.0968810839
Rred_693 VDD.$182.Metal1 VDD.$617.Metal2 12.6157751291
Rred_694 VDD.$182.Metal1 VDD.$618.Metal2 9.18715616563
Rred_695 VDD.$182.Metal1 VDD.$619.Metal2 9.58934553755
Rred_696 VDD.$182.Metal1 VDD.P5.pSD 4.40269128628
Rred_697 VDD.$185.Metal1 VDD.$215.Metal1 0.0680471464162
Rred_698 VDD.$185.Metal1 VDD.$621.Metal2 4.52943380941
Rred_699 VDD.$185.Metal1 VDD.$643.Metal2 4.5867534068
Rred_700 VDD.$185.Metal1 VDD.$852.Metal3 1131.50554324
Rred_701 VDD.$185.Metal1 VDD.P0.nSD 7.33700774319
Rred_702 VDD.$215.Metal1 VDD.$218.Metal1 0.0330071597633
Rred_703 VDD.$215.Metal1 VDD.$29.Metal1 169.189176348
Rred_704 VDD.$215.Metal1 VDD.$382.Metal1 17.5585690442
Rred_705 VDD.$215.Metal1 VDD.$643.Metal2 8.82278719506
Rred_706 VDD.$215.Metal1 VDD.P0.nSD 1.35843084663
Rred_707 VDD.$218.Metal1 VDD.$257.Metal1 0.0697675062039
Rred_708 VDD.$218.Metal1 VDD.$620.Metal2 15.9298487632
Rred_709 VDD.$218.Metal1 VDD.$643.Metal2 29.6927695696
Rred_710 VDD.$218.Metal1 VDD.$651.Metal2 4.26728190477
Rred_711 VDD.$218.Metal1 VDD.$856.Metal3 1007.58601402
Rred_712 VDD.$218.Metal1 VDD.P0.nSD 9.73459886964
Rred_713 VDD.$240.Metal1 VDD.$242.Metal1 0.380587953605
Rred_714 VDD.$240.Metal1 VDD.$606.Metal2 9.58257958965
Rred_715 VDD.$240.Metal1 VDD.$607.Metal2 9.1793269445
Rred_716 VDD.$240.Metal1 VDD.$608.Metal2 15.5360474609
Rred_717 VDD.$240.Metal1 VDD.$609.Metal2 653.919302103
Rred_718 VDD.$240.Metal1 VDD.P6.pSD 5.02509000547
Rred_719 VDD.$242.Metal1 VDD.$244.Metal1 0.377723728059
Rred_720 VDD.$242.Metal1 VDD.$608.Metal2 22.1667560035
Rred_721 VDD.$242.Metal1 VDD.$609.Metal2 9.13449534951
Rred_722 VDD.$242.Metal1 VDD.$610.Metal2 20.9354207047
Rred_723 VDD.$242.Metal1 VDD.P6.pSD 8.57099587643
Rred_724 VDD.$244.Metal1 VDD.$246.Metal1 0.381682896331
Rred_725 VDD.$244.Metal1 VDD.$610.Metal2 16.2050096923
Rred_726 VDD.$244.Metal1 VDD.$611.Metal2 10.5309757306
Rred_727 VDD.$244.Metal1 VDD.$612.Metal2 31.9902737945
Rred_728 VDD.$244.Metal1 VDD.P6.pSD 8.54749027394
Rred_729 VDD.$246.Metal1 VDD.$247.Metal1 0.186889833711
Rred_730 VDD.$246.Metal1 VDD.$611.Metal2 65.5800612787
Rred_731 VDD.$246.Metal1 VDD.$612.Metal2 12.7565634338
Rred_732 VDD.$246.Metal1 VDD.$613.Metal2 21.4073809524
Rred_733 VDD.$246.Metal1 VDD.P6.pSD 11.415314082
Rred_734 VDD.$247.Metal1 VDD.$249.Metal1 0.378342725478
Rred_735 VDD.$247.Metal1 VDD.$613.Metal2 15.6639372822
Rred_736 VDD.$247.Metal1 VDD.$614.Metal2 14.3820275964
Rred_737 VDD.$247.Metal1 VDD.$615.Metal2 162.515397989
Rred_738 VDD.$247.Metal1 VDD.P6.pSD 11.3902299793
Rred_739 VDD.$249.Metal1 VDD.$252.Metal1 0.5836897818
Rred_740 VDD.$249.Metal1 VDD.$614.Metal2 25.0023689215
Rred_741 VDD.$249.Metal1 VDD.$615.Metal2 9.56445844156
Rred_742 VDD.$249.Metal1 VDD.$616.Metal2 14.1111214102
Rred_743 VDD.$249.Metal1 VDD.$617.Metal2 34.5822472602
Rred_744 VDD.$249.Metal1 VDD.P6.pSD 6.90933999562
Rred_745 VDD.$252.Metal1 VDD.$616.Metal2 27.0968810839
Rred_746 VDD.$252.Metal1 VDD.$617.Metal2 12.6157751291
Rred_747 VDD.$252.Metal1 VDD.$618.Metal2 9.18715616563
Rred_748 VDD.$252.Metal1 VDD.$619.Metal2 9.58934553755
Rred_749 VDD.$252.Metal1 VDD.P6.pSD 4.40269128628
Rred_750 VDD.$257.Metal1 VDD.$298.Metal1 0.0697627488099
Rred_751 VDD.$257.Metal1 VDD.$651.Metal2 4.52934861079
Rred_752 VDD.$257.Metal1 VDD.$688.Metal2 4.5294251432
Rred_753 VDD.$257.Metal1 VDD.$856.Metal3 2299.30001576
Rred_754 VDD.$257.Metal1 VDD.$864.Metal3 2299.30001576
Rred_755 VDD.$257.Metal1 VDD.P0.nSD 7.28220306149
Rred_756 VDD.$279.Metal1 VDD.$281.Metal1 0.380587953605
Rred_757 VDD.$279.Metal1 VDD.$606.Metal2 9.58257958965
Rred_758 VDD.$279.Metal1 VDD.$607.Metal2 9.1793269445
Rred_759 VDD.$279.Metal1 VDD.$608.Metal2 15.5360474609
Rred_760 VDD.$279.Metal1 VDD.$609.Metal2 653.919302103
Rred_761 VDD.$279.Metal1 VDD.P7.pSD 5.02509000547
Rred_762 VDD.$281.Metal1 VDD.$283.Metal1 0.377723728059
Rred_763 VDD.$281.Metal1 VDD.$608.Metal2 22.1667560035
Rred_764 VDD.$281.Metal1 VDD.$609.Metal2 9.13449534951
Rred_765 VDD.$281.Metal1 VDD.$610.Metal2 20.9354207047
Rred_766 VDD.$281.Metal1 VDD.P7.pSD 8.57099587643
Rred_767 VDD.$283.Metal1 VDD.$285.Metal1 0.381682896331
Rred_768 VDD.$283.Metal1 VDD.$610.Metal2 16.2050096923
Rred_769 VDD.$283.Metal1 VDD.$611.Metal2 10.5309757306
Rred_770 VDD.$283.Metal1 VDD.$612.Metal2 31.9902737945
Rred_771 VDD.$283.Metal1 VDD.P7.pSD 8.54749027394
Rred_772 VDD.$285.Metal1 VDD.$286.Metal1 0.186889833711
Rred_773 VDD.$285.Metal1 VDD.$611.Metal2 65.5800612787
Rred_774 VDD.$285.Metal1 VDD.$612.Metal2 12.7565634338
Rred_775 VDD.$285.Metal1 VDD.$613.Metal2 21.4073809524
Rred_776 VDD.$285.Metal1 VDD.P7.pSD 11.415314082
Rred_777 VDD.$286.Metal1 VDD.$288.Metal1 0.378342725478
Rred_778 VDD.$286.Metal1 VDD.$613.Metal2 15.6639372822
Rred_779 VDD.$286.Metal1 VDD.$614.Metal2 14.3820275964
Rred_780 VDD.$286.Metal1 VDD.$615.Metal2 162.515397989
Rred_781 VDD.$286.Metal1 VDD.P7.pSD 11.3902299793
Rred_782 VDD.$288.Metal1 VDD.$291.Metal1 0.5836897818
Rred_783 VDD.$288.Metal1 VDD.$614.Metal2 25.0023689215
Rred_784 VDD.$288.Metal1 VDD.$615.Metal2 9.56445844156
Rred_785 VDD.$288.Metal1 VDD.$616.Metal2 14.1111214102
Rred_786 VDD.$288.Metal1 VDD.$617.Metal2 34.5822472602
Rred_787 VDD.$288.Metal1 VDD.P7.pSD 6.90933999562
Rred_788 VDD.$29.Metal1 VDD.$33.Metal1 0.034706964149
Rred_789 VDD.$29.Metal1 VDD.$382.Metal1 64.8393798854
Rred_790 VDD.$29.Metal1 VDD.$552.Metal2 9
Rred_791 VDD.$29.Metal1 VDD.$554.Metal2 9
Rred_792 VDD.$29.Metal1 VDD.P0.nSD 1.57040820833
Rred_793 VDD.$291.Metal1 VDD.$616.Metal2 27.0968810839
Rred_794 VDD.$291.Metal1 VDD.$617.Metal2 12.6157751291
Rred_795 VDD.$291.Metal1 VDD.$618.Metal2 9.18715616563
Rred_796 VDD.$291.Metal1 VDD.$619.Metal2 9.58934553755
Rred_797 VDD.$291.Metal1 VDD.P7.pSD 4.40269128628
Rred_798 VDD.$298.Metal1 VDD.$339.Metal1 0.0697627488099
Rred_799 VDD.$298.Metal1 VDD.$688.Metal2 4.5292211534
Rred_800 VDD.$298.Metal1 VDD.$696.Metal2 4.5292211534
Rred_801 VDD.$298.Metal1 VDD.$864.Metal3 1131.50554324
Rred_802 VDD.$298.Metal1 VDD.P0.nSD 10.9350967995
Rred_803 VDD.$320.Metal1 VDD.$322.Metal1 0.380587953605
Rred_804 VDD.$320.Metal1 VDD.$359.Metal1 882.444120539
Rred_805 VDD.$320.Metal1 VDD.$703.Metal2 3.63169046122
Rred_806 VDD.$320.Metal1 VDD.$704.Metal2 653.919302103
Rred_807 VDD.$320.Metal1 VDD.P10.pSD 5.02455192033
Rred_808 VDD.$320.Metal1 VDD.P11.pSD 46923.4766102
Rred_809 VDD.$322.Metal1 VDD.$324.Metal1 0.377723728059
Rred_810 VDD.$322.Metal1 VDD.$703.Metal2 22.1667560035
Rred_811 VDD.$322.Metal1 VDD.$704.Metal2 9.13449534951
Rred_812 VDD.$322.Metal1 VDD.$705.Metal2 20.9354207047
Rred_813 VDD.$322.Metal1 VDD.P10.pSD 8.57099587643
Rred_814 VDD.$324.Metal1 VDD.$326.Metal1 0.381682896331
Rred_815 VDD.$324.Metal1 VDD.$705.Metal2 16.2050096923
Rred_816 VDD.$324.Metal1 VDD.$706.Metal2 10.5309757306
Rred_817 VDD.$324.Metal1 VDD.$707.Metal2 31.9902737945
Rred_818 VDD.$324.Metal1 VDD.P10.pSD 8.54749027394
Rred_819 VDD.$326.Metal1 VDD.$327.Metal1 0.186889833711
Rred_820 VDD.$326.Metal1 VDD.$706.Metal2 65.5800612787
Rred_821 VDD.$326.Metal1 VDD.$707.Metal2 12.7565634338
Rred_822 VDD.$326.Metal1 VDD.$708.Metal2 21.4073809524
Rred_823 VDD.$326.Metal1 VDD.P10.pSD 11.415314082
Rred_824 VDD.$327.Metal1 VDD.$329.Metal1 0.378342725478
Rred_825 VDD.$327.Metal1 VDD.$708.Metal2 15.6639372822
Rred_826 VDD.$327.Metal1 VDD.$709.Metal2 14.3820275964
Rred_827 VDD.$327.Metal1 VDD.$710.Metal2 162.515397989
Rred_828 VDD.$327.Metal1 VDD.P10.pSD 11.3902299793
Rred_829 VDD.$329.Metal1 VDD.$332.Metal1 0.5836897818
Rred_830 VDD.$329.Metal1 VDD.$709.Metal2 25.0023689215
Rred_831 VDD.$329.Metal1 VDD.$710.Metal2 9.56445844156
Rred_832 VDD.$329.Metal1 VDD.$711.Metal2 14.1111214102
Rred_833 VDD.$329.Metal1 VDD.$712.Metal2 34.5822472602
Rred_834 VDD.$329.Metal1 VDD.P10.pSD 6.90933999562
Rred_835 VDD.$33.Metal1 VDD.$552.Metal2 5.75400863202
Rred_836 VDD.$33.Metal1 VDD.$554.Metal2 72.2712303767
Rred_837 VDD.$33.Metal1 VDD.$574.Metal2 6.90994880821
Rred_838 VDD.$33.Metal1 VDD.$840.Metal3 4700.1895632
Rred_839 VDD.$33.Metal1 VDD.P0.nSD 9.70138380743
Rred_840 VDD.$332.Metal1 VDD.$711.Metal2 27.0968810839
Rred_841 VDD.$332.Metal1 VDD.$712.Metal2 12.6157751291
Rred_842 VDD.$332.Metal1 VDD.$713.Metal2 9.18715616563
Rred_843 VDD.$332.Metal1 VDD.$714.Metal2 9.58934553755
Rred_844 VDD.$332.Metal1 VDD.P10.pSD 4.40269128628
Rred_845 VDD.$339.Metal1 VDD.$378.Metal1 0.0697675062039
Rred_846 VDD.$339.Metal1 VDD.$696.Metal2 4.52956794175
Rred_847 VDD.$339.Metal1 VDD.$734.Metal2 4.52949140451
Rred_848 VDD.$339.Metal1 VDD.$868.Metal3 1131.50554324
Rred_849 VDD.$339.Metal1 VDD.P0.nSD 7.28220306149
Rred_850 VDD.$359.Metal1 VDD.$361.Metal1 0.380587953605
Rred_851 VDD.$359.Metal1 VDD.$703.Metal2 3.63169046122
Rred_852 VDD.$359.Metal1 VDD.$704.Metal2 653.919302103
Rred_853 VDD.$359.Metal1 VDD.P10.pSD 46923.4766102
Rred_854 VDD.$359.Metal1 VDD.P11.pSD 5.02455192033
Rred_855 VDD.$361.Metal1 VDD.$363.Metal1 0.377723728059
Rred_856 VDD.$361.Metal1 VDD.$703.Metal2 22.1667560035
Rred_857 VDD.$361.Metal1 VDD.$704.Metal2 9.13449534951
Rred_858 VDD.$361.Metal1 VDD.$705.Metal2 20.9354207047
Rred_859 VDD.$361.Metal1 VDD.P11.pSD 8.57099587643
Rred_860 VDD.$363.Metal1 VDD.$365.Metal1 0.381682896331
Rred_861 VDD.$363.Metal1 VDD.$705.Metal2 16.2050096923
Rred_862 VDD.$363.Metal1 VDD.$706.Metal2 10.5309757306
Rred_863 VDD.$363.Metal1 VDD.$707.Metal2 31.9902737945
Rred_864 VDD.$363.Metal1 VDD.P11.pSD 8.54749027394
Rred_865 VDD.$365.Metal1 VDD.$366.Metal1 0.186889833711
Rred_866 VDD.$365.Metal1 VDD.$706.Metal2 65.5800612787
Rred_867 VDD.$365.Metal1 VDD.$707.Metal2 12.7565634338
Rred_868 VDD.$365.Metal1 VDD.$708.Metal2 21.4073809524
Rred_869 VDD.$365.Metal1 VDD.P11.pSD 11.415314082
Rred_870 VDD.$366.Metal1 VDD.$368.Metal1 0.378342725478
Rred_871 VDD.$366.Metal1 VDD.$708.Metal2 15.6639372822
Rred_872 VDD.$366.Metal1 VDD.$709.Metal2 14.3820275964
Rred_873 VDD.$366.Metal1 VDD.$710.Metal2 162.515397989
Rred_874 VDD.$366.Metal1 VDD.P11.pSD 11.3902299793
Rred_875 VDD.$368.Metal1 VDD.$371.Metal1 0.5836897818
Rred_876 VDD.$368.Metal1 VDD.$709.Metal2 25.0023689215
Rred_877 VDD.$368.Metal1 VDD.$710.Metal2 9.56445844156
Rred_878 VDD.$368.Metal1 VDD.$711.Metal2 14.1111214102
Rred_879 VDD.$368.Metal1 VDD.$712.Metal2 34.5822472602
Rred_880 VDD.$368.Metal1 VDD.P11.pSD 6.90933999562
Rred_881 VDD.$371.Metal1 VDD.$711.Metal2 27.0968810839
Rred_882 VDD.$371.Metal1 VDD.$712.Metal2 12.6157751291
Rred_883 VDD.$371.Metal1 VDD.$713.Metal2 9.18715616563
Rred_884 VDD.$371.Metal1 VDD.$714.Metal2 9.58934553755
Rred_885 VDD.$371.Metal1 VDD.P11.pSD 4.40269128628
Rred_886 VDD.$378.Metal1 VDD.$382.Metal1 10.7858347233
Rred_887 VDD.$378.Metal1 VDD.$405.Metal1 0.0577421073734
Rred_888 VDD.$378.Metal1 VDD.$734.Metal2 9.04507551974
Rred_889 VDD.$378.Metal1 VDD.$738.Metal2 4.5
Rred_890 VDD.$378.Metal1 VDD.P0.nSD 2.98429063435
Rred_891 VDD.$382.Metal1 VDD.$405.Metal1 7.88024642579
Rred_892 VDD.$382.Metal1 VDD.$477.Metal1 23.0948908894
Rred_893 VDD.$382.Metal1 VDD.$526.Metal1 92.724788113
Rred_894 VDD.$382.Metal1 VDD.P0.nSD 0.553857709529
Rred_895 VDD.$405.Metal1 VDD.$414.Metal1 0.062476708683
Rred_896 VDD.$405.Metal1 VDD.$738.Metal2 12.0273365854
Rred_897 VDD.$405.Metal1 VDD.$746.Metal2 4.26080335656
Rred_898 VDD.$405.Metal1 VDD.$874.Metal3 911.161862528
Rred_899 VDD.$405.Metal1 VDD.P0.nSD 2.50297487978
Rred_900 VDD.$414.Metal1 VDD.$418.Metal1 0.0288035798108
Rred_901 VDD.$414.Metal1 VDD.$746.Metal2 4.85421689444
Rred_902 VDD.$414.Metal1 VDD.$754.Metal2 12.110655615
Rred_903 VDD.$414.Metal1 VDD.$878.Metal3 1510.47534001
Rred_904 VDD.$414.Metal1 VDD.P0.nSD 10.561735539
Rred_905 VDD.$418.Metal1 VDD.$422.Metal1 0.0288148543721
Rred_906 VDD.$418.Metal1 VDD.$746.Metal2 36.3319668451
Rred_907 VDD.$418.Metal1 VDD.$754.Metal2 6.74547383614
Rred_908 VDD.$418.Metal1 VDD.$878.Metal3 4531.42602004
Rred_909 VDD.$418.Metal1 VDD.P0.nSD 17
Rred_910 VDD.$422.Metal1 VDD.$426.Metal1 0.0288102356806
Rred_911 VDD.$422.Metal1 VDD.$754.Metal2 7.22666075946
Rred_912 VDD.$422.Metal1 VDD.$762.Metal2 26.8602678301
Rred_913 VDD.$422.Metal1 VDD.$882.Metal3 3350.08883691
Rred_914 VDD.$422.Metal1 VDD.P0.nSD 17
Rred_915 VDD.$426.Metal1 VDD.$434.Metal1 0.0853731212574
Rred_916 VDD.$426.Metal1 VDD.$754.Metal2 13.7285813354
Rred_917 VDD.$426.Metal1 VDD.$762.Metal2 4.37150919135
Rred_918 VDD.$426.Metal1 VDD.$766.Metal2 15.3908400418
Rred_919 VDD.$426.Metal1 VDD.$882.Metal3 1712.26762775
Rred_920 VDD.$426.Metal1 VDD.P0.nSD 12.7128495574
Rred_921 VDD.$434.Metal1 VDD.$438.Metal1 0.0288102356806
Rred_922 VDD.$434.Metal1 VDD.$762.Metal2 15.3908400418
Rred_923 VDD.$434.Metal1 VDD.$766.Metal2 4.37348774292
Rred_924 VDD.$434.Metal1 VDD.$774.Metal2 13.7285813354
Rred_925 VDD.$434.Metal1 VDD.$888.Metal3 1712.26762775
Rred_926 VDD.$434.Metal1 VDD.P0.nSD 10.2647781402
Rred_927 VDD.$438.Metal1 VDD.$442.Metal1 0.0288148543721
Rred_928 VDD.$438.Metal1 VDD.$766.Metal2 26.8602678301
Rred_929 VDD.$438.Metal1 VDD.$774.Metal2 7.22666075946
Rred_930 VDD.$438.Metal1 VDD.$888.Metal3 3350.08883691
Rred_931 VDD.$438.Metal1 VDD.P0.nSD 17
Rred_932 VDD.$442.Metal1 VDD.$446.Metal1 0.0288035798108
Rred_933 VDD.$442.Metal1 VDD.$774.Metal2 6.74547383614
Rred_934 VDD.$442.Metal1 VDD.$782.Metal2 36.3319668451
Rred_935 VDD.$442.Metal1 VDD.$892.Metal3 4531.42602004
Rred_936 VDD.$442.Metal1 VDD.P0.nSD 17
Rred_937 VDD.$446.Metal1 VDD.$453.Metal1 0.062476708683
Rred_938 VDD.$446.Metal1 VDD.$774.Metal2 12.110655615
Rred_939 VDD.$446.Metal1 VDD.$782.Metal2 4.85421689444
Rred_940 VDD.$446.Metal1 VDD.$892.Metal3 1510.47534001
Rred_941 VDD.$446.Metal1 VDD.P0.nSD 10.561735539
Rred_942 VDD.$453.Metal1 VDD.$477.Metal1 0.0241153846154
Rred_943 VDD.$453.Metal1 VDD.$782.Metal2 4.42729478659
Rred_944 VDD.$453.Metal1 VDD.$790.Metal2 10.856417561
Rred_945 VDD.$453.Metal1 VDD.$896.Metal3 973.96090559
Rred_946 VDD.$453.Metal1 VDD.P0.nSD 12.27188988
Rred_947 VDD.$477.Metal1 VDD.$484.Metal1 0.0590487987513
Rred_948 VDD.$477.Metal1 VDD.$526.Metal1 177.268760844
Rred_949 VDD.$477.Metal1 VDD.$790.Metal2 7.65695728497
Rred_950 VDD.$477.Metal1 VDD.P0.nSD 1.36906495976
Rred_951 VDD.$484.Metal1 VDD.$495.Metal1 0.0858580741152
Rred_952 VDD.$484.Metal1 VDD.$790.Metal2 4.97542949709
Rred_953 VDD.$484.Metal1 VDD.$798.Metal2 4.15032001907
Rred_954 VDD.$484.Metal1 VDD.$802.Metal2 24.6815593895
Rred_955 VDD.$484.Metal1 VDD.$896.Metal3 3883.00395607
Rred_956 VDD.$484.Metal1 VDD.$902.Metal3 1616.98142986
Rred_957 VDD.$484.Metal1 VDD.P0.nSD 6.86899916909
Rred_958 VDD.$495.Metal1 VDD.$499.Metal1 0.0288102356806
Rred_959 VDD.$495.Metal1 VDD.$798.Metal2 11.1330675372
Rred_960 VDD.$495.Metal1 VDD.$802.Metal2 4.59147111355
Rred_961 VDD.$495.Metal1 VDD.$810.Metal2 26.8602678301
Rred_962 VDD.$495.Metal1 VDD.$906.Metal3 3350.08883691
Rred_963 VDD.$495.Metal1 VDD.P0.nSD 8.59388342247
Rred_964 VDD.$499.Metal1 VDD.$507.Metal1 0.0853731212574
Rred_965 VDD.$499.Metal1 VDD.$802.Metal2 13.7285813354
Rred_966 VDD.$499.Metal1 VDD.$810.Metal2 4.37150919135
Rred_967 VDD.$499.Metal1 VDD.$814.Metal2 15.3908400418
Rred_968 VDD.$499.Metal1 VDD.$906.Metal3 1712.26762775
Rred_969 VDD.$499.Metal1 VDD.P0.nSD 12.7128495574
Rred_970 VDD.$507.Metal1 VDD.$511.Metal1 0.0288102356806
Rred_971 VDD.$507.Metal1 VDD.$810.Metal2 15.3908400418
Rred_972 VDD.$507.Metal1 VDD.$814.Metal2 4.37348774292
Rred_973 VDD.$507.Metal1 VDD.$822.Metal2 13.7285813354
Rred_974 VDD.$507.Metal1 VDD.$912.Metal3 1712.26762775
Rred_975 VDD.$507.Metal1 VDD.P0.nSD 10.2647781402
Rred_976 VDD.$51.Metal1 VDD.$53.Metal1 0.380587953605
Rred_977 VDD.$51.Metal1 VDD.$562.Metal2 3.63169046122
Rred_978 VDD.$51.Metal1 VDD.$563.Metal2 653.919302103
Rred_979 VDD.$51.Metal1 VDD.$90.Metal1 882.444120539
Rred_980 VDD.$51.Metal1 VDD.P0.pSD 5.02455192033
Rred_981 VDD.$51.Metal1 VDD.P1.pSD 46923.4766102
Rred_982 VDD.$511.Metal1 VDD.$519.Metal1 0.0578136454443
Rred_983 VDD.$511.Metal1 VDD.$814.Metal2 26.8602678301
Rred_984 VDD.$511.Metal1 VDD.$822.Metal2 5.0372000165
Rred_985 VDD.$511.Metal1 VDD.$826.Metal2 36.1721738876
Rred_986 VDD.$511.Metal1 VDD.$912.Metal3 3350.08883691
Rred_987 VDD.$511.Metal1 VDD.P0.nSD 11.346824069
Rred_988 VDD.$519.Metal1 VDD.$526.Metal1 0.0624713757092
Rred_989 VDD.$519.Metal1 VDD.$822.Metal2 16.6196474619
Rred_990 VDD.$519.Metal1 VDD.$826.Metal2 3.18713018047
Rred_991 VDD.$519.Metal1 VDD.$918.Metal3 527.459391604
Rred_992 VDD.$519.Metal1 VDD.P0.nSD 8.06448071459
Rred_993 VDD.$526.Metal1 VDD.$826.Metal2 3.25936492671
Rred_994 VDD.$526.Metal1 VDD.$918.Metal3 151.476604805
Rred_995 VDD.$526.Metal1 VDD.P0.nSD 1.32351578217
Rred_996 VDD.$53.Metal1 VDD.$55.Metal1 0.377723728059
Rred_997 VDD.$53.Metal1 VDD.$562.Metal2 22.1667560035
Rred_998 VDD.$53.Metal1 VDD.$563.Metal2 9.13449534951
Rred_999 VDD.$53.Metal1 VDD.$564.Metal2 20.9354207047
Rred_1000 VDD.$53.Metal1 VDD.P0.pSD 8.57099587643
Rred_1001 VDD.$55.Metal1 VDD.$564.Metal2 16.2050096923
Rred_1002 VDD.$55.Metal1 VDD.$565.Metal2 10.5309757306
Rred_1003 VDD.$55.Metal1 VDD.$566.Metal2 31.9902737945
Rred_1004 VDD.$55.Metal1 VDD.$57.Metal1 0.381682896331
Rred_1005 VDD.$55.Metal1 VDD.P0.pSD 8.54749027394
Rred_1006 VDD.$552.Metal2 VDD.$554.Metal2 0.113987086184
Rred_1007 VDD.$552.Metal2 VDD.$573.Metal2 0.0840204833163
Rred_1008 VDD.$552.Metal2 VDD.$574.Metal2 0.0993413312346
Rred_1009 VDD.$552.Metal2 VDD.$840.Metal3 4.55225738248
Rred_1010 VDD.$552.Metal2 VDD.P0.GatPoly 497.539403119
Rred_1011 VDD.$554.Metal2 VDD.$574.Metal2 0.450017876452
Rred_1012 VDD.$554.Metal2 VDD.$840.Metal3 16.7458983719
Rred_1013 VDD.$562.Metal2 VDD.$563.Metal2 0.0203267388667
Rred_1014 VDD.$562.Metal2 VDD.$90.Metal1 3.63169046122
Rred_1015 VDD.$562.Metal2 VDD.$92.Metal1 22.1667560035
Rred_1016 VDD.$562.Metal2 VDD.P0.pSD 247.511739921
Rred_1017 VDD.$562.Metal2 VDD.P1.pSD 247.511739921
Rred_1018 VDD.$563.Metal2 VDD.$564.Metal2 0.0203267605634
Rred_1019 VDD.$563.Metal2 VDD.$90.Metal1 653.919302103
Rred_1020 VDD.$563.Metal2 VDD.$92.Metal1 9.13449534951
Rred_1021 VDD.$563.Metal2 VDD.P0.pSD 59609.1460043
Rred_1022 VDD.$563.Metal2 VDD.P1.pSD 59609.1460043
Rred_1023 VDD.$564.Metal2 VDD.$565.Metal2 0.0203267605634
Rred_1024 VDD.$564.Metal2 VDD.$92.Metal1 20.9354207047
Rred_1025 VDD.$564.Metal2 VDD.$94.Metal1 16.2050096923
Rred_1026 VDD.$564.Metal2 VDD.P0.pSD 1913.94243063
Rred_1027 VDD.$564.Metal2 VDD.P1.pSD 1913.94243063
Rred_1028 VDD.$565.Metal2 VDD.$566.Metal2 0.0203266102229
Rred_1029 VDD.$565.Metal2 VDD.$57.Metal1 65.5800612787
Rred_1030 VDD.$565.Metal2 VDD.$94.Metal1 10.5309757306
Rred_1031 VDD.$565.Metal2 VDD.$96.Metal1 65.5800612787
Rred_1032 VDD.$565.Metal2 VDD.P0.pSD 5881.92612918
Rred_1033 VDD.$565.Metal2 VDD.P1.pSD 5881.92612918
Rred_1034 VDD.$566.Metal2 VDD.$567.Metal2 0.0203267605634
Rred_1035 VDD.$566.Metal2 VDD.$57.Metal1 12.7565634338
Rred_1036 VDD.$566.Metal2 VDD.$94.Metal1 31.9902737945
Rred_1037 VDD.$566.Metal2 VDD.$96.Metal1 12.7565634338
Rred_1038 VDD.$566.Metal2 VDD.P0.pSD 2912.41521397
Rred_1039 VDD.$566.Metal2 VDD.P1.pSD 2912.41521397
Rred_1040 VDD.$567.Metal2 VDD.$568.Metal2 0.0203266886285
Rred_1041 VDD.$567.Metal2 VDD.$57.Metal1 21.4073809524
Rred_1042 VDD.$567.Metal2 VDD.$58.Metal1 15.6639372822
Rred_1043 VDD.$567.Metal2 VDD.$96.Metal1 12.7926067357
Rred_1044 VDD.$567.Metal2 VDD.$98.Metal1 31.757760527
Rred_1045 VDD.$567.Metal2 VDD.P1.pSD 2891.62473453
Rred_1046 VDD.$568.Metal2 VDD.$569.Metal2 0.0203267220914
Rred_1047 VDD.$568.Metal2 VDD.$58.Metal1 14.3820275964
Rred_1048 VDD.$568.Metal2 VDD.$60.Metal1 25.0023689215
Rred_1049 VDD.$568.Metal2 VDD.$96.Metal1 68.529904295
Rred_1050 VDD.$568.Metal2 VDD.$98.Metal1 10.4541785882
Rred_1051 VDD.$568.Metal2 VDD.P0.pSD 2281.03594069
Rred_1052 VDD.$568.Metal2 VDD.P1.pSD 6233.6637038
Rred_1053 VDD.$569.Metal2 VDD.$570.Metal2 0.0203267605634
Rred_1054 VDD.$569.Metal2 VDD.$58.Metal1 162.515397989
Rred_1055 VDD.$569.Metal2 VDD.$60.Metal1 9.56445844156
Rred_1056 VDD.$569.Metal2 VDD.$98.Metal1 16.3231774838
Rred_1057 VDD.$569.Metal2 VDD.P0.pSD 14797.4396422
Rred_1058 VDD.$569.Metal2 VDD.P1.pSD 1870.71936508
Rred_1059 VDD.$57.Metal1 VDD.$58.Metal1 0.186889833711
Rred_1060 VDD.$57.Metal1 VDD.P0.pSD 11.415314082
Rred_1061 VDD.$570.Metal2 VDD.$571.Metal2 0.020326492463
Rred_1062 VDD.$570.Metal2 VDD.$60.Metal1 14.1111214102
Rred_1063 VDD.$570.Metal2 VDD.$63.Metal1 27.0968810839
Rred_1064 VDD.$570.Metal2 VDD.P0.pSD 839.629362494
Rred_1065 VDD.$570.Metal2 VDD.P1.pSD 59173.1023761
Rred_1066 VDD.$571.Metal2 VDD.$572.Metal2 0.0203267605634
Rred_1067 VDD.$571.Metal2 VDD.$60.Metal1 34.5822472602
Rred_1068 VDD.$571.Metal2 VDD.$63.Metal1 12.6157751291
Rred_1069 VDD.$571.Metal2 VDD.P0.pSD 1033.12106166
Rred_1070 VDD.$571.Metal2 VDD.P1.pSD 2045.60058229
Rred_1071 VDD.$572.Metal2 VDD.$573.Metal2 0.0203261587295
Rred_1072 VDD.$572.Metal2 VDD.$63.Metal1 9.18715616563
Rred_1073 VDD.$572.Metal2 VDD.P0.pSD 1290.36739816
Rred_1074 VDD.$572.Metal2 VDD.P1.pSD 1290.36739816
Rred_1075 VDD.$573.Metal2 VDD.$63.Metal1 9.58934553755
Rred_1076 VDD.$573.Metal2 VDD.P0.GatPoly 321.364965756
Rred_1077 VDD.$573.Metal2 VDD.P0.pSD 350.314065943
Rred_1078 VDD.$573.Metal2 VDD.P1.pSD 350.314065943
Rred_1079 VDD.$574.Metal2 VDD.$597.Metal2 0.0778985170312
Rred_1080 VDD.$574.Metal2 VDD.$840.Metal3 6.90438383852
Rred_1081 VDD.$574.Metal2 VDD.$844.Metal3 4.68175392026
Rred_1082 VDD.$574.Metal2 VDD.P0.nSD 3786.06805636
Rred_1083 VDD.$58.Metal1 VDD.$60.Metal1 0.378342725478
Rred_1084 VDD.$58.Metal1 VDD.P0.pSD 11.3902299793
Rred_1085 VDD.$597.Metal2 VDD.$621.Metal2 0.0727293596086
Rred_1086 VDD.$597.Metal2 VDD.$844.Metal3 2.9692672555
Rred_1087 VDD.$597.Metal2 VDD.$852.Metal3 9.19927248124
Rred_1088 VDD.$597.Metal2 VDD.P0.nSD 11349.2128252
Rred_1089 VDD.$60.Metal1 VDD.$63.Metal1 0.5836897818
Rred_1090 VDD.$60.Metal1 VDD.P0.pSD 6.90933999562
Rred_1091 VDD.$606.Metal2 VDD.$607.Metal2 0.011101194144
Rred_1092 VDD.$606.Metal2 VDD.P3.pSD 352.120024064
Rred_1093 VDD.$606.Metal2 VDD.P5.pSD 352.120024064
Rred_1094 VDD.$606.Metal2 VDD.P6.pSD 352.120024064
Rred_1095 VDD.$606.Metal2 VDD.P7.pSD 352.120024064
Rred_1096 VDD.$607.Metal2 VDD.$608.Metal2 0.0111015384615
Rred_1097 VDD.$607.Metal2 VDD.P3.pSD 1345.81773311
Rred_1098 VDD.$607.Metal2 VDD.P5.pSD 1345.81773311
Rred_1099 VDD.$607.Metal2 VDD.P6.pSD 1345.81773311
Rred_1100 VDD.$607.Metal2 VDD.P7.pSD 1345.81773311
Rred_1101 VDD.$608.Metal2 VDD.$609.Metal2 0.0111015255179
Rred_1102 VDD.$608.Metal2 VDD.P3.pSD 1997.23651617
Rred_1103 VDD.$608.Metal2 VDD.P5.pSD 1997.23651617
Rred_1104 VDD.$608.Metal2 VDD.P6.pSD 1997.23651617
Rred_1105 VDD.$608.Metal2 VDD.P7.pSD 1997.23651617
Rred_1106 VDD.$609.Metal2 VDD.$610.Metal2 0.0111015384615
Rred_1107 VDD.$609.Metal2 VDD.P3.pSD 59609.1460043
Rred_1108 VDD.$609.Metal2 VDD.P5.pSD 59609.1460043
Rred_1109 VDD.$609.Metal2 VDD.P6.pSD 59609.1460043
Rred_1110 VDD.$609.Metal2 VDD.P7.pSD 59609.1460043
Rred_1111 VDD.$610.Metal2 VDD.$611.Metal2 0.0111015384615
Rred_1112 VDD.$610.Metal2 VDD.P3.pSD 1913.94243063
Rred_1113 VDD.$610.Metal2 VDD.P5.pSD 1913.94243063
Rred_1114 VDD.$610.Metal2 VDD.P6.pSD 1913.94243063
Rred_1115 VDD.$610.Metal2 VDD.P7.pSD 1913.94243063
Rred_1116 VDD.$611.Metal2 VDD.$612.Metal2 0.0111014487732
Rred_1117 VDD.$611.Metal2 VDD.P3.pSD 5881.92612918
Rred_1118 VDD.$611.Metal2 VDD.P5.pSD 5881.92612918
Rred_1119 VDD.$611.Metal2 VDD.P6.pSD 5881.92612918
Rred_1120 VDD.$611.Metal2 VDD.P7.pSD 5881.92612918
Rred_1121 VDD.$612.Metal2 VDD.$613.Metal2 0.0111015384615
Rred_1122 VDD.$612.Metal2 VDD.P3.pSD 2912.41521397
Rred_1123 VDD.$612.Metal2 VDD.P5.pSD 2912.41521397
Rred_1124 VDD.$612.Metal2 VDD.P6.pSD 2912.41521397
Rred_1125 VDD.$612.Metal2 VDD.P7.pSD 2912.41521397
Rred_1126 VDD.$613.Metal2 VDD.$614.Metal2 0.0111015170044
Rred_1127 VDD.$613.Metal2 VDD.P3.pSD 2891.62473453
Rred_1128 VDD.$614.Metal2 VDD.$615.Metal2 0.0111015040348
Rred_1129 VDD.$614.Metal2 VDD.P3.pSD 6233.6637038
Rred_1130 VDD.$614.Metal2 VDD.P5.pSD 2281.03594069
Rred_1131 VDD.$614.Metal2 VDD.P6.pSD 2281.03594069
Rred_1132 VDD.$614.Metal2 VDD.P7.pSD 2281.03594069
Rred_1133 VDD.$615.Metal2 VDD.$616.Metal2 0.0111015384615
Rred_1134 VDD.$615.Metal2 VDD.P3.pSD 1797.39860489
Rred_1135 VDD.$615.Metal2 VDD.P5.pSD 14797.4396422
Rred_1136 VDD.$615.Metal2 VDD.P6.pSD 14797.4396422
Rred_1137 VDD.$615.Metal2 VDD.P7.pSD 14797.4396422
Rred_1138 VDD.$616.Metal2 VDD.$617.Metal2 0.0111013081646
Rred_1139 VDD.$616.Metal2 VDD.P5.pSD 839.629362494
Rred_1140 VDD.$616.Metal2 VDD.P6.pSD 839.629362494
Rred_1141 VDD.$616.Metal2 VDD.P7.pSD 839.629362494
Rred_1142 VDD.$617.Metal2 VDD.$618.Metal2 0.0111012660574
Rred_1143 VDD.$617.Metal2 VDD.$619.Metal2 472.225957222
Rred_1144 VDD.$617.Metal2 VDD.P3.pSD 221.749330389
Rred_1145 VDD.$617.Metal2 VDD.P5.pSD 1033.12106166
Rred_1146 VDD.$617.Metal2 VDD.P6.pSD 1033.12106166
Rred_1147 VDD.$617.Metal2 VDD.P7.pSD 1033.12106166
Rred_1148 VDD.$618.Metal2 VDD.$619.Metal2 0.0111007370359
Rred_1149 VDD.$618.Metal2 VDD.P3.pSD 131.529428424
Rred_1150 VDD.$618.Metal2 VDD.P5.pSD 1290.36739816
Rred_1151 VDD.$618.Metal2 VDD.P6.pSD 1290.36739816
Rred_1152 VDD.$618.Metal2 VDD.P7.pSD 1290.36739816
Rred_1153 VDD.$619.Metal2 VDD.$620.Metal2 0.0180061538462
Rred_1154 VDD.$619.Metal2 VDD.P3.pSD 106.427143405
Rred_1155 VDD.$619.Metal2 VDD.P5.pSD 350.314065943
Rred_1156 VDD.$619.Metal2 VDD.P6.pSD 350.314065943
Rred_1157 VDD.$619.Metal2 VDD.P7.pSD 350.314065943
Rred_1158 VDD.$620.Metal2 VDD.$643.Metal2 0.0617815022686
Rred_1159 VDD.$620.Metal2 VDD.$651.Metal2 0.127721987417
Rred_1160 VDD.$620.Metal2 VDD.$856.Metal3 15.9298487632
Rred_1161 VDD.$620.Metal2 VDD.P1.GatPoly 195.230769231
Rred_1162 VDD.$620.Metal2 VDD.P2.GatPoly 195.230769231
Rred_1163 VDD.$621.Metal2 VDD.$643.Metal2 0.0727385628444
Rred_1164 VDD.$621.Metal2 VDD.$844.Metal3 9.19927248124
Rred_1165 VDD.$621.Metal2 VDD.$852.Metal3 3.03398943114
Rred_1166 VDD.$621.Metal2 VDD.P0.nSD 3786.06805636
Rred_1167 VDD.$63.Metal1 VDD.P0.pSD 4.40269128628
Rred_1168 VDD.$643.Metal2 VDD.$651.Metal2 0.238070028016
Rred_1169 VDD.$643.Metal2 VDD.$852.Metal3 3.91966086174
Rred_1170 VDD.$643.Metal2 VDD.$856.Metal3 9.10399197067
Rred_1171 VDD.$643.Metal2 VDD.P0.nSD 3903.30058275
Rred_1172 VDD.$651.Metal2 VDD.$688.Metal2 0.0727293596086
Rred_1173 VDD.$651.Metal2 VDD.$856.Metal3 2.91413061061
Rred_1174 VDD.$651.Metal2 VDD.$864.Metal3 9.19927248124
Rred_1175 VDD.$651.Metal2 VDD.P0.nSD 3786.03958067
Rred_1176 VDD.$688.Metal2 VDD.$696.Metal2 0.0727385628444
Rred_1177 VDD.$688.Metal2 VDD.$856.Metal3 9.19927248124
Rred_1178 VDD.$688.Metal2 VDD.$864.Metal3 3.03398943114
Rred_1179 VDD.$688.Metal2 VDD.P0.nSD 3785.96364057
Rred_1180 VDD.$696.Metal2 VDD.$734.Metal2 0.0727385628444
Rred_1181 VDD.$696.Metal2 VDD.$864.Metal3 4.52704202798
Rred_1182 VDD.$696.Metal2 VDD.$868.Metal3 4.52704202798
Rred_1183 VDD.$696.Metal2 VDD.P0.nSD 3785.96364057
Rred_1184 VDD.$703.Metal2 VDD.$704.Metal2 0.0203267388667
Rred_1185 VDD.$703.Metal2 VDD.P10.pSD 247.511739921
Rred_1186 VDD.$703.Metal2 VDD.P11.pSD 247.511739921
Rred_1187 VDD.$704.Metal2 VDD.$705.Metal2 0.0203267605634
Rred_1188 VDD.$704.Metal2 VDD.P10.pSD 59609.1460043
Rred_1189 VDD.$704.Metal2 VDD.P11.pSD 59609.1460043
Rred_1190 VDD.$705.Metal2 VDD.$706.Metal2 0.0203267605634
Rred_1191 VDD.$705.Metal2 VDD.P10.pSD 1913.94243063
Rred_1192 VDD.$705.Metal2 VDD.P11.pSD 1913.94243063
Rred_1193 VDD.$706.Metal2 VDD.$707.Metal2 0.0203266102229
Rred_1194 VDD.$706.Metal2 VDD.P10.pSD 5881.92612918
Rred_1195 VDD.$706.Metal2 VDD.P11.pSD 5881.92612918
Rred_1196 VDD.$707.Metal2 VDD.$708.Metal2 0.0203267605634
Rred_1197 VDD.$707.Metal2 VDD.P10.pSD 2912.41521397
Rred_1198 VDD.$707.Metal2 VDD.P11.pSD 2912.41521397
Rred_1199 VDD.$708.Metal2 VDD.$709.Metal2 0.0203267605634
Rred_1200 VDD.$709.Metal2 VDD.$710.Metal2 0.0203266836195
Rred_1201 VDD.$709.Metal2 VDD.P10.pSD 2281.03594069
Rred_1202 VDD.$709.Metal2 VDD.P11.pSD 2281.03594069
Rred_1203 VDD.$710.Metal2 VDD.$711.Metal2 0.0203267605634
Rred_1204 VDD.$710.Metal2 VDD.P10.pSD 14797.4396422
Rred_1205 VDD.$710.Metal2 VDD.P11.pSD 14797.4396422
Rred_1206 VDD.$711.Metal2 VDD.$712.Metal2 0.0203262458507
Rred_1207 VDD.$711.Metal2 VDD.P10.pSD 839.629362494
Rred_1208 VDD.$711.Metal2 VDD.P11.pSD 839.629362494
Rred_1209 VDD.$712.Metal2 VDD.$713.Metal2 0.0203267605634
Rred_1210 VDD.$712.Metal2 VDD.P10.pSD 1033.12106166
Rred_1211 VDD.$712.Metal2 VDD.P11.pSD 1033.12106166
Rred_1212 VDD.$713.Metal2 VDD.$714.Metal2 0.0203261587295
Rred_1213 VDD.$713.Metal2 VDD.P10.pSD 1290.36739816
Rred_1214 VDD.$713.Metal2 VDD.P11.pSD 1290.36739816
Rred_1215 VDD.$714.Metal2 VDD.$734.Metal2 0.0834003977587
Rred_1216 VDD.$714.Metal2 VDD.$738.Metal2 0.486502320259
Rred_1217 VDD.$714.Metal2 VDD.P10.pSD 350.314065943
Rred_1218 VDD.$714.Metal2 VDD.P11.pSD 350.314065943
Rred_1219 VDD.$714.Metal2 VDD.P3.GatPoly 363.67208826
Rred_1220 VDD.$734.Metal2 VDD.$738.Metal2 0.0385178358865
Rred_1221 VDD.$734.Metal2 VDD.$868.Metal3 3.70074063916
Rred_1222 VDD.$734.Metal2 VDD.$874.Metal3 16.6232928414
Rred_1223 VDD.$734.Metal2 VDD.P0.nSD 3786.03958067
Rred_1224 VDD.$734.Metal2 VDD.P3.GatPoly 493.867477107
Rred_1225 VDD.$738.Metal2 VDD.$746.Metal2 0.096432512
Rred_1226 VDD.$738.Metal2 VDD.$868.Metal3 10.0971112073
Rred_1227 VDD.$738.Metal2 VDD.$874.Metal3 4.90341845367
Rred_1228 VDD.$738.Metal2 VDD.P3.GatPoly 2880.89361646
Rred_1229 VDD.$746.Metal2 VDD.$754.Metal2 0.0727382164928
Rred_1230 VDD.$746.Metal2 VDD.$874.Metal3 4.03957567934
Rred_1231 VDD.$746.Metal2 VDD.$878.Metal3 4.52703127146
Rred_1232 VDD.$746.Metal2 VDD.P0.nSD 4563.47019166
Rred_1233 VDD.$754.Metal2 VDD.$762.Metal2 0.0727381494756
Rred_1234 VDD.$754.Metal2 VDD.$878.Metal3 4.52703127146
Rred_1235 VDD.$754.Metal2 VDD.$882.Metal3 4.52702919012
Rred_1236 VDD.$762.Metal2 VDD.$766.Metal2 0.0360787659354
Rred_1237 VDD.$762.Metal2 VDD.$882.Metal3 3.88510036215
Rred_1238 VDD.$762.Metal2 VDD.$888.Metal3 13.6446092814
Rred_1239 VDD.$762.Metal2 VDD.P0.nSD 9087.91528723
Rred_1240 VDD.$766.Metal2 VDD.$774.Metal2 0.0727381494756
Rred_1241 VDD.$766.Metal2 VDD.$882.Metal3 13.6446092814
Rred_1242 VDD.$766.Metal2 VDD.$888.Metal3 3.88510036215
Rred_1243 VDD.$766.Metal2 VDD.P0.nSD 4670.76209806
Rred_1244 VDD.$774.Metal2 VDD.$782.Metal2 0.0727382164928
Rred_1245 VDD.$774.Metal2 VDD.$888.Metal3 4.52702919012
Rred_1246 VDD.$774.Metal2 VDD.$892.Metal3 4.52703127146
Rred_1247 VDD.$782.Metal2 VDD.$790.Metal2 0.0870443434667
Rred_1248 VDD.$782.Metal2 VDD.$892.Metal3 4.52703127146
Rred_1249 VDD.$782.Metal2 VDD.$896.Metal3 4.18892394245
Rred_1250 VDD.$782.Metal2 VDD.P0.nSD 4563.47019166
Rred_1251 VDD.$790.Metal2 VDD.$798.Metal2 0.072735045669
Rred_1252 VDD.$790.Metal2 VDD.$896.Metal3 3.93298749474
Rred_1253 VDD.$790.Metal2 VDD.$902.Metal3 5.98232813615
Rred_1254 VDD.$790.Metal2 VDD.P0.nSD 5982.7031946
Rred_1255 VDD.$798.Metal2 VDD.$802.Metal2 0.0360795932553
Rred_1256 VDD.$798.Metal2 VDD.$896.Metal3 31.13306283
Rred_1257 VDD.$798.Metal2 VDD.$902.Metal3 3.3405115159
Rred_1258 VDD.$798.Metal2 VDD.P0.nSD 2749.51965841
Rred_1259 VDD.$802.Metal2 VDD.$810.Metal2 0.0727381494756
Rred_1260 VDD.$802.Metal2 VDD.$902.Metal3 9.03608
Rred_1261 VDD.$802.Metal2 VDD.$906.Metal3 4.52702919012
Rred_1262 VDD.$802.Metal2 VDD.P0.nSD 4996.13797425
Rred_1263 VDD.$810.Metal2 VDD.$814.Metal2 0.0360787659354
Rred_1264 VDD.$810.Metal2 VDD.$906.Metal3 3.88510036215
Rred_1265 VDD.$810.Metal2 VDD.$912.Metal3 13.6446092814
Rred_1266 VDD.$810.Metal2 VDD.P0.nSD 9087.91528723
Rred_1267 VDD.$814.Metal2 VDD.$822.Metal2 0.0727381494756
Rred_1268 VDD.$814.Metal2 VDD.$906.Metal3 13.6446092814
Rred_1269 VDD.$814.Metal2 VDD.$912.Metal3 3.88510036215
Rred_1270 VDD.$814.Metal2 VDD.P0.nSD 4670.76209806
Rred_1271 VDD.$822.Metal2 VDD.$826.Metal2 0.0360791098952
Rred_1272 VDD.$822.Metal2 VDD.$912.Metal3 3.88510036215
Rred_1273 VDD.$822.Metal2 VDD.$918.Metal3 13.6446092814
Rred_1274 VDD.$822.Metal2 VDD.P0.nSD 9808.94261738
Rred_1275 VDD.$826.Metal2 VDD.$912.Metal3 13.6446092814
Rred_1276 VDD.$826.Metal2 VDD.$918.Metal3 1.74559777083
Rred_1277 VDD.$826.Metal2 VDD.P0.nSD 3857.25883382
Rred_1278 VDD.$840.Metal3 VDD.$844.Metal3 0.0724492814222
Rred_1279 VDD.$844.Metal3 VDD.$852.Metal3 0.147222110321
Rred_1280 VDD.$852.Metal3 VDD.$856.Metal3 0.105270340267
Rred_1281 VDD.$856.Metal3 VDD.$864.Metal3 0.147222110321
Rred_1282 VDD.$864.Metal3 VDD.$868.Metal3 0.0724492814222
Rred_1283 VDD.$868.Metal3 VDD.$874.Metal3 0.133281867937
Rred_1284 VDD.$874.Metal3 VDD.$878.Metal3 0.0724492814222
Rred_1285 VDD.$878.Metal3 VDD.$882.Metal3 0.0724492814222
Rred_1286 VDD.$882.Metal3 VDD.$888.Metal3 0.109399445083
Rred_1287 VDD.$888.Metal3 VDD.$892.Metal3 0.0724492814222
Rred_1288 VDD.$892.Metal3 VDD.$896.Metal3 0.0724492814222
Rred_1289 VDD.$896.Metal3 VDD.$902.Metal3 0.123816258411
Rred_1290 VDD.$90.Metal1 VDD.$92.Metal1 0.380587953605
Rred_1291 VDD.$90.Metal1 VDD.P0.pSD 46923.4766102
Rred_1292 VDD.$90.Metal1 VDD.P1.pSD 5.02455192033
Rred_1293 VDD.$902.Metal3 VDD.$906.Metal3 0.0724492814222
Rred_1294 VDD.$906.Metal3 VDD.$912.Metal3 0.109399445083
Rred_1295 VDD.$912.Metal3 VDD.$918.Metal3 0.109399445083
Rred_1296 VDD.$918.Metal3 VDD.P0.nSD 297112.516488
Rred_1297 VDD.$92.Metal1 VDD.$94.Metal1 0.377723728059
Rred_1298 VDD.$92.Metal1 VDD.P1.pSD 8.57099587643
Rred_1299 VDD.$94.Metal1 VDD.$96.Metal1 0.381682896331
Rred_1300 VDD.$94.Metal1 VDD.P1.pSD 8.54749027394
Rred_1301 VDD.$96.Metal1 VDD.$98.Metal1 0.378908730097
Rred_1302 VDD.$96.Metal1 VDD.P1.pSD 8.57731352064
Rred_1303 VDD.$98.Metal1 VDD.P1.pSD 8.54740010041
Rred_1304 VDD.P0.pSD VDD.P1.pSD 2380255.02965
Rred_1305 VDD.P10.pSD VDD.P11.pSD 2380255.02965
Rred_1306 VSS VSS.$284.Metal2 11.1173283422
Rred_1307 VSS VSS.$286.Metal2 25.9080880799
Rred_1308 VSS VSS.$474.Metal3 0.0618036776159
Rred_1309 VSS VSS.$5.Metal1 1698.83430276
Rred_1310 VSS.$114.Metal1 VSS.$134.Metal1 0.105410323679
Rred_1311 VSS.$114.Metal1 VSS.$339.Metal2 4.52935675254
Rred_1312 VSS.$114.Metal1 VSS.$350.Metal2 3.8865344864
Rred_1313 VSS.$114.Metal1 VSS.$354.Metal2 13.6664872244
Rred_1314 VSS.$114.Metal1 VSS.$496.Metal3 1131.50554324
Rred_1315 VSS.$114.Metal1 VSS.$94.Metal1 0.0697692902273
Rred_1316 VSS.$114.Metal1 VSS.P0.pSD 7.09519826614
Rred_1317 VSS.$127.Metal1 VSS.$132.Metal1 0.0297583844475
Rred_1318 VSS.$127.Metal1 VSS.$155.Metal1 0.01053830501
Rred_1319 VSS.$127.Metal1 VSS.$359.Metal2 30.6089859155
Rred_1320 VSS.$127.Metal1 VSS.P0.pSD 26.3331158564
Rred_1321 VSS.$127.Metal1 VSS.P10.nSD 17
Rred_1322 VSS.$127.Metal1 VSS.P11.nSD 17
Rred_1323 VSS.$129.Metal1 VSS.$156.Metal1 0.0105382910983
Rred_1324 VSS.$129.Metal1 VSS.$220.Metal1 3.8610805109
Rred_1325 VSS.$129.Metal1 VSS.$359.Metal2 30.7472078873
Rred_1326 VSS.$129.Metal1 VSS.$87.Metal1 2.82886025119
Rred_1327 VSS.$129.Metal1 VSS.P0.pSD 1.81069439417
Rred_1328 VSS.$129.Metal1 VSS.P10.nSD 17
Rred_1329 VSS.$129.Metal1 VSS.P11.nSD 17
Rred_1330 VSS.$132.Metal1 VSS.$134.Metal1 0.121670250145
Rred_1331 VSS.$132.Metal1 VSS.$147.Metal1 0.090487843497
Rred_1332 VSS.$132.Metal1 VSS.$359.Metal2 14.9463434019
Rred_1333 VSS.$132.Metal1 VSS.$368.Metal2 9.90739884711
Rred_1334 VSS.$132.Metal1 VSS.$372.Metal2 155.392150235
Rred_1335 VSS.$132.Metal1 VSS.P0.pSD 7.46767834394
Rred_1336 VSS.$132.Metal1 VSS.P3.GatPoly 51.6153846154
Rred_1337 VSS.$134.Metal1 VSS.$147.Metal1 0.103796623668
Rred_1338 VSS.$134.Metal1 VSS.$350.Metal2 13.6685770249
Rred_1339 VSS.$134.Metal1 VSS.$354.Metal2 3.88846617232
Rred_1340 VSS.$134.Metal1 VSS.$368.Metal2 5.15945320707
Rred_1341 VSS.$134.Metal1 VSS.$502.Metal3 1131.50554324
Rred_1342 VSS.$134.Metal1 VSS.P0.pSD 6.32711804638
Rred_1343 VSS.$147.Metal1 VSS.$165.Metal1 0.0925006381148
Rred_1344 VSS.$147.Metal1 VSS.$368.Metal2 13.4568132194
Rred_1345 VSS.$147.Metal1 VSS.$372.Metal2 4.5
Rred_1346 VSS.$147.Metal1 VSS.$376.Metal2 11.994713692
Rred_1347 VSS.$147.Metal1 VSS.P0.pSD 5.96827393681
Rred_1348 VSS.$155.Metal1 VSS.$156.Metal1 0.0223244982672
Rred_1349 VSS.$155.Metal1 VSS.$359.Metal2 5.27741136474
Rred_1350 VSS.$155.Metal1 VSS.P0.pSD 17
Rred_1351 VSS.$155.Metal1 VSS.P10.nSD 34.0223098592
Rred_1352 VSS.$155.Metal1 VSS.P11.nSD 34.0223098592
Rred_1353 VSS.$156.Metal1 VSS.$359.Metal2 5.30124273919
Rred_1354 VSS.$156.Metal1 VSS.P0.pSD 17
Rred_1355 VSS.$156.Metal1 VSS.P10.nSD 34.0223098592
Rred_1356 VSS.$156.Metal1 VSS.P11.nSD 34.0223098592
Rred_1357 VSS.$165.Metal1 VSS.$175.Metal1 0.0697634921526
Rred_1358 VSS.$165.Metal1 VSS.$376.Metal2 4.03902298024
Rred_1359 VSS.$165.Metal1 VSS.$384.Metal2 4.52923087149
Rred_1360 VSS.$165.Metal1 VSS.$510.Metal3 1131.50554324
Rred_1361 VSS.$165.Metal1 VSS.P0.pSD 5.97081979029
Rred_1362 VSS.$175.Metal1 VSS.$181.Metal1 0.044524624365
Rred_1363 VSS.$175.Metal1 VSS.$384.Metal2 4.5294155924
Rred_1364 VSS.$175.Metal1 VSS.$392.Metal2 6.29720846297
Rred_1365 VSS.$175.Metal1 VSS.$510.Metal3 2299.30001576
Rred_1366 VSS.$175.Metal1 VSS.$518.Metal3 2299.30001576
Rred_1367 VSS.$175.Metal1 VSS.P0.pSD 9.18482397801
Rred_1368 VSS.$181.Metal1 VSS.$185.Metal1 0.0560167897426
Rred_1369 VSS.$181.Metal1 VSS.$392.Metal2 4.27332110327
Rred_1370 VSS.$181.Metal1 VSS.$400.Metal2 16.4545769116
Rred_1371 VSS.$181.Metal1 VSS.$518.Metal3 2052.26153277
Rred_1372 VSS.$181.Metal1 VSS.P0.pSD 12.5778971728
Rred_1373 VSS.$185.Metal1 VSS.$195.Metal1 0.0736766349237
Rred_1374 VSS.$185.Metal1 VSS.$392.Metal2 20.359052789
Rred_1375 VSS.$185.Metal1 VSS.$400.Metal2 3.85284553293
Rred_1376 VSS.$185.Metal1 VSS.$404.Metal2 9.55189855927
Rred_1377 VSS.$185.Metal1 VSS.$518.Metal3 2539.23884563
Rred_1378 VSS.$185.Metal1 VSS.P0.pSD 9.35715368916
Rred_1379 VSS.$195.Metal1 VSS.$199.Metal1 0.034708954142
Rred_1380 VSS.$195.Metal1 VSS.$400.Metal2 87.0723867281
Rred_1381 VSS.$195.Metal1 VSS.$404.Metal2 8.60131479348
Rred_1382 VSS.$195.Metal1 VSS.$408.Metal2 4.5
Rred_1383 VSS.$195.Metal1 VSS.P0.pSD 9.46089304491
Rred_1384 VSS.$199.Metal1 VSS.$209.Metal1 0.0697670271501
Rred_1385 VSS.$199.Metal1 VSS.$408.Metal2 9.07158718037
Rred_1386 VSS.$199.Metal1 VSS.$416.Metal2 4.5295903308
Rred_1387 VSS.$199.Metal1 VSS.$522.Metal3 2299.30001576
Rred_1388 VSS.$199.Metal1 VSS.$530.Metal3 2299.30001576
Rred_1389 VSS.$199.Metal1 VSS.P0.pSD 9.34447084101
Rred_1390 VSS.$209.Metal1 VSS.$211.Metal1 0.0241153846154
Rred_1391 VSS.$209.Metal1 VSS.$416.Metal2 4.19117675303
Rred_1392 VSS.$209.Metal1 VSS.$424.Metal2 10.856417561
Rred_1393 VSS.$209.Metal1 VSS.$530.Metal3 973.96090559
Rred_1394 VSS.$209.Metal1 VSS.P0.pSD 10.9591705311
Rred_1395 VSS.$211.Metal1 VSS.$220.Metal1 1.1043310741
Rred_1396 VSS.$211.Metal1 VSS.$231.Metal1 0.0945957896356
Rred_1397 VSS.$211.Metal1 VSS.$424.Metal2 6.10146469971
Rred_1398 VSS.$211.Metal1 VSS.$428.Metal2 12.2660719519
Rred_1399 VSS.$211.Metal1 VSS.P0.pSD 2.84107762125
Rred_1400 VSS.$220.Metal1 VSS.$255.Metal1 6.46062345193
Rred_1401 VSS.$220.Metal1 VSS.$452.Metal2 158.828895123
Rred_1402 VSS.$220.Metal1 VSS.$548.Metal3 2207.72496669
Rred_1403 VSS.$220.Metal1 VSS.$87.Metal1 18.3013850937
Rred_1404 VSS.$220.Metal1 VSS.P0.pSD 0.838146050081
Rred_1405 VSS.$231.Metal1 VSS.$241.Metal1 0.0797673901407
Rred_1406 VSS.$231.Metal1 VSS.$424.Metal2 17.6518459128
Rred_1407 VSS.$231.Metal1 VSS.$428.Metal2 4.01697746038
Rred_1408 VSS.$231.Metal1 VSS.$436.Metal2 4.26862441364
Rred_1409 VSS.$231.Metal1 VSS.$440.Metal2 36.8884768635
Rred_1410 VSS.$231.Metal1 VSS.$536.Metal3 1131.50554324
Rred_1411 VSS.$231.Metal1 VSS.P0.pSD 5.81617256077
Rred_1412 VSS.$241.Metal1 VSS.$245.Metal1 0.0560174710716
Rred_1413 VSS.$241.Metal1 VSS.$436.Metal2 10.3418055803
Rred_1414 VSS.$241.Metal1 VSS.$440.Metal2 5.144849397
Rred_1415 VSS.$241.Metal1 VSS.$444.Metal2 8.16194783983
Rred_1416 VSS.$241.Metal1 VSS.P0.pSD 8.93029950357
Rred_1417 VSS.$245.Metal1 VSS.$255.Metal1 0.0736766349237
Rred_1418 VSS.$245.Metal1 VSS.$444.Metal2 10.0986812256
Rred_1419 VSS.$245.Metal1 VSS.$448.Metal2 4.75216894929
Rred_1420 VSS.$245.Metal1 VSS.$452.Metal2 9.55189855927
Rred_1421 VSS.$245.Metal1 VSS.P0.pSD 9.35715368916
Rred_1422 VSS.$255.Metal1 VSS.$448.Metal2 87.0723867281
Rred_1423 VSS.$255.Metal1 VSS.$452.Metal2 1.15841926135
Rred_1424 VSS.$255.Metal1 VSS.$548.Metal3 23.6142916368
Rred_1425 VSS.$255.Metal1 VSS.P0.pSD 1.31505839116
Rred_1426 VSS.$284.Metal2 VSS.$286.Metal2 0.0281457925312
Rred_1427 VSS.$284.Metal2 VSS.$33.Metal1 1.88307315367
Rred_1428 VSS.$284.Metal2 VSS.$474.Metal3 5.72298309744
Rred_1429 VSS.$284.Metal2 VSS.$5.Metal1 4.02522480072
Rred_1430 VSS.$284.Metal2 VSS.$87.Metal1 15334.7514836
Rred_1431 VSS.$284.Metal2 VSS.P0.nSD 291.595673923
Rred_1432 VSS.$284.Metal2 VSS.P0.pSD 2770.16980491
Rred_1433 VSS.$284.Metal2 VSS.P1.nSD 291.595673923
Rred_1434 VSS.$286.Metal2 VSS.$292.Metal2 0.0560408109258
Rred_1435 VSS.$286.Metal2 VSS.$42.Metal1 88.5932638236
Rred_1436 VSS.$286.Metal2 VSS.$474.Metal3 7.22480057158
Rred_1437 VSS.$286.Metal2 VSS.$5.Metal1 6.05386408974
Rred_1438 VSS.$292.Metal2 VSS.$303.Metal2 0.0778985170312
Rred_1439 VSS.$292.Metal2 VSS.$42.Metal1 4.16811066173
Rred_1440 VSS.$292.Metal2 VSS.$474.Metal3 9.03608
Rred_1441 VSS.$292.Metal2 VSS.$478.Metal3 4.68175392026
Rred_1442 VSS.$292.Metal2 VSS.$5.Metal1 11.9148232701
Rred_1443 VSS.$303.Metal2 VSS.$307.Metal2 0.0360785005417
Rred_1444 VSS.$303.Metal2 VSS.$42.Metal1 3.78097338211
Rred_1445 VSS.$303.Metal2 VSS.$478.Metal3 3.7796127565
Rred_1446 VSS.$303.Metal2 VSS.$484.Metal3 13.6446092814
Rred_1447 VSS.$303.Metal2 VSS.$61.Metal1 13.6684214064
Rred_1448 VSS.$303.Metal2 VSS.P0.pSD 3425.34709313
Rred_1449 VSS.$307.Metal2 VSS.$321.Metal2 0.0727385628444
Rred_1450 VSS.$307.Metal2 VSS.$42.Metal1 13.6665671183
Rred_1451 VSS.$307.Metal2 VSS.$478.Metal3 13.6446092814
Rred_1452 VSS.$307.Metal2 VSS.$484.Metal3 3.88510981734
Rred_1453 VSS.$307.Metal2 VSS.$61.Metal1 3.88845990631
Rred_1454 VSS.$307.Metal2 VSS.P0.pSD 2442.70817626
Rred_1455 VSS.$311.Metal2 VSS.$321.Metal2 0.0709503402667
Rred_1456 VSS.$311.Metal2 VSS.$329.Metal2 0.03432
Rred_1457 VSS.$311.Metal2 VSS.$488.Metal3 8.84912780488
Rred_1458 VSS.$311.Metal2 VSS.$74.Metal1 8.84912780488
Rred_1459 VSS.$311.Metal2 VSS.$78.Metal1 0.97892003842
Rred_1460 VSS.$311.Metal2 VSS.P1.GatPoly 1493.73720349
Rred_1461 VSS.$311.Metal2 VSS.P2.GatPoly 1493.73720349
Rred_1462 VSS.$311.Metal2 VSS.P3.nSD 150.938831609
Rred_1463 VSS.$311.Metal2 VSS.P5.nSD 188.735078514
Rred_1464 VSS.$311.Metal2 VSS.P6.nSD 188.735078514
Rred_1465 VSS.$311.Metal2 VSS.P7.nSD 150.938831609
Rred_1466 VSS.$321.Metal2 VSS.$484.Metal3 4.52704202798
Rred_1467 VSS.$321.Metal2 VSS.$488.Metal3 4.58378158306
Rred_1468 VSS.$321.Metal2 VSS.$61.Metal1 4.52949140451
Rred_1469 VSS.$321.Metal2 VSS.$74.Metal1 4.58609525075
Rred_1470 VSS.$321.Metal2 VSS.P0.pSD 3786.03958067
Rred_1471 VSS.$329.Metal2 VSS.$339.Metal2 0.0727260257265
Rred_1472 VSS.$329.Metal2 VSS.$488.Metal3 5.61539484435
Rred_1473 VSS.$329.Metal2 VSS.$496.Metal3 6.75268382834
Rred_1474 VSS.$329.Metal2 VSS.$78.Metal1 8.82278719506
Rred_1475 VSS.$329.Metal2 VSS.$94.Metal1 4.58655392977
Rred_1476 VSS.$329.Metal2 VSS.P0.pSD 3903.30058275
Rred_1477 VSS.$33.Metal1 VSS.$5.Metal1 0.0997187514489
Rred_1478 VSS.$33.Metal1 VSS.$87.Metal1 5.38746412996
Rred_1479 VSS.$33.Metal1 VSS.P0.GatPoly 51.6153846154
Rred_1480 VSS.$33.Metal1 VSS.P0.nSD 5.87557265109
Rred_1481 VSS.$33.Metal1 VSS.P0.pSD 1.96251765316
Rred_1482 VSS.$33.Metal1 VSS.P1.nSD 5.87557265109
Rred_1483 VSS.$339.Metal2 VSS.$350.Metal2 0.0727385628444
Rred_1484 VSS.$339.Metal2 VSS.$488.Metal3 11.3322042642
Rred_1485 VSS.$339.Metal2 VSS.$496.Metal3 2.86438307423
Rred_1486 VSS.$339.Metal2 VSS.$94.Metal1 4.52926538438
Rred_1487 VSS.$339.Metal2 VSS.P0.pSD 3786.06805636
Rred_1488 VSS.$350.Metal2 VSS.$354.Metal2 0.03607850055
Rred_1489 VSS.$350.Metal2 VSS.$496.Metal3 3.88510981734
Rred_1490 VSS.$350.Metal2 VSS.$502.Metal3 13.6446092814
Rred_1491 VSS.$350.Metal2 VSS.P0.pSD 3425.43485177
Rred_1492 VSS.$354.Metal2 VSS.$368.Metal2 0.0727385628444
Rred_1493 VSS.$354.Metal2 VSS.$496.Metal3 13.6446092814
Rred_1494 VSS.$354.Metal2 VSS.$502.Metal3 3.88510981734
Rred_1495 VSS.$354.Metal2 VSS.P0.pSD 2442.73038029
Rred_1496 VSS.$359.Metal2 VSS.$368.Metal2 0.0917136768656
Rred_1497 VSS.$359.Metal2 VSS.$372.Metal2 0.534996448383
Rred_1498 VSS.$368.Metal2 VSS.$372.Metal2 0.0382906198712
Rred_1499 VSS.$368.Metal2 VSS.$376.Metal2 2664.71640683
Rred_1500 VSS.$368.Metal2 VSS.$502.Metal3 3.53498559815
Rred_1501 VSS.$368.Metal2 VSS.$510.Metal3 21.3651039907
Rred_1502 VSS.$368.Metal2 VSS.P0.pSD 3587.23396955
Rred_1503 VSS.$372.Metal2 VSS.$376.Metal2 0.0593973412959
Rred_1504 VSS.$372.Metal2 VSS.$502.Metal3 8.03337879278
Rred_1505 VSS.$372.Metal2 VSS.$510.Metal3 10.6398978272
Rred_1506 VSS.$376.Metal2 VSS.$384.Metal2 0.0727385628444
Rred_1507 VSS.$376.Metal2 VSS.$502.Metal3 21.3651039907
Rred_1508 VSS.$376.Metal2 VSS.$510.Metal3 3.53195719213
Rred_1509 VSS.$376.Metal2 VSS.P0.pSD 2295.69548367
Rred_1510 VSS.$384.Metal2 VSS.$392.Metal2 0.0727293596086
Rred_1511 VSS.$384.Metal2 VSS.$510.Metal3 3.03398943114
Rred_1512 VSS.$384.Metal2 VSS.$518.Metal3 9.19927248124
Rred_1513 VSS.$384.Metal2 VSS.P0.pSD 3785.97550669
Rred_1514 VSS.$392.Metal2 VSS.$400.Metal2 0.0727376781403
Rred_1515 VSS.$392.Metal2 VSS.$510.Metal3 9.19927248124
Rred_1516 VSS.$392.Metal2 VSS.$518.Metal3 3.03397709002
Rred_1517 VSS.$392.Metal2 VSS.P0.pSD 22361.1155026
Rred_1518 VSS.$400.Metal2 VSS.$404.Metal2 0.0360798846835
Rred_1519 VSS.$400.Metal2 VSS.$518.Metal3 4.52701455193
Rred_1520 VSS.$400.Metal2 VSS.$522.Metal3 9.03608
Rred_1521 VSS.$400.Metal2 VSS.P0.pSD 24597.3445589
Rred_1522 VSS.$404.Metal2 VSS.$408.Metal2 0.03608
Rred_1523 VSS.$404.Metal2 VSS.$522.Metal3 4.5
Rred_1524 VSS.$404.Metal2 VSS.P0.pSD 3516.73173813
Rred_1525 VSS.$408.Metal2 VSS.$416.Metal2 0.0727293596086
Rred_1526 VSS.$408.Metal2 VSS.$522.Metal3 4.55847300828
Rred_1527 VSS.$408.Metal2 VSS.$530.Metal3 9.19927248124
Rred_1528 VSS.$416.Metal2 VSS.$424.Metal2 0.0870443434667
Rred_1529 VSS.$416.Metal2 VSS.$522.Metal3 9.19927248124
Rred_1530 VSS.$416.Metal2 VSS.$530.Metal3 2.87828558308
Rred_1531 VSS.$416.Metal2 VSS.P0.pSD 3396.69064367
Rred_1532 VSS.$42.Metal1 VSS.$478.Metal3 1062.25078202
Rred_1533 VSS.$42.Metal1 VSS.$5.Metal1 0.104783984188
Rred_1534 VSS.$42.Metal1 VSS.$61.Metal1 0.105410939904
Rred_1535 VSS.$42.Metal1 VSS.P0.pSD 11.7391277666
Rred_1536 VSS.$424.Metal2 VSS.$428.Metal2 0.0360784917253
Rred_1537 VSS.$424.Metal2 VSS.$530.Metal3 4.50169370321
Rred_1538 VSS.$424.Metal2 VSS.$536.Metal3 11.1081657727
Rred_1539 VSS.$424.Metal2 VSS.P0.pSD 2772.79393216
Rred_1540 VSS.$428.Metal2 VSS.$436.Metal2 0.0727385628444
Rred_1541 VSS.$428.Metal2 VSS.$530.Metal3 15.4430597327
Rred_1542 VSS.$428.Metal2 VSS.$536.Metal3 3.76326086274
Rred_1543 VSS.$428.Metal2 VSS.P0.pSD 2110.59751567
Rred_1544 VSS.$436.Metal2 VSS.$440.Metal2 0.0360797278126
Rred_1545 VSS.$436.Metal2 VSS.$536.Metal3 4.52704202798
Rred_1546 VSS.$436.Metal2 VSS.$540.Metal3 9.03608
Rred_1547 VSS.$436.Metal2 VSS.P0.pSD 3112.28517808
Rred_1548 VSS.$440.Metal2 VSS.$444.Metal2 0.03608
Rred_1549 VSS.$440.Metal2 VSS.$540.Metal3 4.5
Rred_1550 VSS.$440.Metal2 VSS.P0.pSD 8700.07246641
Rred_1551 VSS.$444.Metal2 VSS.$448.Metal2 0.036078858678
Rred_1552 VSS.$444.Metal2 VSS.$452.Metal2 2290.22785576
Rred_1553 VSS.$444.Metal2 VSS.$540.Metal3 6.05597561142
Rred_1554 VSS.$444.Metal2 VSS.$548.Metal3 18.3625380079
Rred_1555 VSS.$448.Metal2 VSS.$452.Metal2 0.0360787433689
Rred_1556 VSS.$448.Metal2 VSS.$540.Metal3 9.14460928142
Rred_1557 VSS.$448.Metal2 VSS.$548.Metal3 9.14460928142
Rred_1558 VSS.$448.Metal2 VSS.P0.pSD 24597.3445589
Rred_1559 VSS.$452.Metal2 VSS.$540.Metal3 18.3625380079
Rred_1560 VSS.$452.Metal2 VSS.$548.Metal3 1.06265258244
Rred_1561 VSS.$452.Metal2 VSS.P0.pSD 39.9601702517
Rred_1562 VSS.$474.Metal3 VSS.$478.Metal3 0.0724492814222
Rred_1563 VSS.$474.Metal3 VSS.$5.Metal1 2401.80022114
Rred_1564 VSS.$478.Metal3 VSS.$484.Metal3 0.109399445083
Rred_1565 VSS.$484.Metal3 VSS.$488.Metal3 0.0724492814222
Rred_1566 VSS.$484.Metal3 VSS.$61.Metal1 1131.50554324
Rred_1567 VSS.$488.Metal3 VSS.$496.Metal3 0.181356844226
Rred_1568 VSS.$488.Metal3 VSS.$74.Metal1 1160.28773665
Rred_1569 VSS.$488.Metal3 VSS.$94.Metal1 2832.41283444
Rred_1570 VSS.$496.Metal3 VSS.$502.Metal3 0.109399445083
Rred_1571 VSS.$496.Metal3 VSS.$94.Metal1 1949.32660069
Rred_1572 VSS.$5.Metal1 VSS.$87.Metal1 23.9489802374
Rred_1573 VSS.$5.Metal1 VSS.P0.pSD 4.32630042833
Rred_1574 VSS.$502.Metal3 VSS.$510.Metal3 0.171300655997
Rred_1575 VSS.$510.Metal3 VSS.$518.Metal3 0.147222110321
Rred_1576 VSS.$518.Metal3 VSS.$522.Metal3 0.0724492814222
Rred_1577 VSS.$522.Metal3 VSS.$530.Metal3 0.147222110321
Rred_1578 VSS.$530.Metal3 VSS.$536.Metal3 0.123819021146
Rred_1579 VSS.$536.Metal3 VSS.$540.Metal3 0.0724492814222
Rred_1580 VSS.$540.Metal3 VSS.$548.Metal3 0.147226749184
Rred_1581 VSS.$548.Metal3 VSS.P0.pSD 564.923883816
Rred_1582 VSS.$61.Metal1 VSS.$74.Metal1 0.0697675062039
Rred_1583 VSS.$61.Metal1 VSS.P0.pSD 6.40399376665
Rred_1584 VSS.$74.Metal1 VSS.$78.Metal1 0.0330071597633
Rred_1585 VSS.$74.Metal1 VSS.P0.pSD 9.73459886964
Rred_1586 VSS.$78.Metal1 VSS.$87.Metal1 0.329036736458
Rred_1587 VSS.$78.Metal1 VSS.$94.Metal1 0.0680471464162
Rred_1588 VSS.$78.Metal1 VSS.P0.pSD 1.96965160797
Rred_1589 VSS.$78.Metal1 VSS.P1.GatPoly 54.7877805522
Rred_1590 VSS.$78.Metal1 VSS.P2.GatPoly 54.7877805522
Rred_1591 VSS.$78.Metal1 VSS.P3.nSD 6.04999466106
Rred_1592 VSS.$78.Metal1 VSS.P5.nSD 5.96906886407
Rred_1593 VSS.$78.Metal1 VSS.P6.nSD 5.96906886407
Rred_1594 VSS.$78.Metal1 VSS.P7.nSD 6.04999466106
Rred_1595 VSS.$87.Metal1 VSS.P0.pSD 1.06294970849
Rred_1596 VSS.$94.Metal1 VSS.P0.pSD 7.33700774319
Rred_1597 VSS.P0.nSD VSS.P1.nSD 702.986321288
Rred_1598 VSS.P1.GatPoly VSS.P3.nSD 4221.79686251
Rred_1599 VSS.P1.GatPoly VSS.P5.nSD 5281.52231965
Rred_1600 VSS.P10.nSD VSS.P11.nSD 51849.6565655
Rred_1601 VSS.P2.GatPoly VSS.P6.nSD 5281.52231965
Rred_1602 VSS.P2.GatPoly VSS.P7.nSD 4221.79686251
Rred_1603 VSS.P3.nSD VSS.P5.nSD 583.21730711
Rred_1604 VSS.P6.nSD VSS.P7.nSD 583.21730711
.ENDS iqmod_spdt_switch_pex
