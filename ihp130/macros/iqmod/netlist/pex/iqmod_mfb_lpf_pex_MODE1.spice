* PEX produced on Sat Mar 28 10:02:44 PM CET 2026 using /foss/tools/sak/sak-pex.sh with m=1 and s=1
* NGSPICE file created from iqmod_mfb_lpf_pex.ext - technology: ihp-sg13g2

.subckt iqmod_mfb_lpf_pex voutp vinp voutn vinn VDD VSS di_filter_en
X0 VSS iqmod_mfb_lpf_pex_half_0.iqmod_mfb_lpf_pex_ota_core_hybrid_bm_half_0.iqmod_mfb_lpf_pex_ota_core_inv_NF20$1_1.vin voutn VSS sg13_lv_nmos ad=0.19p pd=1.38u as=0.19p ps=1.38u w=1u l=1u
X1 VSS iqmod_mfb_lpf_pex_half_1.iqmod_mfb_lpf_pex_ota_core_hybrid_bm_half_0.iqmod_mfb_lpf_pex_ota_core_tg$1_0.v_b voutn VSS sg13_lv_nmos ad=0.19p pd=1.38u as=0.19p ps=1.38u w=1u l=1u
X2 iqmod_mfb_lpf_pex_half_1.iqmod_mfb_lpf_pex_ota_core_hybrid_bm_half_0.iqmod_mfb_lpf_pex_ota_core_tg$1_0.v_b iqmod_mfb_lpf_pex_half_1.iqmod_mfb_lpf_pex_ota_core_hybrid_bm_half_0.iqmod_mfb_lpf_pex_ota_core_tg$1_0.v_a VDD VDD sg13_lv_pmos ad=1.14p pd=6.38u as=1.14p ps=6.38u w=6u l=1u
X3 VSS VSS VSS VSS sg13_lv_nmos ad=0.34p pd=2.68u as=2.362n ps=3.33876m w=1u l=1u
X4 iqmod_mfb_lpf_pex_half_1.iqmod_mfb_lpf_pex_ota_core_hybrid_bm_half_0.iqmod_mfb_lpf_pex_ota_core_inv_NF20$1_0.vout voutp VSS VSS sg13_lv_nmos ad=0.19p pd=1.38u as=0.19p ps=1.38u w=1u l=1u
X5 VDD voutn iqmod_mfb_lpf_pex_half_1.iqmod_mfb_lpf_pex_ota_core_hybrid_bm_half_0.iqmod_mfb_lpf_pex_ota_core_inv_NF20$1_0.vout VDD sg13_lv_pmos ad=1.14p pd=6.38u as=1.14p ps=6.38u w=6u l=1u
X6 voutn iqmod_mfb_lpf_pex_half_0.iqmod_mfb_lpf_pex_ota_core_hybrid_bm_half_0.iqmod_mfb_lpf_pex_ota_core_inv_NF20$1_1.vin VDD VDD sg13_lv_pmos ad=1.14p pd=6.38u as=1.14p ps=6.38u w=6u l=1u
X7 iqmod_mfb_lpf_pex_half_1.iqmod_mfb_lpf_pex_ota_core_hybrid_bm_half_0.iqmod_mfb_lpf_pex_ota_core_tg$1_0.v_b iqmod_mfb_lpf_pex_half_1.iqmod_mfb_lpf_pex_ota_core_hybrid_bm_half_0.iqmod_mfb_lpf_pex_ota_core_tg$1_0.di_tg_ctrl_n iqmod_mfb_lpf_pex_half_1.iqmod_mfb_lpf_pex_ota_core_hybrid_bm_half_0.iqmod_mfb_lpf_pex_ota_core_tg$1_0.v_a VDD sg13_lv_pmos ad=1.14p pd=6.38u as=1.14p ps=6.38u w=6u l=0.13u
X8 VSS VSS VSS rhigh l=27u w=0.5u
X9 iqmod_mfb_lpf_pex_half_1.iqmod_mfb_lpf_pex_ota_core_hybrid_bm_half_0.iqmod_mfb_lpf_pex_ota_core_tg$1_0.v_a iqmod_mfb_lpf_pex_half_0.iqmod_mfb_lpf_pex_ota_core_hybrid_bm_half_0.iqmod_mfb_lpf_pex_ota_core_inv_NF20$1_1.vin VDD VDD sg13_lv_pmos ad=1.14p pd=6.38u as=1.14p ps=6.38u w=6u l=1u
X10 VSS iqmod_mfb_lpf_pex_half_1.iqmod_mfb_lpf_pex_ota_core_hybrid_bm_half_0.iqmod_mfb_lpf_pex_ota_core_tg$1_0.v_b voutp VSS sg13_lv_nmos ad=0.19p pd=1.38u as=0.19p ps=1.38u w=1u l=1u
X11 iqmod_mfb_lpf_pex_half_1.iqmod_mfb_lpf_pex_ota_core_hybrid_bm_half_0.iqmod_mfb_lpf_pex_ota_core_inv_NF6$1_1.vout iqmod_mfb_lpf_pex_half_1.iqmod_mfb_lpf_pex_ota_core_hybrid_bm_half_0.iqmod_mfb_lpf_pex_ota_core_inv_NF20$1_0.vout VSS VSS sg13_lv_nmos ad=0.19p pd=1.38u as=0.19p ps=1.38u w=1u l=1u
X12 VSS VSS VSS rhigh l=31u w=0.5u
X13 vinn iqmod_mfb_lpf_pex_half_1.iqmod_mfb_lpf_pex_ota_core_hybrid_bm_half_0.iqmod_mfb_lpf_pex_ota_core_tg$1_0.di_tg_ctrl_n iqmod_mfb_lpf_pex_half_1.iqmod_mfb_lpf_pex_ota_core_hybrid_bm_half_0.iqmod_mfb_lpf_pex_ota_core_inv_NF20$1_1.vin VDD sg13_lv_pmos ad=1.14p pd=6.38u as=1.14p ps=6.38u w=6u l=0.13u
X14 VSS VSS VSS rhigh l=60u w=0.5u
X15 voutp iqmod_mfb_lpf_pex_half_1.iqmod_mfb_lpf_pex_ota_core_hybrid_bm_half_0.iqmod_mfb_lpf_pex_ota_core_tg$1_0.v_b VSS VSS sg13_lv_nmos ad=0.19p pd=1.38u as=0.19p ps=1.38u w=1u l=1u
X16 VDD iqmod_mfb_lpf_pex_half_1.iqmod_mfb_lpf_pex_ota_core_hybrid_bm_half_0.iqmod_mfb_lpf_pex_ota_core_tg$1_0.v_b voutp VDD sg13_lv_pmos ad=1.14p pd=6.38u as=1.14p ps=6.38u w=6u l=1u
X17 iqmod_mfb_lpf_pex_half_1.C2_half iqmod_mfb_lpf_pex_half_1.iqmod_mfb_lpf_pex_R2_0.v_a cap_cmim l=8u w=8u
X18 iqmod_mfb_lpf_pex_half_1.iqmod_mfb_lpf_pex_ota_core_hybrid_bm_half_0.iqmod_mfb_lpf_pex_ota_core_inv_NF20$1_0.vout voutp VDD VDD sg13_lv_pmos ad=1.14p pd=6.38u as=1.14p ps=6.38u w=6u l=1u
X19 VDD VDD VDD VDD sg13_lv_pmos ad=2.04p pd=12.68u as=1.62466n ps=3.23532m w=6u l=1u
X20 VSS iqmod_mfb_lpf_pex_half_0.iqmod_mfb_lpf_pex_ota_core_hybrid_bm_half_0.iqmod_mfb_lpf_pex_ota_core_tg$1_0.di_tg_ctrl_n iqmod_mfb_lpf_pex_half_0.iqmod_mfb_lpf_pex_ota_core_hybrid_bm_half_0.iqmod_mfb_lpf_pex_ota_core_spdt_switch$1_0.iqmod_mfb_lpf_pex_ota_core_spdt_switch_inv$2_0.vout VSS sg13_lv_nmos ad=0.19p pd=1.38u as=0.19p ps=1.38u w=1u l=0.13u
X21 VSS VSS VSS VSS sg13_lv_nmos ad=0.34p pd=2.68u as=0 ps=0 w=1u l=1u
X22 voutn iqmod_mfb_lpf_pex_half_1.iqmod_mfb_lpf_pex_ota_core_hybrid_bm_half_0.iqmod_mfb_lpf_pex_ota_core_tg$1_0.v_b VSS VSS sg13_lv_nmos ad=0.19p pd=1.38u as=0.19p ps=1.38u w=1u l=1u
X23 iqmod_mfb_lpf_pex_half_1.iqmod_mfb_lpf_pex_ota_core_hybrid_bm_half_0.iqmod_mfb_lpf_pex_ota_core_inv_NF6$1_1.vout iqmod_mfb_lpf_pex_half_1.iqmod_mfb_lpf_pex_ota_core_hybrid_bm_half_0.iqmod_mfb_lpf_pex_ota_core_tg$1_0.di_tg_ctrl_n iqmod_mfb_lpf_pex_half_1.iqmod_mfb_lpf_pex_ota_core_hybrid_bm_half_0.iqmod_mfb_lpf_pex_ota_core_inv_NF20$1_0.vout VDD sg13_lv_pmos ad=1.14p pd=6.38u as=1.14p ps=6.38u w=6u l=0.13u
X24 iqmod_mfb_lpf_pex_half_1.iqmod_mfb_lpf_pex_ota_core_hybrid_bm_half_0.iqmod_mfb_lpf_pex_ota_core_inv_NF6$1_1.vout iqmod_mfb_lpf_pex_half_1.iqmod_mfb_lpf_pex_ota_core_hybrid_bm_half_0.iqmod_mfb_lpf_pex_ota_core_inv_NF20$1_0.vout VDD VDD sg13_lv_pmos ad=1.14p pd=6.38u as=1.14p ps=6.38u w=6u l=1u
X25 iqmod_mfb_lpf_pex_half_1.iqmod_mfb_lpf_pex_ota_core_hybrid_bm_half_0.iqmod_mfb_lpf_pex_ota_core_inv_NF6$1_1.vout di_filter_en iqmod_mfb_lpf_pex_half_1.iqmod_mfb_lpf_pex_ota_core_hybrid_bm_half_0.iqmod_mfb_lpf_pex_ota_core_inv_NF20$1_0.vout VSS sg13_lv_nmos ad=0.19p pd=1.38u as=0.19p ps=1.38u w=1u l=0.13u
X26 iqmod_mfb_lpf_pex_half_1.iqmod_mfb_lpf_pex_ota_core_hybrid_bm_half_0.iqmod_mfb_lpf_pex_ota_core_tg$1_0.v_b iqmod_mfb_lpf_pex_half_1.iqmod_mfb_lpf_pex_ota_core_hybrid_bm_half_0.iqmod_mfb_lpf_pex_ota_core_inv_NF6$1_1.vout VSS VSS sg13_lv_nmos ad=0.19p pd=1.38u as=0.19p ps=1.38u w=1u l=1u
X27 VDD iqmod_mfb_lpf_pex_half_0.iqmod_mfb_lpf_pex_ota_core_hybrid_bm_half_0.iqmod_mfb_lpf_pex_ota_core_tg$1_0.di_tg_ctrl_n iqmod_mfb_lpf_pex_half_0.iqmod_mfb_lpf_pex_ota_core_hybrid_bm_half_0.iqmod_mfb_lpf_pex_ota_core_spdt_switch$1_0.iqmod_mfb_lpf_pex_ota_core_spdt_switch_inv$2_0.vout VDD sg13_lv_pmos ad=1.14p pd=6.38u as=1.14p ps=6.38u w=6u l=0.13u
X28 vinp iqmod_mfb_lpf_pex_half_0.iqmod_mfb_lpf_pex_ota_core_hybrid_bm_half_0.iqmod_mfb_lpf_pex_ota_core_tg$1_0.di_tg_ctrl_n iqmod_mfb_lpf_pex_half_0.iqmod_mfb_lpf_pex_ota_core_hybrid_bm_half_0.iqmod_mfb_lpf_pex_ota_core_inv_NF20$1_1.vin VDD sg13_lv_pmos ad=1.14p pd=6.38u as=1.14p ps=6.38u w=6u l=0.13u
X29 VDD voutn iqmod_mfb_lpf_pex_half_1.iqmod_mfb_lpf_pex_ota_core_hybrid_bm_half_0.iqmod_mfb_lpf_pex_ota_core_inv_NF20$1_0.vout VDD sg13_lv_pmos ad=1.14p pd=6.38u as=1.14p ps=6.38u w=6u l=1u
X30 voutn iqmod_mfb_lpf_pex_half_0.iqmod_mfb_lpf_pex_ota_core_hybrid_bm_half_0.iqmod_mfb_lpf_pex_ota_core_inv_NF20$1_1.vin VSS VSS sg13_lv_nmos ad=0.19p pd=1.38u as=0.19p ps=1.38u w=1u l=1u
X31 iqmod_mfb_lpf_pex_half_1.iqmod_mfb_lpf_pex_R1_0.v_b iqmod_mfb_lpf_pex_half_1.C1_half cap_cmim l=8u w=8u
X32 iqmod_mfb_lpf_pex_half_1.iqmod_mfb_lpf_pex_ota_core_hybrid_bm_half_0.iqmod_mfb_lpf_pex_ota_core_inv_NF20$1_0.vout voutn VDD VDD sg13_lv_pmos ad=1.14p pd=6.38u as=1.14p ps=6.38u w=6u l=1u
X33 voutp vinn cap_cmim l=8u w=8u
X34 iqmod_mfb_lpf_pex_half_1.iqmod_mfb_lpf_pex_ota_core_hybrid_bm_half_0.iqmod_mfb_lpf_pex_ota_core_tg$1_0.v_b iqmod_mfb_lpf_pex_half_1.iqmod_mfb_lpf_pex_ota_core_hybrid_bm_half_0.iqmod_mfb_lpf_pex_ota_core_inv_NF6$1_1.vout VDD VDD sg13_lv_pmos ad=1.14p pd=6.38u as=1.14p ps=6.38u w=6u l=1u
X35 a_13404_n4303# iqmod_mfb_lpf_pex_half_1.iqmod_mfb_lpf_pex_R2_0.v_a VSS rhigh l=59u w=0.5u
X36 vinn a_6122_n4303# VSS rhigh l=27u w=0.5u
X37 VSS voutn iqmod_mfb_lpf_pex_half_1.iqmod_mfb_lpf_pex_ota_core_hybrid_bm_half_0.iqmod_mfb_lpf_pex_ota_core_inv_NF20$1_0.vout VSS sg13_lv_nmos ad=0.19p pd=1.38u as=0.19p ps=1.38u w=1u l=1u
X38 iqmod_mfb_lpf_pex_half_1.iqmod_mfb_lpf_pex_R1_0.v_b iqmod_mfb_lpf_pex_half_1.C1_half cap_cmim l=8u w=8u
X39 VDD VDD VDD VDD sg13_lv_pmos ad=1.14p pd=6.38u as=0 ps=0 w=6u l=1u
X40 VSS VSS VSS VSS sg13_lv_nmos ad=0.34p pd=2.68u as=0 ps=0 w=1u l=0.13u
X41 VSS VSS VSS rhigh l=59u w=0.5u
X42 iqmod_mfb_lpf_pex_half_1.C2_half iqmod_mfb_lpf_pex_half_1.iqmod_mfb_lpf_pex_R2_0.v_a cap_cmim l=8u w=8u
X43 VSS iqmod_mfb_lpf_pex_half_1.iqmod_mfb_lpf_pex_ota_core_hybrid_bm_half_0.iqmod_mfb_lpf_pex_ota_core_tg$1_0.v_b voutp VSS sg13_lv_nmos ad=0.19p pd=1.38u as=0.19p ps=1.38u w=1u l=1u
X44 VSS iqmod_mfb_lpf_pex_half_1.iqmod_mfb_lpf_pex_ota_core_hybrid_bm_half_0.iqmod_mfb_lpf_pex_ota_core_inv_NF20$1_0.vout iqmod_mfb_lpf_pex_half_1.iqmod_mfb_lpf_pex_ota_core_hybrid_bm_half_0.iqmod_mfb_lpf_pex_ota_core_inv_NF6$1_1.vout VSS sg13_lv_nmos ad=0.19p pd=1.38u as=0.19p ps=1.38u w=1u l=1u
X45 VSS iqmod_mfb_lpf_pex_half_1.iqmod_mfb_lpf_pex_ota_core_hybrid_bm_half_0.iqmod_mfb_lpf_pex_ota_core_tg$1_0.v_b voutp VSS sg13_lv_nmos ad=0.19p pd=1.38u as=0.19p ps=1.38u w=1u l=1u
X46 iqmod_mfb_lpf_pex_half_1.iqmod_mfb_lpf_pex_ota_core_hybrid_bm_half_0.iqmod_mfb_lpf_pex_ota_core_inv_NF6$1_1.vout iqmod_mfb_lpf_pex_half_1.iqmod_mfb_lpf_pex_ota_core_hybrid_bm_half_0.iqmod_mfb_lpf_pex_ota_core_inv_NF20$1_0.vout VDD VDD sg13_lv_pmos ad=1.14p pd=6.38u as=1.14p ps=6.38u w=6u l=1u
X47 VSS voutp iqmod_mfb_lpf_pex_half_1.iqmod_mfb_lpf_pex_ota_core_hybrid_bm_half_0.iqmod_mfb_lpf_pex_ota_core_inv_NF20$1_0.vout VSS sg13_lv_nmos ad=0.19p pd=1.38u as=0.19p ps=1.38u w=1u l=1u
X48 VDD iqmod_mfb_lpf_pex_half_1.iqmod_mfb_lpf_pex_ota_core_hybrid_bm_half_0.iqmod_mfb_lpf_pex_ota_core_tg$1_0.v_b voutn VDD sg13_lv_pmos ad=1.14p pd=6.38u as=1.14p ps=6.38u w=6u l=1u
X49 voutn iqmod_mfb_lpf_pex_half_1.iqmod_mfb_lpf_pex_ota_core_hybrid_bm_half_0.iqmod_mfb_lpf_pex_ota_core_tg$1_0.v_b VSS VSS sg13_lv_nmos ad=0.19p pd=1.38u as=0.19p ps=1.38u w=1u l=1u
X50 VSS VSS VSS VSS sg13_lv_nmos ad=0.19p pd=1.38u as=0 ps=0 w=1u l=0.13u
X51 iqmod_mfb_lpf_pex_half_1.iqmod_mfb_lpf_pex_ota_core_hybrid_bm_half_0.iqmod_mfb_lpf_pex_ota_core_inv_NF20$1_0.vout voutp VSS VSS sg13_lv_nmos ad=0.19p pd=1.38u as=0.19p ps=1.38u w=1u l=1u
X52 VSS iqmod_mfb_lpf_pex_half_1.iqmod_mfb_lpf_pex_ota_core_hybrid_bm_half_0.iqmod_mfb_lpf_pex_ota_core_inv_NF6$1_1.vout iqmod_mfb_lpf_pex_half_1.iqmod_mfb_lpf_pex_ota_core_hybrid_bm_half_0.iqmod_mfb_lpf_pex_ota_core_tg$1_0.v_b VSS sg13_lv_nmos ad=0.19p pd=1.38u as=0.19p ps=1.38u w=1u l=1u
X53 VSS VSS VSS VSS sg13_lv_nmos ad=0.34p pd=2.68u as=0 ps=0 w=1u l=1u
X54 iqmod_mfb_lpf_pex_half_1.iqmod_mfb_lpf_pex_ota_core_hybrid_bm_half_0.iqmod_mfb_lpf_pex_ota_core_inv_NF20$1_0.vout di_filter_en iqmod_mfb_lpf_pex_half_1.iqmod_mfb_lpf_pex_ota_core_hybrid_bm_half_0.iqmod_mfb_lpf_pex_ota_core_inv_NF6$1_1.vout VSS sg13_lv_nmos ad=0.34p pd=2.68u as=0.19p ps=1.38u w=1u l=0.13u
X55 voutn iqmod_mfb_lpf_pex_half_1.iqmod_mfb_lpf_pex_ota_core_hybrid_bm_half_0.iqmod_mfb_lpf_pex_ota_core_tg$1_0.v_b VDD VDD sg13_lv_pmos ad=1.14p pd=6.38u as=1.14p ps=6.38u w=6u l=1u
X56 iqmod_mfb_lpf_pex_half_1.C2_half iqmod_mfb_lpf_pex_half_1.iqmod_mfb_lpf_pex_R2_0.v_a cap_cmim l=8u w=8u
X57 iqmod_mfb_lpf_pex_half_1.iqmod_mfb_lpf_pex_ota_core_hybrid_bm_half_0.iqmod_mfb_lpf_pex_ota_core_inv_NF6$1_1.vout di_filter_en iqmod_mfb_lpf_pex_half_1.iqmod_mfb_lpf_pex_ota_core_hybrid_bm_half_0.iqmod_mfb_lpf_pex_ota_core_inv_NF20$1_0.vout VSS sg13_lv_nmos ad=0.19p pd=1.38u as=0.34p ps=2.68u w=1u l=0.13u
X58 VSS voutp iqmod_mfb_lpf_pex_half_1.iqmod_mfb_lpf_pex_ota_core_hybrid_bm_half_0.iqmod_mfb_lpf_pex_ota_core_inv_NF20$1_0.vout VSS sg13_lv_nmos ad=0.19p pd=1.38u as=0.19p ps=1.38u w=1u l=1u
X59 voutp iqmod_mfb_lpf_pex_half_1.iqmod_mfb_lpf_pex_ota_core_hybrid_bm_half_0.iqmod_mfb_lpf_pex_ota_core_inv_NF20$1_1.vin VSS VSS sg13_lv_nmos ad=0.19p pd=1.38u as=0.19p ps=1.38u w=1u l=1u
X60 voutp iqmod_mfb_lpf_pex_half_1.iqmod_mfb_lpf_pex_ota_core_hybrid_bm_half_0.iqmod_mfb_lpf_pex_ota_core_tg$1_0.v_b VDD VDD sg13_lv_pmos ad=1.14p pd=6.38u as=1.14p ps=6.38u w=6u l=1u
X61 iqmod_mfb_lpf_pex_half_1.iqmod_mfb_lpf_pex_ota_core_hybrid_bm_half_0.iqmod_mfb_lpf_pex_ota_core_inv_NF20$1_0.vout voutn VDD VDD sg13_lv_pmos ad=1.14p pd=6.38u as=1.14p ps=6.38u w=6u l=1u
X62 VDD iqmod_mfb_lpf_pex_half_1.iqmod_mfb_lpf_pex_ota_core_hybrid_bm_half_0.iqmod_mfb_lpf_pex_ota_core_inv_NF20$1_0.vout iqmod_mfb_lpf_pex_half_1.iqmod_mfb_lpf_pex_ota_core_hybrid_bm_half_0.iqmod_mfb_lpf_pex_ota_core_inv_NF6$1_1.vout VDD sg13_lv_pmos ad=1.14p pd=6.38u as=1.14p ps=6.38u w=6u l=1u
X63 iqmod_mfb_lpf_pex_half_1.iqmod_mfb_lpf_pex_ota_core_hybrid_bm_half_0.iqmod_mfb_lpf_pex_ota_core_inv_NF6$1_1.vout di_filter_en iqmod_mfb_lpf_pex_half_1.iqmod_mfb_lpf_pex_ota_core_hybrid_bm_half_0.iqmod_mfb_lpf_pex_ota_core_inv_NF20$1_0.vout VSS sg13_lv_nmos ad=0.19p pd=1.38u as=0.19p ps=1.38u w=1u l=0.13u
X64 VDD iqmod_mfb_lpf_pex_half_1.iqmod_mfb_lpf_pex_ota_core_hybrid_bm_half_0.iqmod_mfb_lpf_pex_ota_core_inv_NF20$1_1.vin voutp VDD sg13_lv_pmos ad=1.14p pd=6.38u as=1.14p ps=6.38u w=6u l=1u
X65 voutn iqmod_mfb_lpf_pex_half_0.iqmod_mfb_lpf_pex_ota_core_hybrid_bm_half_0.iqmod_mfb_lpf_pex_ota_core_inv_NF20$1_1.vin VSS VSS sg13_lv_nmos ad=0.19p pd=1.38u as=0.19p ps=1.38u w=1u l=1u
X66 iqmod_mfb_lpf_pex_half_1.iqmod_mfb_lpf_pex_ota_core_hybrid_bm_half_0.iqmod_mfb_lpf_pex_ota_core_inv_NF20$1_0.vout voutp VSS VSS sg13_lv_nmos ad=0.19p pd=1.38u as=0.19p ps=1.38u w=1u l=1u
X67 VSS voutn iqmod_mfb_lpf_pex_half_1.iqmod_mfb_lpf_pex_ota_core_hybrid_bm_half_0.iqmod_mfb_lpf_pex_ota_core_inv_NF20$1_0.vout VSS sg13_lv_nmos ad=0.19p pd=1.38u as=0.19p ps=1.38u w=1u l=1u
X68 VDD VDD VDD VDD sg13_lv_pmos ad=2.04p pd=12.68u as=0 ps=0 w=6u l=1u
X69 iqmod_mfb_lpf_pex_half_1.iqmod_mfb_lpf_pex_ota_core_hybrid_bm_half_0.iqmod_mfb_lpf_pex_ota_core_inv_NF20$1_0.vout di_filter_en iqmod_mfb_lpf_pex_half_1.iqmod_mfb_lpf_pex_ota_core_hybrid_bm_half_0.iqmod_mfb_lpf_pex_ota_core_inv_NF6$1_1.vout VSS sg13_lv_nmos ad=0.19p pd=1.38u as=0.19p ps=1.38u w=1u l=0.13u
X70 VSS iqmod_mfb_lpf_pex_half_0.iqmod_mfb_lpf_pex_ota_core_hybrid_bm_half_0.iqmod_mfb_lpf_pex_ota_core_inv_NF20$1_1.vin voutn VSS sg13_lv_nmos ad=0.19p pd=1.38u as=0.19p ps=1.38u w=1u l=1u
X71 iqmod_mfb_lpf_pex_half_1.iqmod_mfb_lpf_pex_ota_core_hybrid_bm_half_0.iqmod_mfb_lpf_pex_ota_core_inv_NF20$1_0.vout voutp VDD VDD sg13_lv_pmos ad=1.14p pd=6.38u as=1.14p ps=6.38u w=6u l=1u
X72 voutp iqmod_mfb_lpf_pex_half_1.iqmod_mfb_lpf_pex_ota_core_hybrid_bm_half_0.iqmod_mfb_lpf_pex_ota_core_tg$1_0.v_b VSS VSS sg13_lv_nmos ad=0.19p pd=1.38u as=0.19p ps=1.38u w=1u l=1u
X73 iqmod_mfb_lpf_pex_half_1.iqmod_mfb_lpf_pex_ota_core_hybrid_bm_half_0.iqmod_mfb_lpf_pex_ota_core_tg$1_0.v_b iqmod_mfb_lpf_pex_half_1.iqmod_mfb_lpf_pex_ota_core_hybrid_bm_half_0.iqmod_mfb_lpf_pex_ota_core_tg$1_0.di_tg_ctrl_n iqmod_mfb_lpf_pex_half_1.iqmod_mfb_lpf_pex_ota_core_hybrid_bm_half_0.iqmod_mfb_lpf_pex_ota_core_tg$1_0.v_a VDD sg13_lv_pmos ad=1.14p pd=6.38u as=2.04p ps=12.68u w=6u l=0.13u
X74 iqmod_mfb_lpf_pex_half_1.iqmod_mfb_lpf_pex_ota_core_hybrid_bm_half_0.iqmod_mfb_lpf_pex_ota_core_inv_NF20$1_0.vout voutn VSS VSS sg13_lv_nmos ad=0.19p pd=1.38u as=0.19p ps=1.38u w=1u l=1u
X75 voutp iqmod_mfb_lpf_pex_half_1.iqmod_mfb_lpf_pex_ota_core_hybrid_bm_half_0.iqmod_mfb_lpf_pex_ota_core_inv_NF20$1_1.vin VDD VDD sg13_lv_pmos ad=1.14p pd=6.38u as=1.14p ps=6.38u w=6u l=1u
X76 VDD iqmod_mfb_lpf_pex_half_0.iqmod_mfb_lpf_pex_ota_core_hybrid_bm_half_0.iqmod_mfb_lpf_pex_ota_core_inv_NF20$1_1.vin voutn VDD sg13_lv_pmos ad=1.14p pd=6.38u as=1.14p ps=6.38u w=6u l=1u
X77 iqmod_mfb_lpf_pex_half_1.iqmod_mfb_lpf_pex_ota_core_hybrid_bm_half_0.iqmod_mfb_lpf_pex_ota_core_inv_NF20$1_0.vout voutn VDD VDD sg13_lv_pmos ad=1.14p pd=6.38u as=1.14p ps=6.38u w=6u l=1u
X78 VSS iqmod_mfb_lpf_pex_half_1.iqmod_mfb_lpf_pex_ota_core_hybrid_bm_half_0.iqmod_mfb_lpf_pex_ota_core_tg$1_0.v_b voutp VSS sg13_lv_nmos ad=0.19p pd=1.38u as=0.19p ps=1.38u w=1u l=1u
X79 iqmod_mfb_lpf_pex_half_0.iqmod_mfb_lpf_pex_ota_core_hybrid_bm_half_0.iqmod_mfb_lpf_pex_ota_core_inv_NF20$1_1.vin iqmod_mfb_lpf_pex_half_0.iqmod_mfb_lpf_pex_ota_core_hybrid_bm_half_0.iqmod_mfb_lpf_pex_ota_core_tg$1_0.di_tg_ctrl_n vinp VDD sg13_lv_pmos ad=1.14p pd=6.38u as=1.14p ps=6.38u w=6u l=0.13u
X80 VDD voutp iqmod_mfb_lpf_pex_half_1.iqmod_mfb_lpf_pex_ota_core_hybrid_bm_half_0.iqmod_mfb_lpf_pex_ota_core_inv_NF20$1_0.vout VDD sg13_lv_pmos ad=1.14p pd=6.38u as=1.14p ps=6.38u w=6u l=1u
X81 VDD iqmod_mfb_lpf_pex_half_0.iqmod_mfb_lpf_pex_ota_core_hybrid_bm_half_0.iqmod_mfb_lpf_pex_ota_core_inv_NF20$1_1.vin iqmod_mfb_lpf_pex_half_1.iqmod_mfb_lpf_pex_ota_core_hybrid_bm_half_0.iqmod_mfb_lpf_pex_ota_core_tg$1_0.v_a VDD sg13_lv_pmos ad=1.14p pd=6.38u as=1.14p ps=6.38u w=6u l=1u
X82 iqmod_mfb_lpf_pex_half_1.iqmod_mfb_lpf_pex_ota_core_hybrid_bm_half_0.iqmod_mfb_lpf_pex_ota_core_tg$1_0.v_a iqmod_mfb_lpf_pex_half_0.iqmod_mfb_lpf_pex_ota_core_hybrid_bm_half_0.iqmod_mfb_lpf_pex_ota_core_tg$1_0.di_tg_ctrl_n iqmod_mfb_lpf_pex_half_1.iqmod_mfb_lpf_pex_ota_core_hybrid_bm_half_0.iqmod_mfb_lpf_pex_ota_core_tg$1_0.v_b VDD sg13_lv_pmos ad=1.14p pd=6.38u as=1.14p ps=6.38u w=6u l=0.13u
X83 VDD voutn iqmod_mfb_lpf_pex_half_1.iqmod_mfb_lpf_pex_ota_core_hybrid_bm_half_0.iqmod_mfb_lpf_pex_ota_core_inv_NF20$1_0.vout VDD sg13_lv_pmos ad=1.14p pd=6.38u as=1.14p ps=6.38u w=6u l=1u
X84 a_13404_n4303# a_25290_n4603# VSS rhigh l=59u w=0.5u
X85 a_636_n4603# a_6122_n4303# VSS rhigh l=27u w=0.5u
X86 iqmod_mfb_lpf_pex_half_1.iqmod_mfb_lpf_pex_ota_core_hybrid_bm_half_0.iqmod_mfb_lpf_pex_ota_core_tg$1_0.v_a di_filter_en iqmod_mfb_lpf_pex_half_1.iqmod_mfb_lpf_pex_ota_core_hybrid_bm_half_0.iqmod_mfb_lpf_pex_ota_core_tg$1_0.v_b VSS sg13_lv_nmos ad=0.34p pd=2.68u as=0.19p ps=1.38u w=1u l=0.13u
X87 iqmod_mfb_lpf_pex_half_1.iqmod_mfb_lpf_pex_ota_core_hybrid_bm_half_0.iqmod_mfb_lpf_pex_ota_core_inv_NF20$1_1.vin iqmod_mfb_lpf_pex_half_1.iqmod_mfb_lpf_pex_ota_core_hybrid_bm_half_0.iqmod_mfb_lpf_pex_ota_core_tg$1_0.di_tg_ctrl_n VDD VSS sg13_lv_nmos ad=0.19p pd=1.38u as=0.34p ps=2.68u w=1u l=0.13u
X88 a_6620_n4303# iqmod_mfb_lpf_pex_half_1.iqmod_mfb_lpf_pex_R2_0.v_a VSS rhigh l=31u w=0.5u
X89 voutp iqmod_mfb_lpf_pex_half_1.iqmod_mfb_lpf_pex_ota_core_hybrid_bm_half_0.iqmod_mfb_lpf_pex_ota_core_inv_NF20$1_1.vin VDD VDD sg13_lv_pmos ad=1.14p pd=6.38u as=1.14p ps=6.38u w=6u l=1u
X90 VDD iqmod_mfb_lpf_pex_half_1.iqmod_mfb_lpf_pex_ota_core_hybrid_bm_half_0.iqmod_mfb_lpf_pex_ota_core_tg$1_0.v_b voutn VDD sg13_lv_pmos ad=1.14p pd=6.38u as=1.14p ps=6.38u w=6u l=1u
X91 iqmod_mfb_lpf_pex_half_1.iqmod_mfb_lpf_pex_ota_core_hybrid_bm_half_0.iqmod_mfb_lpf_pex_ota_core_tg$1_0.v_b di_filter_en iqmod_mfb_lpf_pex_half_1.iqmod_mfb_lpf_pex_ota_core_hybrid_bm_half_0.iqmod_mfb_lpf_pex_ota_core_tg$1_0.v_a VSS sg13_lv_nmos ad=0.19p pd=1.38u as=0.19p ps=1.38u w=1u l=0.13u
X92 iqmod_mfb_lpf_pex_half_1.iqmod_mfb_lpf_pex_R2_0.v_a a_37874_n4303# VSS rhigh l=60u w=0.5u
X93 iqmod_mfb_lpf_pex_half_1.iqmod_mfb_lpf_pex_ota_core_hybrid_bm_half_0.iqmod_mfb_lpf_pex_ota_core_inv_NF20$1_1.vin iqmod_mfb_lpf_pex_half_1.iqmod_mfb_lpf_pex_ota_core_hybrid_bm_half_0.iqmod_mfb_lpf_pex_ota_core_spdt_switch$1_0.iqmod_mfb_lpf_pex_ota_core_spdt_switch_inv$2_0.vout vinn VSS sg13_lv_nmos ad=0.19p pd=1.38u as=0.19p ps=1.38u w=1u l=0.13u
X94 a_13404_3903# iqmod_mfb_lpf_pex_half_1.C2_half VSS rhigh l=59u w=0.5u
X95 VSS iqmod_mfb_lpf_pex_half_0.iqmod_mfb_lpf_pex_ota_core_hybrid_bm_half_0.iqmod_mfb_lpf_pex_ota_core_inv_NF20$1_1.vin voutn VSS sg13_lv_nmos ad=0.19p pd=1.38u as=0.19p ps=1.38u w=1u l=1u
X96 iqmod_mfb_lpf_pex_half_1.iqmod_mfb_lpf_pex_ota_core_hybrid_bm_half_0.iqmod_mfb_lpf_pex_ota_core_tg$1_0.v_a iqmod_mfb_lpf_pex_half_1.iqmod_mfb_lpf_pex_ota_core_hybrid_bm_half_0.iqmod_mfb_lpf_pex_ota_core_inv_NF20$1_1.vin VDD VDD sg13_lv_pmos ad=1.14p pd=6.38u as=1.14p ps=6.38u w=6u l=1u
X97 VSS iqmod_mfb_lpf_pex_half_1.iqmod_mfb_lpf_pex_ota_core_hybrid_bm_half_0.iqmod_mfb_lpf_pex_ota_core_tg$1_0.v_b voutp VSS sg13_lv_nmos ad=0.19p pd=1.38u as=0.19p ps=1.38u w=1u l=1u
X98 voutn iqmod_mfb_lpf_pex_half_1.iqmod_mfb_lpf_pex_ota_core_hybrid_bm_half_0.iqmod_mfb_lpf_pex_ota_core_tg$1_0.v_b VSS VSS sg13_lv_nmos ad=0.19p pd=1.38u as=0.19p ps=1.38u w=1u l=1u
X99 iqmod_mfb_lpf_pex_half_1.iqmod_mfb_lpf_pex_ota_core_hybrid_bm_half_0.iqmod_mfb_lpf_pex_ota_core_tg$1_0.v_a iqmod_mfb_lpf_pex_half_0.iqmod_mfb_lpf_pex_ota_core_hybrid_bm_half_0.iqmod_mfb_lpf_pex_ota_core_inv_NF20$1_1.vin VSS VSS sg13_lv_nmos ad=0.19p pd=1.38u as=0.19p ps=1.38u w=1u l=1u
X100 iqmod_mfb_lpf_pex_half_1.C1_half iqmod_mfb_lpf_pex_half_1.iqmod_mfb_lpf_pex_R1_0.v_b cap_cmim l=8u w=8u
X101 VDD VDD VDD VDD sg13_lv_pmos ad=1.14p pd=6.38u as=0 ps=0 w=6u l=1u
X102 voutp iqmod_mfb_lpf_pex_half_1.iqmod_mfb_lpf_pex_ota_core_hybrid_bm_half_0.iqmod_mfb_lpf_pex_ota_core_tg$1_0.v_b VSS VSS sg13_lv_nmos ad=0.19p pd=1.38u as=0.19p ps=1.38u w=1u l=1u
X103 voutp iqmod_mfb_lpf_pex_half_1.iqmod_mfb_lpf_pex_ota_core_hybrid_bm_half_0.iqmod_mfb_lpf_pex_ota_core_inv_NF20$1_1.vin VSS VSS sg13_lv_nmos ad=0.19p pd=1.38u as=0.19p ps=1.38u w=1u l=1u
X104 iqmod_mfb_lpf_pex_half_1.iqmod_mfb_lpf_pex_ota_core_hybrid_bm_half_0.iqmod_mfb_lpf_pex_ota_core_inv_NF20$1_0.vout voutp VDD VDD sg13_lv_pmos ad=1.14p pd=6.38u as=1.14p ps=6.38u w=6u l=1u
X105 VDD iqmod_mfb_lpf_pex_half_1.iqmod_mfb_lpf_pex_ota_core_hybrid_bm_half_0.iqmod_mfb_lpf_pex_ota_core_inv_NF6$1_1.vout iqmod_mfb_lpf_pex_half_1.iqmod_mfb_lpf_pex_ota_core_hybrid_bm_half_0.iqmod_mfb_lpf_pex_ota_core_tg$1_0.v_b VDD sg13_lv_pmos ad=1.14p pd=6.38u as=1.14p ps=6.38u w=6u l=1u
X106 VSS VSS VSS VSS sg13_lv_nmos ad=0.19p pd=1.38u as=0 ps=0 w=1u l=1u
X107 VSS iqmod_mfb_lpf_pex_half_1.iqmod_mfb_lpf_pex_ota_core_hybrid_bm_half_0.iqmod_mfb_lpf_pex_ota_core_inv_NF20$1_1.vin voutp VSS sg13_lv_nmos ad=0.19p pd=1.38u as=0.19p ps=1.38u w=1u l=1u
X108 iqmod_mfb_lpf_pex_half_1.iqmod_mfb_lpf_pex_ota_core_hybrid_bm_half_0.iqmod_mfb_lpf_pex_ota_core_inv_NF6$1_1.vout iqmod_mfb_lpf_pex_half_1.iqmod_mfb_lpf_pex_ota_core_hybrid_bm_half_0.iqmod_mfb_lpf_pex_ota_core_inv_NF20$1_0.vout VDD VDD sg13_lv_pmos ad=1.14p pd=6.38u as=1.14p ps=6.38u w=6u l=1u
X109 VSS iqmod_mfb_lpf_pex_half_1.iqmod_mfb_lpf_pex_ota_core_hybrid_bm_half_0.iqmod_mfb_lpf_pex_ota_core_tg$1_0.v_a iqmod_mfb_lpf_pex_half_1.iqmod_mfb_lpf_pex_ota_core_hybrid_bm_half_0.iqmod_mfb_lpf_pex_ota_core_tg$1_0.v_b VSS sg13_lv_nmos ad=0.19p pd=1.38u as=0.19p ps=1.38u w=1u l=1u
X110 VDD iqmod_mfb_lpf_pex_half_1.iqmod_mfb_lpf_pex_ota_core_hybrid_bm_half_0.iqmod_mfb_lpf_pex_ota_core_spdt_switch$1_0.iqmod_mfb_lpf_pex_ota_core_spdt_switch_inv$2_0.vout iqmod_mfb_lpf_pex_half_1.iqmod_mfb_lpf_pex_ota_core_hybrid_bm_half_0.iqmod_mfb_lpf_pex_ota_core_inv_NF20$1_1.vin VDD sg13_lv_pmos ad=2.04p pd=12.68u as=1.14p ps=6.38u w=6u l=0.13u
X111 VDD VDD VDD VDD sg13_lv_pmos ad=1.14p pd=6.38u as=0 ps=0 w=6u l=1u
X112 VDD iqmod_mfb_lpf_pex_half_1.iqmod_mfb_lpf_pex_ota_core_hybrid_bm_half_0.iqmod_mfb_lpf_pex_ota_core_inv_NF6$1_1.vout iqmod_mfb_lpf_pex_half_1.iqmod_mfb_lpf_pex_ota_core_hybrid_bm_half_0.iqmod_mfb_lpf_pex_ota_core_tg$1_0.v_b VDD sg13_lv_pmos ad=1.14p pd=6.38u as=1.14p ps=6.38u w=6u l=1u
X113 voutp iqmod_mfb_lpf_pex_half_1.iqmod_mfb_lpf_pex_ota_core_hybrid_bm_half_0.iqmod_mfb_lpf_pex_ota_core_tg$1_0.v_b VDD VDD sg13_lv_pmos ad=1.14p pd=6.38u as=1.14p ps=6.38u w=6u l=1u
X114 iqmod_mfb_lpf_pex_half_1.iqmod_mfb_lpf_pex_ota_core_hybrid_bm_half_0.iqmod_mfb_lpf_pex_ota_core_inv_NF6$1_1.vout di_filter_en iqmod_mfb_lpf_pex_half_1.iqmod_mfb_lpf_pex_ota_core_hybrid_bm_half_0.iqmod_mfb_lpf_pex_ota_core_inv_NF20$1_0.vout VSS sg13_lv_nmos ad=0.19p pd=1.38u as=0.19p ps=1.38u w=1u l=0.13u
X115 voutp iqmod_mfb_lpf_pex_half_1.iqmod_mfb_lpf_pex_ota_core_hybrid_bm_half_0.iqmod_mfb_lpf_pex_ota_core_tg$1_0.v_b VSS VSS sg13_lv_nmos ad=0.19p pd=1.38u as=0.19p ps=1.38u w=1u l=1u
X116 iqmod_mfb_lpf_pex_half_1.iqmod_mfb_lpf_pex_ota_core_hybrid_bm_half_0.iqmod_mfb_lpf_pex_ota_core_inv_NF20$1_0.vout iqmod_mfb_lpf_pex_half_0.iqmod_mfb_lpf_pex_ota_core_hybrid_bm_half_0.iqmod_mfb_lpf_pex_ota_core_tg$1_0.di_tg_ctrl_n iqmod_mfb_lpf_pex_half_1.iqmod_mfb_lpf_pex_ota_core_hybrid_bm_half_0.iqmod_mfb_lpf_pex_ota_core_inv_NF6$1_1.vout VDD sg13_lv_pmos ad=1.14p pd=6.38u as=1.14p ps=6.38u w=6u l=0.13u
X117 VDD iqmod_mfb_lpf_pex_half_1.iqmod_mfb_lpf_pex_ota_core_hybrid_bm_half_0.iqmod_mfb_lpf_pex_ota_core_inv_NF20$1_0.vout iqmod_mfb_lpf_pex_half_1.iqmod_mfb_lpf_pex_ota_core_hybrid_bm_half_0.iqmod_mfb_lpf_pex_ota_core_inv_NF6$1_1.vout VDD sg13_lv_pmos ad=1.14p pd=6.38u as=1.14p ps=6.38u w=6u l=1u
X118 iqmod_mfb_lpf_pex_half_1.C1_half iqmod_mfb_lpf_pex_half_1.iqmod_mfb_lpf_pex_R1_0.v_b cap_cmim l=8u w=8u
X119 iqmod_mfb_lpf_pex_half_1.iqmod_mfb_lpf_pex_ota_core_hybrid_bm_half_0.iqmod_mfb_lpf_pex_ota_core_inv_NF20$1_0.vout di_filter_en iqmod_mfb_lpf_pex_half_1.iqmod_mfb_lpf_pex_ota_core_hybrid_bm_half_0.iqmod_mfb_lpf_pex_ota_core_inv_NF6$1_1.vout VSS sg13_lv_nmos ad=0.34p pd=2.68u as=0.19p ps=1.38u w=1u l=0.13u
X120 VSS iqmod_mfb_lpf_pex_half_1.iqmod_mfb_lpf_pex_ota_core_hybrid_bm_half_0.iqmod_mfb_lpf_pex_ota_core_tg$1_0.v_a iqmod_mfb_lpf_pex_half_1.iqmod_mfb_lpf_pex_ota_core_hybrid_bm_half_0.iqmod_mfb_lpf_pex_ota_core_tg$1_0.v_b VSS sg13_lv_nmos ad=0.19p pd=1.38u as=0.19p ps=1.38u w=1u l=1u
X121 VSS VSS VSS VSS sg13_lv_nmos ad=0.34p pd=2.68u as=0 ps=0 w=1u l=1u
X122 voutn iqmod_mfb_lpf_pex_half_1.iqmod_mfb_lpf_pex_ota_core_hybrid_bm_half_0.iqmod_mfb_lpf_pex_ota_core_tg$1_0.v_b VDD VDD sg13_lv_pmos ad=1.14p pd=6.38u as=1.14p ps=6.38u w=6u l=1u
X123 voutn iqmod_mfb_lpf_pex_half_1.iqmod_mfb_lpf_pex_ota_core_hybrid_bm_half_0.iqmod_mfb_lpf_pex_ota_core_tg$1_0.v_b VDD VDD sg13_lv_pmos ad=1.14p pd=6.38u as=1.14p ps=6.38u w=6u l=1u
X124 VDD iqmod_mfb_lpf_pex_half_1.iqmod_mfb_lpf_pex_ota_core_hybrid_bm_half_0.iqmod_mfb_lpf_pex_ota_core_inv_NF20$1_1.vin voutp VDD sg13_lv_pmos ad=1.14p pd=6.38u as=1.14p ps=6.38u w=6u l=1u
X125 VDD iqmod_mfb_lpf_pex_half_1.iqmod_mfb_lpf_pex_ota_core_hybrid_bm_half_0.iqmod_mfb_lpf_pex_ota_core_inv_NF20$1_1.vin iqmod_mfb_lpf_pex_half_1.iqmod_mfb_lpf_pex_ota_core_hybrid_bm_half_0.iqmod_mfb_lpf_pex_ota_core_tg$1_0.v_a VDD sg13_lv_pmos ad=1.14p pd=6.38u as=1.14p ps=6.38u w=6u l=1u
X126 iqmod_mfb_lpf_pex_half_0.iqmod_mfb_lpf_pex_ota_core_hybrid_bm_half_0.iqmod_mfb_lpf_pex_ota_core_inv_NF20$1_1.vin iqmod_mfb_lpf_pex_half_0.iqmod_mfb_lpf_pex_ota_core_hybrid_bm_half_0.iqmod_mfb_lpf_pex_ota_core_spdt_switch$1_0.iqmod_mfb_lpf_pex_ota_core_spdt_switch_inv$2_0.vout VDD VDD sg13_lv_pmos ad=1.14p pd=6.38u as=1.14p ps=6.38u w=6u l=0.13u
X127 VDD iqmod_mfb_lpf_pex_half_1.iqmod_mfb_lpf_pex_ota_core_hybrid_bm_half_0.iqmod_mfb_lpf_pex_ota_core_tg$1_0.v_b voutn VDD sg13_lv_pmos ad=1.14p pd=6.38u as=1.14p ps=6.38u w=6u l=1u
X128 VDD VDD VDD VDD sg13_lv_pmos ad=1.14p pd=6.38u as=0 ps=0 w=6u l=0.13u
X129 iqmod_mfb_lpf_pex_half_1.C1_half iqmod_mfb_lpf_pex_half_1.iqmod_mfb_lpf_pex_R1_0.v_b cap_cmim l=8u w=8u
X130 VDD VDD VDD VDD sg13_lv_pmos ad=2.04p pd=12.68u as=0 ps=0 w=6u l=0.13u
X131 VSS VSS VSS VSS sg13_lv_nmos ad=0.19p pd=1.38u as=0 ps=0 w=1u l=1u
X132 vinn a_25290_n4603# VSS rhigh l=59u w=0.5u
X133 a_636_n4603# iqmod_mfb_lpf_pex_half_1.iqmod_mfb_lpf_pex_R1_0.v_b VSS rhigh l=27u w=0.5u
X134 voutp iqmod_mfb_lpf_pex_half_1.iqmod_mfb_lpf_pex_ota_core_hybrid_bm_half_0.iqmod_mfb_lpf_pex_ota_core_inv_NF20$1_1.vin VDD VDD sg13_lv_pmos ad=1.14p pd=6.38u as=1.14p ps=6.38u w=6u l=1u
X135 iqmod_mfb_lpf_pex_half_1.iqmod_mfb_lpf_pex_ota_core_hybrid_bm_half_0.iqmod_mfb_lpf_pex_ota_core_inv_NF20$1_0.vout voutp VSS VSS sg13_lv_nmos ad=0.19p pd=1.38u as=0.19p ps=1.38u w=1u l=1u
X136 VSS VSS VSS VSS sg13_lv_nmos ad=0.19p pd=1.38u as=0 ps=0 w=1u l=1u
X137 VSS iqmod_mfb_lpf_pex_half_1.iqmod_mfb_lpf_pex_ota_core_hybrid_bm_half_0.iqmod_mfb_lpf_pex_ota_core_inv_NF20$1_1.vin voutp VSS sg13_lv_nmos ad=0.19p pd=1.38u as=0.19p ps=1.38u w=1u l=1u
X138 VSS iqmod_mfb_lpf_pex_half_0.iqmod_mfb_lpf_pex_ota_core_hybrid_bm_half_0.iqmod_mfb_lpf_pex_ota_core_inv_NF20$1_1.vin voutn VSS sg13_lv_nmos ad=0.19p pd=1.38u as=0.19p ps=1.38u w=1u l=1u
X139 iqmod_mfb_lpf_pex_half_1.iqmod_mfb_lpf_pex_ota_core_hybrid_bm_half_0.iqmod_mfb_lpf_pex_ota_core_inv_NF20$1_1.vin iqmod_mfb_lpf_pex_half_1.iqmod_mfb_lpf_pex_ota_core_hybrid_bm_half_0.iqmod_mfb_lpf_pex_ota_core_tg$1_0.di_tg_ctrl_n vinn VDD sg13_lv_pmos ad=1.14p pd=6.38u as=1.14p ps=6.38u w=6u l=0.13u
X140 a_6620_n4303# a_12906_n4603# VSS rhigh l=31u w=0.5u
X141 iqmod_mfb_lpf_pex_half_0.iqmod_mfb_lpf_pex_ota_core_hybrid_bm_half_0.iqmod_mfb_lpf_pex_ota_core_tg$1_0.di_tg_ctrl_n di_filter_en VDD VDD sg13_lv_pmos ad=1.14p pd=6.38u as=1.14p ps=6.38u w=6u l=0.13u
X142 VDD VDD VDD VDD sg13_lv_pmos ad=2.04p pd=12.68u as=0 ps=0 w=6u l=1u
X143 iqmod_mfb_lpf_pex_half_1.iqmod_mfb_lpf_pex_ota_core_hybrid_bm_half_0.iqmod_mfb_lpf_pex_ota_core_tg$1_0.v_a iqmod_mfb_lpf_pex_half_1.iqmod_mfb_lpf_pex_ota_core_hybrid_bm_half_0.iqmod_mfb_lpf_pex_ota_core_inv_NF20$1_1.vin VDD VDD sg13_lv_pmos ad=1.14p pd=6.38u as=1.14p ps=6.38u w=6u l=1u
X144 voutn iqmod_mfb_lpf_pex_half_0.iqmod_mfb_lpf_pex_ota_core_hybrid_bm_half_0.iqmod_mfb_lpf_pex_ota_core_inv_NF20$1_1.vin VSS VSS sg13_lv_nmos ad=0.19p pd=1.38u as=0.19p ps=1.38u w=1u l=1u
X145 a_25788_n4603# a_37874_n4303# VSS rhigh l=60u w=0.5u
X146 VSS VSS VSS VSS sg13_lv_nmos ad=0.19p pd=1.38u as=0 ps=0 w=1u l=0.13u
X147 voutp iqmod_mfb_lpf_pex_half_1.iqmod_mfb_lpf_pex_ota_core_hybrid_bm_half_0.iqmod_mfb_lpf_pex_ota_core_tg$1_0.v_b VDD VDD sg13_lv_pmos ad=1.14p pd=6.38u as=1.14p ps=6.38u w=6u l=1u
X148 VSS voutn iqmod_mfb_lpf_pex_half_1.iqmod_mfb_lpf_pex_ota_core_hybrid_bm_half_0.iqmod_mfb_lpf_pex_ota_core_inv_NF20$1_0.vout VSS sg13_lv_nmos ad=0.19p pd=1.38u as=0.19p ps=1.38u w=1u l=1u
X149 VSS iqmod_mfb_lpf_pex_half_1.iqmod_mfb_lpf_pex_ota_core_hybrid_bm_half_0.iqmod_mfb_lpf_pex_ota_core_tg$1_0.v_b voutn VSS sg13_lv_nmos ad=0.19p pd=1.38u as=0.19p ps=1.38u w=1u l=1u
X150 VDD iqmod_mfb_lpf_pex_half_0.iqmod_mfb_lpf_pex_ota_core_hybrid_bm_half_0.iqmod_mfb_lpf_pex_ota_core_inv_NF20$1_1.vin voutn VDD sg13_lv_pmos ad=1.14p pd=6.38u as=1.14p ps=6.38u w=6u l=1u
X151 VDD iqmod_mfb_lpf_pex_half_0.iqmod_mfb_lpf_pex_ota_core_hybrid_bm_half_0.iqmod_mfb_lpf_pex_ota_core_tg$1_0.di_tg_ctrl_n iqmod_mfb_lpf_pex_half_0.iqmod_mfb_lpf_pex_ota_core_hybrid_bm_half_0.iqmod_mfb_lpf_pex_ota_core_inv_NF20$1_1.vin VSS sg13_lv_nmos ad=0.19p pd=1.38u as=0.19p ps=1.38u w=1u l=0.13u
X152 iqmod_mfb_lpf_pex_half_1.C1_half iqmod_mfb_lpf_pex_half_1.iqmod_mfb_lpf_pex_R1_0.v_b cap_cmim l=8u w=8u
X153 VSS VSS VSS VSS sg13_lv_nmos ad=0.34p pd=2.68u as=0 ps=0 w=1u l=0.13u
X154 iqmod_mfb_lpf_pex_half_1.iqmod_mfb_lpf_pex_ota_core_hybrid_bm_half_0.iqmod_mfb_lpf_pex_ota_core_inv_NF20$1_1.vin iqmod_mfb_lpf_pex_half_1.iqmod_mfb_lpf_pex_ota_core_hybrid_bm_half_0.iqmod_mfb_lpf_pex_ota_core_tg$1_0.di_tg_ctrl_n VDD VSS sg13_lv_nmos ad=0.19p pd=1.38u as=0.19p ps=1.38u w=1u l=0.13u
X155 vinn iqmod_mfb_lpf_pex_half_1.iqmod_mfb_lpf_pex_ota_core_hybrid_bm_half_0.iqmod_mfb_lpf_pex_ota_core_tg$1_0.di_tg_ctrl_n iqmod_mfb_lpf_pex_half_1.iqmod_mfb_lpf_pex_ota_core_hybrid_bm_half_0.iqmod_mfb_lpf_pex_ota_core_inv_NF20$1_1.vin VDD sg13_lv_pmos ad=2.04p pd=12.68u as=1.14p ps=6.38u w=6u l=0.13u
X156 voutn iqmod_mfb_lpf_pex_half_0.iqmod_mfb_lpf_pex_ota_core_hybrid_bm_half_0.iqmod_mfb_lpf_pex_ota_core_inv_NF20$1_1.vin VDD VDD sg13_lv_pmos ad=1.14p pd=6.38u as=1.14p ps=6.38u w=6u l=1u
X157 VDD voutn iqmod_mfb_lpf_pex_half_1.iqmod_mfb_lpf_pex_ota_core_hybrid_bm_half_0.iqmod_mfb_lpf_pex_ota_core_inv_NF20$1_0.vout VDD sg13_lv_pmos ad=1.14p pd=6.38u as=1.14p ps=6.38u w=6u l=1u
X158 iqmod_mfb_lpf_pex_half_1.iqmod_mfb_lpf_pex_ota_core_hybrid_bm_half_0.iqmod_mfb_lpf_pex_ota_core_inv_NF20$1_0.vout iqmod_mfb_lpf_pex_half_1.iqmod_mfb_lpf_pex_ota_core_hybrid_bm_half_0.iqmod_mfb_lpf_pex_ota_core_tg$1_0.di_tg_ctrl_n iqmod_mfb_lpf_pex_half_1.iqmod_mfb_lpf_pex_ota_core_hybrid_bm_half_0.iqmod_mfb_lpf_pex_ota_core_inv_NF6$1_1.vout VDD sg13_lv_pmos ad=1.14p pd=6.38u as=1.14p ps=6.38u w=6u l=0.13u
X159 VDD VDD VDD VDD sg13_lv_pmos ad=2.04p pd=12.68u as=0 ps=0 w=6u l=1u
X160 VDD iqmod_mfb_lpf_pex_half_1.iqmod_mfb_lpf_pex_ota_core_hybrid_bm_half_0.iqmod_mfb_lpf_pex_ota_core_inv_NF20$1_1.vin voutp VDD sg13_lv_pmos ad=1.14p pd=6.38u as=1.14p ps=6.38u w=6u l=1u
X161 iqmod_mfb_lpf_pex_half_1.iqmod_mfb_lpf_pex_ota_core_hybrid_bm_half_0.iqmod_mfb_lpf_pex_ota_core_inv_NF20$1_1.vin iqmod_mfb_lpf_pex_half_1.iqmod_mfb_lpf_pex_ota_core_hybrid_bm_half_0.iqmod_mfb_lpf_pex_ota_core_spdt_switch$1_0.iqmod_mfb_lpf_pex_ota_core_spdt_switch_inv$2_0.vout VDD VDD sg13_lv_pmos ad=1.14p pd=6.38u as=1.14p ps=6.38u w=6u l=0.13u
X162 iqmod_mfb_lpf_pex_half_1.iqmod_mfb_lpf_pex_ota_core_hybrid_bm_half_0.iqmod_mfb_lpf_pex_ota_core_tg$1_0.v_a iqmod_mfb_lpf_pex_half_0.iqmod_mfb_lpf_pex_ota_core_hybrid_bm_half_0.iqmod_mfb_lpf_pex_ota_core_inv_NF20$1_1.vin VDD VDD sg13_lv_pmos ad=1.14p pd=6.38u as=1.14p ps=6.38u w=6u l=1u
X163 iqmod_mfb_lpf_pex_half_1.iqmod_mfb_lpf_pex_ota_core_hybrid_bm_half_0.iqmod_mfb_lpf_pex_ota_core_inv_NF20$1_0.vout voutn VDD VDD sg13_lv_pmos ad=1.14p pd=6.38u as=1.14p ps=6.38u w=6u l=1u
X164 VDD iqmod_mfb_lpf_pex_half_0.iqmod_mfb_lpf_pex_ota_core_hybrid_bm_half_0.iqmod_mfb_lpf_pex_ota_core_inv_NF20$1_1.vin voutn VDD sg13_lv_pmos ad=1.14p pd=6.38u as=1.14p ps=6.38u w=6u l=1u
X165 iqmod_mfb_lpf_pex_half_1.iqmod_mfb_lpf_pex_ota_core_hybrid_bm_half_0.iqmod_mfb_lpf_pex_ota_core_tg$1_0.v_b iqmod_mfb_lpf_pex_half_1.iqmod_mfb_lpf_pex_ota_core_hybrid_bm_half_0.iqmod_mfb_lpf_pex_ota_core_inv_NF6$1_1.vout VDD VDD sg13_lv_pmos ad=1.14p pd=6.38u as=1.14p ps=6.38u w=6u l=1u
X166 VSS iqmod_mfb_lpf_pex_half_1.iqmod_mfb_lpf_pex_ota_core_hybrid_bm_half_0.iqmod_mfb_lpf_pex_ota_core_tg$1_0.v_b voutp VSS sg13_lv_nmos ad=0.19p pd=1.38u as=0.19p ps=1.38u w=1u l=1u
X167 VDD iqmod_mfb_lpf_pex_half_1.iqmod_mfb_lpf_pex_ota_core_hybrid_bm_half_0.iqmod_mfb_lpf_pex_ota_core_inv_NF20$1_1.vin iqmod_mfb_lpf_pex_half_1.iqmod_mfb_lpf_pex_ota_core_hybrid_bm_half_0.iqmod_mfb_lpf_pex_ota_core_tg$1_0.v_a VDD sg13_lv_pmos ad=1.14p pd=6.38u as=1.14p ps=6.38u w=6u l=1u
X168 VSS voutn iqmod_mfb_lpf_pex_half_1.iqmod_mfb_lpf_pex_ota_core_hybrid_bm_half_0.iqmod_mfb_lpf_pex_ota_core_inv_NF20$1_0.vout VSS sg13_lv_nmos ad=0.19p pd=1.38u as=0.19p ps=1.38u w=1u l=1u
X169 VDD iqmod_mfb_lpf_pex_half_0.iqmod_mfb_lpf_pex_ota_core_hybrid_bm_half_0.iqmod_mfb_lpf_pex_ota_core_inv_NF20$1_1.vin iqmod_mfb_lpf_pex_half_1.iqmod_mfb_lpf_pex_ota_core_hybrid_bm_half_0.iqmod_mfb_lpf_pex_ota_core_tg$1_0.v_a VDD sg13_lv_pmos ad=1.14p pd=6.38u as=1.14p ps=6.38u w=6u l=1u
X170 iqmod_mfb_lpf_pex_half_1.C1_half iqmod_mfb_lpf_pex_half_1.iqmod_mfb_lpf_pex_R1_0.v_b cap_cmim l=8u w=8u
X171 VDD iqmod_mfb_lpf_pex_half_1.iqmod_mfb_lpf_pex_ota_core_hybrid_bm_half_0.iqmod_mfb_lpf_pex_ota_core_tg$1_0.v_b voutp VDD sg13_lv_pmos ad=1.14p pd=6.38u as=1.14p ps=6.38u w=6u l=1u
X172 voutp iqmod_mfb_lpf_pex_half_1.iqmod_mfb_lpf_pex_ota_core_hybrid_bm_half_0.iqmod_mfb_lpf_pex_ota_core_tg$1_0.v_b VSS VSS sg13_lv_nmos ad=0.19p pd=1.38u as=0.19p ps=1.38u w=1u l=1u
X173 VSS iqmod_mfb_lpf_pex_half_1.iqmod_mfb_lpf_pex_ota_core_hybrid_bm_half_0.iqmod_mfb_lpf_pex_ota_core_inv_NF20$1_1.vin voutp VSS sg13_lv_nmos ad=0.19p pd=1.38u as=0.19p ps=1.38u w=1u l=1u
X174 iqmod_mfb_lpf_pex_half_1.iqmod_mfb_lpf_pex_ota_core_hybrid_bm_half_0.iqmod_mfb_lpf_pex_ota_core_tg$1_0.di_tg_ctrl_n di_filter_en VDD VDD sg13_lv_pmos ad=1.14p pd=6.38u as=1.14p ps=6.38u w=6u l=0.13u
X175 a_13404_3903# a_25290_4203# VSS rhigh l=59u w=0.5u
X176 VSS iqmod_mfb_lpf_pex_half_1.iqmod_mfb_lpf_pex_ota_core_hybrid_bm_half_0.iqmod_mfb_lpf_pex_ota_core_inv_NF20$1_1.vin iqmod_mfb_lpf_pex_half_1.iqmod_mfb_lpf_pex_ota_core_hybrid_bm_half_0.iqmod_mfb_lpf_pex_ota_core_tg$1_0.v_a VSS sg13_lv_nmos ad=0.19p pd=1.38u as=0.19p ps=1.38u w=1u l=1u
X177 VDD VDD VDD VDD sg13_lv_pmos ad=2.04p pd=12.68u as=0 ps=0 w=6u l=0.13u
X178 iqmod_mfb_lpf_pex_half_1.iqmod_mfb_lpf_pex_ota_core_hybrid_bm_half_0.iqmod_mfb_lpf_pex_ota_core_tg$1_0.v_b iqmod_mfb_lpf_pex_half_1.iqmod_mfb_lpf_pex_ota_core_hybrid_bm_half_0.iqmod_mfb_lpf_pex_ota_core_inv_NF6$1_1.vout VSS VSS sg13_lv_nmos ad=0.19p pd=1.38u as=0.19p ps=1.38u w=1u l=1u
X179 iqmod_mfb_lpf_pex_half_1.iqmod_mfb_lpf_pex_ota_core_hybrid_bm_half_0.iqmod_mfb_lpf_pex_ota_core_inv_NF20$1_0.vout voutn VSS VSS sg13_lv_nmos ad=0.19p pd=1.38u as=0.19p ps=1.38u w=1u l=1u
X180 iqmod_mfb_lpf_pex_half_0.iqmod_mfb_lpf_pex_ota_core_hybrid_bm_half_0.iqmod_mfb_lpf_pex_ota_core_inv_NF20$1_1.vin iqmod_mfb_lpf_pex_half_0.iqmod_mfb_lpf_pex_ota_core_hybrid_bm_half_0.iqmod_mfb_lpf_pex_ota_core_tg$1_0.di_tg_ctrl_n VDD VSS sg13_lv_nmos ad=0.19p pd=1.38u as=0.19p ps=1.38u w=1u l=0.13u
X181 VSS VSS VSS rhigh l=59u w=0.5u
X182 VSS iqmod_mfb_lpf_pex_half_1.iqmod_mfb_lpf_pex_ota_core_hybrid_bm_half_0.iqmod_mfb_lpf_pex_ota_core_inv_NF20$1_1.vin voutp VSS sg13_lv_nmos ad=0.19p pd=1.38u as=0.19p ps=1.38u w=1u l=1u
X183 VSS VSS VSS VSS sg13_lv_nmos ad=0.19p pd=1.38u as=0 ps=0 w=1u l=1u
X184 VDD VDD VDD VDD sg13_lv_pmos ad=1.14p pd=6.38u as=0 ps=0 w=6u l=1u
X185 VSS VSS VSS rhigh l=27u w=0.5u
X186 VDD VDD VDD VDD sg13_lv_pmos ad=1.14p pd=6.38u as=0 ps=0 w=6u l=1u
X187 VSS VSS VSS VSS sg13_lv_nmos ad=0.34p pd=2.68u as=0 ps=0 w=1u l=1u
X188 VDD iqmod_mfb_lpf_pex_half_1.iqmod_mfb_lpf_pex_ota_core_hybrid_bm_half_0.iqmod_mfb_lpf_pex_ota_core_inv_NF6$1_1.vout iqmod_mfb_lpf_pex_half_1.iqmod_mfb_lpf_pex_ota_core_hybrid_bm_half_0.iqmod_mfb_lpf_pex_ota_core_tg$1_0.v_b VDD sg13_lv_pmos ad=1.14p pd=6.38u as=1.14p ps=6.38u w=6u l=1u
X189 iqmod_mfb_lpf_pex_half_1.iqmod_mfb_lpf_pex_ota_core_hybrid_bm_half_0.iqmod_mfb_lpf_pex_ota_core_tg$1_0.v_a di_filter_en iqmod_mfb_lpf_pex_half_1.iqmod_mfb_lpf_pex_ota_core_hybrid_bm_half_0.iqmod_mfb_lpf_pex_ota_core_tg$1_0.v_b VSS sg13_lv_nmos ad=0.19p pd=1.38u as=0.19p ps=1.38u w=1u l=0.13u
X190 iqmod_mfb_lpf_pex_half_1.iqmod_mfb_lpf_pex_R1_0.v_b a_12906_n4603# VSS rhigh l=31u w=0.5u
X191 VSS iqmod_mfb_lpf_pex_half_1.iqmod_mfb_lpf_pex_ota_core_hybrid_bm_half_0.iqmod_mfb_lpf_pex_ota_core_inv_NF20$1_1.vin iqmod_mfb_lpf_pex_half_1.iqmod_mfb_lpf_pex_ota_core_hybrid_bm_half_0.iqmod_mfb_lpf_pex_ota_core_tg$1_0.v_a VSS sg13_lv_nmos ad=0.19p pd=1.38u as=0.19p ps=1.38u w=1u l=1u
X192 voutp iqmod_mfb_lpf_pex_half_1.iqmod_mfb_lpf_pex_ota_core_hybrid_bm_half_0.iqmod_mfb_lpf_pex_ota_core_inv_NF20$1_1.vin VSS VSS sg13_lv_nmos ad=0.19p pd=1.38u as=0.19p ps=1.38u w=1u l=1u
X193 VSS iqmod_mfb_lpf_pex_half_0.iqmod_mfb_lpf_pex_ota_core_hybrid_bm_half_0.iqmod_mfb_lpf_pex_ota_core_inv_NF20$1_1.vin voutn VSS sg13_lv_nmos ad=0.19p pd=1.38u as=0.19p ps=1.38u w=1u l=1u
X194 VDD VDD VDD VDD sg13_lv_pmos ad=1.14p pd=6.38u as=0 ps=0 w=6u l=0.13u
X195 a_25788_n4603# voutp VSS rhigh l=60u w=0.5u
X196 iqmod_mfb_lpf_pex_half_1.iqmod_mfb_lpf_pex_ota_core_hybrid_bm_half_0.iqmod_mfb_lpf_pex_ota_core_inv_NF20$1_0.vout voutn VSS VSS sg13_lv_nmos ad=0.19p pd=1.38u as=0.19p ps=1.38u w=1u l=1u
X197 VDD VDD VDD VDD sg13_lv_pmos ad=1.14p pd=6.38u as=0 ps=0 w=6u l=1u
X198 iqmod_mfb_lpf_pex_half_1.iqmod_mfb_lpf_pex_ota_core_hybrid_bm_half_0.iqmod_mfb_lpf_pex_ota_core_tg$1_0.v_a iqmod_mfb_lpf_pex_half_1.iqmod_mfb_lpf_pex_ota_core_hybrid_bm_half_0.iqmod_mfb_lpf_pex_ota_core_inv_NF20$1_1.vin VSS VSS sg13_lv_nmos ad=0.19p pd=1.38u as=0.19p ps=1.38u w=1u l=1u
X199 VSS iqmod_mfb_lpf_pex_half_1.iqmod_mfb_lpf_pex_ota_core_hybrid_bm_half_0.iqmod_mfb_lpf_pex_ota_core_inv_NF20$1_1.vin voutp VSS sg13_lv_nmos ad=0.19p pd=1.38u as=0.19p ps=1.38u w=1u l=1u
X200 iqmod_mfb_lpf_pex_half_1.iqmod_mfb_lpf_pex_ota_core_hybrid_bm_half_0.iqmod_mfb_lpf_pex_ota_core_inv_NF6$1_1.vout iqmod_mfb_lpf_pex_half_1.iqmod_mfb_lpf_pex_ota_core_hybrid_bm_half_0.iqmod_mfb_lpf_pex_ota_core_inv_NF20$1_0.vout VDD VDD sg13_lv_pmos ad=1.14p pd=6.38u as=1.14p ps=6.38u w=6u l=1u
X201 voutp iqmod_mfb_lpf_pex_half_1.iqmod_mfb_lpf_pex_ota_core_hybrid_bm_half_0.iqmod_mfb_lpf_pex_ota_core_tg$1_0.v_b VDD VDD sg13_lv_pmos ad=1.14p pd=6.38u as=1.14p ps=6.38u w=6u l=1u
X202 VDD iqmod_mfb_lpf_pex_half_1.iqmod_mfb_lpf_pex_ota_core_hybrid_bm_half_0.iqmod_mfb_lpf_pex_ota_core_inv_NF20$1_0.vout iqmod_mfb_lpf_pex_half_1.iqmod_mfb_lpf_pex_ota_core_hybrid_bm_half_0.iqmod_mfb_lpf_pex_ota_core_inv_NF6$1_1.vout VDD sg13_lv_pmos ad=1.14p pd=6.38u as=1.14p ps=6.38u w=6u l=1u
X203 VDD voutp iqmod_mfb_lpf_pex_half_1.iqmod_mfb_lpf_pex_ota_core_hybrid_bm_half_0.iqmod_mfb_lpf_pex_ota_core_inv_NF20$1_0.vout VDD sg13_lv_pmos ad=1.14p pd=6.38u as=1.14p ps=6.38u w=6u l=1u
X204 iqmod_mfb_lpf_pex_half_1.iqmod_mfb_lpf_pex_ota_core_hybrid_bm_half_0.iqmod_mfb_lpf_pex_ota_core_tg$1_0.v_a iqmod_mfb_lpf_pex_half_1.iqmod_mfb_lpf_pex_ota_core_hybrid_bm_half_0.iqmod_mfb_lpf_pex_ota_core_tg$1_0.di_tg_ctrl_n iqmod_mfb_lpf_pex_half_1.iqmod_mfb_lpf_pex_ota_core_hybrid_bm_half_0.iqmod_mfb_lpf_pex_ota_core_tg$1_0.v_b VDD sg13_lv_pmos ad=2.04p pd=12.68u as=1.14p ps=6.38u w=6u l=0.13u
X205 iqmod_mfb_lpf_pex_half_1.iqmod_mfb_lpf_pex_ota_core_hybrid_bm_half_0.iqmod_mfb_lpf_pex_ota_core_tg$1_0.v_b di_filter_en iqmod_mfb_lpf_pex_half_1.iqmod_mfb_lpf_pex_ota_core_hybrid_bm_half_0.iqmod_mfb_lpf_pex_ota_core_tg$1_0.v_a VSS sg13_lv_nmos ad=0.19p pd=1.38u as=0.34p ps=2.68u w=1u l=0.13u
X206 iqmod_mfb_lpf_pex_half_1.iqmod_mfb_lpf_pex_ota_core_hybrid_bm_half_0.iqmod_mfb_lpf_pex_ota_core_inv_NF20$1_1.vin iqmod_mfb_lpf_pex_half_1.iqmod_mfb_lpf_pex_ota_core_hybrid_bm_half_0.iqmod_mfb_lpf_pex_ota_core_spdt_switch$1_0.iqmod_mfb_lpf_pex_ota_core_spdt_switch_inv$2_0.vout vinn VSS sg13_lv_nmos ad=0.19p pd=1.38u as=0.34p ps=2.68u w=1u l=0.13u
X207 iqmod_mfb_lpf_pex_half_1.iqmod_mfb_lpf_pex_ota_core_hybrid_bm_half_0.iqmod_mfb_lpf_pex_ota_core_spdt_switch$1_0.iqmod_mfb_lpf_pex_ota_core_spdt_switch_inv$2_0.vout iqmod_mfb_lpf_pex_half_1.iqmod_mfb_lpf_pex_ota_core_hybrid_bm_half_0.iqmod_mfb_lpf_pex_ota_core_tg$1_0.di_tg_ctrl_n VSS VSS sg13_lv_nmos ad=0.19p pd=1.38u as=0.19p ps=1.38u w=1u l=0.13u
X208 iqmod_mfb_lpf_pex_half_1.iqmod_mfb_lpf_pex_ota_core_hybrid_bm_half_0.iqmod_mfb_lpf_pex_ota_core_tg$1_0.v_b iqmod_mfb_lpf_pex_half_1.iqmod_mfb_lpf_pex_ota_core_hybrid_bm_half_0.iqmod_mfb_lpf_pex_ota_core_inv_NF6$1_1.vout VDD VDD sg13_lv_pmos ad=1.14p pd=6.38u as=1.14p ps=6.38u w=6u l=1u
X209 VSS iqmod_mfb_lpf_pex_half_0.iqmod_mfb_lpf_pex_ota_core_hybrid_bm_half_0.iqmod_mfb_lpf_pex_ota_core_inv_NF20$1_1.vin voutn VSS sg13_lv_nmos ad=0.19p pd=1.38u as=0.19p ps=1.38u w=1u l=1u
X210 VSS VSS VSS VSS sg13_lv_nmos ad=0.19p pd=1.38u as=0 ps=0 w=1u l=1u
X211 voutn iqmod_mfb_lpf_pex_half_1.iqmod_mfb_lpf_pex_ota_core_hybrid_bm_half_0.iqmod_mfb_lpf_pex_ota_core_tg$1_0.v_b VDD VDD sg13_lv_pmos ad=1.14p pd=6.38u as=1.14p ps=6.38u w=6u l=1u
X212 VDD iqmod_mfb_lpf_pex_half_1.iqmod_mfb_lpf_pex_ota_core_hybrid_bm_half_0.iqmod_mfb_lpf_pex_ota_core_tg$1_0.v_b voutp VDD sg13_lv_pmos ad=1.14p pd=6.38u as=1.14p ps=6.38u w=6u l=1u
X213 iqmod_mfb_lpf_pex_half_1.iqmod_mfb_lpf_pex_ota_core_hybrid_bm_half_0.iqmod_mfb_lpf_pex_ota_core_tg$1_0.v_a iqmod_mfb_lpf_pex_half_1.iqmod_mfb_lpf_pex_ota_core_hybrid_bm_half_0.iqmod_mfb_lpf_pex_ota_core_tg$1_0.di_tg_ctrl_n iqmod_mfb_lpf_pex_half_1.iqmod_mfb_lpf_pex_ota_core_hybrid_bm_half_0.iqmod_mfb_lpf_pex_ota_core_tg$1_0.v_b VDD sg13_lv_pmos ad=1.14p pd=6.38u as=1.14p ps=6.38u w=6u l=0.13u
X214 VSS iqmod_mfb_lpf_pex_half_1.iqmod_mfb_lpf_pex_ota_core_hybrid_bm_half_0.iqmod_mfb_lpf_pex_ota_core_tg$1_0.v_a iqmod_mfb_lpf_pex_half_1.iqmod_mfb_lpf_pex_ota_core_hybrid_bm_half_0.iqmod_mfb_lpf_pex_ota_core_tg$1_0.v_b VSS sg13_lv_nmos ad=0.19p pd=1.38u as=0.19p ps=1.38u w=1u l=1u
X215 voutn iqmod_mfb_lpf_pex_half_1.iqmod_mfb_lpf_pex_ota_core_hybrid_bm_half_0.iqmod_mfb_lpf_pex_ota_core_tg$1_0.v_b VSS VSS sg13_lv_nmos ad=0.19p pd=1.38u as=0.19p ps=1.38u w=1u l=1u
X216 VSS VSS VSS rhigh l=31u w=0.5u
X217 VSS VSS VSS VSS sg13_lv_nmos ad=0.19p pd=1.38u as=0 ps=0 w=1u l=1u
X218 VSS voutp iqmod_mfb_lpf_pex_half_1.iqmod_mfb_lpf_pex_ota_core_hybrid_bm_half_0.iqmod_mfb_lpf_pex_ota_core_inv_NF20$1_0.vout VSS sg13_lv_nmos ad=0.19p pd=1.38u as=0.19p ps=1.38u w=1u l=1u
X219 VSS iqmod_mfb_lpf_pex_half_0.iqmod_mfb_lpf_pex_ota_core_hybrid_bm_half_0.iqmod_mfb_lpf_pex_ota_core_inv_NF20$1_1.vin iqmod_mfb_lpf_pex_half_1.iqmod_mfb_lpf_pex_ota_core_hybrid_bm_half_0.iqmod_mfb_lpf_pex_ota_core_tg$1_0.v_a VSS sg13_lv_nmos ad=0.19p pd=1.38u as=0.19p ps=1.38u w=1u l=1u
X220 iqmod_mfb_lpf_pex_half_1.iqmod_mfb_lpf_pex_ota_core_hybrid_bm_half_0.iqmod_mfb_lpf_pex_ota_core_tg$1_0.v_b iqmod_mfb_lpf_pex_half_1.iqmod_mfb_lpf_pex_ota_core_hybrid_bm_half_0.iqmod_mfb_lpf_pex_ota_core_tg$1_0.v_a VSS VSS sg13_lv_nmos ad=0.19p pd=1.38u as=0.19p ps=1.38u w=1u l=1u
X221 VDD iqmod_mfb_lpf_pex_half_1.iqmod_mfb_lpf_pex_ota_core_hybrid_bm_half_0.iqmod_mfb_lpf_pex_ota_core_tg$1_0.v_b voutp VDD sg13_lv_pmos ad=1.14p pd=6.38u as=1.14p ps=6.38u w=6u l=1u
X222 VDD iqmod_mfb_lpf_pex_half_0.iqmod_mfb_lpf_pex_ota_core_hybrid_bm_half_0.iqmod_mfb_lpf_pex_ota_core_tg$1_0.di_tg_ctrl_n iqmod_mfb_lpf_pex_half_0.iqmod_mfb_lpf_pex_ota_core_hybrid_bm_half_0.iqmod_mfb_lpf_pex_ota_core_inv_NF20$1_1.vin VSS sg13_lv_nmos ad=0.19p pd=1.38u as=0.19p ps=1.38u w=1u l=0.13u
X223 voutp iqmod_mfb_lpf_pex_half_1.iqmod_mfb_lpf_pex_ota_core_hybrid_bm_half_0.iqmod_mfb_lpf_pex_ota_core_inv_NF20$1_1.vin VDD VDD sg13_lv_pmos ad=1.14p pd=6.38u as=1.14p ps=6.38u w=6u l=1u
X224 VDD iqmod_mfb_lpf_pex_half_0.iqmod_mfb_lpf_pex_ota_core_hybrid_bm_half_0.iqmod_mfb_lpf_pex_ota_core_inv_NF20$1_1.vin voutn VDD sg13_lv_pmos ad=1.14p pd=6.38u as=1.14p ps=6.38u w=6u l=1u
X225 iqmod_mfb_lpf_pex_half_1.iqmod_mfb_lpf_pex_ota_core_hybrid_bm_half_0.iqmod_mfb_lpf_pex_ota_core_inv_NF20$1_0.vout voutp VDD VDD sg13_lv_pmos ad=1.14p pd=6.38u as=1.14p ps=6.38u w=6u l=1u
X226 VSS iqmod_mfb_lpf_pex_half_0.iqmod_mfb_lpf_pex_ota_core_hybrid_bm_half_0.iqmod_mfb_lpf_pex_ota_core_inv_NF20$1_1.vin voutn VSS sg13_lv_nmos ad=0.19p pd=1.38u as=0.19p ps=1.38u w=1u l=1u
X227 vinp a_25290_4203# VSS rhigh l=59u w=0.5u
X228 VDD VDD VDD VDD sg13_lv_pmos ad=1.14p pd=6.38u as=0 ps=0 w=6u l=1u
X229 iqmod_mfb_lpf_pex_half_1.iqmod_mfb_lpf_pex_ota_core_hybrid_bm_half_0.iqmod_mfb_lpf_pex_ota_core_tg$1_0.v_b di_filter_en iqmod_mfb_lpf_pex_half_1.iqmod_mfb_lpf_pex_ota_core_hybrid_bm_half_0.iqmod_mfb_lpf_pex_ota_core_tg$1_0.v_a VSS sg13_lv_nmos ad=0.19p pd=1.38u as=0.19p ps=1.38u w=1u l=0.13u
X230 VDD VDD VDD VDD sg13_lv_pmos ad=2.04p pd=12.68u as=0 ps=0 w=6u l=1u
X231 voutn iqmod_mfb_lpf_pex_half_0.iqmod_mfb_lpf_pex_ota_core_hybrid_bm_half_0.iqmod_mfb_lpf_pex_ota_core_inv_NF20$1_1.vin VDD VDD sg13_lv_pmos ad=1.14p pd=6.38u as=1.14p ps=6.38u w=6u l=1u
X232 iqmod_mfb_lpf_pex_half_1.iqmod_mfb_lpf_pex_ota_core_hybrid_bm_half_0.iqmod_mfb_lpf_pex_ota_core_inv_NF20$1_0.vout iqmod_mfb_lpf_pex_half_0.iqmod_mfb_lpf_pex_ota_core_hybrid_bm_half_0.iqmod_mfb_lpf_pex_ota_core_tg$1_0.di_tg_ctrl_n iqmod_mfb_lpf_pex_half_1.iqmod_mfb_lpf_pex_ota_core_hybrid_bm_half_0.iqmod_mfb_lpf_pex_ota_core_inv_NF6$1_1.vout VDD sg13_lv_pmos ad=1.14p pd=6.38u as=1.14p ps=6.38u w=6u l=0.13u
X233 voutp iqmod_mfb_lpf_pex_half_1.iqmod_mfb_lpf_pex_ota_core_hybrid_bm_half_0.iqmod_mfb_lpf_pex_ota_core_tg$1_0.v_b VDD VDD sg13_lv_pmos ad=1.14p pd=6.38u as=1.14p ps=6.38u w=6u l=1u
X234 VSS iqmod_mfb_lpf_pex_half_1.iqmod_mfb_lpf_pex_ota_core_hybrid_bm_half_0.iqmod_mfb_lpf_pex_ota_core_inv_NF20$1_0.vout iqmod_mfb_lpf_pex_half_1.iqmod_mfb_lpf_pex_ota_core_hybrid_bm_half_0.iqmod_mfb_lpf_pex_ota_core_inv_NF6$1_1.vout VSS sg13_lv_nmos ad=0.19p pd=1.38u as=0.19p ps=1.38u w=1u l=1u
X235 VSS voutn iqmod_mfb_lpf_pex_half_1.iqmod_mfb_lpf_pex_ota_core_hybrid_bm_half_0.iqmod_mfb_lpf_pex_ota_core_inv_NF20$1_0.vout VSS sg13_lv_nmos ad=0.19p pd=1.38u as=0.19p ps=1.38u w=1u l=1u
X236 iqmod_mfb_lpf_pex_half_1.iqmod_mfb_lpf_pex_ota_core_hybrid_bm_half_0.iqmod_mfb_lpf_pex_ota_core_tg$1_0.v_a iqmod_mfb_lpf_pex_half_0.iqmod_mfb_lpf_pex_ota_core_hybrid_bm_half_0.iqmod_mfb_lpf_pex_ota_core_inv_NF20$1_1.vin VDD VDD sg13_lv_pmos ad=1.14p pd=6.38u as=1.14p ps=6.38u w=6u l=1u
X237 VDD voutn iqmod_mfb_lpf_pex_half_1.iqmod_mfb_lpf_pex_ota_core_hybrid_bm_half_0.iqmod_mfb_lpf_pex_ota_core_inv_NF20$1_0.vout VDD sg13_lv_pmos ad=1.14p pd=6.38u as=1.14p ps=6.38u w=6u l=1u
X238 iqmod_mfb_lpf_pex_half_1.iqmod_mfb_lpf_pex_ota_core_hybrid_bm_half_0.iqmod_mfb_lpf_pex_ota_core_inv_NF6$1_1.vout di_filter_en iqmod_mfb_lpf_pex_half_1.iqmod_mfb_lpf_pex_ota_core_hybrid_bm_half_0.iqmod_mfb_lpf_pex_ota_core_inv_NF20$1_0.vout VSS sg13_lv_nmos ad=0.19p pd=1.38u as=0.34p ps=2.68u w=1u l=0.13u
X239 VSS VSS VSS rhigh l=31u w=0.5u
X240 iqmod_mfb_lpf_pex_half_1.iqmod_mfb_lpf_pex_ota_core_hybrid_bm_half_0.iqmod_mfb_lpf_pex_ota_core_tg$1_0.v_a di_filter_en iqmod_mfb_lpf_pex_half_1.iqmod_mfb_lpf_pex_ota_core_hybrid_bm_half_0.iqmod_mfb_lpf_pex_ota_core_tg$1_0.v_b VSS sg13_lv_nmos ad=0.19p pd=1.38u as=0.19p ps=1.38u w=1u l=0.13u
X241 VSS VSS VSS rhigh l=60u w=0.5u
X242 voutn iqmod_mfb_lpf_pex_half_0.iqmod_mfb_lpf_pex_ota_core_hybrid_bm_half_0.iqmod_mfb_lpf_pex_ota_core_inv_NF20$1_1.vin VDD VDD sg13_lv_pmos ad=1.14p pd=6.38u as=1.14p ps=6.38u w=6u l=1u
X243 iqmod_mfb_lpf_pex_half_1.iqmod_mfb_lpf_pex_R1_0.v_b iqmod_mfb_lpf_pex_half_1.C1_half cap_cmim l=8u w=8u
X244 VSS iqmod_mfb_lpf_pex_half_1.iqmod_mfb_lpf_pex_ota_core_hybrid_bm_half_0.iqmod_mfb_lpf_pex_ota_core_tg$1_0.v_b voutp VSS sg13_lv_nmos ad=0.19p pd=1.38u as=0.19p ps=1.38u w=1u l=1u
X245 VSS VSS VSS VSS sg13_lv_nmos ad=0.34p pd=2.68u as=0 ps=0 w=1u l=1u
X246 vinp iqmod_mfb_lpf_pex_half_0.iqmod_mfb_lpf_pex_ota_core_hybrid_bm_half_0.iqmod_mfb_lpf_pex_ota_core_tg$1_0.di_tg_ctrl_n iqmod_mfb_lpf_pex_half_0.iqmod_mfb_lpf_pex_ota_core_hybrid_bm_half_0.iqmod_mfb_lpf_pex_ota_core_inv_NF20$1_1.vin VDD sg13_lv_pmos ad=2.04p pd=12.68u as=1.14p ps=6.38u w=6u l=0.13u
X247 iqmod_mfb_lpf_pex_half_1.iqmod_mfb_lpf_pex_ota_core_hybrid_bm_half_0.iqmod_mfb_lpf_pex_ota_core_tg$1_0.v_b iqmod_mfb_lpf_pex_half_0.iqmod_mfb_lpf_pex_ota_core_hybrid_bm_half_0.iqmod_mfb_lpf_pex_ota_core_tg$1_0.di_tg_ctrl_n iqmod_mfb_lpf_pex_half_1.iqmod_mfb_lpf_pex_ota_core_hybrid_bm_half_0.iqmod_mfb_lpf_pex_ota_core_tg$1_0.v_a VDD sg13_lv_pmos ad=1.14p pd=6.38u as=1.14p ps=6.38u w=6u l=0.13u
X248 iqmod_mfb_lpf_pex_half_1.iqmod_mfb_lpf_pex_ota_core_hybrid_bm_half_0.iqmod_mfb_lpf_pex_ota_core_tg$1_0.v_a iqmod_mfb_lpf_pex_half_0.iqmod_mfb_lpf_pex_ota_core_hybrid_bm_half_0.iqmod_mfb_lpf_pex_ota_core_tg$1_0.di_tg_ctrl_n iqmod_mfb_lpf_pex_half_1.iqmod_mfb_lpf_pex_ota_core_hybrid_bm_half_0.iqmod_mfb_lpf_pex_ota_core_tg$1_0.v_b VDD sg13_lv_pmos ad=1.14p pd=6.38u as=1.14p ps=6.38u w=6u l=0.13u
X249 VDD voutp iqmod_mfb_lpf_pex_half_1.iqmod_mfb_lpf_pex_ota_core_hybrid_bm_half_0.iqmod_mfb_lpf_pex_ota_core_inv_NF20$1_0.vout VDD sg13_lv_pmos ad=1.14p pd=6.38u as=1.14p ps=6.38u w=6u l=1u
X250 VDD iqmod_mfb_lpf_pex_half_1.iqmod_mfb_lpf_pex_ota_core_hybrid_bm_half_0.iqmod_mfb_lpf_pex_ota_core_inv_NF6$1_1.vout iqmod_mfb_lpf_pex_half_1.iqmod_mfb_lpf_pex_ota_core_hybrid_bm_half_0.iqmod_mfb_lpf_pex_ota_core_tg$1_0.v_b VDD sg13_lv_pmos ad=1.14p pd=6.38u as=1.14p ps=6.38u w=6u l=1u
X251 voutp iqmod_mfb_lpf_pex_half_1.iqmod_mfb_lpf_pex_ota_core_hybrid_bm_half_0.iqmod_mfb_lpf_pex_ota_core_inv_NF20$1_1.vin VSS VSS sg13_lv_nmos ad=0.19p pd=1.38u as=0.19p ps=1.38u w=1u l=1u
X252 vinn iqmod_mfb_lpf_pex_half_1.iqmod_mfb_lpf_pex_ota_core_hybrid_bm_half_0.iqmod_mfb_lpf_pex_ota_core_spdt_switch$1_0.iqmod_mfb_lpf_pex_ota_core_spdt_switch_inv$2_0.vout iqmod_mfb_lpf_pex_half_1.iqmod_mfb_lpf_pex_ota_core_hybrid_bm_half_0.iqmod_mfb_lpf_pex_ota_core_inv_NF20$1_1.vin VSS sg13_lv_nmos ad=0.19p pd=1.38u as=0.19p ps=1.38u w=1u l=0.13u
X253 voutn iqmod_mfb_lpf_pex_half_0.iqmod_mfb_lpf_pex_ota_core_hybrid_bm_half_0.iqmod_mfb_lpf_pex_ota_core_inv_NF20$1_1.vin VSS VSS sg13_lv_nmos ad=0.19p pd=1.38u as=0.19p ps=1.38u w=1u l=1u
X254 VSS iqmod_mfb_lpf_pex_half_1.iqmod_mfb_lpf_pex_ota_core_hybrid_bm_half_0.iqmod_mfb_lpf_pex_ota_core_tg$1_0.v_b voutn VSS sg13_lv_nmos ad=0.19p pd=1.38u as=0.19p ps=1.38u w=1u l=1u
X255 iqmod_mfb_lpf_pex_half_1.iqmod_mfb_lpf_pex_ota_core_hybrid_bm_half_0.iqmod_mfb_lpf_pex_ota_core_tg$1_0.v_a iqmod_mfb_lpf_pex_half_1.iqmod_mfb_lpf_pex_ota_core_hybrid_bm_half_0.iqmod_mfb_lpf_pex_ota_core_inv_NF20$1_1.vin VSS VSS sg13_lv_nmos ad=0.19p pd=1.38u as=0.19p ps=1.38u w=1u l=1u
X256 iqmod_mfb_lpf_pex_half_0.iqmod_mfb_lpf_pex_ota_core_hybrid_bm_half_0.iqmod_mfb_lpf_pex_ota_core_inv_NF20$1_1.vin iqmod_mfb_lpf_pex_half_0.iqmod_mfb_lpf_pex_ota_core_hybrid_bm_half_0.iqmod_mfb_lpf_pex_ota_core_tg$1_0.di_tg_ctrl_n VDD VSS sg13_lv_nmos ad=0.19p pd=1.38u as=0.19p ps=1.38u w=1u l=0.13u
X257 VSS iqmod_mfb_lpf_pex_half_1.iqmod_mfb_lpf_pex_ota_core_hybrid_bm_half_0.iqmod_mfb_lpf_pex_ota_core_inv_NF20$1_1.vin voutp VSS sg13_lv_nmos ad=0.19p pd=1.38u as=0.19p ps=1.38u w=1u l=1u
X258 a_6620_3903# iqmod_mfb_lpf_pex_half_1.C2_half VSS rhigh l=31u w=0.5u
X259 VDD voutp iqmod_mfb_lpf_pex_half_1.iqmod_mfb_lpf_pex_ota_core_hybrid_bm_half_0.iqmod_mfb_lpf_pex_ota_core_inv_NF20$1_0.vout VDD sg13_lv_pmos ad=1.14p pd=6.38u as=1.14p ps=6.38u w=6u l=1u
X260 VSS VSS VSS VSS sg13_lv_nmos ad=0.19p pd=1.38u as=0 ps=0 w=1u l=1u
X261 VSS iqmod_mfb_lpf_pex_half_1.iqmod_mfb_lpf_pex_ota_core_hybrid_bm_half_0.iqmod_mfb_lpf_pex_ota_core_inv_NF20$1_1.vin iqmod_mfb_lpf_pex_half_1.iqmod_mfb_lpf_pex_ota_core_hybrid_bm_half_0.iqmod_mfb_lpf_pex_ota_core_tg$1_0.v_a VSS sg13_lv_nmos ad=0.19p pd=1.38u as=0.19p ps=1.38u w=1u l=1u
X262 VDD iqmod_mfb_lpf_pex_half_1.iqmod_mfb_lpf_pex_ota_core_hybrid_bm_half_0.iqmod_mfb_lpf_pex_ota_core_tg$1_0.v_b voutp VDD sg13_lv_pmos ad=1.14p pd=6.38u as=1.14p ps=6.38u w=6u l=1u
X263 VDD VDD VDD VDD sg13_lv_pmos ad=2.04p pd=12.68u as=0 ps=0 w=6u l=1u
X264 iqmod_mfb_lpf_pex_half_1.iqmod_mfb_lpf_pex_ota_core_hybrid_bm_half_0.iqmod_mfb_lpf_pex_ota_core_inv_NF20$1_0.vout voutn VDD VDD sg13_lv_pmos ad=1.14p pd=6.38u as=1.14p ps=6.38u w=6u l=1u
X265 iqmod_mfb_lpf_pex_half_1.iqmod_mfb_lpf_pex_ota_core_hybrid_bm_half_0.iqmod_mfb_lpf_pex_ota_core_inv_NF20$1_0.vout voutp VDD VDD sg13_lv_pmos ad=1.14p pd=6.38u as=1.14p ps=6.38u w=6u l=1u
X266 iqmod_mfb_lpf_pex_half_1.iqmod_mfb_lpf_pex_ota_core_hybrid_bm_half_0.iqmod_mfb_lpf_pex_ota_core_tg$1_0.v_b iqmod_mfb_lpf_pex_half_1.iqmod_mfb_lpf_pex_ota_core_hybrid_bm_half_0.iqmod_mfb_lpf_pex_ota_core_inv_NF6$1_1.vout VDD VDD sg13_lv_pmos ad=1.14p pd=6.38u as=1.14p ps=6.38u w=6u l=1u
X267 VSS VSS VSS rhigh l=59u w=0.5u
X268 VSS voutn iqmod_mfb_lpf_pex_half_1.iqmod_mfb_lpf_pex_ota_core_hybrid_bm_half_0.iqmod_mfb_lpf_pex_ota_core_inv_NF20$1_0.vout VSS sg13_lv_nmos ad=0.19p pd=1.38u as=0.19p ps=1.38u w=1u l=1u
X269 voutn iqmod_mfb_lpf_pex_half_0.iqmod_mfb_lpf_pex_ota_core_hybrid_bm_half_0.iqmod_mfb_lpf_pex_ota_core_inv_NF20$1_1.vin VDD VDD sg13_lv_pmos ad=1.14p pd=6.38u as=1.14p ps=6.38u w=6u l=1u
X270 VDD iqmod_mfb_lpf_pex_half_1.iqmod_mfb_lpf_pex_ota_core_hybrid_bm_half_0.iqmod_mfb_lpf_pex_ota_core_inv_NF20$1_1.vin voutp VDD sg13_lv_pmos ad=1.14p pd=6.38u as=1.14p ps=6.38u w=6u l=1u
X271 VSS iqmod_mfb_lpf_pex_half_0.iqmod_mfb_lpf_pex_ota_core_hybrid_bm_half_0.iqmod_mfb_lpf_pex_ota_core_inv_NF20$1_1.vin iqmod_mfb_lpf_pex_half_1.iqmod_mfb_lpf_pex_ota_core_hybrid_bm_half_0.iqmod_mfb_lpf_pex_ota_core_tg$1_0.v_a VSS sg13_lv_nmos ad=0.19p pd=1.38u as=0.19p ps=1.38u w=1u l=1u
X272 iqmod_mfb_lpf_pex_half_1.iqmod_mfb_lpf_pex_ota_core_hybrid_bm_half_0.iqmod_mfb_lpf_pex_ota_core_tg$1_0.v_b di_filter_en iqmod_mfb_lpf_pex_half_1.iqmod_mfb_lpf_pex_ota_core_hybrid_bm_half_0.iqmod_mfb_lpf_pex_ota_core_tg$1_0.v_a VSS sg13_lv_nmos ad=0.19p pd=1.38u as=0.19p ps=1.38u w=1u l=0.13u
X273 iqmod_mfb_lpf_pex_half_1.iqmod_mfb_lpf_pex_ota_core_hybrid_bm_half_0.iqmod_mfb_lpf_pex_ota_core_inv_NF6$1_1.vout iqmod_mfb_lpf_pex_half_0.iqmod_mfb_lpf_pex_ota_core_hybrid_bm_half_0.iqmod_mfb_lpf_pex_ota_core_tg$1_0.di_tg_ctrl_n iqmod_mfb_lpf_pex_half_1.iqmod_mfb_lpf_pex_ota_core_hybrid_bm_half_0.iqmod_mfb_lpf_pex_ota_core_inv_NF20$1_0.vout VDD sg13_lv_pmos ad=1.14p pd=6.38u as=1.14p ps=6.38u w=6u l=0.13u
X274 iqmod_mfb_lpf_pex_half_1.iqmod_mfb_lpf_pex_ota_core_hybrid_bm_half_0.iqmod_mfb_lpf_pex_ota_core_inv_NF20$1_0.vout voutn VSS VSS sg13_lv_nmos ad=0.19p pd=1.38u as=0.19p ps=1.38u w=1u l=1u
X275 iqmod_mfb_lpf_pex_half_1.iqmod_mfb_lpf_pex_ota_core_hybrid_bm_half_0.iqmod_mfb_lpf_pex_ota_core_tg$1_0.v_b iqmod_mfb_lpf_pex_half_1.iqmod_mfb_lpf_pex_ota_core_hybrid_bm_half_0.iqmod_mfb_lpf_pex_ota_core_tg$1_0.v_a VSS VSS sg13_lv_nmos ad=0.19p pd=1.38u as=0.19p ps=1.38u w=1u l=1u
X276 iqmod_mfb_lpf_pex_half_1.iqmod_mfb_lpf_pex_ota_core_hybrid_bm_half_0.iqmod_mfb_lpf_pex_ota_core_tg$1_0.v_a iqmod_mfb_lpf_pex_half_0.iqmod_mfb_lpf_pex_ota_core_hybrid_bm_half_0.iqmod_mfb_lpf_pex_ota_core_inv_NF20$1_1.vin VSS VSS sg13_lv_nmos ad=0.19p pd=1.38u as=0.19p ps=1.38u w=1u l=1u
X277 iqmod_mfb_lpf_pex_half_1.iqmod_mfb_lpf_pex_ota_core_hybrid_bm_half_0.iqmod_mfb_lpf_pex_ota_core_inv_NF6$1_1.vout iqmod_mfb_lpf_pex_half_1.iqmod_mfb_lpf_pex_ota_core_hybrid_bm_half_0.iqmod_mfb_lpf_pex_ota_core_inv_NF20$1_0.vout VSS VSS sg13_lv_nmos ad=0.19p pd=1.38u as=0.19p ps=1.38u w=1u l=1u
X278 VDD voutp iqmod_mfb_lpf_pex_half_1.iqmod_mfb_lpf_pex_ota_core_hybrid_bm_half_0.iqmod_mfb_lpf_pex_ota_core_inv_NF20$1_0.vout VDD sg13_lv_pmos ad=1.14p pd=6.38u as=1.14p ps=6.38u w=6u l=1u
X279 iqmod_mfb_lpf_pex_half_1.iqmod_mfb_lpf_pex_ota_core_hybrid_bm_half_0.iqmod_mfb_lpf_pex_ota_core_tg$1_0.v_b iqmod_mfb_lpf_pex_half_1.iqmod_mfb_lpf_pex_ota_core_hybrid_bm_half_0.iqmod_mfb_lpf_pex_ota_core_tg$1_0.v_a VDD VDD sg13_lv_pmos ad=1.14p pd=6.38u as=1.14p ps=6.38u w=6u l=1u
X280 VSS VSS VSS VSS sg13_lv_nmos ad=0.34p pd=2.68u as=0 ps=0 w=1u l=1u
X281 iqmod_mfb_lpf_pex_half_1.iqmod_mfb_lpf_pex_ota_core_hybrid_bm_half_0.iqmod_mfb_lpf_pex_ota_core_tg$1_0.v_b iqmod_mfb_lpf_pex_half_1.iqmod_mfb_lpf_pex_ota_core_hybrid_bm_half_0.iqmod_mfb_lpf_pex_ota_core_inv_NF6$1_1.vout VSS VSS sg13_lv_nmos ad=0.19p pd=1.38u as=0.19p ps=1.38u w=1u l=1u
X282 VDD iqmod_mfb_lpf_pex_half_0.iqmod_mfb_lpf_pex_ota_core_hybrid_bm_half_0.iqmod_mfb_lpf_pex_ota_core_spdt_switch$1_0.iqmod_mfb_lpf_pex_ota_core_spdt_switch_inv$2_0.vout iqmod_mfb_lpf_pex_half_0.iqmod_mfb_lpf_pex_ota_core_hybrid_bm_half_0.iqmod_mfb_lpf_pex_ota_core_inv_NF20$1_1.vin VDD sg13_lv_pmos ad=2.04p pd=12.68u as=1.14p ps=6.38u w=6u l=0.13u
X283 VSS iqmod_mfb_lpf_pex_half_1.iqmod_mfb_lpf_pex_ota_core_hybrid_bm_half_0.iqmod_mfb_lpf_pex_ota_core_inv_NF20$1_0.vout iqmod_mfb_lpf_pex_half_1.iqmod_mfb_lpf_pex_ota_core_hybrid_bm_half_0.iqmod_mfb_lpf_pex_ota_core_inv_NF6$1_1.vout VSS sg13_lv_nmos ad=0.19p pd=1.38u as=0.19p ps=1.38u w=1u l=1u
X284 VSS iqmod_mfb_lpf_pex_half_0.iqmod_mfb_lpf_pex_ota_core_hybrid_bm_half_0.iqmod_mfb_lpf_pex_ota_core_inv_NF20$1_1.vin voutn VSS sg13_lv_nmos ad=0.19p pd=1.38u as=0.19p ps=1.38u w=1u l=1u
X285 iqmod_mfb_lpf_pex_half_1.iqmod_mfb_lpf_pex_ota_core_hybrid_bm_half_0.iqmod_mfb_lpf_pex_ota_core_inv_NF20$1_0.vout voutp VSS VSS sg13_lv_nmos ad=0.19p pd=1.38u as=0.19p ps=1.38u w=1u l=1u
X286 VDD iqmod_mfb_lpf_pex_half_1.iqmod_mfb_lpf_pex_ota_core_hybrid_bm_half_0.iqmod_mfb_lpf_pex_ota_core_tg$1_0.v_a iqmod_mfb_lpf_pex_half_1.iqmod_mfb_lpf_pex_ota_core_hybrid_bm_half_0.iqmod_mfb_lpf_pex_ota_core_tg$1_0.v_b VDD sg13_lv_pmos ad=1.14p pd=6.38u as=1.14p ps=6.38u w=6u l=1u
X287 iqmod_mfb_lpf_pex_half_1.iqmod_mfb_lpf_pex_ota_core_hybrid_bm_half_0.iqmod_mfb_lpf_pex_ota_core_inv_NF20$1_0.vout voutn VSS VSS sg13_lv_nmos ad=0.19p pd=1.38u as=0.19p ps=1.38u w=1u l=1u
X288 VDD iqmod_mfb_lpf_pex_half_0.iqmod_mfb_lpf_pex_ota_core_hybrid_bm_half_0.iqmod_mfb_lpf_pex_ota_core_tg$1_0.di_tg_ctrl_n iqmod_mfb_lpf_pex_half_0.iqmod_mfb_lpf_pex_ota_core_hybrid_bm_half_0.iqmod_mfb_lpf_pex_ota_core_inv_NF20$1_1.vin VSS sg13_lv_nmos ad=0.34p pd=2.68u as=0.19p ps=1.38u w=1u l=0.13u
X289 VDD voutn iqmod_mfb_lpf_pex_half_1.iqmod_mfb_lpf_pex_ota_core_hybrid_bm_half_0.iqmod_mfb_lpf_pex_ota_core_inv_NF20$1_0.vout VDD sg13_lv_pmos ad=1.14p pd=6.38u as=1.14p ps=6.38u w=6u l=1u
X290 iqmod_mfb_lpf_pex_half_0.iqmod_mfb_lpf_pex_ota_core_hybrid_bm_half_0.iqmod_mfb_lpf_pex_ota_core_inv_NF20$1_1.vin iqmod_mfb_lpf_pex_half_0.iqmod_mfb_lpf_pex_ota_core_hybrid_bm_half_0.iqmod_mfb_lpf_pex_ota_core_tg$1_0.di_tg_ctrl_n VDD VSS sg13_lv_nmos ad=0.19p pd=1.38u as=0.34p ps=2.68u w=1u l=0.13u
X291 iqmod_mfb_lpf_pex_half_1.iqmod_mfb_lpf_pex_ota_core_hybrid_bm_half_0.iqmod_mfb_lpf_pex_ota_core_inv_NF6$1_1.vout iqmod_mfb_lpf_pex_half_1.iqmod_mfb_lpf_pex_ota_core_hybrid_bm_half_0.iqmod_mfb_lpf_pex_ota_core_inv_NF20$1_0.vout VSS VSS sg13_lv_nmos ad=0.19p pd=1.38u as=0.19p ps=1.38u w=1u l=1u
X292 VSS voutp iqmod_mfb_lpf_pex_half_1.iqmod_mfb_lpf_pex_ota_core_hybrid_bm_half_0.iqmod_mfb_lpf_pex_ota_core_inv_NF20$1_0.vout VSS sg13_lv_nmos ad=0.19p pd=1.38u as=0.19p ps=1.38u w=1u l=1u
X293 VDD di_filter_en iqmod_mfb_lpf_pex_half_0.iqmod_mfb_lpf_pex_ota_core_hybrid_bm_half_0.iqmod_mfb_lpf_pex_ota_core_tg$1_0.di_tg_ctrl_n VDD sg13_lv_pmos ad=1.14p pd=6.38u as=1.14p ps=6.38u w=6u l=0.13u
X294 voutn iqmod_mfb_lpf_pex_half_0.iqmod_mfb_lpf_pex_ota_core_hybrid_bm_half_0.iqmod_mfb_lpf_pex_ota_core_inv_NF20$1_1.vin VDD VDD sg13_lv_pmos ad=1.14p pd=6.38u as=1.14p ps=6.38u w=6u l=1u
X295 VDD iqmod_mfb_lpf_pex_half_0.iqmod_mfb_lpf_pex_ota_core_hybrid_bm_half_0.iqmod_mfb_lpf_pex_ota_core_spdt_switch$1_0.iqmod_mfb_lpf_pex_ota_core_spdt_switch_inv$2_0.vout iqmod_mfb_lpf_pex_half_0.iqmod_mfb_lpf_pex_ota_core_hybrid_bm_half_0.iqmod_mfb_lpf_pex_ota_core_inv_NF20$1_1.vin VDD sg13_lv_pmos ad=1.14p pd=6.38u as=1.14p ps=6.38u w=6u l=0.13u
X296 VSS VSS VSS rhigh l=60u w=0.5u
X297 iqmod_mfb_lpf_pex_half_1.iqmod_mfb_lpf_pex_ota_core_hybrid_bm_half_0.iqmod_mfb_lpf_pex_ota_core_inv_NF20$1_0.vout voutp VDD VDD sg13_lv_pmos ad=1.14p pd=6.38u as=1.14p ps=6.38u w=6u l=1u
X298 VDD iqmod_mfb_lpf_pex_half_1.iqmod_mfb_lpf_pex_ota_core_hybrid_bm_half_0.iqmod_mfb_lpf_pex_ota_core_tg$1_0.di_tg_ctrl_n iqmod_mfb_lpf_pex_half_1.iqmod_mfb_lpf_pex_ota_core_hybrid_bm_half_0.iqmod_mfb_lpf_pex_ota_core_inv_NF20$1_1.vin VSS sg13_lv_nmos ad=0.19p pd=1.38u as=0.19p ps=1.38u w=1u l=0.13u
X299 voutp iqmod_mfb_lpf_pex_half_1.iqmod_mfb_lpf_pex_ota_core_hybrid_bm_half_0.iqmod_mfb_lpf_pex_ota_core_tg$1_0.v_b VSS VSS sg13_lv_nmos ad=0.19p pd=1.38u as=0.19p ps=1.38u w=1u l=1u
X300 iqmod_mfb_lpf_pex_half_1.iqmod_mfb_lpf_pex_ota_core_hybrid_bm_half_0.iqmod_mfb_lpf_pex_ota_core_tg$1_0.v_a di_filter_en iqmod_mfb_lpf_pex_half_1.iqmod_mfb_lpf_pex_ota_core_hybrid_bm_half_0.iqmod_mfb_lpf_pex_ota_core_tg$1_0.v_b VSS sg13_lv_nmos ad=0.34p pd=2.68u as=0.19p ps=1.38u w=1u l=0.13u
X301 VDD VDD VDD VDD sg13_lv_pmos ad=1.14p pd=6.38u as=0 ps=0 w=6u l=1u
X302 iqmod_mfb_lpf_pex_half_1.iqmod_mfb_lpf_pex_ota_core_hybrid_bm_half_0.iqmod_mfb_lpf_pex_ota_core_tg$1_0.v_b di_filter_en iqmod_mfb_lpf_pex_half_1.iqmod_mfb_lpf_pex_ota_core_hybrid_bm_half_0.iqmod_mfb_lpf_pex_ota_core_tg$1_0.v_a VSS sg13_lv_nmos ad=0.19p pd=1.38u as=0.34p ps=2.68u w=1u l=0.13u
X303 iqmod_mfb_lpf_pex_half_1.iqmod_mfb_lpf_pex_ota_core_hybrid_bm_half_0.iqmod_mfb_lpf_pex_ota_core_inv_NF20$1_0.vout voutn VDD VDD sg13_lv_pmos ad=1.14p pd=6.38u as=1.14p ps=6.38u w=6u l=1u
X304 iqmod_mfb_lpf_pex_half_0.iqmod_mfb_lpf_pex_ota_core_hybrid_bm_half_0.iqmod_mfb_lpf_pex_ota_core_inv_NF20$1_1.vin iqmod_mfb_lpf_pex_half_0.iqmod_mfb_lpf_pex_ota_core_hybrid_bm_half_0.iqmod_mfb_lpf_pex_ota_core_spdt_switch$1_0.iqmod_mfb_lpf_pex_ota_core_spdt_switch_inv$2_0.vout vinp VSS sg13_lv_nmos ad=0.19p pd=1.38u as=0.19p ps=1.38u w=1u l=0.13u
X305 VDD iqmod_mfb_lpf_pex_half_1.iqmod_mfb_lpf_pex_ota_core_hybrid_bm_half_0.iqmod_mfb_lpf_pex_ota_core_inv_NF20$1_1.vin voutp VDD sg13_lv_pmos ad=1.14p pd=6.38u as=1.14p ps=6.38u w=6u l=1u
X306 voutn iqmod_mfb_lpf_pex_half_1.iqmod_mfb_lpf_pex_ota_core_hybrid_bm_half_0.iqmod_mfb_lpf_pex_ota_core_tg$1_0.v_b VSS VSS sg13_lv_nmos ad=0.19p pd=1.38u as=0.19p ps=1.38u w=1u l=1u
X307 voutn iqmod_mfb_lpf_pex_half_0.iqmod_mfb_lpf_pex_ota_core_hybrid_bm_half_0.iqmod_mfb_lpf_pex_ota_core_inv_NF20$1_1.vin VSS VSS sg13_lv_nmos ad=0.19p pd=1.38u as=0.19p ps=1.38u w=1u l=1u
X308 VDD iqmod_mfb_lpf_pex_half_1.iqmod_mfb_lpf_pex_ota_core_hybrid_bm_half_0.iqmod_mfb_lpf_pex_ota_core_tg$1_0.v_b voutn VDD sg13_lv_pmos ad=1.14p pd=6.38u as=1.14p ps=6.38u w=6u l=1u
X309 VSS iqmod_mfb_lpf_pex_half_1.iqmod_mfb_lpf_pex_ota_core_hybrid_bm_half_0.iqmod_mfb_lpf_pex_ota_core_tg$1_0.v_b voutn VSS sg13_lv_nmos ad=0.19p pd=1.38u as=0.19p ps=1.38u w=1u l=1u
X310 VSS VSS VSS VSS sg13_lv_nmos ad=0.34p pd=2.68u as=0 ps=0 w=1u l=0.13u
X311 VSS iqmod_mfb_lpf_pex_half_0.iqmod_mfb_lpf_pex_ota_core_hybrid_bm_half_0.iqmod_mfb_lpf_pex_ota_core_inv_NF20$1_1.vin iqmod_mfb_lpf_pex_half_1.iqmod_mfb_lpf_pex_ota_core_hybrid_bm_half_0.iqmod_mfb_lpf_pex_ota_core_tg$1_0.v_a VSS sg13_lv_nmos ad=0.19p pd=1.38u as=0.19p ps=1.38u w=1u l=1u
X312 voutn iqmod_mfb_lpf_pex_half_1.iqmod_mfb_lpf_pex_ota_core_hybrid_bm_half_0.iqmod_mfb_lpf_pex_ota_core_tg$1_0.v_b VDD VDD sg13_lv_pmos ad=1.14p pd=6.38u as=1.14p ps=6.38u w=6u l=1u
X313 VDD iqmod_mfb_lpf_pex_half_1.iqmod_mfb_lpf_pex_ota_core_hybrid_bm_half_0.iqmod_mfb_lpf_pex_ota_core_tg$1_0.v_b voutp VDD sg13_lv_pmos ad=1.14p pd=6.38u as=1.14p ps=6.38u w=6u l=1u
X314 VSS voutp iqmod_mfb_lpf_pex_half_1.iqmod_mfb_lpf_pex_ota_core_hybrid_bm_half_0.iqmod_mfb_lpf_pex_ota_core_inv_NF20$1_0.vout VSS sg13_lv_nmos ad=0.19p pd=1.38u as=0.19p ps=1.38u w=1u l=1u
X315 voutp iqmod_mfb_lpf_pex_half_1.iqmod_mfb_lpf_pex_ota_core_hybrid_bm_half_0.iqmod_mfb_lpf_pex_ota_core_inv_NF20$1_1.vin VSS VSS sg13_lv_nmos ad=0.19p pd=1.38u as=0.19p ps=1.38u w=1u l=1u
X316 iqmod_mfb_lpf_pex_half_1.iqmod_mfb_lpf_pex_ota_core_hybrid_bm_half_0.iqmod_mfb_lpf_pex_ota_core_tg$1_0.v_b iqmod_mfb_lpf_pex_half_1.iqmod_mfb_lpf_pex_ota_core_hybrid_bm_half_0.iqmod_mfb_lpf_pex_ota_core_tg$1_0.v_a VSS VSS sg13_lv_nmos ad=0.19p pd=1.38u as=0.19p ps=1.38u w=1u l=1u
X317 iqmod_mfb_lpf_pex_half_1.iqmod_mfb_lpf_pex_ota_core_hybrid_bm_half_0.iqmod_mfb_lpf_pex_ota_core_inv_NF20$1_0.vout voutn VSS VSS sg13_lv_nmos ad=0.19p pd=1.38u as=0.19p ps=1.38u w=1u l=1u
X318 VDD VDD VDD VDD sg13_lv_pmos ad=2.04p pd=12.68u as=0 ps=0 w=6u l=1u
X319 iqmod_mfb_lpf_pex_half_0.iqmod_mfb_lpf_pex_ota_core_hybrid_bm_half_0.iqmod_mfb_lpf_pex_ota_core_tg$1_0.di_tg_ctrl_n di_filter_en VSS VSS sg13_lv_nmos ad=0.19p pd=1.38u as=0.19p ps=1.38u w=1u l=0.13u
X320 voutp iqmod_mfb_lpf_pex_half_1.iqmod_mfb_lpf_pex_ota_core_hybrid_bm_half_0.iqmod_mfb_lpf_pex_ota_core_inv_NF20$1_1.vin VDD VDD sg13_lv_pmos ad=1.14p pd=6.38u as=1.14p ps=6.38u w=6u l=1u
X321 iqmod_mfb_lpf_pex_half_1.iqmod_mfb_lpf_pex_ota_core_hybrid_bm_half_0.iqmod_mfb_lpf_pex_ota_core_tg$1_0.v_a iqmod_mfb_lpf_pex_half_1.iqmod_mfb_lpf_pex_ota_core_hybrid_bm_half_0.iqmod_mfb_lpf_pex_ota_core_inv_NF20$1_1.vin VSS VSS sg13_lv_nmos ad=0.19p pd=1.38u as=0.19p ps=1.38u w=1u l=1u
X322 voutn iqmod_mfb_lpf_pex_half_0.iqmod_mfb_lpf_pex_ota_core_hybrid_bm_half_0.iqmod_mfb_lpf_pex_ota_core_inv_NF20$1_1.vin VSS VSS sg13_lv_nmos ad=0.19p pd=1.38u as=0.19p ps=1.38u w=1u l=1u
X323 vinn iqmod_mfb_lpf_pex_half_1.iqmod_mfb_lpf_pex_ota_core_hybrid_bm_half_0.iqmod_mfb_lpf_pex_ota_core_tg$1_0.di_tg_ctrl_n iqmod_mfb_lpf_pex_half_1.iqmod_mfb_lpf_pex_ota_core_hybrid_bm_half_0.iqmod_mfb_lpf_pex_ota_core_inv_NF20$1_1.vin VDD sg13_lv_pmos ad=1.14p pd=6.38u as=1.14p ps=6.38u w=6u l=0.13u
X324 a_6620_3903# a_12906_4203# VSS rhigh l=31u w=0.5u
X325 VSS voutn iqmod_mfb_lpf_pex_half_1.iqmod_mfb_lpf_pex_ota_core_hybrid_bm_half_0.iqmod_mfb_lpf_pex_ota_core_inv_NF20$1_0.vout VSS sg13_lv_nmos ad=0.19p pd=1.38u as=0.19p ps=1.38u w=1u l=1u
X326 iqmod_mfb_lpf_pex_half_1.iqmod_mfb_lpf_pex_ota_core_hybrid_bm_half_0.iqmod_mfb_lpf_pex_ota_core_tg$1_0.v_a iqmod_mfb_lpf_pex_half_1.iqmod_mfb_lpf_pex_ota_core_hybrid_bm_half_0.iqmod_mfb_lpf_pex_ota_core_inv_NF20$1_1.vin VDD VDD sg13_lv_pmos ad=1.14p pd=6.38u as=1.14p ps=6.38u w=6u l=1u
X327 VDD voutp iqmod_mfb_lpf_pex_half_1.iqmod_mfb_lpf_pex_ota_core_hybrid_bm_half_0.iqmod_mfb_lpf_pex_ota_core_inv_NF20$1_0.vout VDD sg13_lv_pmos ad=1.14p pd=6.38u as=1.14p ps=6.38u w=6u l=1u
X328 iqmod_mfb_lpf_pex_half_1.iqmod_mfb_lpf_pex_ota_core_hybrid_bm_half_0.iqmod_mfb_lpf_pex_ota_core_tg$1_0.v_b iqmod_mfb_lpf_pex_half_1.iqmod_mfb_lpf_pex_ota_core_hybrid_bm_half_0.iqmod_mfb_lpf_pex_ota_core_inv_NF6$1_1.vout VDD VDD sg13_lv_pmos ad=1.14p pd=6.38u as=1.14p ps=6.38u w=6u l=1u
X329 VSS VSS VSS VSS sg13_lv_nmos ad=0.34p pd=2.68u as=0 ps=0 w=1u l=1u
X330 iqmod_mfb_lpf_pex_half_1.iqmod_mfb_lpf_pex_R2_0.v_a iqmod_mfb_lpf_pex_half_1.C2_half cap_cmim l=8u w=8u
X331 iqmod_mfb_lpf_pex_half_1.iqmod_mfb_lpf_pex_ota_core_hybrid_bm_half_0.iqmod_mfb_lpf_pex_ota_core_inv_NF20$1_0.vout voutp VDD VDD sg13_lv_pmos ad=1.14p pd=6.38u as=1.14p ps=6.38u w=6u l=1u
X332 iqmod_mfb_lpf_pex_half_1.C2_half a_37874_3903# VSS rhigh l=60u w=0.5u
X333 iqmod_mfb_lpf_pex_half_1.iqmod_mfb_lpf_pex_ota_core_hybrid_bm_half_0.iqmod_mfb_lpf_pex_ota_core_inv_NF6$1_1.vout iqmod_mfb_lpf_pex_half_1.iqmod_mfb_lpf_pex_ota_core_hybrid_bm_half_0.iqmod_mfb_lpf_pex_ota_core_tg$1_0.di_tg_ctrl_n iqmod_mfb_lpf_pex_half_1.iqmod_mfb_lpf_pex_ota_core_hybrid_bm_half_0.iqmod_mfb_lpf_pex_ota_core_inv_NF20$1_0.vout VDD sg13_lv_pmos ad=1.14p pd=6.38u as=1.14p ps=6.38u w=6u l=0.13u
X334 VSS VSS VSS VSS sg13_lv_nmos ad=0.34p pd=2.68u as=0 ps=0 w=1u l=1u
X335 VSS iqmod_mfb_lpf_pex_half_1.iqmod_mfb_lpf_pex_ota_core_hybrid_bm_half_0.iqmod_mfb_lpf_pex_ota_core_inv_NF6$1_1.vout iqmod_mfb_lpf_pex_half_1.iqmod_mfb_lpf_pex_ota_core_hybrid_bm_half_0.iqmod_mfb_lpf_pex_ota_core_tg$1_0.v_b VSS sg13_lv_nmos ad=0.19p pd=1.38u as=0.19p ps=1.38u w=1u l=1u
X336 vinp iqmod_mfb_lpf_pex_half_0.iqmod_mfb_lpf_pex_ota_core_hybrid_bm_half_0.iqmod_mfb_lpf_pex_ota_core_spdt_switch$1_0.iqmod_mfb_lpf_pex_ota_core_spdt_switch_inv$2_0.vout iqmod_mfb_lpf_pex_half_0.iqmod_mfb_lpf_pex_ota_core_hybrid_bm_half_0.iqmod_mfb_lpf_pex_ota_core_inv_NF20$1_1.vin VSS sg13_lv_nmos ad=0.19p pd=1.38u as=0.19p ps=1.38u w=1u l=0.13u
X337 voutn iqmod_mfb_lpf_pex_half_0.iqmod_mfb_lpf_pex_ota_core_hybrid_bm_half_0.iqmod_mfb_lpf_pex_ota_core_inv_NF20$1_1.vin VSS VSS sg13_lv_nmos ad=0.19p pd=1.38u as=0.19p ps=1.38u w=1u l=1u
X338 voutn vinp cap_cmim l=8u w=8u
X339 VDD iqmod_mfb_lpf_pex_half_1.iqmod_mfb_lpf_pex_ota_core_hybrid_bm_half_0.iqmod_mfb_lpf_pex_ota_core_inv_NF20$1_1.vin voutp VDD sg13_lv_pmos ad=1.14p pd=6.38u as=1.14p ps=6.38u w=6u l=1u
X340 VDD iqmod_mfb_lpf_pex_half_1.iqmod_mfb_lpf_pex_ota_core_hybrid_bm_half_0.iqmod_mfb_lpf_pex_ota_core_spdt_switch$1_0.iqmod_mfb_lpf_pex_ota_core_spdt_switch_inv$2_0.vout iqmod_mfb_lpf_pex_half_1.iqmod_mfb_lpf_pex_ota_core_hybrid_bm_half_0.iqmod_mfb_lpf_pex_ota_core_inv_NF20$1_1.vin VDD sg13_lv_pmos ad=1.14p pd=6.38u as=1.14p ps=6.38u w=6u l=0.13u
X341 VDD VDD VDD VDD sg13_lv_pmos ad=2.04p pd=12.68u as=0 ps=0 w=6u l=0.13u
X342 iqmod_mfb_lpf_pex_half_1.iqmod_mfb_lpf_pex_ota_core_hybrid_bm_half_0.iqmod_mfb_lpf_pex_ota_core_tg$1_0.v_b iqmod_mfb_lpf_pex_half_1.iqmod_mfb_lpf_pex_ota_core_hybrid_bm_half_0.iqmod_mfb_lpf_pex_ota_core_tg$1_0.v_a VDD VDD sg13_lv_pmos ad=1.14p pd=6.38u as=1.14p ps=6.38u w=6u l=1u
X343 VDD iqmod_mfb_lpf_pex_half_1.iqmod_mfb_lpf_pex_ota_core_hybrid_bm_half_0.iqmod_mfb_lpf_pex_ota_core_inv_NF20$1_1.vin iqmod_mfb_lpf_pex_half_1.iqmod_mfb_lpf_pex_ota_core_hybrid_bm_half_0.iqmod_mfb_lpf_pex_ota_core_tg$1_0.v_a VDD sg13_lv_pmos ad=1.14p pd=6.38u as=1.14p ps=6.38u w=6u l=1u
X344 VSS voutp iqmod_mfb_lpf_pex_half_1.iqmod_mfb_lpf_pex_ota_core_hybrid_bm_half_0.iqmod_mfb_lpf_pex_ota_core_inv_NF20$1_0.vout VSS sg13_lv_nmos ad=0.19p pd=1.38u as=0.19p ps=1.38u w=1u l=1u
X345 vinn iqmod_mfb_lpf_pex_half_1.iqmod_mfb_lpf_pex_ota_core_hybrid_bm_half_0.iqmod_mfb_lpf_pex_ota_core_spdt_switch$1_0.iqmod_mfb_lpf_pex_ota_core_spdt_switch_inv$2_0.vout iqmod_mfb_lpf_pex_half_1.iqmod_mfb_lpf_pex_ota_core_hybrid_bm_half_0.iqmod_mfb_lpf_pex_ota_core_inv_NF20$1_1.vin VSS sg13_lv_nmos ad=0.19p pd=1.38u as=0.19p ps=1.38u w=1u l=0.13u
X346 VDD iqmod_mfb_lpf_pex_half_1.iqmod_mfb_lpf_pex_ota_core_hybrid_bm_half_0.iqmod_mfb_lpf_pex_ota_core_tg$1_0.v_b voutn VDD sg13_lv_pmos ad=1.14p pd=6.38u as=1.14p ps=6.38u w=6u l=1u
X347 VDD iqmod_mfb_lpf_pex_half_1.iqmod_mfb_lpf_pex_ota_core_hybrid_bm_half_0.iqmod_mfb_lpf_pex_ota_core_tg$1_0.v_b voutp VDD sg13_lv_pmos ad=1.14p pd=6.38u as=1.14p ps=6.38u w=6u l=1u
X348 VSS iqmod_mfb_lpf_pex_half_1.iqmod_mfb_lpf_pex_ota_core_hybrid_bm_half_0.iqmod_mfb_lpf_pex_ota_core_tg$1_0.di_tg_ctrl_n iqmod_mfb_lpf_pex_half_1.iqmod_mfb_lpf_pex_ota_core_hybrid_bm_half_0.iqmod_mfb_lpf_pex_ota_core_spdt_switch$1_0.iqmod_mfb_lpf_pex_ota_core_spdt_switch_inv$2_0.vout VSS sg13_lv_nmos ad=0.19p pd=1.38u as=0.19p ps=1.38u w=1u l=0.13u
X349 VDD iqmod_mfb_lpf_pex_half_1.iqmod_mfb_lpf_pex_ota_core_hybrid_bm_half_0.iqmod_mfb_lpf_pex_ota_core_tg$1_0.v_b voutn VDD sg13_lv_pmos ad=1.14p pd=6.38u as=1.14p ps=6.38u w=6u l=1u
X350 voutp iqmod_mfb_lpf_pex_half_1.iqmod_mfb_lpf_pex_ota_core_hybrid_bm_half_0.iqmod_mfb_lpf_pex_ota_core_inv_NF20$1_1.vin VDD VDD sg13_lv_pmos ad=1.14p pd=6.38u as=1.14p ps=6.38u w=6u l=1u
X351 VSS iqmod_mfb_lpf_pex_half_1.iqmod_mfb_lpf_pex_ota_core_hybrid_bm_half_0.iqmod_mfb_lpf_pex_ota_core_tg$1_0.v_b voutn VSS sg13_lv_nmos ad=0.19p pd=1.38u as=0.19p ps=1.38u w=1u l=1u
X352 iqmod_mfb_lpf_pex_half_1.iqmod_mfb_lpf_pex_ota_core_hybrid_bm_half_0.iqmod_mfb_lpf_pex_ota_core_inv_NF20$1_0.vout voutp VSS VSS sg13_lv_nmos ad=0.19p pd=1.38u as=0.19p ps=1.38u w=1u l=1u
X353 VDD voutp iqmod_mfb_lpf_pex_half_1.iqmod_mfb_lpf_pex_ota_core_hybrid_bm_half_0.iqmod_mfb_lpf_pex_ota_core_inv_NF20$1_0.vout VDD sg13_lv_pmos ad=1.14p pd=6.38u as=1.14p ps=6.38u w=6u l=1u
X354 iqmod_mfb_lpf_pex_half_1.iqmod_mfb_lpf_pex_ota_core_hybrid_bm_half_0.iqmod_mfb_lpf_pex_ota_core_tg$1_0.v_b iqmod_mfb_lpf_pex_half_1.iqmod_mfb_lpf_pex_ota_core_hybrid_bm_half_0.iqmod_mfb_lpf_pex_ota_core_inv_NF6$1_1.vout VSS VSS sg13_lv_nmos ad=0.19p pd=1.38u as=0.19p ps=1.38u w=1u l=1u
X355 VDD voutn iqmod_mfb_lpf_pex_half_1.iqmod_mfb_lpf_pex_ota_core_hybrid_bm_half_0.iqmod_mfb_lpf_pex_ota_core_inv_NF20$1_0.vout VDD sg13_lv_pmos ad=1.14p pd=6.38u as=1.14p ps=6.38u w=6u l=1u
X356 VDD di_filter_en iqmod_mfb_lpf_pex_half_1.iqmod_mfb_lpf_pex_ota_core_hybrid_bm_half_0.iqmod_mfb_lpf_pex_ota_core_tg$1_0.di_tg_ctrl_n VDD sg13_lv_pmos ad=1.14p pd=6.38u as=1.14p ps=6.38u w=6u l=0.13u
X357 VSS iqmod_mfb_lpf_pex_half_1.iqmod_mfb_lpf_pex_ota_core_hybrid_bm_half_0.iqmod_mfb_lpf_pex_ota_core_tg$1_0.v_a iqmod_mfb_lpf_pex_half_1.iqmod_mfb_lpf_pex_ota_core_hybrid_bm_half_0.iqmod_mfb_lpf_pex_ota_core_tg$1_0.v_b VSS sg13_lv_nmos ad=0.19p pd=1.38u as=0.19p ps=1.38u w=1u l=1u
X358 VSS di_filter_en iqmod_mfb_lpf_pex_half_0.iqmod_mfb_lpf_pex_ota_core_hybrid_bm_half_0.iqmod_mfb_lpf_pex_ota_core_tg$1_0.di_tg_ctrl_n VSS sg13_lv_nmos ad=0.19p pd=1.38u as=0.19p ps=1.38u w=1u l=0.13u
X359 VDD VDD VDD VDD sg13_lv_pmos ad=2.04p pd=12.68u as=0 ps=0 w=6u l=1u
X360 iqmod_mfb_lpf_pex_half_1.iqmod_mfb_lpf_pex_ota_core_hybrid_bm_half_0.iqmod_mfb_lpf_pex_ota_core_inv_NF20$1_0.vout voutn VDD VDD sg13_lv_pmos ad=1.14p pd=6.38u as=1.14p ps=6.38u w=6u l=1u
X361 iqmod_mfb_lpf_pex_half_1.iqmod_mfb_lpf_pex_ota_core_hybrid_bm_half_0.iqmod_mfb_lpf_pex_ota_core_spdt_switch$1_0.iqmod_mfb_lpf_pex_ota_core_spdt_switch_inv$2_0.vout iqmod_mfb_lpf_pex_half_1.iqmod_mfb_lpf_pex_ota_core_hybrid_bm_half_0.iqmod_mfb_lpf_pex_ota_core_tg$1_0.di_tg_ctrl_n VDD VDD sg13_lv_pmos ad=1.14p pd=6.38u as=1.14p ps=6.38u w=6u l=0.13u
X362 voutn iqmod_mfb_lpf_pex_half_0.iqmod_mfb_lpf_pex_ota_core_hybrid_bm_half_0.iqmod_mfb_lpf_pex_ota_core_inv_NF20$1_1.vin VDD VDD sg13_lv_pmos ad=1.14p pd=6.38u as=1.14p ps=6.38u w=6u l=1u
X363 VDD voutn iqmod_mfb_lpf_pex_half_1.iqmod_mfb_lpf_pex_ota_core_hybrid_bm_half_0.iqmod_mfb_lpf_pex_ota_core_inv_NF20$1_0.vout VDD sg13_lv_pmos ad=1.14p pd=6.38u as=1.14p ps=6.38u w=6u l=1u
X364 iqmod_mfb_lpf_pex_half_1.iqmod_mfb_lpf_pex_ota_core_hybrid_bm_half_0.iqmod_mfb_lpf_pex_ota_core_inv_NF20$1_0.vout voutn VSS VSS sg13_lv_nmos ad=0.19p pd=1.38u as=0.19p ps=1.38u w=1u l=1u
X365 iqmod_mfb_lpf_pex_half_1.iqmod_mfb_lpf_pex_ota_core_hybrid_bm_half_0.iqmod_mfb_lpf_pex_ota_core_inv_NF6$1_1.vout iqmod_mfb_lpf_pex_half_0.iqmod_mfb_lpf_pex_ota_core_hybrid_bm_half_0.iqmod_mfb_lpf_pex_ota_core_tg$1_0.di_tg_ctrl_n iqmod_mfb_lpf_pex_half_1.iqmod_mfb_lpf_pex_ota_core_hybrid_bm_half_0.iqmod_mfb_lpf_pex_ota_core_inv_NF20$1_0.vout VDD sg13_lv_pmos ad=1.14p pd=6.38u as=1.14p ps=6.38u w=6u l=0.13u
X366 iqmod_mfb_lpf_pex_half_1.C1_half a_12906_4203# VSS rhigh l=31u w=0.5u
X367 iqmod_mfb_lpf_pex_half_1.iqmod_mfb_lpf_pex_ota_core_hybrid_bm_half_0.iqmod_mfb_lpf_pex_ota_core_inv_NF20$1_0.vout voutn VDD VDD sg13_lv_pmos ad=1.14p pd=6.38u as=1.14p ps=6.38u w=6u l=1u
X368 voutn iqmod_mfb_lpf_pex_half_1.iqmod_mfb_lpf_pex_ota_core_hybrid_bm_half_0.iqmod_mfb_lpf_pex_ota_core_tg$1_0.v_b VSS VSS sg13_lv_nmos ad=0.19p pd=1.38u as=0.19p ps=1.38u w=1u l=1u
X369 VSS iqmod_mfb_lpf_pex_half_1.iqmod_mfb_lpf_pex_ota_core_hybrid_bm_half_0.iqmod_mfb_lpf_pex_ota_core_tg$1_0.v_b voutp VSS sg13_lv_nmos ad=0.19p pd=1.38u as=0.19p ps=1.38u w=1u l=1u
X370 iqmod_mfb_lpf_pex_half_1.iqmod_mfb_lpf_pex_ota_core_hybrid_bm_half_0.iqmod_mfb_lpf_pex_ota_core_tg$1_0.v_a iqmod_mfb_lpf_pex_half_0.iqmod_mfb_lpf_pex_ota_core_hybrid_bm_half_0.iqmod_mfb_lpf_pex_ota_core_inv_NF20$1_1.vin VSS VSS sg13_lv_nmos ad=0.19p pd=1.38u as=0.19p ps=1.38u w=1u l=1u
X371 iqmod_mfb_lpf_pex_half_1.iqmod_mfb_lpf_pex_ota_core_hybrid_bm_half_0.iqmod_mfb_lpf_pex_ota_core_tg$1_0.v_b iqmod_mfb_lpf_pex_half_1.iqmod_mfb_lpf_pex_ota_core_hybrid_bm_half_0.iqmod_mfb_lpf_pex_ota_core_inv_NF6$1_1.vout VSS VSS sg13_lv_nmos ad=0.19p pd=1.38u as=0.19p ps=1.38u w=1u l=1u
X372 voutn iqmod_mfb_lpf_pex_half_1.iqmod_mfb_lpf_pex_ota_core_hybrid_bm_half_0.iqmod_mfb_lpf_pex_ota_core_tg$1_0.v_b VDD VDD sg13_lv_pmos ad=1.14p pd=6.38u as=1.14p ps=6.38u w=6u l=1u
X373 voutp iqmod_mfb_lpf_pex_half_1.iqmod_mfb_lpf_pex_ota_core_hybrid_bm_half_0.iqmod_mfb_lpf_pex_ota_core_inv_NF20$1_1.vin VDD VDD sg13_lv_pmos ad=1.14p pd=6.38u as=1.14p ps=6.38u w=6u l=1u
X374 voutp iqmod_mfb_lpf_pex_half_1.iqmod_mfb_lpf_pex_ota_core_hybrid_bm_half_0.iqmod_mfb_lpf_pex_ota_core_tg$1_0.v_b VSS VSS sg13_lv_nmos ad=0.19p pd=1.38u as=0.19p ps=1.38u w=1u l=1u
X375 VDD iqmod_mfb_lpf_pex_half_1.iqmod_mfb_lpf_pex_ota_core_hybrid_bm_half_0.iqmod_mfb_lpf_pex_ota_core_inv_NF6$1_1.vout iqmod_mfb_lpf_pex_half_1.iqmod_mfb_lpf_pex_ota_core_hybrid_bm_half_0.iqmod_mfb_lpf_pex_ota_core_tg$1_0.v_b VDD sg13_lv_pmos ad=1.14p pd=6.38u as=1.14p ps=6.38u w=6u l=1u
X376 VDD VDD VDD VDD sg13_lv_pmos ad=1.14p pd=6.38u as=0 ps=0 w=6u l=1u
X377 VDD iqmod_mfb_lpf_pex_half_1.iqmod_mfb_lpf_pex_ota_core_hybrid_bm_half_0.iqmod_mfb_lpf_pex_ota_core_tg$1_0.v_b voutn VDD sg13_lv_pmos ad=1.14p pd=6.38u as=1.14p ps=6.38u w=6u l=1u
X378 voutp iqmod_mfb_lpf_pex_half_1.iqmod_mfb_lpf_pex_ota_core_hybrid_bm_half_0.iqmod_mfb_lpf_pex_ota_core_tg$1_0.v_b VDD VDD sg13_lv_pmos ad=1.14p pd=6.38u as=1.14p ps=6.38u w=6u l=1u
X379 VDD iqmod_mfb_lpf_pex_half_1.iqmod_mfb_lpf_pex_ota_core_hybrid_bm_half_0.iqmod_mfb_lpf_pex_ota_core_inv_NF20$1_1.vin voutp VDD sg13_lv_pmos ad=1.14p pd=6.38u as=1.14p ps=6.38u w=6u l=1u
X380 iqmod_mfb_lpf_pex_half_1.iqmod_mfb_lpf_pex_ota_core_hybrid_bm_half_0.iqmod_mfb_lpf_pex_ota_core_inv_NF20$1_0.vout voutp VSS VSS sg13_lv_nmos ad=0.19p pd=1.38u as=0.19p ps=1.38u w=1u l=1u
X381 VSS iqmod_mfb_lpf_pex_half_0.iqmod_mfb_lpf_pex_ota_core_hybrid_bm_half_0.iqmod_mfb_lpf_pex_ota_core_inv_NF20$1_1.vin voutn VSS sg13_lv_nmos ad=0.19p pd=1.38u as=0.19p ps=1.38u w=1u l=1u
X382 iqmod_mfb_lpf_pex_half_0.iqmod_mfb_lpf_pex_ota_core_hybrid_bm_half_0.iqmod_mfb_lpf_pex_ota_core_inv_NF20$1_1.vin iqmod_mfb_lpf_pex_half_0.iqmod_mfb_lpf_pex_ota_core_hybrid_bm_half_0.iqmod_mfb_lpf_pex_ota_core_spdt_switch$1_0.iqmod_mfb_lpf_pex_ota_core_spdt_switch_inv$2_0.vout VDD VDD sg13_lv_pmos ad=1.14p pd=6.38u as=2.04p ps=12.68u w=6u l=0.13u
X383 iqmod_mfb_lpf_pex_half_1.iqmod_mfb_lpf_pex_ota_core_hybrid_bm_half_0.iqmod_mfb_lpf_pex_ota_core_tg$1_0.v_a iqmod_mfb_lpf_pex_half_0.iqmod_mfb_lpf_pex_ota_core_hybrid_bm_half_0.iqmod_mfb_lpf_pex_ota_core_tg$1_0.di_tg_ctrl_n iqmod_mfb_lpf_pex_half_1.iqmod_mfb_lpf_pex_ota_core_hybrid_bm_half_0.iqmod_mfb_lpf_pex_ota_core_tg$1_0.v_b VDD sg13_lv_pmos ad=2.04p pd=12.68u as=1.14p ps=6.38u w=6u l=0.13u
X384 iqmod_mfb_lpf_pex_half_1.iqmod_mfb_lpf_pex_ota_core_hybrid_bm_half_0.iqmod_mfb_lpf_pex_ota_core_tg$1_0.v_b iqmod_mfb_lpf_pex_half_1.iqmod_mfb_lpf_pex_ota_core_hybrid_bm_half_0.iqmod_mfb_lpf_pex_ota_core_inv_NF6$1_1.vout VDD VDD sg13_lv_pmos ad=1.14p pd=6.38u as=1.14p ps=6.38u w=6u l=1u
X385 iqmod_mfb_lpf_pex_half_1.iqmod_mfb_lpf_pex_ota_core_hybrid_bm_half_0.iqmod_mfb_lpf_pex_ota_core_inv_NF20$1_0.vout voutn VSS VSS sg13_lv_nmos ad=0.19p pd=1.38u as=0.19p ps=1.38u w=1u l=1u
X386 voutn iqmod_mfb_lpf_pex_half_1.iqmod_mfb_lpf_pex_ota_core_hybrid_bm_half_0.iqmod_mfb_lpf_pex_ota_core_tg$1_0.v_b VSS VSS sg13_lv_nmos ad=0.19p pd=1.38u as=0.19p ps=1.38u w=1u l=1u
X387 iqmod_mfb_lpf_pex_half_0.iqmod_mfb_lpf_pex_ota_core_hybrid_bm_half_0.iqmod_mfb_lpf_pex_ota_core_inv_NF20$1_1.vin iqmod_mfb_lpf_pex_half_0.iqmod_mfb_lpf_pex_ota_core_hybrid_bm_half_0.iqmod_mfb_lpf_pex_ota_core_spdt_switch$1_0.iqmod_mfb_lpf_pex_ota_core_spdt_switch_inv$2_0.vout vinp VSS sg13_lv_nmos ad=0.19p pd=1.38u as=0.34p ps=2.68u w=1u l=0.13u
X388 iqmod_mfb_lpf_pex_half_1.iqmod_mfb_lpf_pex_ota_core_hybrid_bm_half_0.iqmod_mfb_lpf_pex_ota_core_tg$1_0.v_b iqmod_mfb_lpf_pex_half_1.iqmod_mfb_lpf_pex_ota_core_hybrid_bm_half_0.iqmod_mfb_lpf_pex_ota_core_tg$1_0.v_a VDD VDD sg13_lv_pmos ad=1.14p pd=6.38u as=1.14p ps=6.38u w=6u l=1u
X389 VDD iqmod_mfb_lpf_pex_half_1.iqmod_mfb_lpf_pex_ota_core_hybrid_bm_half_0.iqmod_mfb_lpf_pex_ota_core_inv_NF20$1_1.vin iqmod_mfb_lpf_pex_half_1.iqmod_mfb_lpf_pex_ota_core_hybrid_bm_half_0.iqmod_mfb_lpf_pex_ota_core_tg$1_0.v_a VDD sg13_lv_pmos ad=1.14p pd=6.38u as=1.14p ps=6.38u w=6u l=1u
X390 iqmod_mfb_lpf_pex_half_1.iqmod_mfb_lpf_pex_ota_core_hybrid_bm_half_0.iqmod_mfb_lpf_pex_ota_core_tg$1_0.v_b iqmod_mfb_lpf_pex_half_0.iqmod_mfb_lpf_pex_ota_core_hybrid_bm_half_0.iqmod_mfb_lpf_pex_ota_core_tg$1_0.di_tg_ctrl_n iqmod_mfb_lpf_pex_half_1.iqmod_mfb_lpf_pex_ota_core_hybrid_bm_half_0.iqmod_mfb_lpf_pex_ota_core_tg$1_0.v_a VDD sg13_lv_pmos ad=1.14p pd=6.38u as=1.14p ps=6.38u w=6u l=0.13u
X391 voutn iqmod_mfb_lpf_pex_half_0.iqmod_mfb_lpf_pex_ota_core_hybrid_bm_half_0.iqmod_mfb_lpf_pex_ota_core_inv_NF20$1_1.vin VSS VSS sg13_lv_nmos ad=0.19p pd=1.38u as=0.19p ps=1.38u w=1u l=1u
X392 iqmod_mfb_lpf_pex_half_0.iqmod_mfb_lpf_pex_ota_core_hybrid_bm_half_0.iqmod_mfb_lpf_pex_ota_core_inv_NF20$1_1.vin iqmod_mfb_lpf_pex_half_0.iqmod_mfb_lpf_pex_ota_core_hybrid_bm_half_0.iqmod_mfb_lpf_pex_ota_core_tg$1_0.di_tg_ctrl_n vinp VDD sg13_lv_pmos ad=1.14p pd=6.38u as=1.14p ps=6.38u w=6u l=0.13u
X393 VDD iqmod_mfb_lpf_pex_half_1.iqmod_mfb_lpf_pex_ota_core_hybrid_bm_half_0.iqmod_mfb_lpf_pex_ota_core_tg$1_0.v_b voutp VDD sg13_lv_pmos ad=1.14p pd=6.38u as=1.14p ps=6.38u w=6u l=1u
X394 iqmod_mfb_lpf_pex_half_1.iqmod_mfb_lpf_pex_ota_core_hybrid_bm_half_0.iqmod_mfb_lpf_pex_ota_core_tg$1_0.v_b iqmod_mfb_lpf_pex_half_1.iqmod_mfb_lpf_pex_ota_core_hybrid_bm_half_0.iqmod_mfb_lpf_pex_ota_core_tg$1_0.di_tg_ctrl_n iqmod_mfb_lpf_pex_half_1.iqmod_mfb_lpf_pex_ota_core_hybrid_bm_half_0.iqmod_mfb_lpf_pex_ota_core_tg$1_0.v_a VDD sg13_lv_pmos ad=1.14p pd=6.38u as=1.14p ps=6.38u w=6u l=0.13u
X395 VDD iqmod_mfb_lpf_pex_half_1.iqmod_mfb_lpf_pex_ota_core_hybrid_bm_half_0.iqmod_mfb_lpf_pex_ota_core_tg$1_0.v_b voutn VDD sg13_lv_pmos ad=1.14p pd=6.38u as=1.14p ps=6.38u w=6u l=1u
X396 VSS VSS VSS VSS sg13_lv_nmos ad=0.19p pd=1.38u as=0 ps=0 w=1u l=0.13u
X397 VDD iqmod_mfb_lpf_pex_half_1.iqmod_mfb_lpf_pex_ota_core_hybrid_bm_half_0.iqmod_mfb_lpf_pex_ota_core_inv_NF20$1_1.vin voutp VDD sg13_lv_pmos ad=1.14p pd=6.38u as=1.14p ps=6.38u w=6u l=1u
X398 iqmod_mfb_lpf_pex_half_1.iqmod_mfb_lpf_pex_ota_core_hybrid_bm_half_0.iqmod_mfb_lpf_pex_ota_core_inv_NF20$1_0.vout voutp VSS VSS sg13_lv_nmos ad=0.19p pd=1.38u as=0.19p ps=1.38u w=1u l=1u
X399 VSS iqmod_mfb_lpf_pex_half_1.iqmod_mfb_lpf_pex_ota_core_hybrid_bm_half_0.iqmod_mfb_lpf_pex_ota_core_inv_NF20$1_1.vin voutp VSS sg13_lv_nmos ad=0.19p pd=1.38u as=0.19p ps=1.38u w=1u l=1u
X400 voutn iqmod_mfb_lpf_pex_half_1.iqmod_mfb_lpf_pex_ota_core_hybrid_bm_half_0.iqmod_mfb_lpf_pex_ota_core_tg$1_0.v_b VDD VDD sg13_lv_pmos ad=1.14p pd=6.38u as=1.14p ps=6.38u w=6u l=1u
X401 iqmod_mfb_lpf_pex_half_1.iqmod_mfb_lpf_pex_ota_core_hybrid_bm_half_0.iqmod_mfb_lpf_pex_ota_core_inv_NF20$1_1.vin iqmod_mfb_lpf_pex_half_1.iqmod_mfb_lpf_pex_ota_core_hybrid_bm_half_0.iqmod_mfb_lpf_pex_ota_core_spdt_switch$1_0.iqmod_mfb_lpf_pex_ota_core_spdt_switch_inv$2_0.vout vinn VSS sg13_lv_nmos ad=0.19p pd=1.38u as=0.19p ps=1.38u w=1u l=0.13u
X402 voutn iqmod_mfb_lpf_pex_half_0.iqmod_mfb_lpf_pex_ota_core_hybrid_bm_half_0.iqmod_mfb_lpf_pex_ota_core_inv_NF20$1_1.vin VDD VDD sg13_lv_pmos ad=1.14p pd=6.38u as=1.14p ps=6.38u w=6u l=1u
X403 iqmod_mfb_lpf_pex_half_1.iqmod_mfb_lpf_pex_ota_core_hybrid_bm_half_0.iqmod_mfb_lpf_pex_ota_core_tg$1_0.v_a di_filter_en iqmod_mfb_lpf_pex_half_1.iqmod_mfb_lpf_pex_ota_core_hybrid_bm_half_0.iqmod_mfb_lpf_pex_ota_core_tg$1_0.v_b VSS sg13_lv_nmos ad=0.19p pd=1.38u as=0.19p ps=1.38u w=1u l=0.13u
X404 VSS iqmod_mfb_lpf_pex_half_1.iqmod_mfb_lpf_pex_ota_core_hybrid_bm_half_0.iqmod_mfb_lpf_pex_ota_core_inv_NF20$1_1.vin iqmod_mfb_lpf_pex_half_1.iqmod_mfb_lpf_pex_ota_core_hybrid_bm_half_0.iqmod_mfb_lpf_pex_ota_core_tg$1_0.v_a VSS sg13_lv_nmos ad=0.19p pd=1.38u as=0.19p ps=1.38u w=1u l=1u
X405 VSS voutp iqmod_mfb_lpf_pex_half_1.iqmod_mfb_lpf_pex_ota_core_hybrid_bm_half_0.iqmod_mfb_lpf_pex_ota_core_inv_NF20$1_0.vout VSS sg13_lv_nmos ad=0.19p pd=1.38u as=0.19p ps=1.38u w=1u l=1u
X406 VSS VSS VSS VSS sg13_lv_nmos ad=0.19p pd=1.38u as=0 ps=0 w=1u l=1u
X407 voutp iqmod_mfb_lpf_pex_half_1.iqmod_mfb_lpf_pex_ota_core_hybrid_bm_half_0.iqmod_mfb_lpf_pex_ota_core_inv_NF20$1_1.vin VDD VDD sg13_lv_pmos ad=1.14p pd=6.38u as=1.14p ps=6.38u w=6u l=1u
X408 VDD VDD VDD VDD sg13_lv_pmos ad=1.14p pd=6.38u as=0 ps=0 w=6u l=1u
X409 VDD iqmod_mfb_lpf_pex_half_0.iqmod_mfb_lpf_pex_ota_core_hybrid_bm_half_0.iqmod_mfb_lpf_pex_ota_core_inv_NF20$1_1.vin voutn VDD sg13_lv_pmos ad=1.14p pd=6.38u as=1.14p ps=6.38u w=6u l=1u
X410 iqmod_mfb_lpf_pex_half_1.iqmod_mfb_lpf_pex_ota_core_hybrid_bm_half_0.iqmod_mfb_lpf_pex_ota_core_inv_NF20$1_0.vout voutp VDD VDD sg13_lv_pmos ad=1.14p pd=6.38u as=1.14p ps=6.38u w=6u l=1u
X411 VSS iqmod_mfb_lpf_pex_half_1.iqmod_mfb_lpf_pex_ota_core_hybrid_bm_half_0.iqmod_mfb_lpf_pex_ota_core_tg$1_0.v_b voutp VSS sg13_lv_nmos ad=0.19p pd=1.38u as=0.19p ps=1.38u w=1u l=1u
X412 VDD iqmod_mfb_lpf_pex_half_1.iqmod_mfb_lpf_pex_ota_core_hybrid_bm_half_0.iqmod_mfb_lpf_pex_ota_core_tg$1_0.v_a iqmod_mfb_lpf_pex_half_1.iqmod_mfb_lpf_pex_ota_core_hybrid_bm_half_0.iqmod_mfb_lpf_pex_ota_core_tg$1_0.v_b VDD sg13_lv_pmos ad=1.14p pd=6.38u as=1.14p ps=6.38u w=6u l=1u
X413 iqmod_mfb_lpf_pex_half_1.iqmod_mfb_lpf_pex_ota_core_hybrid_bm_half_0.iqmod_mfb_lpf_pex_ota_core_tg$1_0.v_a iqmod_mfb_lpf_pex_half_1.iqmod_mfb_lpf_pex_ota_core_hybrid_bm_half_0.iqmod_mfb_lpf_pex_ota_core_inv_NF20$1_1.vin VDD VDD sg13_lv_pmos ad=1.14p pd=6.38u as=1.14p ps=6.38u w=6u l=1u
X414 voutp iqmod_mfb_lpf_pex_half_1.iqmod_mfb_lpf_pex_ota_core_hybrid_bm_half_0.iqmod_mfb_lpf_pex_ota_core_tg$1_0.v_b VDD VDD sg13_lv_pmos ad=1.14p pd=6.38u as=1.14p ps=6.38u w=6u l=1u
X415 VSS iqmod_mfb_lpf_pex_half_1.iqmod_mfb_lpf_pex_ota_core_hybrid_bm_half_0.iqmod_mfb_lpf_pex_ota_core_tg$1_0.v_b voutn VSS sg13_lv_nmos ad=0.19p pd=1.38u as=0.19p ps=1.38u w=1u l=1u
X416 VSS VSS VSS rhigh l=27u w=0.5u
X417 VSS iqmod_mfb_lpf_pex_half_0.iqmod_mfb_lpf_pex_ota_core_hybrid_bm_half_0.iqmod_mfb_lpf_pex_ota_core_inv_NF20$1_1.vin iqmod_mfb_lpf_pex_half_1.iqmod_mfb_lpf_pex_ota_core_hybrid_bm_half_0.iqmod_mfb_lpf_pex_ota_core_tg$1_0.v_a VSS sg13_lv_nmos ad=0.19p pd=1.38u as=0.19p ps=1.38u w=1u l=1u
X418 voutn iqmod_mfb_lpf_pex_half_1.iqmod_mfb_lpf_pex_ota_core_hybrid_bm_half_0.iqmod_mfb_lpf_pex_ota_core_tg$1_0.v_b VDD VDD sg13_lv_pmos ad=1.14p pd=6.38u as=1.14p ps=6.38u w=6u l=1u
X419 iqmod_mfb_lpf_pex_half_1.iqmod_mfb_lpf_pex_ota_core_hybrid_bm_half_0.iqmod_mfb_lpf_pex_ota_core_inv_NF6$1_1.vout iqmod_mfb_lpf_pex_half_1.iqmod_mfb_lpf_pex_ota_core_hybrid_bm_half_0.iqmod_mfb_lpf_pex_ota_core_tg$1_0.di_tg_ctrl_n iqmod_mfb_lpf_pex_half_1.iqmod_mfb_lpf_pex_ota_core_hybrid_bm_half_0.iqmod_mfb_lpf_pex_ota_core_inv_NF20$1_0.vout VDD sg13_lv_pmos ad=1.14p pd=6.38u as=2.04p ps=12.68u w=6u l=0.13u
X420 a_25788_4203# a_37874_3903# VSS rhigh l=60u w=0.5u
X421 iqmod_mfb_lpf_pex_half_1.iqmod_mfb_lpf_pex_ota_core_hybrid_bm_half_0.iqmod_mfb_lpf_pex_ota_core_inv_NF20$1_0.vout iqmod_mfb_lpf_pex_half_0.iqmod_mfb_lpf_pex_ota_core_hybrid_bm_half_0.iqmod_mfb_lpf_pex_ota_core_tg$1_0.di_tg_ctrl_n iqmod_mfb_lpf_pex_half_1.iqmod_mfb_lpf_pex_ota_core_hybrid_bm_half_0.iqmod_mfb_lpf_pex_ota_core_inv_NF6$1_1.vout VDD sg13_lv_pmos ad=2.04p pd=12.68u as=1.14p ps=6.38u w=6u l=0.13u
X422 VDD VDD VDD VDD sg13_lv_pmos ad=2.04p pd=12.68u as=0 ps=0 w=6u l=1u
X423 VSS iqmod_mfb_lpf_pex_half_1.iqmod_mfb_lpf_pex_ota_core_hybrid_bm_half_0.iqmod_mfb_lpf_pex_ota_core_tg$1_0.v_b voutn VSS sg13_lv_nmos ad=0.19p pd=1.38u as=0.19p ps=1.38u w=1u l=1u
X424 VSS VSS VSS rhigh l=31u w=0.5u
X425 VDD iqmod_mfb_lpf_pex_half_1.iqmod_mfb_lpf_pex_ota_core_hybrid_bm_half_0.iqmod_mfb_lpf_pex_ota_core_tg$1_0.v_a iqmod_mfb_lpf_pex_half_1.iqmod_mfb_lpf_pex_ota_core_hybrid_bm_half_0.iqmod_mfb_lpf_pex_ota_core_tg$1_0.v_b VDD sg13_lv_pmos ad=1.14p pd=6.38u as=1.14p ps=6.38u w=6u l=1u
X426 iqmod_mfb_lpf_pex_half_1.iqmod_mfb_lpf_pex_ota_core_hybrid_bm_half_0.iqmod_mfb_lpf_pex_ota_core_tg$1_0.v_b iqmod_mfb_lpf_pex_half_1.iqmod_mfb_lpf_pex_ota_core_hybrid_bm_half_0.iqmod_mfb_lpf_pex_ota_core_tg$1_0.v_a VSS VSS sg13_lv_nmos ad=0.19p pd=1.38u as=0.19p ps=1.38u w=1u l=1u
X427 VDD iqmod_mfb_lpf_pex_half_1.iqmod_mfb_lpf_pex_ota_core_hybrid_bm_half_0.iqmod_mfb_lpf_pex_ota_core_inv_NF20$1_1.vin voutp VDD sg13_lv_pmos ad=1.14p pd=6.38u as=1.14p ps=6.38u w=6u l=1u
X428 VSS iqmod_mfb_lpf_pex_half_1.iqmod_mfb_lpf_pex_ota_core_hybrid_bm_half_0.iqmod_mfb_lpf_pex_ota_core_inv_NF6$1_1.vout iqmod_mfb_lpf_pex_half_1.iqmod_mfb_lpf_pex_ota_core_hybrid_bm_half_0.iqmod_mfb_lpf_pex_ota_core_tg$1_0.v_b VSS sg13_lv_nmos ad=0.19p pd=1.38u as=0.19p ps=1.38u w=1u l=1u
X429 iqmod_mfb_lpf_pex_half_1.iqmod_mfb_lpf_pex_ota_core_hybrid_bm_half_0.iqmod_mfb_lpf_pex_ota_core_inv_NF6$1_1.vout iqmod_mfb_lpf_pex_half_1.iqmod_mfb_lpf_pex_ota_core_hybrid_bm_half_0.iqmod_mfb_lpf_pex_ota_core_inv_NF20$1_0.vout VSS VSS sg13_lv_nmos ad=0.19p pd=1.38u as=0.19p ps=1.38u w=1u l=1u
X430 vinp iqmod_mfb_lpf_pex_half_0.iqmod_mfb_lpf_pex_ota_core_hybrid_bm_half_0.iqmod_mfb_lpf_pex_ota_core_spdt_switch$1_0.iqmod_mfb_lpf_pex_ota_core_spdt_switch_inv$2_0.vout iqmod_mfb_lpf_pex_half_0.iqmod_mfb_lpf_pex_ota_core_hybrid_bm_half_0.iqmod_mfb_lpf_pex_ota_core_inv_NF20$1_1.vin VSS sg13_lv_nmos ad=0.19p pd=1.38u as=0.19p ps=1.38u w=1u l=0.13u
X431 VSS VSS VSS VSS sg13_lv_nmos ad=0.19p pd=1.38u as=0 ps=0 w=1u l=1u
X432 iqmod_mfb_lpf_pex_half_1.iqmod_mfb_lpf_pex_ota_core_hybrid_bm_half_0.iqmod_mfb_lpf_pex_ota_core_tg$1_0.v_a iqmod_mfb_lpf_pex_half_1.iqmod_mfb_lpf_pex_ota_core_hybrid_bm_half_0.iqmod_mfb_lpf_pex_ota_core_tg$1_0.di_tg_ctrl_n iqmod_mfb_lpf_pex_half_1.iqmod_mfb_lpf_pex_ota_core_hybrid_bm_half_0.iqmod_mfb_lpf_pex_ota_core_tg$1_0.v_b VDD sg13_lv_pmos ad=1.14p pd=6.38u as=1.14p ps=6.38u w=6u l=0.13u
X433 VDD VDD VDD VDD sg13_lv_pmos ad=2.04p pd=12.68u as=0 ps=0 w=6u l=1u
X434 iqmod_mfb_lpf_pex_half_1.iqmod_mfb_lpf_pex_ota_core_hybrid_bm_half_0.iqmod_mfb_lpf_pex_ota_core_inv_NF20$1_0.vout di_filter_en iqmod_mfb_lpf_pex_half_1.iqmod_mfb_lpf_pex_ota_core_hybrid_bm_half_0.iqmod_mfb_lpf_pex_ota_core_inv_NF6$1_1.vout VSS sg13_lv_nmos ad=0.19p pd=1.38u as=0.19p ps=1.38u w=1u l=0.13u
X435 voutn iqmod_mfb_lpf_pex_half_0.iqmod_mfb_lpf_pex_ota_core_hybrid_bm_half_0.iqmod_mfb_lpf_pex_ota_core_inv_NF20$1_1.vin VSS VSS sg13_lv_nmos ad=0.19p pd=1.38u as=0.19p ps=1.38u w=1u l=1u
X436 VDD VDD VDD VDD sg13_lv_pmos ad=2.04p pd=12.68u as=0 ps=0 w=6u l=1u
X437 VSS voutn iqmod_mfb_lpf_pex_half_1.iqmod_mfb_lpf_pex_ota_core_hybrid_bm_half_0.iqmod_mfb_lpf_pex_ota_core_inv_NF20$1_0.vout VSS sg13_lv_nmos ad=0.19p pd=1.38u as=0.19p ps=1.38u w=1u l=1u
X438 iqmod_mfb_lpf_pex_half_1.iqmod_mfb_lpf_pex_ota_core_hybrid_bm_half_0.iqmod_mfb_lpf_pex_ota_core_inv_NF20$1_0.vout voutn VDD VDD sg13_lv_pmos ad=1.14p pd=6.38u as=1.14p ps=6.38u w=6u l=1u
X439 VDD iqmod_mfb_lpf_pex_half_0.iqmod_mfb_lpf_pex_ota_core_hybrid_bm_half_0.iqmod_mfb_lpf_pex_ota_core_inv_NF20$1_1.vin voutn VDD sg13_lv_pmos ad=1.14p pd=6.38u as=1.14p ps=6.38u w=6u l=1u
X440 VDD VDD VDD VDD sg13_lv_pmos ad=1.14p pd=6.38u as=0 ps=0 w=6u l=1u
X441 iqmod_mfb_lpf_pex_half_1.iqmod_mfb_lpf_pex_ota_core_hybrid_bm_half_0.iqmod_mfb_lpf_pex_ota_core_inv_NF20$1_1.vin iqmod_mfb_lpf_pex_half_1.iqmod_mfb_lpf_pex_ota_core_hybrid_bm_half_0.iqmod_mfb_lpf_pex_ota_core_tg$1_0.di_tg_ctrl_n vinn VDD sg13_lv_pmos ad=1.14p pd=6.38u as=2.04p ps=12.68u w=6u l=0.13u
X442 voutp iqmod_mfb_lpf_pex_half_1.iqmod_mfb_lpf_pex_ota_core_hybrid_bm_half_0.iqmod_mfb_lpf_pex_ota_core_tg$1_0.v_b VSS VSS sg13_lv_nmos ad=0.19p pd=1.38u as=0.19p ps=1.38u w=1u l=1u
X443 VDD VDD VDD VDD sg13_lv_pmos ad=1.14p pd=6.38u as=0 ps=0 w=6u l=0.13u
X444 voutp iqmod_mfb_lpf_pex_half_1.iqmod_mfb_lpf_pex_ota_core_hybrid_bm_half_0.iqmod_mfb_lpf_pex_ota_core_tg$1_0.v_b VSS VSS sg13_lv_nmos ad=0.19p pd=1.38u as=0.19p ps=1.38u w=1u l=1u
X445 VDD voutp iqmod_mfb_lpf_pex_half_1.iqmod_mfb_lpf_pex_ota_core_hybrid_bm_half_0.iqmod_mfb_lpf_pex_ota_core_inv_NF20$1_0.vout VDD sg13_lv_pmos ad=1.14p pd=6.38u as=1.14p ps=6.38u w=6u l=1u
X446 VDD VDD VDD VDD sg13_lv_pmos ad=2.04p pd=12.68u as=0 ps=0 w=6u l=0.13u
X447 iqmod_mfb_lpf_pex_half_0.iqmod_mfb_lpf_pex_ota_core_hybrid_bm_half_0.iqmod_mfb_lpf_pex_ota_core_inv_NF20$1_1.vin iqmod_mfb_lpf_pex_half_0.iqmod_mfb_lpf_pex_ota_core_hybrid_bm_half_0.iqmod_mfb_lpf_pex_ota_core_spdt_switch$1_0.iqmod_mfb_lpf_pex_ota_core_spdt_switch_inv$2_0.vout VDD VDD sg13_lv_pmos ad=1.14p pd=6.38u as=1.14p ps=6.38u w=6u l=0.13u
X448 iqmod_mfb_lpf_pex_half_1.iqmod_mfb_lpf_pex_ota_core_hybrid_bm_half_0.iqmod_mfb_lpf_pex_ota_core_inv_NF20$1_1.vin iqmod_mfb_lpf_pex_half_1.iqmod_mfb_lpf_pex_ota_core_hybrid_bm_half_0.iqmod_mfb_lpf_pex_ota_core_tg$1_0.di_tg_ctrl_n VDD VSS sg13_lv_nmos ad=0.19p pd=1.38u as=0.19p ps=1.38u w=1u l=0.13u
X449 VDD iqmod_mfb_lpf_pex_half_1.iqmod_mfb_lpf_pex_ota_core_hybrid_bm_half_0.iqmod_mfb_lpf_pex_ota_core_tg$1_0.v_b voutp VDD sg13_lv_pmos ad=1.14p pd=6.38u as=1.14p ps=6.38u w=6u l=1u
X450 VSS iqmod_mfb_lpf_pex_half_1.iqmod_mfb_lpf_pex_ota_core_hybrid_bm_half_0.iqmod_mfb_lpf_pex_ota_core_tg$1_0.v_b voutp VSS sg13_lv_nmos ad=0.19p pd=1.38u as=0.19p ps=1.38u w=1u l=1u
X451 iqmod_mfb_lpf_pex_half_1.iqmod_mfb_lpf_pex_ota_core_hybrid_bm_half_0.iqmod_mfb_lpf_pex_ota_core_inv_NF20$1_0.vout voutp VDD VDD sg13_lv_pmos ad=1.14p pd=6.38u as=1.14p ps=6.38u w=6u l=1u
X452 VSS iqmod_mfb_lpf_pex_half_1.iqmod_mfb_lpf_pex_ota_core_hybrid_bm_half_0.iqmod_mfb_lpf_pex_ota_core_tg$1_0.v_b voutn VSS sg13_lv_nmos ad=0.19p pd=1.38u as=0.19p ps=1.38u w=1u l=1u
X453 iqmod_mfb_lpf_pex_half_1.iqmod_mfb_lpf_pex_ota_core_hybrid_bm_half_0.iqmod_mfb_lpf_pex_ota_core_inv_NF20$1_0.vout iqmod_mfb_lpf_pex_half_1.iqmod_mfb_lpf_pex_ota_core_hybrid_bm_half_0.iqmod_mfb_lpf_pex_ota_core_tg$1_0.di_tg_ctrl_n iqmod_mfb_lpf_pex_half_1.iqmod_mfb_lpf_pex_ota_core_hybrid_bm_half_0.iqmod_mfb_lpf_pex_ota_core_inv_NF6$1_1.vout VDD sg13_lv_pmos ad=1.14p pd=6.38u as=1.14p ps=6.38u w=6u l=0.13u
X454 iqmod_mfb_lpf_pex_half_1.iqmod_mfb_lpf_pex_ota_core_hybrid_bm_half_0.iqmod_mfb_lpf_pex_ota_core_tg$1_0.di_tg_ctrl_n di_filter_en VSS VSS sg13_lv_nmos ad=0.19p pd=1.38u as=0.19p ps=1.38u w=1u l=0.13u
X455 VDD iqmod_mfb_lpf_pex_half_1.iqmod_mfb_lpf_pex_ota_core_hybrid_bm_half_0.iqmod_mfb_lpf_pex_ota_core_tg$1_0.v_b voutn VDD sg13_lv_pmos ad=1.14p pd=6.38u as=1.14p ps=6.38u w=6u l=1u
X456 voutn iqmod_mfb_lpf_pex_half_1.iqmod_mfb_lpf_pex_ota_core_hybrid_bm_half_0.iqmod_mfb_lpf_pex_ota_core_tg$1_0.v_b VSS VSS sg13_lv_nmos ad=0.19p pd=1.38u as=0.19p ps=1.38u w=1u l=1u
X457 iqmod_mfb_lpf_pex_half_1.iqmod_mfb_lpf_pex_ota_core_hybrid_bm_half_0.iqmod_mfb_lpf_pex_ota_core_tg$1_0.v_a iqmod_mfb_lpf_pex_half_0.iqmod_mfb_lpf_pex_ota_core_hybrid_bm_half_0.iqmod_mfb_lpf_pex_ota_core_inv_NF20$1_1.vin VSS VSS sg13_lv_nmos ad=0.19p pd=1.38u as=0.19p ps=1.38u w=1u l=1u
X458 vinp a_6122_3903# VSS rhigh l=27u w=0.5u
X459 VSS iqmod_mfb_lpf_pex_half_1.iqmod_mfb_lpf_pex_ota_core_hybrid_bm_half_0.iqmod_mfb_lpf_pex_ota_core_inv_NF20$1_1.vin voutp VSS sg13_lv_nmos ad=0.19p pd=1.38u as=0.19p ps=1.38u w=1u l=1u
X460 voutn iqmod_mfb_lpf_pex_half_1.iqmod_mfb_lpf_pex_ota_core_hybrid_bm_half_0.iqmod_mfb_lpf_pex_ota_core_tg$1_0.v_b VDD VDD sg13_lv_pmos ad=1.14p pd=6.38u as=1.14p ps=6.38u w=6u l=1u
X461 VDD iqmod_mfb_lpf_pex_half_1.iqmod_mfb_lpf_pex_ota_core_hybrid_bm_half_0.iqmod_mfb_lpf_pex_ota_core_inv_NF20$1_0.vout iqmod_mfb_lpf_pex_half_1.iqmod_mfb_lpf_pex_ota_core_hybrid_bm_half_0.iqmod_mfb_lpf_pex_ota_core_inv_NF6$1_1.vout VDD sg13_lv_pmos ad=1.14p pd=6.38u as=1.14p ps=6.38u w=6u l=1u
X462 iqmod_mfb_lpf_pex_half_1.iqmod_mfb_lpf_pex_R1_0.v_b iqmod_mfb_lpf_pex_half_1.C1_half cap_cmim l=8u w=8u
X463 a_25788_4203# voutn VSS rhigh l=60u w=0.5u
X464 VSS voutp iqmod_mfb_lpf_pex_half_1.iqmod_mfb_lpf_pex_ota_core_hybrid_bm_half_0.iqmod_mfb_lpf_pex_ota_core_inv_NF20$1_0.vout VSS sg13_lv_nmos ad=0.19p pd=1.38u as=0.19p ps=1.38u w=1u l=1u
X465 voutp iqmod_mfb_lpf_pex_half_1.iqmod_mfb_lpf_pex_ota_core_hybrid_bm_half_0.iqmod_mfb_lpf_pex_ota_core_inv_NF20$1_1.vin VSS VSS sg13_lv_nmos ad=0.19p pd=1.38u as=0.19p ps=1.38u w=1u l=1u
X466 voutp iqmod_mfb_lpf_pex_half_1.iqmod_mfb_lpf_pex_ota_core_hybrid_bm_half_0.iqmod_mfb_lpf_pex_ota_core_tg$1_0.v_b VDD VDD sg13_lv_pmos ad=1.14p pd=6.38u as=1.14p ps=6.38u w=6u l=1u
X467 VSS iqmod_mfb_lpf_pex_half_1.iqmod_mfb_lpf_pex_ota_core_hybrid_bm_half_0.iqmod_mfb_lpf_pex_ota_core_tg$1_0.v_a iqmod_mfb_lpf_pex_half_1.iqmod_mfb_lpf_pex_ota_core_hybrid_bm_half_0.iqmod_mfb_lpf_pex_ota_core_tg$1_0.v_b VSS sg13_lv_nmos ad=0.19p pd=1.38u as=0.19p ps=1.38u w=1u l=1u
X468 VDD iqmod_mfb_lpf_pex_half_0.iqmod_mfb_lpf_pex_ota_core_hybrid_bm_half_0.iqmod_mfb_lpf_pex_ota_core_inv_NF20$1_1.vin voutn VDD sg13_lv_pmos ad=1.14p pd=6.38u as=1.14p ps=6.38u w=6u l=1u
X469 VDD voutp iqmod_mfb_lpf_pex_half_1.iqmod_mfb_lpf_pex_ota_core_hybrid_bm_half_0.iqmod_mfb_lpf_pex_ota_core_inv_NF20$1_0.vout VDD sg13_lv_pmos ad=1.14p pd=6.38u as=1.14p ps=6.38u w=6u l=1u
X470 VSS iqmod_mfb_lpf_pex_half_0.iqmod_mfb_lpf_pex_ota_core_hybrid_bm_half_0.iqmod_mfb_lpf_pex_ota_core_inv_NF20$1_1.vin voutn VSS sg13_lv_nmos ad=0.19p pd=1.38u as=0.19p ps=1.38u w=1u l=1u
X471 iqmod_mfb_lpf_pex_half_1.iqmod_mfb_lpf_pex_ota_core_hybrid_bm_half_0.iqmod_mfb_lpf_pex_ota_core_tg$1_0.v_a iqmod_mfb_lpf_pex_half_1.iqmod_mfb_lpf_pex_ota_core_hybrid_bm_half_0.iqmod_mfb_lpf_pex_ota_core_inv_NF20$1_1.vin VSS VSS sg13_lv_nmos ad=0.19p pd=1.38u as=0.19p ps=1.38u w=1u l=1u
X472 iqmod_mfb_lpf_pex_half_1.iqmod_mfb_lpf_pex_ota_core_hybrid_bm_half_0.iqmod_mfb_lpf_pex_ota_core_inv_NF20$1_0.vout voutp VSS VSS sg13_lv_nmos ad=0.19p pd=1.38u as=0.19p ps=1.38u w=1u l=1u
X473 VSS iqmod_mfb_lpf_pex_half_1.iqmod_mfb_lpf_pex_ota_core_hybrid_bm_half_0.iqmod_mfb_lpf_pex_ota_core_inv_NF20$1_1.vin voutp VSS sg13_lv_nmos ad=0.19p pd=1.38u as=0.19p ps=1.38u w=1u l=1u
X474 iqmod_mfb_lpf_pex_half_1.iqmod_mfb_lpf_pex_ota_core_hybrid_bm_half_0.iqmod_mfb_lpf_pex_ota_core_inv_NF20$1_0.vout voutn VSS VSS sg13_lv_nmos ad=0.19p pd=1.38u as=0.19p ps=1.38u w=1u l=1u
X475 VDD iqmod_mfb_lpf_pex_half_0.iqmod_mfb_lpf_pex_ota_core_hybrid_bm_half_0.iqmod_mfb_lpf_pex_ota_core_inv_NF20$1_1.vin iqmod_mfb_lpf_pex_half_1.iqmod_mfb_lpf_pex_ota_core_hybrid_bm_half_0.iqmod_mfb_lpf_pex_ota_core_tg$1_0.v_a VDD sg13_lv_pmos ad=1.14p pd=6.38u as=1.14p ps=6.38u w=6u l=1u
X476 iqmod_mfb_lpf_pex_half_1.iqmod_mfb_lpf_pex_R1_0.v_b iqmod_mfb_lpf_pex_half_1.C1_half cap_cmim l=8u w=8u
X477 VDD iqmod_mfb_lpf_pex_half_1.iqmod_mfb_lpf_pex_ota_core_hybrid_bm_half_0.iqmod_mfb_lpf_pex_ota_core_tg$1_0.v_b voutp VDD sg13_lv_pmos ad=1.14p pd=6.38u as=1.14p ps=6.38u w=6u l=1u
X478 iqmod_mfb_lpf_pex_half_1.iqmod_mfb_lpf_pex_ota_core_hybrid_bm_half_0.iqmod_mfb_lpf_pex_ota_core_tg$1_0.v_a iqmod_mfb_lpf_pex_half_0.iqmod_mfb_lpf_pex_ota_core_hybrid_bm_half_0.iqmod_mfb_lpf_pex_ota_core_inv_NF20$1_1.vin VSS VSS sg13_lv_nmos ad=0.19p pd=1.38u as=0.19p ps=1.38u w=1u l=1u
X479 VSS iqmod_mfb_lpf_pex_half_1.iqmod_mfb_lpf_pex_ota_core_hybrid_bm_half_0.iqmod_mfb_lpf_pex_ota_core_inv_NF20$1_1.vin iqmod_mfb_lpf_pex_half_1.iqmod_mfb_lpf_pex_ota_core_hybrid_bm_half_0.iqmod_mfb_lpf_pex_ota_core_tg$1_0.v_a VSS sg13_lv_nmos ad=0.19p pd=1.38u as=0.19p ps=1.38u w=1u l=1u
X480 VDD iqmod_mfb_lpf_pex_half_0.iqmod_mfb_lpf_pex_ota_core_hybrid_bm_half_0.iqmod_mfb_lpf_pex_ota_core_inv_NF20$1_1.vin voutn VDD sg13_lv_pmos ad=1.14p pd=6.38u as=1.14p ps=6.38u w=6u l=1u
X481 iqmod_mfb_lpf_pex_half_1.iqmod_mfb_lpf_pex_ota_core_hybrid_bm_half_0.iqmod_mfb_lpf_pex_ota_core_inv_NF6$1_1.vout iqmod_mfb_lpf_pex_half_1.iqmod_mfb_lpf_pex_ota_core_hybrid_bm_half_0.iqmod_mfb_lpf_pex_ota_core_inv_NF20$1_0.vout VDD VDD sg13_lv_pmos ad=1.14p pd=6.38u as=1.14p ps=6.38u w=6u l=1u
X482 VDD VDD VDD VDD sg13_lv_pmos ad=2.04p pd=12.68u as=0 ps=0 w=6u l=1u
X483 VSS VSS VSS VSS sg13_lv_nmos ad=0.19p pd=1.38u as=0 ps=0 w=1u l=1u
X484 VDD iqmod_mfb_lpf_pex_half_0.iqmod_mfb_lpf_pex_ota_core_hybrid_bm_half_0.iqmod_mfb_lpf_pex_ota_core_inv_NF20$1_1.vin iqmod_mfb_lpf_pex_half_1.iqmod_mfb_lpf_pex_ota_core_hybrid_bm_half_0.iqmod_mfb_lpf_pex_ota_core_tg$1_0.v_a VDD sg13_lv_pmos ad=1.14p pd=6.38u as=1.14p ps=6.38u w=6u l=1u
X485 voutn iqmod_mfb_lpf_pex_half_0.iqmod_mfb_lpf_pex_ota_core_hybrid_bm_half_0.iqmod_mfb_lpf_pex_ota_core_inv_NF20$1_1.vin VDD VDD sg13_lv_pmos ad=1.14p pd=6.38u as=1.14p ps=6.38u w=6u l=1u
X486 VSS iqmod_mfb_lpf_pex_half_1.iqmod_mfb_lpf_pex_ota_core_hybrid_bm_half_0.iqmod_mfb_lpf_pex_ota_core_inv_NF20$1_0.vout iqmod_mfb_lpf_pex_half_1.iqmod_mfb_lpf_pex_ota_core_hybrid_bm_half_0.iqmod_mfb_lpf_pex_ota_core_inv_NF6$1_1.vout VSS sg13_lv_nmos ad=0.19p pd=1.38u as=0.19p ps=1.38u w=1u l=1u
X487 iqmod_mfb_lpf_pex_half_1.iqmod_mfb_lpf_pex_ota_core_hybrid_bm_half_0.iqmod_mfb_lpf_pex_ota_core_tg$1_0.v_a iqmod_mfb_lpf_pex_half_0.iqmod_mfb_lpf_pex_ota_core_hybrid_bm_half_0.iqmod_mfb_lpf_pex_ota_core_inv_NF20$1_1.vin VDD VDD sg13_lv_pmos ad=1.14p pd=6.38u as=1.14p ps=6.38u w=6u l=1u
X488 VDD iqmod_mfb_lpf_pex_half_0.iqmod_mfb_lpf_pex_ota_core_hybrid_bm_half_0.iqmod_mfb_lpf_pex_ota_core_inv_NF20$1_1.vin voutn VDD sg13_lv_pmos ad=1.14p pd=6.38u as=1.14p ps=6.38u w=6u l=1u
X489 voutp iqmod_mfb_lpf_pex_half_1.iqmod_mfb_lpf_pex_ota_core_hybrid_bm_half_0.iqmod_mfb_lpf_pex_ota_core_tg$1_0.v_b VDD VDD sg13_lv_pmos ad=1.14p pd=6.38u as=1.14p ps=6.38u w=6u l=1u
X490 VSS VSS VSS VSS sg13_lv_nmos ad=0.19p pd=1.38u as=0 ps=0 w=1u l=1u
X491 VSS VSS VSS VSS sg13_lv_nmos ad=0.19p pd=1.38u as=0 ps=0 w=1u l=1u
X492 iqmod_mfb_lpf_pex_half_0.iqmod_mfb_lpf_pex_ota_core_hybrid_bm_half_0.iqmod_mfb_lpf_pex_ota_core_spdt_switch$1_0.iqmod_mfb_lpf_pex_ota_core_spdt_switch_inv$2_0.vout iqmod_mfb_lpf_pex_half_0.iqmod_mfb_lpf_pex_ota_core_hybrid_bm_half_0.iqmod_mfb_lpf_pex_ota_core_tg$1_0.di_tg_ctrl_n VDD VDD sg13_lv_pmos ad=1.14p pd=6.38u as=1.14p ps=6.38u w=6u l=0.13u
X493 iqmod_mfb_lpf_pex_half_0.iqmod_mfb_lpf_pex_ota_core_hybrid_bm_half_0.iqmod_mfb_lpf_pex_ota_core_inv_NF20$1_1.vin iqmod_mfb_lpf_pex_half_0.iqmod_mfb_lpf_pex_ota_core_hybrid_bm_half_0.iqmod_mfb_lpf_pex_ota_core_tg$1_0.di_tg_ctrl_n vinp VDD sg13_lv_pmos ad=1.14p pd=6.38u as=2.04p ps=12.68u w=6u l=0.13u
X494 iqmod_mfb_lpf_pex_half_1.iqmod_mfb_lpf_pex_ota_core_hybrid_bm_half_0.iqmod_mfb_lpf_pex_ota_core_tg$1_0.v_b iqmod_mfb_lpf_pex_half_0.iqmod_mfb_lpf_pex_ota_core_hybrid_bm_half_0.iqmod_mfb_lpf_pex_ota_core_tg$1_0.di_tg_ctrl_n iqmod_mfb_lpf_pex_half_1.iqmod_mfb_lpf_pex_ota_core_hybrid_bm_half_0.iqmod_mfb_lpf_pex_ota_core_tg$1_0.v_a VDD sg13_lv_pmos ad=1.14p pd=6.38u as=2.04p ps=12.68u w=6u l=0.13u
X495 VDD VDD VDD VDD sg13_lv_pmos ad=2.04p pd=12.68u as=0 ps=0 w=6u l=1u
X496 VSS iqmod_mfb_lpf_pex_half_1.iqmod_mfb_lpf_pex_ota_core_hybrid_bm_half_0.iqmod_mfb_lpf_pex_ota_core_inv_NF6$1_1.vout iqmod_mfb_lpf_pex_half_1.iqmod_mfb_lpf_pex_ota_core_hybrid_bm_half_0.iqmod_mfb_lpf_pex_ota_core_tg$1_0.v_b VSS sg13_lv_nmos ad=0.19p pd=1.38u as=0.19p ps=1.38u w=1u l=1u
X497 VSS VSS VSS VSS sg13_lv_nmos ad=0.19p pd=1.38u as=0 ps=0 w=1u l=0.13u
X498 VSS iqmod_mfb_lpf_pex_half_1.iqmod_mfb_lpf_pex_ota_core_hybrid_bm_half_0.iqmod_mfb_lpf_pex_ota_core_tg$1_0.v_b voutn VSS sg13_lv_nmos ad=0.19p pd=1.38u as=0.19p ps=1.38u w=1u l=1u
X499 iqmod_mfb_lpf_pex_half_1.iqmod_mfb_lpf_pex_ota_core_hybrid_bm_half_0.iqmod_mfb_lpf_pex_ota_core_tg$1_0.v_b iqmod_mfb_lpf_pex_half_1.iqmod_mfb_lpf_pex_ota_core_hybrid_bm_half_0.iqmod_mfb_lpf_pex_ota_core_tg$1_0.v_a VSS VSS sg13_lv_nmos ad=0.19p pd=1.38u as=0.19p ps=1.38u w=1u l=1u
X500 VDD iqmod_mfb_lpf_pex_half_1.iqmod_mfb_lpf_pex_ota_core_hybrid_bm_half_0.iqmod_mfb_lpf_pex_ota_core_tg$1_0.v_a iqmod_mfb_lpf_pex_half_1.iqmod_mfb_lpf_pex_ota_core_hybrid_bm_half_0.iqmod_mfb_lpf_pex_ota_core_tg$1_0.v_b VDD sg13_lv_pmos ad=1.14p pd=6.38u as=1.14p ps=6.38u w=6u l=1u
X501 VDD voutn iqmod_mfb_lpf_pex_half_1.iqmod_mfb_lpf_pex_ota_core_hybrid_bm_half_0.iqmod_mfb_lpf_pex_ota_core_inv_NF20$1_0.vout VDD sg13_lv_pmos ad=1.14p pd=6.38u as=1.14p ps=6.38u w=6u l=1u
X502 VSS VSS VSS VSS sg13_lv_nmos ad=0.34p pd=2.68u as=0 ps=0 w=1u l=1u
X503 iqmod_mfb_lpf_pex_half_1.iqmod_mfb_lpf_pex_ota_core_hybrid_bm_half_0.iqmod_mfb_lpf_pex_ota_core_inv_NF6$1_1.vout iqmod_mfb_lpf_pex_half_1.iqmod_mfb_lpf_pex_ota_core_hybrid_bm_half_0.iqmod_mfb_lpf_pex_ota_core_inv_NF20$1_0.vout VSS VSS sg13_lv_nmos ad=0.19p pd=1.38u as=0.19p ps=1.38u w=1u l=1u
X504 VSS VSS VSS rhigh l=60u w=0.5u
X505 iqmod_mfb_lpf_pex_half_1.iqmod_mfb_lpf_pex_ota_core_hybrid_bm_half_0.iqmod_mfb_lpf_pex_ota_core_tg$1_0.v_b iqmod_mfb_lpf_pex_half_1.iqmod_mfb_lpf_pex_ota_core_hybrid_bm_half_0.iqmod_mfb_lpf_pex_ota_core_tg$1_0.v_a VDD VDD sg13_lv_pmos ad=1.14p pd=6.38u as=1.14p ps=6.38u w=6u l=1u
X506 iqmod_mfb_lpf_pex_half_0.iqmod_mfb_lpf_pex_ota_core_hybrid_bm_half_0.iqmod_mfb_lpf_pex_ota_core_inv_NF20$1_1.vin iqmod_mfb_lpf_pex_half_0.iqmod_mfb_lpf_pex_ota_core_hybrid_bm_half_0.iqmod_mfb_lpf_pex_ota_core_spdt_switch$1_0.iqmod_mfb_lpf_pex_ota_core_spdt_switch_inv$2_0.vout vinp VSS sg13_lv_nmos ad=0.19p pd=1.38u as=0.19p ps=1.38u w=1u l=0.13u
X507 VSS iqmod_mfb_lpf_pex_half_1.iqmod_mfb_lpf_pex_ota_core_hybrid_bm_half_0.iqmod_mfb_lpf_pex_ota_core_inv_NF20$1_0.vout iqmod_mfb_lpf_pex_half_1.iqmod_mfb_lpf_pex_ota_core_hybrid_bm_half_0.iqmod_mfb_lpf_pex_ota_core_inv_NF6$1_1.vout VSS sg13_lv_nmos ad=0.19p pd=1.38u as=0.19p ps=1.38u w=1u l=1u
X508 VSS voutn iqmod_mfb_lpf_pex_half_1.iqmod_mfb_lpf_pex_ota_core_hybrid_bm_half_0.iqmod_mfb_lpf_pex_ota_core_inv_NF20$1_0.vout VSS sg13_lv_nmos ad=0.19p pd=1.38u as=0.19p ps=1.38u w=1u l=1u
X509 voutp iqmod_mfb_lpf_pex_half_1.iqmod_mfb_lpf_pex_ota_core_hybrid_bm_half_0.iqmod_mfb_lpf_pex_ota_core_inv_NF20$1_1.vin VDD VDD sg13_lv_pmos ad=1.14p pd=6.38u as=1.14p ps=6.38u w=6u l=1u
X510 VSS iqmod_mfb_lpf_pex_half_1.iqmod_mfb_lpf_pex_ota_core_hybrid_bm_half_0.iqmod_mfb_lpf_pex_ota_core_tg$1_0.v_b voutn VSS sg13_lv_nmos ad=0.19p pd=1.38u as=0.19p ps=1.38u w=1u l=1u
X511 VSS iqmod_mfb_lpf_pex_half_0.iqmod_mfb_lpf_pex_ota_core_hybrid_bm_half_0.iqmod_mfb_lpf_pex_ota_core_inv_NF20$1_1.vin iqmod_mfb_lpf_pex_half_1.iqmod_mfb_lpf_pex_ota_core_hybrid_bm_half_0.iqmod_mfb_lpf_pex_ota_core_tg$1_0.v_a VSS sg13_lv_nmos ad=0.19p pd=1.38u as=0.19p ps=1.38u w=1u l=1u
X512 voutp iqmod_mfb_lpf_pex_half_1.iqmod_mfb_lpf_pex_ota_core_hybrid_bm_half_0.iqmod_mfb_lpf_pex_ota_core_tg$1_0.v_b VSS VSS sg13_lv_nmos ad=0.19p pd=1.38u as=0.19p ps=1.38u w=1u l=1u
X513 VDD iqmod_mfb_lpf_pex_half_1.iqmod_mfb_lpf_pex_ota_core_hybrid_bm_half_0.iqmod_mfb_lpf_pex_ota_core_inv_NF20$1_0.vout iqmod_mfb_lpf_pex_half_1.iqmod_mfb_lpf_pex_ota_core_hybrid_bm_half_0.iqmod_mfb_lpf_pex_ota_core_inv_NF6$1_1.vout VDD sg13_lv_pmos ad=1.14p pd=6.38u as=1.14p ps=6.38u w=6u l=1u
X514 VDD voutp iqmod_mfb_lpf_pex_half_1.iqmod_mfb_lpf_pex_ota_core_hybrid_bm_half_0.iqmod_mfb_lpf_pex_ota_core_inv_NF20$1_0.vout VDD sg13_lv_pmos ad=1.14p pd=6.38u as=1.14p ps=6.38u w=6u l=1u
X515 iqmod_mfb_lpf_pex_half_1.iqmod_mfb_lpf_pex_R2_0.v_a iqmod_mfb_lpf_pex_half_1.C2_half cap_cmim l=8u w=8u
X516 iqmod_mfb_lpf_pex_half_1.iqmod_mfb_lpf_pex_ota_core_hybrid_bm_half_0.iqmod_mfb_lpf_pex_ota_core_inv_NF6$1_1.vout iqmod_mfb_lpf_pex_half_1.iqmod_mfb_lpf_pex_ota_core_hybrid_bm_half_0.iqmod_mfb_lpf_pex_ota_core_inv_NF20$1_0.vout VSS VSS sg13_lv_nmos ad=0.19p pd=1.38u as=0.19p ps=1.38u w=1u l=1u
X517 iqmod_mfb_lpf_pex_half_1.iqmod_mfb_lpf_pex_ota_core_hybrid_bm_half_0.iqmod_mfb_lpf_pex_ota_core_inv_NF6$1_1.vout iqmod_mfb_lpf_pex_half_0.iqmod_mfb_lpf_pex_ota_core_hybrid_bm_half_0.iqmod_mfb_lpf_pex_ota_core_tg$1_0.di_tg_ctrl_n iqmod_mfb_lpf_pex_half_1.iqmod_mfb_lpf_pex_ota_core_hybrid_bm_half_0.iqmod_mfb_lpf_pex_ota_core_inv_NF20$1_0.vout VDD sg13_lv_pmos ad=1.14p pd=6.38u as=2.04p ps=12.68u w=6u l=0.13u
X518 iqmod_mfb_lpf_pex_half_1.iqmod_mfb_lpf_pex_ota_core_hybrid_bm_half_0.iqmod_mfb_lpf_pex_ota_core_inv_NF20$1_0.vout voutp VDD VDD sg13_lv_pmos ad=1.14p pd=6.38u as=1.14p ps=6.38u w=6u l=1u
X519 VSS iqmod_mfb_lpf_pex_half_1.iqmod_mfb_lpf_pex_ota_core_hybrid_bm_half_0.iqmod_mfb_lpf_pex_ota_core_inv_NF20$1_1.vin voutp VSS sg13_lv_nmos ad=0.19p pd=1.38u as=0.19p ps=1.38u w=1u l=1u
X520 iqmod_mfb_lpf_pex_half_1.iqmod_mfb_lpf_pex_ota_core_hybrid_bm_half_0.iqmod_mfb_lpf_pex_ota_core_inv_NF20$1_0.vout iqmod_mfb_lpf_pex_half_1.iqmod_mfb_lpf_pex_ota_core_hybrid_bm_half_0.iqmod_mfb_lpf_pex_ota_core_tg$1_0.di_tg_ctrl_n iqmod_mfb_lpf_pex_half_1.iqmod_mfb_lpf_pex_ota_core_hybrid_bm_half_0.iqmod_mfb_lpf_pex_ota_core_inv_NF6$1_1.vout VDD sg13_lv_pmos ad=2.04p pd=12.68u as=1.14p ps=6.38u w=6u l=0.13u
X521 iqmod_mfb_lpf_pex_half_1.iqmod_mfb_lpf_pex_R2_0.v_a iqmod_mfb_lpf_pex_half_1.C2_half cap_cmim l=8u w=8u
X522 VDD iqmod_mfb_lpf_pex_half_1.iqmod_mfb_lpf_pex_ota_core_hybrid_bm_half_0.iqmod_mfb_lpf_pex_ota_core_tg$1_0.v_b voutn VDD sg13_lv_pmos ad=1.14p pd=6.38u as=1.14p ps=6.38u w=6u l=1u
X523 VSS VSS VSS VSS sg13_lv_nmos ad=0.19p pd=1.38u as=0 ps=0 w=1u l=1u
X524 a_636_4203# a_6122_3903# VSS rhigh l=27u w=0.5u
X525 iqmod_mfb_lpf_pex_half_1.iqmod_mfb_lpf_pex_ota_core_hybrid_bm_half_0.iqmod_mfb_lpf_pex_ota_core_inv_NF20$1_1.vin iqmod_mfb_lpf_pex_half_1.iqmod_mfb_lpf_pex_ota_core_hybrid_bm_half_0.iqmod_mfb_lpf_pex_ota_core_spdt_switch$1_0.iqmod_mfb_lpf_pex_ota_core_spdt_switch_inv$2_0.vout VDD VDD sg13_lv_pmos ad=1.14p pd=6.38u as=1.14p ps=6.38u w=6u l=0.13u
X526 VSS VSS VSS VSS sg13_lv_nmos ad=0.34p pd=2.68u as=0 ps=0 w=1u l=1u
X527 voutp iqmod_mfb_lpf_pex_half_1.iqmod_mfb_lpf_pex_ota_core_hybrid_bm_half_0.iqmod_mfb_lpf_pex_ota_core_inv_NF20$1_1.vin VSS VSS sg13_lv_nmos ad=0.19p pd=1.38u as=0.19p ps=1.38u w=1u l=1u
X528 iqmod_mfb_lpf_pex_half_1.iqmod_mfb_lpf_pex_ota_core_hybrid_bm_half_0.iqmod_mfb_lpf_pex_ota_core_inv_NF20$1_0.vout di_filter_en iqmod_mfb_lpf_pex_half_1.iqmod_mfb_lpf_pex_ota_core_hybrid_bm_half_0.iqmod_mfb_lpf_pex_ota_core_inv_NF6$1_1.vout VSS sg13_lv_nmos ad=0.19p pd=1.38u as=0.19p ps=1.38u w=1u l=0.13u
X529 VSS voutp iqmod_mfb_lpf_pex_half_1.iqmod_mfb_lpf_pex_ota_core_hybrid_bm_half_0.iqmod_mfb_lpf_pex_ota_core_inv_NF20$1_0.vout VSS sg13_lv_nmos ad=0.19p pd=1.38u as=0.19p ps=1.38u w=1u l=1u
X530 iqmod_mfb_lpf_pex_half_1.iqmod_mfb_lpf_pex_ota_core_hybrid_bm_half_0.iqmod_mfb_lpf_pex_ota_core_tg$1_0.v_a iqmod_mfb_lpf_pex_half_1.iqmod_mfb_lpf_pex_ota_core_hybrid_bm_half_0.iqmod_mfb_lpf_pex_ota_core_inv_NF20$1_1.vin VSS VSS sg13_lv_nmos ad=0.19p pd=1.38u as=0.19p ps=1.38u w=1u l=1u
X531 vinp iqmod_mfb_lpf_pex_half_0.iqmod_mfb_lpf_pex_ota_core_hybrid_bm_half_0.iqmod_mfb_lpf_pex_ota_core_tg$1_0.di_tg_ctrl_n iqmod_mfb_lpf_pex_half_0.iqmod_mfb_lpf_pex_ota_core_hybrid_bm_half_0.iqmod_mfb_lpf_pex_ota_core_inv_NF20$1_1.vin VDD sg13_lv_pmos ad=1.14p pd=6.38u as=1.14p ps=6.38u w=6u l=0.13u
X532 voutn iqmod_mfb_lpf_pex_half_0.iqmod_mfb_lpf_pex_ota_core_hybrid_bm_half_0.iqmod_mfb_lpf_pex_ota_core_inv_NF20$1_1.vin VDD VDD sg13_lv_pmos ad=1.14p pd=6.38u as=1.14p ps=6.38u w=6u l=1u
X533 voutp iqmod_mfb_lpf_pex_half_1.iqmod_mfb_lpf_pex_ota_core_hybrid_bm_half_0.iqmod_mfb_lpf_pex_ota_core_inv_NF20$1_1.vin VSS VSS sg13_lv_nmos ad=0.19p pd=1.38u as=0.19p ps=1.38u w=1u l=1u
X534 iqmod_mfb_lpf_pex_half_1.iqmod_mfb_lpf_pex_ota_core_hybrid_bm_half_0.iqmod_mfb_lpf_pex_ota_core_tg$1_0.v_a iqmod_mfb_lpf_pex_half_0.iqmod_mfb_lpf_pex_ota_core_hybrid_bm_half_0.iqmod_mfb_lpf_pex_ota_core_inv_NF20$1_1.vin VDD VDD sg13_lv_pmos ad=1.14p pd=6.38u as=1.14p ps=6.38u w=6u l=1u
X535 vinp iqmod_mfb_lpf_pex_half_0.iqmod_mfb_lpf_pex_ota_core_hybrid_bm_half_0.iqmod_mfb_lpf_pex_ota_core_spdt_switch$1_0.iqmod_mfb_lpf_pex_ota_core_spdt_switch_inv$2_0.vout iqmod_mfb_lpf_pex_half_0.iqmod_mfb_lpf_pex_ota_core_hybrid_bm_half_0.iqmod_mfb_lpf_pex_ota_core_inv_NF20$1_1.vin VSS sg13_lv_nmos ad=0.34p pd=2.68u as=0.19p ps=1.38u w=1u l=0.13u
X536 VDD iqmod_mfb_lpf_pex_half_0.iqmod_mfb_lpf_pex_ota_core_hybrid_bm_half_0.iqmod_mfb_lpf_pex_ota_core_inv_NF20$1_1.vin voutn VDD sg13_lv_pmos ad=1.14p pd=6.38u as=1.14p ps=6.38u w=6u l=1u
X537 VDD VDD VDD VDD sg13_lv_pmos ad=1.14p pd=6.38u as=0 ps=0 w=6u l=0.13u
X538 vinn iqmod_mfb_lpf_pex_half_1.iqmod_mfb_lpf_pex_ota_core_hybrid_bm_half_0.iqmod_mfb_lpf_pex_ota_core_spdt_switch$1_0.iqmod_mfb_lpf_pex_ota_core_spdt_switch_inv$2_0.vout iqmod_mfb_lpf_pex_half_1.iqmod_mfb_lpf_pex_ota_core_hybrid_bm_half_0.iqmod_mfb_lpf_pex_ota_core_inv_NF20$1_1.vin VSS sg13_lv_nmos ad=0.34p pd=2.68u as=0.19p ps=1.38u w=1u l=0.13u
X539 VSS VSS VSS VSS sg13_lv_nmos ad=0.34p pd=2.68u as=0 ps=0 w=1u l=1u
X540 iqmod_mfb_lpf_pex_half_1.iqmod_mfb_lpf_pex_ota_core_hybrid_bm_half_0.iqmod_mfb_lpf_pex_ota_core_tg$1_0.v_b di_filter_en iqmod_mfb_lpf_pex_half_1.iqmod_mfb_lpf_pex_ota_core_hybrid_bm_half_0.iqmod_mfb_lpf_pex_ota_core_tg$1_0.v_a VSS sg13_lv_nmos ad=0.19p pd=1.38u as=0.19p ps=1.38u w=1u l=0.13u
X541 VDD iqmod_mfb_lpf_pex_half_0.iqmod_mfb_lpf_pex_ota_core_hybrid_bm_half_0.iqmod_mfb_lpf_pex_ota_core_inv_NF20$1_1.vin iqmod_mfb_lpf_pex_half_1.iqmod_mfb_lpf_pex_ota_core_hybrid_bm_half_0.iqmod_mfb_lpf_pex_ota_core_tg$1_0.v_a VDD sg13_lv_pmos ad=1.14p pd=6.38u as=1.14p ps=6.38u w=6u l=1u
X542 VDD VDD VDD VDD sg13_lv_pmos ad=1.14p pd=6.38u as=0 ps=0 w=6u l=1u
X543 VDD iqmod_mfb_lpf_pex_half_1.iqmod_mfb_lpf_pex_ota_core_hybrid_bm_half_0.iqmod_mfb_lpf_pex_ota_core_tg$1_0.di_tg_ctrl_n iqmod_mfb_lpf_pex_half_1.iqmod_mfb_lpf_pex_ota_core_hybrid_bm_half_0.iqmod_mfb_lpf_pex_ota_core_spdt_switch$1_0.iqmod_mfb_lpf_pex_ota_core_spdt_switch_inv$2_0.vout VDD sg13_lv_pmos ad=1.14p pd=6.38u as=1.14p ps=6.38u w=6u l=0.13u
X544 iqmod_mfb_lpf_pex_half_1.iqmod_mfb_lpf_pex_ota_core_hybrid_bm_half_0.iqmod_mfb_lpf_pex_ota_core_tg$1_0.v_a di_filter_en iqmod_mfb_lpf_pex_half_1.iqmod_mfb_lpf_pex_ota_core_hybrid_bm_half_0.iqmod_mfb_lpf_pex_ota_core_tg$1_0.v_b VSS sg13_lv_nmos ad=0.19p pd=1.38u as=0.19p ps=1.38u w=1u l=0.13u
X545 VSS iqmod_mfb_lpf_pex_half_1.iqmod_mfb_lpf_pex_ota_core_hybrid_bm_half_0.iqmod_mfb_lpf_pex_ota_core_inv_NF6$1_1.vout iqmod_mfb_lpf_pex_half_1.iqmod_mfb_lpf_pex_ota_core_hybrid_bm_half_0.iqmod_mfb_lpf_pex_ota_core_tg$1_0.v_b VSS sg13_lv_nmos ad=0.19p pd=1.38u as=0.19p ps=1.38u w=1u l=1u
X546 voutn iqmod_mfb_lpf_pex_half_1.iqmod_mfb_lpf_pex_ota_core_hybrid_bm_half_0.iqmod_mfb_lpf_pex_ota_core_tg$1_0.v_b VSS VSS sg13_lv_nmos ad=0.19p pd=1.38u as=0.19p ps=1.38u w=1u l=1u
X547 VDD iqmod_mfb_lpf_pex_half_1.iqmod_mfb_lpf_pex_ota_core_hybrid_bm_half_0.iqmod_mfb_lpf_pex_ota_core_inv_NF6$1_1.vout iqmod_mfb_lpf_pex_half_1.iqmod_mfb_lpf_pex_ota_core_hybrid_bm_half_0.iqmod_mfb_lpf_pex_ota_core_tg$1_0.v_b VDD sg13_lv_pmos ad=1.14p pd=6.38u as=1.14p ps=6.38u w=6u l=1u
X548 VSS iqmod_mfb_lpf_pex_half_1.iqmod_mfb_lpf_pex_ota_core_hybrid_bm_half_0.iqmod_mfb_lpf_pex_ota_core_inv_NF20$1_0.vout iqmod_mfb_lpf_pex_half_1.iqmod_mfb_lpf_pex_ota_core_hybrid_bm_half_0.iqmod_mfb_lpf_pex_ota_core_inv_NF6$1_1.vout VSS sg13_lv_nmos ad=0.19p pd=1.38u as=0.19p ps=1.38u w=1u l=1u
X549 iqmod_mfb_lpf_pex_half_1.iqmod_mfb_lpf_pex_ota_core_hybrid_bm_half_0.iqmod_mfb_lpf_pex_ota_core_tg$1_0.v_b iqmod_mfb_lpf_pex_half_1.iqmod_mfb_lpf_pex_ota_core_hybrid_bm_half_0.iqmod_mfb_lpf_pex_ota_core_tg$1_0.v_a VDD VDD sg13_lv_pmos ad=1.14p pd=6.38u as=1.14p ps=6.38u w=6u l=1u
X550 voutp iqmod_mfb_lpf_pex_half_1.iqmod_mfb_lpf_pex_ota_core_hybrid_bm_half_0.iqmod_mfb_lpf_pex_ota_core_inv_NF20$1_1.vin VDD VDD sg13_lv_pmos ad=1.14p pd=6.38u as=1.14p ps=6.38u w=6u l=1u
X551 VSS VSS VSS VSS sg13_lv_nmos ad=0.34p pd=2.68u as=0 ps=0 w=1u l=0.13u
X552 iqmod_mfb_lpf_pex_half_1.iqmod_mfb_lpf_pex_ota_core_hybrid_bm_half_0.iqmod_mfb_lpf_pex_ota_core_inv_NF20$1_1.vin iqmod_mfb_lpf_pex_half_1.iqmod_mfb_lpf_pex_ota_core_hybrid_bm_half_0.iqmod_mfb_lpf_pex_ota_core_tg$1_0.di_tg_ctrl_n vinn VDD sg13_lv_pmos ad=1.14p pd=6.38u as=1.14p ps=6.38u w=6u l=0.13u
X553 VDD iqmod_mfb_lpf_pex_half_1.iqmod_mfb_lpf_pex_ota_core_hybrid_bm_half_0.iqmod_mfb_lpf_pex_ota_core_tg$1_0.v_a iqmod_mfb_lpf_pex_half_1.iqmod_mfb_lpf_pex_ota_core_hybrid_bm_half_0.iqmod_mfb_lpf_pex_ota_core_tg$1_0.v_b VDD sg13_lv_pmos ad=1.14p pd=6.38u as=1.14p ps=6.38u w=6u l=1u
X554 iqmod_mfb_lpf_pex_half_1.iqmod_mfb_lpf_pex_ota_core_hybrid_bm_half_0.iqmod_mfb_lpf_pex_ota_core_tg$1_0.v_a iqmod_mfb_lpf_pex_half_1.iqmod_mfb_lpf_pex_ota_core_hybrid_bm_half_0.iqmod_mfb_lpf_pex_ota_core_inv_NF20$1_1.vin VDD VDD sg13_lv_pmos ad=1.14p pd=6.38u as=1.14p ps=6.38u w=6u l=1u
X555 VSS VSS VSS VSS sg13_lv_nmos ad=0.34p pd=2.68u as=0 ps=0 w=1u l=1u
X556 iqmod_mfb_lpf_pex_half_1.iqmod_mfb_lpf_pex_ota_core_hybrid_bm_half_0.iqmod_mfb_lpf_pex_ota_core_inv_NF20$1_0.vout voutp VSS VSS sg13_lv_nmos ad=0.19p pd=1.38u as=0.19p ps=1.38u w=1u l=1u
X557 iqmod_mfb_lpf_pex_half_1.iqmod_mfb_lpf_pex_ota_core_hybrid_bm_half_0.iqmod_mfb_lpf_pex_ota_core_tg$1_0.v_b iqmod_mfb_lpf_pex_half_1.iqmod_mfb_lpf_pex_ota_core_hybrid_bm_half_0.iqmod_mfb_lpf_pex_ota_core_inv_NF6$1_1.vout VSS VSS sg13_lv_nmos ad=0.19p pd=1.38u as=0.19p ps=1.38u w=1u l=1u
X558 iqmod_mfb_lpf_pex_half_1.iqmod_mfb_lpf_pex_ota_core_hybrid_bm_half_0.iqmod_mfb_lpf_pex_ota_core_inv_NF20$1_0.vout voutn VSS VSS sg13_lv_nmos ad=0.19p pd=1.38u as=0.19p ps=1.38u w=1u l=1u
X559 VDD VDD VDD VDD sg13_lv_pmos ad=2.04p pd=12.68u as=0 ps=0 w=6u l=1u
X560 voutp iqmod_mfb_lpf_pex_half_1.iqmod_mfb_lpf_pex_ota_core_hybrid_bm_half_0.iqmod_mfb_lpf_pex_ota_core_tg$1_0.v_b VDD VDD sg13_lv_pmos ad=1.14p pd=6.38u as=1.14p ps=6.38u w=6u l=1u
X561 VDD iqmod_mfb_lpf_pex_half_1.iqmod_mfb_lpf_pex_ota_core_hybrid_bm_half_0.iqmod_mfb_lpf_pex_ota_core_spdt_switch$1_0.iqmod_mfb_lpf_pex_ota_core_spdt_switch_inv$2_0.vout iqmod_mfb_lpf_pex_half_1.iqmod_mfb_lpf_pex_ota_core_hybrid_bm_half_0.iqmod_mfb_lpf_pex_ota_core_inv_NF20$1_1.vin VDD sg13_lv_pmos ad=1.14p pd=6.38u as=1.14p ps=6.38u w=6u l=0.13u
X562 VDD iqmod_mfb_lpf_pex_half_1.iqmod_mfb_lpf_pex_ota_core_hybrid_bm_half_0.iqmod_mfb_lpf_pex_ota_core_inv_NF20$1_1.vin voutp VDD sg13_lv_pmos ad=1.14p pd=6.38u as=1.14p ps=6.38u w=6u l=1u
X563 voutn iqmod_mfb_lpf_pex_half_1.iqmod_mfb_lpf_pex_ota_core_hybrid_bm_half_0.iqmod_mfb_lpf_pex_ota_core_tg$1_0.v_b VSS VSS sg13_lv_nmos ad=0.19p pd=1.38u as=0.19p ps=1.38u w=1u l=1u
X564 voutp iqmod_mfb_lpf_pex_half_1.iqmod_mfb_lpf_pex_ota_core_hybrid_bm_half_0.iqmod_mfb_lpf_pex_ota_core_inv_NF20$1_1.vin VSS VSS sg13_lv_nmos ad=0.19p pd=1.38u as=0.19p ps=1.38u w=1u l=1u
X565 a_636_4203# iqmod_mfb_lpf_pex_half_1.C1_half VSS rhigh l=27u w=0.5u
X566 VDD VDD VDD VDD sg13_lv_pmos ad=1.14p pd=6.38u as=0 ps=0 w=6u l=1u
X567 VSS VSS VSS rhigh l=59u w=0.5u
X568 VDD iqmod_mfb_lpf_pex_half_1.iqmod_mfb_lpf_pex_ota_core_hybrid_bm_half_0.iqmod_mfb_lpf_pex_ota_core_inv_NF20$1_0.vout iqmod_mfb_lpf_pex_half_1.iqmod_mfb_lpf_pex_ota_core_hybrid_bm_half_0.iqmod_mfb_lpf_pex_ota_core_inv_NF6$1_1.vout VDD sg13_lv_pmos ad=1.14p pd=6.38u as=1.14p ps=6.38u w=6u l=1u
X569 VDD VDD VDD VDD sg13_lv_pmos ad=1.14p pd=6.38u as=0 ps=0 w=6u l=1u
X570 VSS VSS VSS rhigh l=27u w=0.5u
X571 VDD iqmod_mfb_lpf_pex_half_1.iqmod_mfb_lpf_pex_ota_core_hybrid_bm_half_0.iqmod_mfb_lpf_pex_ota_core_inv_NF20$1_1.vin iqmod_mfb_lpf_pex_half_1.iqmod_mfb_lpf_pex_ota_core_hybrid_bm_half_0.iqmod_mfb_lpf_pex_ota_core_tg$1_0.v_a VDD sg13_lv_pmos ad=1.14p pd=6.38u as=1.14p ps=6.38u w=6u l=1u
X572 iqmod_mfb_lpf_pex_half_1.iqmod_mfb_lpf_pex_ota_core_hybrid_bm_half_0.iqmod_mfb_lpf_pex_ota_core_inv_NF20$1_0.vout voutn VDD VDD sg13_lv_pmos ad=1.14p pd=6.38u as=1.14p ps=6.38u w=6u l=1u
X573 iqmod_mfb_lpf_pex_half_1.iqmod_mfb_lpf_pex_ota_core_hybrid_bm_half_0.iqmod_mfb_lpf_pex_ota_core_inv_NF6$1_1.vout di_filter_en iqmod_mfb_lpf_pex_half_1.iqmod_mfb_lpf_pex_ota_core_hybrid_bm_half_0.iqmod_mfb_lpf_pex_ota_core_inv_NF20$1_0.vout VSS sg13_lv_nmos ad=0.19p pd=1.38u as=0.19p ps=1.38u w=1u l=0.13u
X574 voutn iqmod_mfb_lpf_pex_half_0.iqmod_mfb_lpf_pex_ota_core_hybrid_bm_half_0.iqmod_mfb_lpf_pex_ota_core_inv_NF20$1_1.vin VSS VSS sg13_lv_nmos ad=0.19p pd=1.38u as=0.19p ps=1.38u w=1u l=1u
X575 VSS VSS VSS VSS sg13_lv_nmos ad=0.19p pd=1.38u as=0 ps=0 w=1u l=1u
X576 VSS VSS VSS VSS sg13_lv_nmos ad=0.34p pd=2.68u as=0 ps=0 w=1u l=1u
X577 VSS voutn iqmod_mfb_lpf_pex_half_1.iqmod_mfb_lpf_pex_ota_core_hybrid_bm_half_0.iqmod_mfb_lpf_pex_ota_core_inv_NF20$1_0.vout VSS sg13_lv_nmos ad=0.19p pd=1.38u as=0.19p ps=1.38u w=1u l=1u
X578 iqmod_mfb_lpf_pex_half_1.iqmod_mfb_lpf_pex_ota_core_hybrid_bm_half_0.iqmod_mfb_lpf_pex_ota_core_inv_NF6$1_1.vout iqmod_mfb_lpf_pex_half_1.iqmod_mfb_lpf_pex_ota_core_hybrid_bm_half_0.iqmod_mfb_lpf_pex_ota_core_inv_NF20$1_0.vout VDD VDD sg13_lv_pmos ad=1.14p pd=6.38u as=1.14p ps=6.38u w=6u l=1u
X579 VDD voutn iqmod_mfb_lpf_pex_half_1.iqmod_mfb_lpf_pex_ota_core_hybrid_bm_half_0.iqmod_mfb_lpf_pex_ota_core_inv_NF20$1_0.vout VDD sg13_lv_pmos ad=1.14p pd=6.38u as=1.14p ps=6.38u w=6u l=1u
X580 iqmod_mfb_lpf_pex_half_1.iqmod_mfb_lpf_pex_ota_core_hybrid_bm_half_0.iqmod_mfb_lpf_pex_ota_core_tg$1_0.v_b iqmod_mfb_lpf_pex_half_1.iqmod_mfb_lpf_pex_ota_core_hybrid_bm_half_0.iqmod_mfb_lpf_pex_ota_core_tg$1_0.v_a VSS VSS sg13_lv_nmos ad=0.19p pd=1.38u as=0.19p ps=1.38u w=1u l=1u
X581 VDD iqmod_mfb_lpf_pex_half_0.iqmod_mfb_lpf_pex_ota_core_hybrid_bm_half_0.iqmod_mfb_lpf_pex_ota_core_spdt_switch$1_0.iqmod_mfb_lpf_pex_ota_core_spdt_switch_inv$2_0.vout iqmod_mfb_lpf_pex_half_0.iqmod_mfb_lpf_pex_ota_core_hybrid_bm_half_0.iqmod_mfb_lpf_pex_ota_core_inv_NF20$1_1.vin VDD sg13_lv_pmos ad=1.14p pd=6.38u as=1.14p ps=6.38u w=6u l=0.13u
X582 VDD iqmod_mfb_lpf_pex_half_1.iqmod_mfb_lpf_pex_ota_core_hybrid_bm_half_0.iqmod_mfb_lpf_pex_ota_core_tg$1_0.di_tg_ctrl_n iqmod_mfb_lpf_pex_half_1.iqmod_mfb_lpf_pex_ota_core_hybrid_bm_half_0.iqmod_mfb_lpf_pex_ota_core_inv_NF20$1_1.vin VSS sg13_lv_nmos ad=0.34p pd=2.68u as=0.19p ps=1.38u w=1u l=0.13u
X583 VSS iqmod_mfb_lpf_pex_half_1.iqmod_mfb_lpf_pex_ota_core_hybrid_bm_half_0.iqmod_mfb_lpf_pex_ota_core_inv_NF6$1_1.vout iqmod_mfb_lpf_pex_half_1.iqmod_mfb_lpf_pex_ota_core_hybrid_bm_half_0.iqmod_mfb_lpf_pex_ota_core_tg$1_0.v_b VSS sg13_lv_nmos ad=0.19p pd=1.38u as=0.19p ps=1.38u w=1u l=1u
X584 voutn iqmod_mfb_lpf_pex_half_1.iqmod_mfb_lpf_pex_ota_core_hybrid_bm_half_0.iqmod_mfb_lpf_pex_ota_core_tg$1_0.v_b VDD VDD sg13_lv_pmos ad=1.14p pd=6.38u as=1.14p ps=6.38u w=6u l=1u
X585 VDD iqmod_mfb_lpf_pex_half_1.iqmod_mfb_lpf_pex_ota_core_hybrid_bm_half_0.iqmod_mfb_lpf_pex_ota_core_tg$1_0.v_a iqmod_mfb_lpf_pex_half_1.iqmod_mfb_lpf_pex_ota_core_hybrid_bm_half_0.iqmod_mfb_lpf_pex_ota_core_tg$1_0.v_b VDD sg13_lv_pmos ad=1.14p pd=6.38u as=1.14p ps=6.38u w=6u l=1u
X586 VSS iqmod_mfb_lpf_pex_half_1.iqmod_mfb_lpf_pex_ota_core_hybrid_bm_half_0.iqmod_mfb_lpf_pex_ota_core_tg$1_0.v_a iqmod_mfb_lpf_pex_half_1.iqmod_mfb_lpf_pex_ota_core_hybrid_bm_half_0.iqmod_mfb_lpf_pex_ota_core_tg$1_0.v_b VSS sg13_lv_nmos ad=0.19p pd=1.38u as=0.19p ps=1.38u w=1u l=1u
X587 VSS voutp iqmod_mfb_lpf_pex_half_1.iqmod_mfb_lpf_pex_ota_core_hybrid_bm_half_0.iqmod_mfb_lpf_pex_ota_core_inv_NF20$1_0.vout VSS sg13_lv_nmos ad=0.19p pd=1.38u as=0.19p ps=1.38u w=1u l=1u
X588 VSS di_filter_en iqmod_mfb_lpf_pex_half_1.iqmod_mfb_lpf_pex_ota_core_hybrid_bm_half_0.iqmod_mfb_lpf_pex_ota_core_tg$1_0.di_tg_ctrl_n VSS sg13_lv_nmos ad=0.19p pd=1.38u as=0.19p ps=1.38u w=1u l=0.13u
X589 iqmod_mfb_lpf_pex_half_0.iqmod_mfb_lpf_pex_ota_core_hybrid_bm_half_0.iqmod_mfb_lpf_pex_ota_core_spdt_switch$1_0.iqmod_mfb_lpf_pex_ota_core_spdt_switch_inv$2_0.vout iqmod_mfb_lpf_pex_half_0.iqmod_mfb_lpf_pex_ota_core_hybrid_bm_half_0.iqmod_mfb_lpf_pex_ota_core_tg$1_0.di_tg_ctrl_n VSS VSS sg13_lv_nmos ad=0.19p pd=1.38u as=0.19p ps=1.38u w=1u l=0.13u
X590 voutp iqmod_mfb_lpf_pex_half_1.iqmod_mfb_lpf_pex_ota_core_hybrid_bm_half_0.iqmod_mfb_lpf_pex_ota_core_inv_NF20$1_1.vin VSS VSS sg13_lv_nmos ad=0.19p pd=1.38u as=0.19p ps=1.38u w=1u l=1u
X591 iqmod_mfb_lpf_pex_half_1.iqmod_mfb_lpf_pex_ota_core_hybrid_bm_half_0.iqmod_mfb_lpf_pex_ota_core_inv_NF20$1_1.vin iqmod_mfb_lpf_pex_half_1.iqmod_mfb_lpf_pex_ota_core_hybrid_bm_half_0.iqmod_mfb_lpf_pex_ota_core_spdt_switch$1_0.iqmod_mfb_lpf_pex_ota_core_spdt_switch_inv$2_0.vout VDD VDD sg13_lv_pmos ad=1.14p pd=6.38u as=2.04p ps=12.68u w=6u l=0.13u
X592 VDD iqmod_mfb_lpf_pex_half_1.iqmod_mfb_lpf_pex_ota_core_hybrid_bm_half_0.iqmod_mfb_lpf_pex_ota_core_tg$1_0.di_tg_ctrl_n iqmod_mfb_lpf_pex_half_1.iqmod_mfb_lpf_pex_ota_core_hybrid_bm_half_0.iqmod_mfb_lpf_pex_ota_core_inv_NF20$1_1.vin VSS sg13_lv_nmos ad=0.19p pd=1.38u as=0.19p ps=1.38u w=1u l=0.13u
X593 iqmod_mfb_lpf_pex_half_1.iqmod_mfb_lpf_pex_ota_core_hybrid_bm_half_0.iqmod_mfb_lpf_pex_ota_core_inv_NF20$1_0.vout di_filter_en iqmod_mfb_lpf_pex_half_1.iqmod_mfb_lpf_pex_ota_core_hybrid_bm_half_0.iqmod_mfb_lpf_pex_ota_core_inv_NF6$1_1.vout VSS sg13_lv_nmos ad=0.19p pd=1.38u as=0.19p ps=1.38u w=1u l=0.13u
C0 vinn VSS 17.35063f
C1 voutp VSS 94.714f
C2 di_filter_en VSS 27.8698f
C3 vinp VSS 17.35063f
C4 voutn VSS 94.714f
C5 VDD VSS 0.35052p
C6 m3_16084_n5108# VSS 0.22014f $ **FLOATING
C7 a_25874_n4903# VSS 7.96743f $ **FLOATING
C8 a_13490_n4903# VSS 7.83464f $ **FLOATING
C9 a_25874_n4603# VSS 7.96743f $ **FLOATING
C10 a_6706_n4903# VSS 4.11651f $ **FLOATING
C11 a_13490_n4603# VSS 7.83464f $ **FLOATING
C12 a_722_n4903# VSS 3.58534f $ **FLOATING
C13 a_25874_n4303# VSS 7.96743f $ **FLOATING
C14 a_25788_n4603# VSS 0.35234f
C15 a_6706_n4603# VSS 4.11651f $ **FLOATING
C16 a_25290_n4603# VSS 0.35234f
C17 a_13490_n4303# VSS 7.83464f $ **FLOATING
C18 iqmod_mfb_lpf_pex_half_1.iqmod_mfb_lpf_pex_R1_0.v_b VSS 22.5486f
C19 a_722_n4603# VSS 3.58534f $ **FLOATING
C20 a_37874_n4303# VSS 0.35234f
C21 a_25874_n4003# VSS 7.96743f $ **FLOATING
C22 a_12906_n4603# VSS 0.35234f
C23 a_6706_n4303# VSS 4.11651f $ **FLOATING
C24 a_13490_n4003# VSS 7.83464f $ **FLOATING
C25 a_13404_n4303# VSS 0.35234f
C26 a_722_n4303# VSS 3.58534f $ **FLOATING
C27 a_636_n4603# VSS 0.35234f
C28 a_25874_n3703# VSS 7.96743f $ **FLOATING
C29 iqmod_mfb_lpf_pex_half_1.iqmod_mfb_lpf_pex_R2_0.v_a VSS 24.2439f
C30 a_6706_n4003# VSS 4.11651f $ **FLOATING
C31 a_6620_n4303# VSS 0.35234f
C32 a_13490_n3703# VSS 7.83464f $ **FLOATING
C33 a_6122_n4303# VSS 0.35234f
C34 a_722_n4003# VSS 3.58534f $ **FLOATING
C35 a_6706_n3703# VSS 4.11651f $ **FLOATING
C36 a_722_n3703# VSS 3.58534f $ **FLOATING
C37 iqmod_mfb_lpf_pex_half_1.iqmod_mfb_lpf_pex_ota_core_hybrid_bm_half_0.iqmod_mfb_lpf_pex_ota_core_inv_NF20$1_1.vin VSS 64.66669f
C38 iqmod_mfb_lpf_pex_half_1.iqmod_mfb_lpf_pex_ota_core_hybrid_bm_half_0.iqmod_mfb_lpf_pex_ota_core_spdt_switch$1_0.iqmod_mfb_lpf_pex_ota_core_spdt_switch_inv$2_0.vout VSS 6.53049f
C39 iqmod_mfb_lpf_pex_half_1.iqmod_mfb_lpf_pex_ota_core_hybrid_bm_half_0.iqmod_mfb_lpf_pex_ota_core_tg$1_0.di_tg_ctrl_n VSS 21.0166f
C40 iqmod_mfb_lpf_pex_half_1.iqmod_mfb_lpf_pex_ota_core_hybrid_bm_half_0.iqmod_mfb_lpf_pex_ota_core_inv_NF20$1_0.vout VSS 79.156f
C41 iqmod_mfb_lpf_pex_half_1.iqmod_mfb_lpf_pex_ota_core_hybrid_bm_half_0.iqmod_mfb_lpf_pex_ota_core_inv_NF6$1_1.vout VSS 46.9298f
C42 iqmod_mfb_lpf_pex_half_1.iqmod_mfb_lpf_pex_ota_core_hybrid_bm_half_0.iqmod_mfb_lpf_pex_ota_core_tg$1_0.v_b VSS 0.11764p
C43 iqmod_mfb_lpf_pex_half_1.iqmod_mfb_lpf_pex_ota_core_hybrid_bm_half_0.iqmod_mfb_lpf_pex_ota_core_tg$1_0.v_a VSS 55.791f
C44 iqmod_mfb_lpf_pex_half_0.iqmod_mfb_lpf_pex_ota_core_hybrid_bm_half_0.iqmod_mfb_lpf_pex_ota_core_inv_NF20$1_1.vin VSS 64.66669f
C45 iqmod_mfb_lpf_pex_half_0.iqmod_mfb_lpf_pex_ota_core_hybrid_bm_half_0.iqmod_mfb_lpf_pex_ota_core_spdt_switch$1_0.iqmod_mfb_lpf_pex_ota_core_spdt_switch_inv$2_0.vout VSS 6.53049f
C46 iqmod_mfb_lpf_pex_half_0.iqmod_mfb_lpf_pex_ota_core_hybrid_bm_half_0.iqmod_mfb_lpf_pex_ota_core_tg$1_0.di_tg_ctrl_n VSS 21.0166f
C47 a_25874_3603# VSS 7.96743f $ **FLOATING
C48 a_13490_3603# VSS 7.83464f $ **FLOATING
C49 a_25874_3903# VSS 7.96743f $ **FLOATING
C50 a_6706_3603# VSS 4.11651f $ **FLOATING
C51 a_13490_3903# VSS 7.83464f $ **FLOATING
C52 a_722_3603# VSS 3.58534f $ **FLOATING
C53 a_37874_3903# VSS 0.35234f
C54 a_25874_4203# VSS 7.96743f $ **FLOATING
C55 iqmod_mfb_lpf_pex_half_1.C2_half VSS 23.8237f
C56 a_6706_3903# VSS 4.11651f $ **FLOATING
C57 a_13490_4203# VSS 7.83464f $ **FLOATING
C58 a_13404_3903# VSS 0.35234f
C59 a_722_3903# VSS 3.58534f $ **FLOATING
C60 a_25874_4503# VSS 7.96743f $ **FLOATING
C61 a_25788_4203# VSS 0.35234f
C62 a_6706_4203# VSS 4.11651f $ **FLOATING
C63 a_6620_3903# VSS 0.35234f
C64 a_25290_4203# VSS 0.35234f
C65 a_13490_4503# VSS 7.83464f $ **FLOATING
C66 a_6122_3903# VSS 0.35234f
C67 a_722_4203# VSS 3.58534f $ **FLOATING
C68 a_25874_4803# VSS 7.96743f $ **FLOATING
C69 a_12906_4203# VSS 0.35234f
C70 a_6706_4503# VSS 4.11651f $ **FLOATING
C71 a_13490_4803# VSS 7.83464f $ **FLOATING
C72 iqmod_mfb_lpf_pex_half_1.C1_half VSS 23.0489f
C73 a_722_4503# VSS 3.58534f $ **FLOATING
C74 a_636_4203# VSS 0.35234f
C75 a_6706_4803# VSS 4.11651f $ **FLOATING
C76 a_722_4803# VSS 3.58534f $ **FLOATING
.ends
