* PEX produced on 2026-11-14 using kpex 0.9.0 with --2.5D --mode RC --blackbox y --reduce ticer
*********************************************************
*** NGSPICE file created by KLayout-PEX 0.9.0
*** -----------------------------------------------------
***     Extraction Engine: KPEX/2.5D
***     Technology: ihp_sg13g2
***     Date: 2026-11-14 14:52:06
*********************************************************

.SUBCKT iqmod_mixer_se2diff_inv_NF54_pex VDD vin vout VSS
X$1 VSS.P1.nSD VSS.P0.GatPoly VSS.P0.nSD VSS sg13_lv_nmos w=1e-06 l=1.3e-07
+ as=3.4e-13 ad=1.9e-13 ps=2.68e-06 pd=1.38e-06
X$2 vout.P0.nSD vin.P0.GatPoly VSS.P1.nSD VSS sg13_lv_nmos w=1e-06 l=1.3e-07
+ as=1.9e-13 ad=1.9e-13 ps=1.38e-06 pd=1.38e-06
X$3 VSS.P3.nSD vin.P1.GatPoly vout.P0.nSD VSS sg13_lv_nmos w=1e-06 l=1.3e-07
+ as=1.9e-13 ad=1.9e-13 ps=1.38e-06 pd=1.38e-06
X$4 vout.P2.nSD vin.P2.GatPoly VSS.P3.nSD VSS sg13_lv_nmos w=1e-06 l=1.3e-07
+ as=1.9e-13 ad=1.9e-13 ps=1.38e-06 pd=1.38e-06
X$5 VSS.P5.nSD vin.P3.GatPoly vout.P2.nSD VSS sg13_lv_nmos w=1e-06 l=1.3e-07
+ as=1.9e-13 ad=1.9e-13 ps=1.38e-06 pd=1.38e-06
X$6 vout.P4.nSD vin.P4.GatPoly VSS.P5.nSD VSS sg13_lv_nmos w=1e-06 l=1.3e-07
+ as=1.9e-13 ad=1.9e-13 ps=1.38e-06 pd=1.38e-06
X$7 VSS.P7.nSD vin.P5.GatPoly vout.P4.nSD VSS sg13_lv_nmos w=1e-06 l=1.3e-07
+ as=1.9e-13 ad=1.9e-13 ps=1.38e-06 pd=1.38e-06
X$8 vout.P6.nSD vin.P6.GatPoly VSS.P7.nSD VSS sg13_lv_nmos w=1e-06 l=1.3e-07
+ as=1.9e-13 ad=1.9e-13 ps=1.38e-06 pd=1.38e-06
X$9 VSS.P10.nSD vin.P7.GatPoly vout.P6.nSD VSS sg13_lv_nmos w=1e-06 l=1.3e-07
+ as=1.9e-13 ad=1.9e-13 ps=1.38e-06 pd=1.38e-06
X$10 vout.P8.nSD vin.P8.GatPoly VSS.P10.nSD VSS sg13_lv_nmos w=1e-06 l=1.3e-07
+ as=1.9e-13 ad=1.9e-13 ps=1.38e-06 pd=1.38e-06
X$11 VSS.P11.nSD vin.P9.GatPoly vout.P8.nSD VSS sg13_lv_nmos w=1e-06 l=1.3e-07
+ as=1.9e-13 ad=1.9e-13 ps=1.38e-06 pd=1.38e-06
X$12 vout.P10.nSD vin.P10.GatPoly VSS.P11.nSD VSS sg13_lv_nmos w=1e-06
+ l=1.3e-07 as=1.9e-13 ad=1.9e-13 ps=1.38e-06 pd=1.38e-06
X$13 VSS.P13.nSD vin.P11.GatPoly vout.P10.nSD VSS sg13_lv_nmos w=1e-06
+ l=1.3e-07 as=1.9e-13 ad=1.9e-13 ps=1.38e-06 pd=1.38e-06
X$14 vout.P12.nSD vin.P12.GatPoly VSS.P13.nSD VSS sg13_lv_nmos w=1e-06
+ l=1.3e-07 as=1.9e-13 ad=1.9e-13 ps=1.38e-06 pd=1.38e-06
X$15 VSS.P15.nSD vin.P13.GatPoly vout.P12.nSD VSS sg13_lv_nmos w=1e-06
+ l=1.3e-07 as=1.9e-13 ad=1.9e-13 ps=1.38e-06 pd=1.38e-06
X$16 vout.P14.nSD vin.P14.GatPoly VSS.P15.nSD VSS sg13_lv_nmos w=1e-06
+ l=1.3e-07 as=1.9e-13 ad=1.9e-13 ps=1.38e-06 pd=1.38e-06
X$17 VSS.P17.nSD vin.P15.GatPoly vout.P14.nSD VSS sg13_lv_nmos w=1e-06
+ l=1.3e-07 as=1.9e-13 ad=1.9e-13 ps=1.38e-06 pd=1.38e-06
X$18 vout.P16.nSD vin.P16.GatPoly VSS.P17.nSD VSS sg13_lv_nmos w=1e-06
+ l=1.3e-07 as=1.9e-13 ad=1.9e-13 ps=1.38e-06 pd=1.38e-06
X$19 VSS.P19.nSD vin.P17.GatPoly vout.P16.nSD VSS sg13_lv_nmos w=1e-06
+ l=1.3e-07 as=1.9e-13 ad=1.9e-13 ps=1.38e-06 pd=1.38e-06
X$20 vout.P18.nSD vin.P18.GatPoly VSS.P19.nSD VSS sg13_lv_nmos w=1e-06
+ l=1.3e-07 as=1.9e-13 ad=1.9e-13 ps=1.38e-06 pd=1.38e-06
X$21 VSS.P21.nSD vin.P19.GatPoly vout.P18.nSD VSS sg13_lv_nmos w=1e-06
+ l=1.3e-07 as=1.9e-13 ad=1.9e-13 ps=1.38e-06 pd=1.38e-06
X$22 vout.P20.nSD vin.P20.GatPoly VSS.P21.nSD VSS sg13_lv_nmos w=1e-06
+ l=1.3e-07 as=1.9e-13 ad=1.9e-13 ps=1.38e-06 pd=1.38e-06
X$23 VSS.P23.nSD vin.P21.GatPoly vout.P20.nSD VSS sg13_lv_nmos w=1e-06
+ l=1.3e-07 as=1.9e-13 ad=1.9e-13 ps=1.38e-06 pd=1.38e-06
X$24 vout.P22.nSD vin.P22.GatPoly VSS.P23.nSD VSS sg13_lv_nmos w=1e-06
+ l=1.3e-07 as=1.9e-13 ad=1.9e-13 ps=1.38e-06 pd=1.38e-06
X$25 VSS.P25.nSD vin.P23.GatPoly vout.P22.nSD VSS sg13_lv_nmos w=1e-06
+ l=1.3e-07 as=1.9e-13 ad=1.9e-13 ps=1.38e-06 pd=1.38e-06
X$26 vout.P24.nSD vin.P24.GatPoly VSS.P25.nSD VSS sg13_lv_nmos w=1e-06
+ l=1.3e-07 as=1.9e-13 ad=1.9e-13 ps=1.38e-06 pd=1.38e-06
X$27 VSS.P27.nSD vin.P25.GatPoly vout.P24.nSD VSS sg13_lv_nmos w=1e-06
+ l=1.3e-07 as=1.9e-13 ad=1.9e-13 ps=1.38e-06 pd=1.38e-06
X$28 vout.P26.nSD vin.P26.GatPoly VSS.P27.nSD VSS sg13_lv_nmos w=1e-06
+ l=1.3e-07 as=1.9e-13 ad=1.9e-13 ps=1.38e-06 pd=1.38e-06
X$29 VSS.P29.nSD vin.P27.GatPoly vout.P26.nSD VSS sg13_lv_nmos w=1e-06
+ l=1.3e-07 as=1.9e-13 ad=1.9e-13 ps=1.38e-06 pd=1.38e-06
X$30 vout.P28.nSD vin.P28.GatPoly VSS.P29.nSD VSS sg13_lv_nmos w=1e-06
+ l=1.3e-07 as=1.9e-13 ad=1.9e-13 ps=1.38e-06 pd=1.38e-06
X$31 VSS.P31.nSD vin.P29.GatPoly vout.P28.nSD VSS sg13_lv_nmos w=1e-06
+ l=1.3e-07 as=1.9e-13 ad=1.9e-13 ps=1.38e-06 pd=1.38e-06
X$32 vout.P30.nSD vin.P30.GatPoly VSS.P31.nSD VSS sg13_lv_nmos w=1e-06
+ l=1.3e-07 as=1.9e-13 ad=1.9e-13 ps=1.38e-06 pd=1.38e-06
X$33 VSS.P33.nSD vin.P31.GatPoly vout.P30.nSD VSS sg13_lv_nmos w=1e-06
+ l=1.3e-07 as=1.9e-13 ad=1.9e-13 ps=1.38e-06 pd=1.38e-06
X$34 vout.P32.nSD vin.P32.GatPoly VSS.P33.nSD VSS sg13_lv_nmos w=1e-06
+ l=1.3e-07 as=1.9e-13 ad=1.9e-13 ps=1.38e-06 pd=1.38e-06
X$35 VSS.P35.nSD vin.P33.GatPoly vout.P32.nSD VSS sg13_lv_nmos w=1e-06
+ l=1.3e-07 as=1.9e-13 ad=1.9e-13 ps=1.38e-06 pd=1.38e-06
X$36 vout.P34.nSD vin.P34.GatPoly VSS.P35.nSD VSS sg13_lv_nmos w=1e-06
+ l=1.3e-07 as=1.9e-13 ad=1.9e-13 ps=1.38e-06 pd=1.38e-06
X$37 VSS.P37.nSD vin.P35.GatPoly vout.P34.nSD VSS sg13_lv_nmos w=1e-06
+ l=1.3e-07 as=1.9e-13 ad=1.9e-13 ps=1.38e-06 pd=1.38e-06
X$38 vout.P36.nSD vin.P36.GatPoly VSS.P37.nSD VSS sg13_lv_nmos w=1e-06
+ l=1.3e-07 as=1.9e-13 ad=1.9e-13 ps=1.38e-06 pd=1.38e-06
X$39 VSS.P39.nSD vin.P37.GatPoly vout.P36.nSD VSS sg13_lv_nmos w=1e-06
+ l=1.3e-07 as=1.9e-13 ad=1.9e-13 ps=1.38e-06 pd=1.38e-06
X$40 vout.P38.nSD vin.P38.GatPoly VSS.P39.nSD VSS sg13_lv_nmos w=1e-06
+ l=1.3e-07 as=1.9e-13 ad=1.9e-13 ps=1.38e-06 pd=1.38e-06
X$41 VSS.P41.nSD vin.P39.GatPoly vout.P38.nSD VSS sg13_lv_nmos w=1e-06
+ l=1.3e-07 as=1.9e-13 ad=1.9e-13 ps=1.38e-06 pd=1.38e-06
X$42 vout.P40.nSD vin.P40.GatPoly VSS.P41.nSD VSS sg13_lv_nmos w=1e-06
+ l=1.3e-07 as=1.9e-13 ad=1.9e-13 ps=1.38e-06 pd=1.38e-06
X$43 VSS.P43.nSD vin.P41.GatPoly vout.P40.nSD VSS sg13_lv_nmos w=1e-06
+ l=1.3e-07 as=1.9e-13 ad=1.9e-13 ps=1.38e-06 pd=1.38e-06
X$44 vout.P42.nSD vin.P42.GatPoly VSS.P43.nSD VSS sg13_lv_nmos w=1e-06
+ l=1.3e-07 as=1.9e-13 ad=1.9e-13 ps=1.38e-06 pd=1.38e-06
X$45 VSS.P45.nSD vin.P43.GatPoly vout.P42.nSD VSS sg13_lv_nmos w=1e-06
+ l=1.3e-07 as=1.9e-13 ad=1.9e-13 ps=1.38e-06 pd=1.38e-06
X$46 vout.P44.nSD vin.P44.GatPoly VSS.P45.nSD VSS sg13_lv_nmos w=1e-06
+ l=1.3e-07 as=1.9e-13 ad=1.9e-13 ps=1.38e-06 pd=1.38e-06
X$47 VSS.P47.nSD vin.P45.GatPoly vout.P44.nSD VSS sg13_lv_nmos w=1e-06
+ l=1.3e-07 as=1.9e-13 ad=1.9e-13 ps=1.38e-06 pd=1.38e-06
X$48 vout.P46.nSD vin.P46.GatPoly VSS.P47.nSD VSS sg13_lv_nmos w=1e-06
+ l=1.3e-07 as=1.9e-13 ad=1.9e-13 ps=1.38e-06 pd=1.38e-06
X$49 VSS.P49.nSD vin.P47.GatPoly vout.P46.nSD VSS sg13_lv_nmos w=1e-06
+ l=1.3e-07 as=1.9e-13 ad=1.9e-13 ps=1.38e-06 pd=1.38e-06
X$50 vout.P48.nSD vin.P48.GatPoly VSS.P49.nSD VSS sg13_lv_nmos w=1e-06
+ l=1.3e-07 as=1.9e-13 ad=1.9e-13 ps=1.38e-06 pd=1.38e-06
X$51 VSS.P51.nSD vin.P49.GatPoly vout.P48.nSD VSS sg13_lv_nmos w=1e-06
+ l=1.3e-07 as=1.9e-13 ad=1.9e-13 ps=1.38e-06 pd=1.38e-06
X$52 vout.P50.nSD vin.P50.GatPoly VSS.P51.nSD VSS sg13_lv_nmos w=1e-06
+ l=1.3e-07 as=1.9e-13 ad=1.9e-13 ps=1.38e-06 pd=1.38e-06
X$53 VSS.P53.nSD vin.P51.GatPoly vout.P50.nSD VSS sg13_lv_nmos w=1e-06
+ l=1.3e-07 as=1.9e-13 ad=1.9e-13 ps=1.38e-06 pd=1.38e-06
X$54 vout.P52.nSD vin.P52.GatPoly VSS.P53.nSD VSS sg13_lv_nmos w=1e-06
+ l=1.3e-07 as=1.9e-13 ad=1.9e-13 ps=1.38e-06 pd=1.38e-06
X$55 VSS.P55.nSD vin.P53.GatPoly vout.P52.nSD VSS sg13_lv_nmos w=1e-06
+ l=1.3e-07 as=1.9e-13 ad=1.9e-13 ps=1.38e-06 pd=1.38e-06
X$56 VSS.P57.nSD VSS.P1.GatPoly VSS.P55.nSD VSS sg13_lv_nmos w=1e-06 l=1.3e-07
+ as=1.9e-13 ad=3.4e-13 ps=1.38e-06 pd=2.68e-06
X$57 VSS.P0.pSD VSS ptap1
X$58 VDD.P1.pSD VDD.P0.GatPoly VDD.P0.pSD \$I125 sg13_lv_pmos w=3e-06 l=1.3e-07
+ as=1.02e-12 ad=5.7e-13 ps=6.68e-06 pd=3.38e-06
X$59 vout.P0.pSD vin.P54.GatPoly VDD.P1.pSD \$I125 sg13_lv_pmos w=3e-06
+ l=1.3e-07 as=5.7e-13 ad=5.7e-13 ps=3.38e-06 pd=3.38e-06
X$60 VDD.P3.pSD vin.P55.GatPoly vout.P0.pSD \$I125 sg13_lv_pmos w=3e-06
+ l=1.3e-07 as=5.7e-13 ad=5.7e-13 ps=3.38e-06 pd=3.38e-06
X$61 vout.P2.pSD vin.P56.GatPoly VDD.P3.pSD \$I125 sg13_lv_pmos w=3e-06
+ l=1.3e-07 as=5.7e-13 ad=5.7e-13 ps=3.38e-06 pd=3.38e-06
X$62 VDD.P5.pSD vin.P57.GatPoly vout.P2.pSD \$I125 sg13_lv_pmos w=3e-06
+ l=1.3e-07 as=5.7e-13 ad=5.7e-13 ps=3.38e-06 pd=3.38e-06
X$63 vout.P4.pSD vin.P58.GatPoly VDD.P5.pSD \$I125 sg13_lv_pmos w=3e-06
+ l=1.3e-07 as=5.7e-13 ad=5.7e-13 ps=3.38e-06 pd=3.38e-06
X$64 VDD.P7.pSD vin.P59.GatPoly vout.P4.pSD \$I125 sg13_lv_pmos w=3e-06
+ l=1.3e-07 as=5.7e-13 ad=5.7e-13 ps=3.38e-06 pd=3.38e-06
X$65 vout.P6.pSD vin.P60.GatPoly VDD.P7.pSD \$I125 sg13_lv_pmos w=3e-06
+ l=1.3e-07 as=5.7e-13 ad=5.7e-13 ps=3.38e-06 pd=3.38e-06
X$66 VDD.P10.pSD vin.P61.GatPoly vout.P6.pSD \$I125 sg13_lv_pmos w=3e-06
+ l=1.3e-07 as=5.7e-13 ad=5.7e-13 ps=3.38e-06 pd=3.38e-06
X$67 vout.P8.pSD vin.P62.GatPoly VDD.P10.pSD \$I125 sg13_lv_pmos w=3e-06
+ l=1.3e-07 as=5.7e-13 ad=5.7e-13 ps=3.38e-06 pd=3.38e-06
X$68 VDD.P11.pSD vin.P63.GatPoly vout.P8.pSD \$I125 sg13_lv_pmos w=3e-06
+ l=1.3e-07 as=5.7e-13 ad=5.7e-13 ps=3.38e-06 pd=3.38e-06
X$69 vout.P10.pSD vin.P64.GatPoly VDD.P11.pSD \$I125 sg13_lv_pmos w=3e-06
+ l=1.3e-07 as=5.7e-13 ad=5.7e-13 ps=3.38e-06 pd=3.38e-06
X$70 VDD.P13.pSD vin.P65.GatPoly vout.P10.pSD \$I125 sg13_lv_pmos w=3e-06
+ l=1.3e-07 as=5.7e-13 ad=5.7e-13 ps=3.38e-06 pd=3.38e-06
X$71 vout.P12.pSD vin.P66.GatPoly VDD.P13.pSD \$I125 sg13_lv_pmos w=3e-06
+ l=1.3e-07 as=5.7e-13 ad=5.7e-13 ps=3.38e-06 pd=3.38e-06
X$72 VDD.P15.pSD vin.P67.GatPoly vout.P12.pSD \$I125 sg13_lv_pmos w=3e-06
+ l=1.3e-07 as=5.7e-13 ad=5.7e-13 ps=3.38e-06 pd=3.38e-06
X$73 vout.P14.pSD vin.P68.GatPoly VDD.P15.pSD \$I125 sg13_lv_pmos w=3e-06
+ l=1.3e-07 as=5.7e-13 ad=5.7e-13 ps=3.38e-06 pd=3.38e-06
X$74 VDD.P17.pSD vin.P69.GatPoly vout.P14.pSD \$I125 sg13_lv_pmos w=3e-06
+ l=1.3e-07 as=5.7e-13 ad=5.7e-13 ps=3.38e-06 pd=3.38e-06
X$75 vout.P16.pSD vin.P70.GatPoly VDD.P17.pSD \$I125 sg13_lv_pmos w=3e-06
+ l=1.3e-07 as=5.7e-13 ad=5.7e-13 ps=3.38e-06 pd=3.38e-06
X$76 VDD.P19.pSD vin.P71.GatPoly vout.P16.pSD \$I125 sg13_lv_pmos w=3e-06
+ l=1.3e-07 as=5.7e-13 ad=5.7e-13 ps=3.38e-06 pd=3.38e-06
X$77 vout.P18.pSD vin.P72.GatPoly VDD.P19.pSD \$I125 sg13_lv_pmos w=3e-06
+ l=1.3e-07 as=5.7e-13 ad=5.7e-13 ps=3.38e-06 pd=3.38e-06
X$78 VDD.P21.pSD vin.P73.GatPoly vout.P18.pSD \$I125 sg13_lv_pmos w=3e-06
+ l=1.3e-07 as=5.7e-13 ad=5.7e-13 ps=3.38e-06 pd=3.38e-06
X$79 vout.P20.pSD vin.P74.GatPoly VDD.P21.pSD \$I125 sg13_lv_pmos w=3e-06
+ l=1.3e-07 as=5.7e-13 ad=5.7e-13 ps=3.38e-06 pd=3.38e-06
X$80 VDD.P23.pSD vin.P75.GatPoly vout.P20.pSD \$I125 sg13_lv_pmos w=3e-06
+ l=1.3e-07 as=5.7e-13 ad=5.7e-13 ps=3.38e-06 pd=3.38e-06
X$81 vout.P22.pSD vin.P76.GatPoly VDD.P23.pSD \$I125 sg13_lv_pmos w=3e-06
+ l=1.3e-07 as=5.7e-13 ad=5.7e-13 ps=3.38e-06 pd=3.38e-06
X$82 VDD.P25.pSD vin.P77.GatPoly vout.P22.pSD \$I125 sg13_lv_pmos w=3e-06
+ l=1.3e-07 as=5.7e-13 ad=5.7e-13 ps=3.38e-06 pd=3.38e-06
X$83 vout.P24.pSD vin.P78.GatPoly VDD.P25.pSD \$I125 sg13_lv_pmos w=3e-06
+ l=1.3e-07 as=5.7e-13 ad=5.7e-13 ps=3.38e-06 pd=3.38e-06
X$84 VDD.P27.pSD vin.P79.GatPoly vout.P24.pSD \$I125 sg13_lv_pmos w=3e-06
+ l=1.3e-07 as=5.7e-13 ad=5.7e-13 ps=3.38e-06 pd=3.38e-06
X$85 vout.P26.pSD vin.P80.GatPoly VDD.P27.pSD \$I125 sg13_lv_pmos w=3e-06
+ l=1.3e-07 as=5.7e-13 ad=5.7e-13 ps=3.38e-06 pd=3.38e-06
X$86 VDD.P29.pSD vin.P81.GatPoly vout.P26.pSD \$I125 sg13_lv_pmos w=3e-06
+ l=1.3e-07 as=5.7e-13 ad=5.7e-13 ps=3.38e-06 pd=3.38e-06
X$87 vout.P28.pSD vin.P82.GatPoly VDD.P29.pSD \$I125 sg13_lv_pmos w=3e-06
+ l=1.3e-07 as=5.7e-13 ad=5.7e-13 ps=3.38e-06 pd=3.38e-06
X$88 VDD.P31.pSD vin.P83.GatPoly vout.P28.pSD \$I125 sg13_lv_pmos w=3e-06
+ l=1.3e-07 as=5.7e-13 ad=5.7e-13 ps=3.38e-06 pd=3.38e-06
X$89 vout.P30.pSD vin.P84.GatPoly VDD.P31.pSD \$I125 sg13_lv_pmos w=3e-06
+ l=1.3e-07 as=5.7e-13 ad=5.7e-13 ps=3.38e-06 pd=3.38e-06
X$90 VDD.P33.pSD vin.P85.GatPoly vout.P30.pSD \$I125 sg13_lv_pmos w=3e-06
+ l=1.3e-07 as=5.7e-13 ad=5.7e-13 ps=3.38e-06 pd=3.38e-06
X$91 vout.P32.pSD vin.P86.GatPoly VDD.P33.pSD \$I125 sg13_lv_pmos w=3e-06
+ l=1.3e-07 as=5.7e-13 ad=5.7e-13 ps=3.38e-06 pd=3.38e-06
X$92 VDD.P35.pSD vin.P87.GatPoly vout.P32.pSD \$I125 sg13_lv_pmos w=3e-06
+ l=1.3e-07 as=5.7e-13 ad=5.7e-13 ps=3.38e-06 pd=3.38e-06
X$93 vout.P34.pSD vin.P88.GatPoly VDD.P35.pSD \$I125 sg13_lv_pmos w=3e-06
+ l=1.3e-07 as=5.7e-13 ad=5.7e-13 ps=3.38e-06 pd=3.38e-06
X$94 VDD.P37.pSD vin.P89.GatPoly vout.P34.pSD \$I125 sg13_lv_pmos w=3e-06
+ l=1.3e-07 as=5.7e-13 ad=5.7e-13 ps=3.38e-06 pd=3.38e-06
X$95 vout.P36.pSD vin.P90.GatPoly VDD.P37.pSD \$I125 sg13_lv_pmos w=3e-06
+ l=1.3e-07 as=5.7e-13 ad=5.7e-13 ps=3.38e-06 pd=3.38e-06
X$96 VDD.P39.pSD vin.P91.GatPoly vout.P36.pSD \$I125 sg13_lv_pmos w=3e-06
+ l=1.3e-07 as=5.7e-13 ad=5.7e-13 ps=3.38e-06 pd=3.38e-06
X$97 vout.P38.pSD vin.P92.GatPoly VDD.P39.pSD \$I125 sg13_lv_pmos w=3e-06
+ l=1.3e-07 as=5.7e-13 ad=5.7e-13 ps=3.38e-06 pd=3.38e-06
X$98 VDD.P41.pSD vin.P93.GatPoly vout.P38.pSD \$I125 sg13_lv_pmos w=3e-06
+ l=1.3e-07 as=5.7e-13 ad=5.7e-13 ps=3.38e-06 pd=3.38e-06
X$99 vout.P40.pSD vin.P94.GatPoly VDD.P41.pSD \$I125 sg13_lv_pmos w=3e-06
+ l=1.3e-07 as=5.7e-13 ad=5.7e-13 ps=3.38e-06 pd=3.38e-06
X$100 VDD.P43.pSD vin.P95.GatPoly vout.P40.pSD \$I125 sg13_lv_pmos w=3e-06
+ l=1.3e-07 as=5.7e-13 ad=5.7e-13 ps=3.38e-06 pd=3.38e-06
X$101 vout.P42.pSD vin.P96.GatPoly VDD.P43.pSD \$I125 sg13_lv_pmos w=3e-06
+ l=1.3e-07 as=5.7e-13 ad=5.7e-13 ps=3.38e-06 pd=3.38e-06
X$102 VDD.P45.pSD vin.P97.GatPoly vout.P42.pSD \$I125 sg13_lv_pmos w=3e-06
+ l=1.3e-07 as=5.7e-13 ad=5.7e-13 ps=3.38e-06 pd=3.38e-06
X$103 vout.P44.pSD vin.P98.GatPoly VDD.P45.pSD \$I125 sg13_lv_pmos w=3e-06
+ l=1.3e-07 as=5.7e-13 ad=5.7e-13 ps=3.38e-06 pd=3.38e-06
X$104 VDD.P47.pSD vin.P99.GatPoly vout.P44.pSD \$I125 sg13_lv_pmos w=3e-06
+ l=1.3e-07 as=5.7e-13 ad=5.7e-13 ps=3.38e-06 pd=3.38e-06
X$105 vout.P46.pSD vin.P100.GatPoly VDD.P47.pSD \$I125 sg13_lv_pmos w=3e-06
+ l=1.3e-07 as=5.7e-13 ad=5.7e-13 ps=3.38e-06 pd=3.38e-06
X$106 VDD.P49.pSD vin.P101.GatPoly vout.P46.pSD \$I125 sg13_lv_pmos w=3e-06
+ l=1.3e-07 as=5.7e-13 ad=5.7e-13 ps=3.38e-06 pd=3.38e-06
X$107 vout.P48.pSD vin.P102.GatPoly VDD.P49.pSD \$I125 sg13_lv_pmos w=3e-06
+ l=1.3e-07 as=5.7e-13 ad=5.7e-13 ps=3.38e-06 pd=3.38e-06
X$108 VDD.P51.pSD vin.P103.GatPoly vout.P48.pSD \$I125 sg13_lv_pmos w=3e-06
+ l=1.3e-07 as=5.7e-13 ad=5.7e-13 ps=3.38e-06 pd=3.38e-06
X$109 vout.P50.pSD vin.P104.GatPoly VDD.P51.pSD \$I125 sg13_lv_pmos w=3e-06
+ l=1.3e-07 as=5.7e-13 ad=5.7e-13 ps=3.38e-06 pd=3.38e-06
X$110 VDD.P53.pSD vin.P105.GatPoly vout.P50.pSD \$I125 sg13_lv_pmos w=3e-06
+ l=1.3e-07 as=5.7e-13 ad=5.7e-13 ps=3.38e-06 pd=3.38e-06
X$111 vout.P52.pSD vin.P106.GatPoly VDD.P53.pSD \$I125 sg13_lv_pmos w=3e-06
+ l=1.3e-07 as=5.7e-13 ad=5.7e-13 ps=3.38e-06 pd=3.38e-06
X$112 VDD.P55.pSD vin.P107.GatPoly vout.P52.pSD \$I125 sg13_lv_pmos w=3e-06
+ l=1.3e-07 as=5.7e-13 ad=5.7e-13 ps=3.38e-06 pd=3.38e-06
X$113 VDD.P57.pSD VDD.P1.GatPoly VDD.P55.pSD \$I125 sg13_lv_pmos w=3e-06
+ l=1.3e-07 as=5.7e-13 ad=1.02e-12 ps=3.38e-06 pd=6.68e-06
X$114 VDD.P0.nSD \$I125 ntap1
* netlist reduce (TICER tau=0.1ps max degree 5, floating max degree 64): 5781 R, 11885 C, 3690 nodes -> 2494 R, 10825 C, 824 nodes
Cred_1 \$I125 VDD 0.012782f
Cred_2 \$I125 VDD.$1002.Metal2 0.00526164f
Cred_3 \$I125 VDD.$1006.Metal2 0.0044697f
Cred_4 \$I125 VDD.$1017.Metal2 0.0114585f
Cred_5 \$I125 VDD.$1025.Metal2 0.0108499f
Cred_6 \$I125 VDD.$1036.Metal2 0.00500147f
Cred_7 \$I125 VDD.$1040.Metal2 0.00472963f
Cred_8 \$I125 VDD.$1051.Metal2 0.0111747f
Cred_9 \$I125 VDD.$1059.Metal2 0.0111747f
Cred_10 \$I125 VDD.$1070.Metal2 0.00472963f
Cred_11 \$I125 VDD.$1074.Metal2 0.0050016f
Cred_12 \$I125 VDD.$1085.Metal2 0.01085f
Cred_13 \$I125 VDD.$1093.Metal2 0.0114585f
Cred_14 \$I125 VDD.$1104.Metal2 0.0044697f
Cred_15 \$I125 VDD.$1108.Metal2 0.00526164f
Cred_16 \$I125 VDD.$1119.Metal2 0.0105434f
Cred_17 \$I125 VDD.$1127.Metal2 0.0117665f
Cred_18 \$I125 VDD.$1138.Metal2 0.00420959f
Cred_19 \$I125 VDD.$1142.Metal2 0.00552126f
Cred_20 \$I125 VDD.$1153.Metal2 0.0102368f
Cred_21 \$I125 VDD.$1161.Metal2 0.0120748f
Cred_22 \$I125 VDD.$1172.Metal2 0.00394928f
Cred_23 \$I125 VDD.$1176.Metal2 0.00578035f
Cred_24 \$I125 VDD.$1187.Metal2 0.00993007f
Cred_25 \$I125 VDD.$1195.Metal2 0.0123837f
Cred_26 \$I125 VDD.$1206.Metal2 0.00368871f
Cred_27 \$I125 VDD.$1210.Metal2 0.00604008f
Cred_28 \$I125 VDD.$1221.Metal2 0.00962369f
Cred_29 \$I125 VDD.$1229.Metal2 0.0126931f
Cred_30 \$I125 VDD.$124.Metal1 0.0386713f
Cred_31 \$I125 VDD.$1240.Metal2 0.00342783f
Cred_32 \$I125 VDD.$1244.Metal2 0.00627516f
Cred_33 \$I125 VDD.$1255.Metal2 0.009266f
Cred_34 \$I125 VDD.$1263.Metal2 0.012103f
Cred_35 \$I125 VDD.$1274.Metal2 0.00414765f
Cred_36 \$I125 VDD.$1287.Metal2 0.0277102f
Cred_37 \$I125 VDD.$1289.Metal2 0.00108833f
Cred_38 \$I125 VDD.$1300.Metal2 0.00778637f
Cred_39 \$I125 VDD.$1314.Metal3 0.00842879f
Cred_40 \$I125 VDD.$1320.Metal3 0.0046339f
Cred_41 \$I125 VDD.$1326.Metal3 0.00386826f
Cred_42 \$I125 VDD.$1330.Metal3 0.00364937f
Cred_43 \$I125 VDD.$1336.Metal3 0.00387375f
Cred_44 \$I125 VDD.$1340.Metal3 0.00369171f
Cred_45 \$I125 VDD.$1346.Metal3 0.00387925f
Cred_46 \$I125 VDD.$1350.Metal3 0.00382963f
Cred_47 \$I125 VDD.$1356.Metal3 0.00388474f
Cred_48 \$I125 VDD.$1360.Metal3 0.00382419f
Cred_49 \$I125 VDD.$1366.Metal3 0.00389024f
Cred_50 \$I125 VDD.$1370.Metal3 0.00378523f
Cred_51 \$I125 VDD.$1376.Metal3 0.00523038f
Cred_52 \$I125 VDD.$1384.Metal3 0.00527009f
Cred_53 \$I125 VDD.$1390.Metal3 0.0037931f
Cred_54 \$I125 VDD.$1394.Metal3 0.00389024f
Cred_55 \$I125 VDD.$1400.Metal3 0.00382419f
Cred_56 \$I125 VDD.$1404.Metal3 0.00388474f
Cred_57 \$I125 VDD.$1410.Metal3 0.00382963f
Cred_58 \$I125 VDD.$1414.Metal3 0.00372039f
Cred_59 \$I125 VDD.$1420.Metal3 0.00380355f
Cred_60 \$I125 VDD.$1424.Metal3 0.0037546f
Cred_61 \$I125 VDD.$143.Metal1 0.012221f
Cred_62 \$I125 VDD.$1430.Metal3 0.00381687f
Cred_63 \$I125 VDD.$1434.Metal3 0.00386826f
Cred_64 \$I125 VDD.$1440.Metal3 0.0046339f
Cred_65 \$I125 VDD.$1446.Metal3 0.00842879f
Cred_66 \$I125 VDD.$151.Metal1 0.039452f
Cred_67 \$I125 VDD.$176.Metal1 0.0387003f
Cred_68 \$I125 VDD.$195.Metal1 0.012316f
Cred_69 \$I125 VDD.$203.Metal1 0.0393297f
Cred_70 \$I125 VDD.$228.Metal1 0.0387307f
Cred_71 \$I125 VDD.$247.Metal1 0.0124111f
Cred_72 \$I125 VDD.$255.Metal1 0.0392057f
Cred_73 \$I125 VDD.$280.Metal1 0.0387624f
Cred_74 \$I125 VDD.$299.Metal1 0.0125066f
Cred_75 \$I125 VDD.$3.Metal1 0.0176986f
Cred_76 \$I125 VDD.$307.Metal1 0.0390798f
Cred_77 \$I125 VDD.$31.Metal1 0.0623497f
Cred_78 \$I125 VDD.$332.Metal1 0.0387953f
Cred_79 \$I125 VDD.$351.Metal1 0.0126027f
Cred_80 \$I125 VDD.$359.Metal1 0.0389519f
Cred_81 \$I125 VDD.$38.Metal1 0.0596687f
Cred_82 \$I125 VDD.$384.Metal1 0.038779f
Cred_83 \$I125 VDD.$409.Metal1 0.038779f
Cred_84 \$I125 VDD.$42.Metal1 0.110678f
Cred_85 \$I125 VDD.$434.Metal1 0.0389519f
Cred_86 \$I125 VDD.$44.Metal1 0.00629695f
Cred_87 \$I125 VDD.$455.Metal1 0.0126027f
Cred_88 \$I125 VDD.$461.Metal1 0.0387953f
Cred_89 \$I125 VDD.$486.Metal1 0.0390798f
Cred_90 \$I125 VDD.$507.Metal1 0.0125066f
Cred_91 \$I125 VDD.$513.Metal1 0.0387624f
Cred_92 \$I125 VDD.$538.Metal1 0.0392057f
Cred_93 \$I125 VDD.$559.Metal1 0.0124111f
Cred_94 \$I125 VDD.$565.Metal1 0.0387307f
Cred_95 \$I125 VDD.$590.Metal1 0.0393297f
Cred_96 \$I125 VDD.$611.Metal1 0.012316f
Cred_97 \$I125 VDD.$617.Metal1 0.0387003f
Cred_98 \$I125 VDD.$64.Metal1 0.0176192f
Cred_99 \$I125 VDD.$642.Metal1 0.039452f
Cred_100 \$I125 VDD.$663.Metal1 0.012221f
Cred_101 \$I125 VDD.$669.Metal1 0.0386713f
Cred_102 \$I125 VDD.$694.Metal1 0.0395727f
Cred_103 \$I125 VDD.$715.Metal1 0.0115963f
Cred_104 \$I125 VDD.$719.Metal1 0.0279197f
Cred_105 \$I125 VDD.$735.Metal1 0.00939896f
Cred_106 \$I125 VDD.$742.Metal1 0.0176192f
Cred_107 \$I125 VDD.$746.Metal1 0.0177198f
Cred_108 \$I125 VDD.$752.Metal1 0.0623549f
Cred_109 \$I125 VDD.$759.Metal1 0.059671f
Cred_110 \$I125 VDD.$761.Metal1 0.00627596f
Cred_111 \$I125 VDD.$765.Metal1 0.0852498f
Cred_112 \$I125 VDD.$807.Metal2 0.00778642f
Cred_113 \$I125 VDD.$819.Metal2 0.0277102f
Cred_114 \$I125 VDD.$822.Metal2 0.0010885f
Cred_115 \$I125 VDD.$836.Metal2 0.00414765f
Cred_116 \$I125 VDD.$847.Metal2 0.012103f
Cred_117 \$I125 VDD.$855.Metal2 0.009266f
Cred_118 \$I125 VDD.$86.Metal1 0.00939896f
Cred_119 \$I125 VDD.$866.Metal2 0.00627516f
Cred_120 \$I125 VDD.$87.Metal1 0.0279197f
Cred_121 \$I125 VDD.$870.Metal2 0.00342783f
Cred_122 \$I125 VDD.$881.Metal2 0.0126931f
Cred_123 \$I125 VDD.$889.Metal2 0.00962388f
Cred_124 \$I125 VDD.$900.Metal2 0.00604046f
Cred_125 \$I125 VDD.$904.Metal2 0.00368871f
Cred_126 \$I125 VDD.$91.Metal1 0.0115963f
Cred_127 \$I125 VDD.$915.Metal2 0.0123837f
Cred_128 \$I125 VDD.$923.Metal2 0.00993032f
Cred_129 \$I125 VDD.$934.Metal2 0.00578086f
Cred_130 \$I125 VDD.$938.Metal2 0.00394928f
Cred_131 \$I125 VDD.$949.Metal2 0.0120748f
Cred_132 \$I125 VDD.$957.Metal2 0.0102368f
Cred_133 \$I125 VDD.$968.Metal2 0.00552126f
Cred_134 \$I125 VDD.$972.Metal2 0.00420959f
Cred_135 \$I125 VDD.$983.Metal2 0.0117665f
Cred_136 \$I125 VDD.$99.Metal1 0.0395727f
Cred_137 \$I125 VDD.$991.Metal2 0.0105434f
Cred_138 \$I125 VDD.P0.GatPoly 0.0260019f
Cred_139 \$I125 VDD.P0.nSD 0.399916f
Cred_140 \$I125 VDD.P0.pSD 0.000962845f
Cred_141 \$I125 VDD.P1.GatPoly 0.0217855f
Cred_142 \$I125 VDD.P1.pSD 0.000962845f
Cred_143 \$I125 VDD.P10.pSD 0.00124657f
Cred_144 \$I125 VDD.P11.pSD 0.00124154f
Cred_145 \$I125 VDD.P13.pSD 0.00124622f
Cred_146 \$I125 VDD.P15.pSD 0.00124231f
Cred_147 \$I125 VDD.P17.pSD 0.00124581f
Cred_148 \$I125 VDD.P19.pSD 0.00124302f
Cred_149 \$I125 VDD.P21.pSD 0.00124536f
Cred_150 \$I125 VDD.P23.pSD 0.00124368f
Cred_151 \$I125 VDD.P25.pSD 0.00124485f
Cred_152 \$I125 VDD.P27.pSD 0.00124429f
Cred_153 \$I125 VDD.P29.pSD 0.00124429f
Cred_154 \$I125 VDD.P3.pSD 0.000126669f
Cred_155 \$I125 VDD.P31.pSD 0.00124485f
Cred_156 \$I125 VDD.P33.pSD 0.00124368f
Cred_157 \$I125 VDD.P35.pSD 0.00124536f
Cred_158 \$I125 VDD.P37.pSD 0.00124302f
Cred_159 \$I125 VDD.P39.pSD 0.00124581f
Cred_160 \$I125 VDD.P41.pSD 0.00124231f
Cred_161 \$I125 VDD.P43.pSD 0.00124622f
Cred_162 \$I125 VDD.P45.pSD 0.00124154f
Cred_163 \$I125 VDD.P47.pSD 0.00124657f
Cred_164 \$I125 VDD.P49.pSD 0.00124072f
Cred_165 \$I125 VDD.P5.pSD 0.00124682f
Cred_166 \$I125 VDD.P51.pSD 0.00124682f
Cred_167 \$I125 VDD.P53.pSD 0.000126669f
Cred_168 \$I125 VDD.P55.pSD 0.000962845f
Cred_169 \$I125 VDD.P57.pSD 0.000962845f
Cred_170 \$I125 VDD.P7.pSD 0.00124072f
Cred_171 \$I125 vin 0.0150963f
Cred_172 \$I125 vin.$102.GatPoly 0.000355089f
Cred_173 \$I125 vin.$103.GatPoly 0.0326952f
Cred_174 \$I125 vin.$108.GatPoly 0.000492685f
Cred_175 \$I125 vin.$109.GatPoly 0.031702f
Cred_176 \$I125 vin.$112.GatPoly 0.000355089f
Cred_177 \$I125 vin.$113.GatPoly 0.0327046f
Cred_178 \$I125 vin.$118.GatPoly 0.000492685f
Cred_179 \$I125 vin.$119.GatPoly 0.031702f
Cred_180 \$I125 vin.$12.GatPoly 0.000507826f
Cred_181 \$I125 vin.$123.GatPoly 0.0327098f
Cred_182 \$I125 vin.$126.GatPoly 0.00106244f
Cred_183 \$I125 vin.$129.GatPoly 0.031702f
Cred_184 \$I125 vin.$13.GatPoly 0.0435448f
Cred_185 \$I125 vin.$132.GatPoly 0.000355089f
Cred_186 \$I125 vin.$133.GatPoly 0.0327049f
Cred_187 \$I125 vin.$138.GatPoly 0.000492685f
Cred_188 \$I125 vin.$139.GatPoly 0.031702f
Cred_189 \$I125 vin.$142.GatPoly 0.000399608f
Cred_190 \$I125 vin.$143.GatPoly 0.0326952f
Cred_191 \$I125 vin.$149.GatPoly 0.031702f
Cred_192 \$I125 vin.$150.GatPoly 0.000399608f
Cred_193 \$I125 vin.$153.GatPoly 0.0327051f
Cred_194 \$I125 vin.$154.GatPoly 0.000492685f
Cred_195 \$I125 vin.$159.GatPoly 0.031702f
Cred_196 \$I125 vin.$160.GatPoly 0.000355089f
Cred_197 \$I125 vin.$163.GatPoly 0.0327101f
Cred_198 \$I125 vin.$164.GatPoly 0.000492685f
Cred_199 \$I125 vin.$169.GatPoly 0.031702f
Cred_200 \$I125 vin.$170.GatPoly 0.000355089f
Cred_201 \$I125 vin.$173.GatPoly 0.0327103f
Cred_202 \$I125 vin.$174.GatPoly 0.000492685f
Cred_203 \$I125 vin.$179.GatPoly 0.031702f
Cred_204 \$I125 vin.$18.GatPoly 0.000492685f
Cred_205 \$I125 vin.$180.GatPoly 0.000355089f
Cred_206 \$I125 vin.$183.GatPoly 0.03271f
Cred_207 \$I125 vin.$184.GatPoly 0.000492685f
Cred_208 \$I125 vin.$189.GatPoly 0.031702f
Cred_209 \$I125 vin.$19.GatPoly 0.031702f
Cred_210 \$I125 vin.$190.GatPoly 0.000507826f
Cred_211 \$I125 vin.$193.GatPoly 0.0327104f
Cred_212 \$I125 vin.$198.GatPoly 0.000560749f
Cred_213 \$I125 vin.$199.GatPoly 0.031702f
Cred_214 \$I125 vin.$202.GatPoly 0.000399608f
Cred_215 \$I125 vin.$203.GatPoly 0.0347389f
Cred_216 \$I125 vin.$210.GatPoly 0.000552345f
Cred_217 \$I125 vin.$211.GatPoly 0.0347391f
Cred_218 \$I125 vin.$215.GatPoly 0.0378481f
Cred_219 \$I125 vin.$218.GatPoly 0.000560749f
Cred_220 \$I125 vin.$22.GatPoly 0.000355089f
Cred_221 \$I125 vin.$222.GatPoly 0.000399608f
Cred_222 \$I125 vin.$223.GatPoly 0.045574f
Cred_223 \$I125 vin.$23.GatPoly 0.0327106f
Cred_224 \$I125 vin.$230.GatPoly 0.000399608f
Cred_225 \$I125 vin.$231.GatPoly 0.0347391f
Cred_226 \$I125 vin.$234.GatPoly 0.000492685f
Cred_227 \$I125 vin.$235.GatPoly 0.0378481f
Cred_228 \$I125 vin.$240.GatPoly 0.000355089f
Cred_229 \$I125 vin.$243.GatPoly 0.0455742f
Cred_230 \$I125 vin.$244.GatPoly 0.000492685f
Cred_231 \$I125 vin.$250.GatPoly 0.000507826f
Cred_232 \$I125 vin.$251.GatPoly 0.0455743f
Cred_233 \$I125 vin.$258.GatPoly 0.000562159f
Cred_234 \$I125 vin.$259.GatPoly 0.0576676f
Cred_235 \$I125 vin.$271.Metal1 0.0580865f
Cred_236 \$I125 vin.$274.Metal1 0.000258392f
Cred_237 \$I125 vin.$275.Metal1 0.00861625f
Cred_238 \$I125 vin.$278.Metal1 8.0781e-05f
Cred_239 \$I125 vin.$279.Metal1 0.0109895f
Cred_240 \$I125 vin.$28.GatPoly 0.000492685f
Cred_241 \$I125 vin.$284.Metal1 0.000195432f
Cred_242 \$I125 vin.$285.Metal1 0.00770135f
Cred_243 \$I125 vin.$289.Metal1 0.0051347f
Cred_244 \$I125 vin.$29.GatPoly 0.031702f
Cred_245 \$I125 vin.$296.Metal1 0.000195432f
Cred_246 \$I125 vin.$297.Metal1 0.00747259f
Cred_247 \$I125 vin.$301.Metal1 0.00510345f
Cred_248 \$I125 vin.$306.Metal1 0.000195432f
Cred_249 \$I125 vin.$307.Metal1 0.00764085f
Cred_250 \$I125 vin.$311.Metal1 0.00515099f
Cred_251 \$I125 vin.$318.Metal1 0.000195432f
Cred_252 \$I125 vin.$319.Metal1 0.00748695f
Cred_253 \$I125 vin.$32.GatPoly 0.000355089f
Cred_254 \$I125 vin.$323.Metal1 0.005127f
Cred_255 \$I125 vin.$328.Metal1 0.000195432f
Cred_256 \$I125 vin.$329.Metal1 0.00763267f
Cred_257 \$I125 vin.$33.GatPoly 0.0327092f
Cred_258 \$I125 vin.$333.Metal1 0.00388052f
Cred_259 \$I125 vin.$337.Metal1 0.0026137f
Cred_260 \$I125 vin.$340.Metal1 0.000195432f
Cred_261 \$I125 vin.$341.Metal1 0.00623038f
Cred_262 \$I125 vin.$345.Metal1 0.00472614f
Cred_263 \$I125 vin.$350.Metal1 0.000195432f
Cred_264 \$I125 vin.$351.Metal1 0.00716185f
Cred_265 \$I125 vin.$355.Metal1 0.00390219f
Cred_266 \$I125 vin.$359.Metal1 0.00260146f
Cred_267 \$I125 vin.$362.Metal1 0.000195432f
Cred_268 \$I125 vin.$363.Metal1 0.00625608f
Cred_269 \$I125 vin.$367.Metal1 0.00473695f
Cred_270 \$I125 vin.$372.Metal1 0.000195432f
Cred_271 \$I125 vin.$373.Metal1 0.00711911f
Cred_272 \$I125 vin.$377.Metal1 0.00391894f
Cred_273 \$I125 vin.$38.GatPoly 0.000492685f
Cred_274 \$I125 vin.$381.Metal1 0.00258823f
Cred_275 \$I125 vin.$384.Metal1 0.000195432f
Cred_276 \$I125 vin.$385.Metal1 0.00615227f
Cred_277 \$I125 vin.$389.Metal1 0.00388074f
Cred_278 \$I125 vin.$39.GatPoly 0.031702f
Cred_279 \$I125 vin.$394.Metal1 0.000195432f
Cred_280 \$I125 vin.$395.Metal1 0.00707863f
Cred_281 \$I125 vin.$399.Metal1 0.00506952f
Cred_282 \$I125 vin.$4.GatPoly 0.000561506f
Cred_283 \$I125 vin.$407.Metal1 0.00744085f
Cred_284 \$I125 vin.$411.Metal1 0.00386954f
Cred_285 \$I125 vin.$416.Metal1 0.000195432f
Cred_286 \$I125 vin.$417.Metal1 0.00703741f
Cred_287 \$I125 vin.$42.GatPoly 0.000355089f
Cred_288 \$I125 vin.$421.Metal1 0.00388182f
Cred_289 \$I125 vin.$425.Metal1 0.00249189f
Cred_290 \$I125 vin.$428.Metal1 0.000219934f
Cred_291 \$I125 vin.$429.Metal1 0.00628066f
Cred_292 \$I125 vin.$43.GatPoly 0.0327105f
Cred_293 \$I125 vin.$433.Metal1 0.00383786f
Cred_294 \$I125 vin.$438.Metal1 0.000195432f
Cred_295 \$I125 vin.$439.Metal1 0.00699243f
Cred_296 \$I125 vin.$443.Metal1 0.00521733f
Cred_297 \$I125 vin.$450.Metal1 0.000195432f
Cred_298 \$I125 vin.$451.Metal1 0.00760139f
Cred_299 \$I125 vin.$455.Metal1 0.0042233f
Cred_300 \$I125 vin.$460.Metal1 0.000195432f
Cred_301 \$I125 vin.$461.Metal1 0.00753019f
Cred_302 \$I125 vin.$465.Metal1 0.00522216f
Cred_303 \$I125 vin.$472.Metal1 0.000195432f
Cred_304 \$I125 vin.$473.Metal1 0.00766063f
Cred_305 \$I125 vin.$477.Metal1 0.00418094f
Cred_306 \$I125 vin.$478.Metal1 8.0781e-05f
Cred_307 \$I125 vin.$48.GatPoly 0.000492685f
Cred_308 \$I125 vin.$482.Metal1 0.000222431f
Cred_309 \$I125 vin.$483.Metal1 0.00751259f
Cred_310 \$I125 vin.$487.Metal1 0.005074f
Cred_311 \$I125 vin.$49.GatPoly 0.031702f
Cred_312 \$I125 vin.$494.Metal1 0.000219934f
Cred_313 \$I125 vin.$495.Metal1 0.00996441f
Cred_314 \$I125 vin.$5.GatPoly 0.0891701f
Cred_315 \$I125 vin.$500.Metal1 8.0781e-05f
Cred_316 \$I125 vin.$501.Metal1 0.00522819f
Cred_317 \$I125 vin.$504.Metal1 0.000222431f
Cred_318 \$I125 vin.$505.Metal1 0.00863448f
Cred_319 \$I125 vin.$509.Metal1 0.0108439f
Cred_320 \$I125 vin.$516.Metal1 0.000219934f
Cred_321 \$I125 vin.$517.Metal1 0.00996928f
Cred_322 \$I125 vin.$52.GatPoly 0.000355089f
Cred_323 \$I125 vin.$523.Metal1 0.00524025f
Cred_324 \$I125 vin.$526.Metal1 0.000195432f
Cred_325 \$I125 vin.$527.Metal1 0.00861464f
Cred_326 \$I125 vin.$53.GatPoly 0.0327093f
Cred_327 \$I125 vin.$531.Metal1 0.0109479f
Cred_328 \$I125 vin.$538.Metal1 0.000195432f
Cred_329 \$I125 vin.$539.Metal1 0.0100081f
Cred_330 \$I125 vin.$544.Metal1 8.0781e-05f
Cred_331 \$I125 vin.$545.Metal1 0.010981f
Cred_332 \$I125 vin.$548.Metal1 0.000290587f
Cred_333 \$I125 vin.$549.Metal1 0.038581f
Cred_334 \$I125 vin.$564.Metal2 0.0015909f
Cred_335 \$I125 vin.$566.Metal2 0.0197695f
Cred_336 \$I125 vin.$569.Metal2 0.000334967f
Cred_337 \$I125 vin.$573.Metal2 0.0091453f
Cred_338 \$I125 vin.$574.Metal2 0.000611895f
Cred_339 \$I125 vin.$577.Metal2 0.00253716f
Cred_340 \$I125 vin.$579.Metal2 0.0052743f
Cred_341 \$I125 vin.$58.GatPoly 0.000492685f
Cred_342 \$I125 vin.$581.Metal2 0.0117811f
Cred_343 \$I125 vin.$584.Metal2 0.00325922f
Cred_344 \$I125 vin.$588.Metal2 0.0083154f
Cred_345 \$I125 vin.$589.Metal2 0.00711418f
Cred_346 \$I125 vin.$59.GatPoly 0.031702f
Cred_347 \$I125 vin.$593.Metal2 0.00262404f
Cred_348 \$I125 vin.$595.Metal2 0.00553502f
Cred_349 \$I125 vin.$597.Metal2 0.00882446f
Cred_350 \$I125 vin.$600.Metal2 0.00322098f
Cred_351 \$I125 vin.$604.Metal2 0.00835095f
Cred_352 \$I125 vin.$605.Metal2 0.00713937f
Cred_353 \$I125 vin.$609.Metal2 0.00249504f
Cred_354 \$I125 vin.$611.Metal2 0.00669901f
Cred_355 \$I125 vin.$613.Metal2 0.00864222f
Cred_356 \$I125 vin.$618.Metal2 0.0047876f
Cred_357 \$I125 vin.$62.GatPoly 0.000355089f
Cred_358 \$I125 vin.$620.Metal2 0.00908936f
Cred_359 \$I125 vin.$623.Metal2 0.00507352f
Cred_360 \$I125 vin.$627.Metal2 0.0078686f
Cred_361 \$I125 vin.$629.Metal2 0.00862662f
Cred_362 \$I125 vin.$63.GatPoly 0.0326952f
Cred_363 \$I125 vin.$634.Metal2 0.00481115f
Cred_364 \$I125 vin.$636.Metal2 0.00909766f
Cred_365 \$I125 vin.$639.Metal2 0.00499544f
Cred_366 \$I125 vin.$643.Metal2 0.00801568f
Cred_367 \$I125 vin.$645.Metal2 0.00853534f
Cred_368 \$I125 vin.$650.Metal2 0.00480794f
Cred_369 \$I125 vin.$652.Metal2 0.00900899f
Cred_370 \$I125 vin.$655.Metal2 0.00497624f
Cred_371 \$I125 vin.$659.Metal2 0.00846869f
Cred_372 \$I125 vin.$662.Metal2 0.00798939f
Cred_373 \$I125 vin.$666.Metal2 0.00488734f
Cred_374 \$I125 vin.$668.Metal2 0.00924519f
Cred_375 \$I125 vin.$671.Metal2 0.00488818f
Cred_376 \$I125 vin.$676.Metal2 0.00844036f
Cred_377 \$I125 vin.$678.Metal2 0.00805627f
Cred_378 \$I125 vin.$68.GatPoly 0.000492685f
Cred_379 \$I125 vin.$682.Metal2 0.00494061f
Cred_380 \$I125 vin.$684.Metal2 0.0090323f
Cred_381 \$I125 vin.$687.Metal2 0.00482675f
Cred_382 \$I125 vin.$69.GatPoly 0.031702f
Cred_383 \$I125 vin.$691.Metal2 0.00853534f
Cred_384 \$I125 vin.$694.Metal2 0.00803225f
Cred_385 \$I125 vin.$698.Metal2 0.00498389f
Cred_386 \$I125 vin.$700.Metal2 0.00909766f
Cred_387 \$I125 vin.$703.Metal2 0.00483228f
Cred_388 \$I125 vin.$707.Metal2 0.00862662f
Cred_389 \$I125 vin.$710.Metal2 0.00788543f
Cred_390 \$I125 vin.$714.Metal2 0.00504045f
Cred_391 \$I125 vin.$716.Metal2 0.00899626f
Cred_392 \$I125 vin.$719.Metal2 0.00487272f
Cred_393 \$I125 vin.$72.GatPoly 0.000355089f
Cred_394 \$I125 vin.$723.Metal2 0.00877661f
Cred_395 \$I125 vin.$726.Metal2 0.00646802f
Cred_396 \$I125 vin.$728.Metal2 0.00259805f
Cred_397 \$I125 vin.$73.GatPoly 0.032704f
Cred_398 \$I125 vin.$732.Metal2 0.00851001f
Cred_399 \$I125 vin.$733.Metal2 0.00724967f
Cred_400 \$I125 vin.$737.Metal2 0.00303106f
Cred_401 \$I125 vin.$739.Metal2 0.00857723f
Cred_402 \$I125 vin.$742.Metal2 0.00566397f
Cred_403 \$I125 vin.$744.Metal2 0.00252968f
Cred_404 \$I125 vin.$748.Metal2 0.00832025f
Cred_405 \$I125 vin.$749.Metal2 0.00712304f
Cred_406 \$I125 vin.$753.Metal2 0.00330239f
Cred_407 \$I125 vin.$755.Metal2 0.00874018f
Cred_408 \$I125 vin.$758.Metal2 0.00531619f
Cred_409 \$I125 vin.$760.Metal2 0.00254035f
Cred_410 \$I125 vin.$764.Metal2 0.00837704f
Cred_411 \$I125 vin.$765.Metal2 0.00713645f
Cred_412 \$I125 vin.$768.Metal2 0.00107804f
Cred_413 \$I125 vin.$769.Metal2 0.0160807f
Cred_414 \$I125 vin.$771.Metal2 0.0172813f
Cred_415 \$I125 vin.$78.GatPoly 0.000492685f
Cred_416 \$I125 vin.$79.GatPoly 0.031702f
Cred_417 \$I125 vin.$82.GatPoly 0.000355089f
Cred_418 \$I125 vin.$83.GatPoly 0.0326952f
Cred_419 \$I125 vin.$88.GatPoly 0.000492685f
Cred_420 \$I125 vin.$89.GatPoly 0.031702f
Cred_421 \$I125 vin.$92.GatPoly 0.000355089f
Cred_422 \$I125 vin.$93.GatPoly 0.0327043f
Cred_423 \$I125 vin.$98.GatPoly 0.000492685f
Cred_424 \$I125 vin.$99.GatPoly 0.031702f
Cred_425 \$I125 vin.P0.GatPoly 9.70908e-08f
Cred_426 \$I125 vin.P100.GatPoly 0.0121433f
Cred_427 \$I125 vin.P101.GatPoly 0.0117542f
Cred_428 \$I125 vin.P102.GatPoly 0.0130676f
Cred_429 \$I125 vin.P103.GatPoly 0.0121433f
Cred_430 \$I125 vin.P104.GatPoly 0.0121433f
Cred_431 \$I125 vin.P105.GatPoly 0.0130676f
Cred_432 \$I125 vin.P106.GatPoly 0.0117542f
Cred_433 \$I125 vin.P107.GatPoly 0.0138121f
Cred_434 \$I125 vin.P11.GatPoly 1.9234e-05f
Cred_435 \$I125 vin.P13.GatPoly 1.9234e-05f
Cred_436 \$I125 vin.P15.GatPoly 1.9234e-05f
Cred_437 \$I125 vin.P17.GatPoly 1.9234e-05f
Cred_438 \$I125 vin.P19.GatPoly 1.9234e-05f
Cred_439 \$I125 vin.P2.GatPoly 4.5742e-05f
Cred_440 \$I125 vin.P21.GatPoly 1.9234e-05f
Cred_441 \$I125 vin.P23.GatPoly 1.9234e-05f
Cred_442 \$I125 vin.P27.GatPoly 1.9234e-05f
Cred_443 \$I125 vin.P29.GatPoly 2.16454e-05f
Cred_444 \$I125 vin.P3.GatPoly 1.9234e-05f
Cred_445 \$I125 vin.P30.GatPoly 2.16454e-05f
Cred_446 \$I125 vin.P32.GatPoly 1.9234e-05f
Cred_447 \$I125 vin.P34.GatPoly 1.9234e-05f
Cred_448 \$I125 vin.P36.GatPoly 1.9234e-05f
Cred_449 \$I125 vin.P38.GatPoly 1.9234e-05f
Cred_450 \$I125 vin.P39.GatPoly 4.5742e-05f
Cred_451 \$I125 vin.P41.GatPoly 2.16454e-05f
Cred_452 \$I125 vin.P42.GatPoly 2.16454e-05f
Cred_453 \$I125 vin.P43.GatPoly 4.5742e-05f
Cred_454 \$I125 vin.P45.GatPoly 2.16454e-05f
Cred_455 \$I125 vin.P46.GatPoly 2.16454e-05f
Cred_456 \$I125 vin.P48.GatPoly 1.9234e-05f
Cred_457 \$I125 vin.P5.GatPoly 1.9234e-05f
Cred_458 \$I125 vin.P50.GatPoly 1.9234e-05f
Cred_459 \$I125 vin.P51.GatPoly 4.5742e-05f
Cred_460 \$I125 vin.P53.GatPoly 1.7877e-07f
Cred_461 \$I125 vin.P54.GatPoly 0.0171537f
Cred_462 \$I125 vin.P55.GatPoly 0.0117542f
Cred_463 \$I125 vin.P56.GatPoly 0.0130676f
Cred_464 \$I125 vin.P57.GatPoly 0.0120988f
Cred_465 \$I125 vin.P58.GatPoly 0.0117542f
Cred_466 \$I125 vin.P59.GatPoly 0.0120988f
Cred_467 \$I125 vin.P60.GatPoly 0.0117542f
Cred_468 \$I125 vin.P61.GatPoly 0.0120988f
Cred_469 \$I125 vin.P62.GatPoly 0.0117542f
Cred_470 \$I125 vin.P63.GatPoly 0.0120988f
Cred_471 \$I125 vin.P64.GatPoly 0.0117542f
Cred_472 \$I125 vin.P65.GatPoly 0.0120988f
Cred_473 \$I125 vin.P66.GatPoly 0.0117542f
Cred_474 \$I125 vin.P67.GatPoly 0.0120988f
Cred_475 \$I125 vin.P68.GatPoly 0.0117542f
Cred_476 \$I125 vin.P69.GatPoly 0.0120988f
Cred_477 \$I125 vin.P7.GatPoly 1.9234e-05f
Cred_478 \$I125 vin.P70.GatPoly 0.0117542f
Cred_479 \$I125 vin.P71.GatPoly 0.0120988f
Cred_480 \$I125 vin.P72.GatPoly 0.0117542f
Cred_481 \$I125 vin.P73.GatPoly 0.0120988f
Cred_482 \$I125 vin.P74.GatPoly 0.0117542f
Cred_483 \$I125 vin.P75.GatPoly 0.0120988f
Cred_484 \$I125 vin.P76.GatPoly 0.0117542f
Cred_485 \$I125 vin.P77.GatPoly 0.0120988f
Cred_486 \$I125 vin.P78.GatPoly 0.0117542f
Cred_487 \$I125 vin.P79.GatPoly 0.0120988f
Cred_488 \$I125 vin.P80.GatPoly 0.0117542f
Cred_489 \$I125 vin.P81.GatPoly 0.0120988f
Cred_490 \$I125 vin.P82.GatPoly 0.0117542f
Cred_491 \$I125 vin.P83.GatPoly 0.0120988f
Cred_492 \$I125 vin.P84.GatPoly 0.0117542f
Cred_493 \$I125 vin.P85.GatPoly 0.0120988f
Cred_494 \$I125 vin.P86.GatPoly 0.0117542f
Cred_495 \$I125 vin.P87.GatPoly 0.0120988f
Cred_496 \$I125 vin.P88.GatPoly 0.0117542f
Cred_497 \$I125 vin.P89.GatPoly 0.0120988f
Cred_498 \$I125 vin.P9.GatPoly 1.9234e-05f
Cred_499 \$I125 vin.P90.GatPoly 0.0117542f
Cred_500 \$I125 vin.P91.GatPoly 0.0120988f
Cred_501 \$I125 vin.P92.GatPoly 0.0117542f
Cred_502 \$I125 vin.P93.GatPoly 0.0120988f
Cred_503 \$I125 vin.P94.GatPoly 0.0117542f
Cred_504 \$I125 vin.P95.GatPoly 0.0121433f
Cred_505 \$I125 vin.P96.GatPoly 0.0121433f
Cred_506 \$I125 vin.P97.GatPoly 0.0117542f
Cred_507 \$I125 vin.P98.GatPoly 0.0130676f
Cred_508 \$I125 vin.P99.GatPoly 0.0121433f
Cred_509 \$I125 vout 0.0512225f
Cred_510 \$I125 vout.$1008.Metal3 0.0199758f
Cred_511 \$I125 vout.$1026.Metal3 0.0199758f
Cred_512 \$I125 vout.$1044.Metal3 0.0199758f
Cred_513 \$I125 vout.$1062.Metal3 0.0199758f
Cred_514 \$I125 vout.$1080.Metal3 0.0199758f
Cred_515 \$I125 vout.$1098.Metal3 0.0199758f
Cred_516 \$I125 vout.$1116.Metal3 0.0199758f
Cred_517 \$I125 vout.$1134.Metal3 0.0199758f
Cred_518 \$I125 vout.$1152.Metal3 0.0199758f
Cred_519 \$I125 vout.$1170.Metal3 0.0151816f
Cred_520 \$I125 vout.$954.Metal3 0.0359754f
Cred_521 \$I125 vout.$972.Metal3 0.0199758f
Cred_522 \$I125 vout.$990.Metal3 0.0199758f
Cred_523 \$I125 vout.P0.nSD 9.628e-05f
Cred_524 \$I125 vout.P0.pSD 0.00317571f
Cred_525 \$I125 vout.P10.pSD 0.00247053f
Cred_526 \$I125 vout.P12.nSD 2.98325e-05f
Cred_527 \$I125 vout.P12.pSD 0.00255146f
Cred_528 \$I125 vout.P14.pSD 0.00247053f
Cred_529 \$I125 vout.P16.nSD 2.98325e-05f
Cred_530 \$I125 vout.P16.pSD 0.00255146f
Cred_531 \$I125 vout.P18.pSD 0.00247053f
Cred_532 \$I125 vout.P2.pSD 0.00247053f
Cred_533 \$I125 vout.P20.nSD 2.98325e-05f
Cred_534 \$I125 vout.P20.pSD 0.00255146f
Cred_535 \$I125 vout.P22.pSD 0.00247053f
Cred_536 \$I125 vout.P24.nSD 2.98325e-05f
Cred_537 \$I125 vout.P24.pSD 0.00255146f
Cred_538 \$I125 vout.P26.pSD 0.00247053f
Cred_539 \$I125 vout.P28.nSD 2.98325e-05f
Cred_540 \$I125 vout.P28.pSD 0.00255146f
Cred_541 \$I125 vout.P30.pSD 0.00247053f
Cred_542 \$I125 vout.P32.nSD 2.98325e-05f
Cred_543 \$I125 vout.P32.pSD 0.00255146f
Cred_544 \$I125 vout.P34.pSD 0.00247053f
Cred_545 \$I125 vout.P36.nSD 2.98325e-05f
Cred_546 \$I125 vout.P36.pSD 0.00255146f
Cred_547 \$I125 vout.P38.pSD 0.00247053f
Cred_548 \$I125 vout.P4.nSD 2.98325e-05f
Cred_549 \$I125 vout.P4.pSD 0.00255146f
Cred_550 \$I125 vout.P40.nSD 2.98325e-05f
Cred_551 \$I125 vout.P40.pSD 0.00255146f
Cred_552 \$I125 vout.P42.pSD 0.00247053f
Cred_553 \$I125 vout.P44.nSD 2.98325e-05f
Cred_554 \$I125 vout.P44.pSD 0.00255146f
Cred_555 \$I125 vout.P46.pSD 0.00247053f
Cred_556 \$I125 vout.P48.nSD 2.98325e-05f
Cred_557 \$I125 vout.P48.pSD 0.00255146f
Cred_558 \$I125 vout.P50.pSD 0.00247053f
Cred_559 \$I125 vout.P52.pSD 0.00287579f
Cred_560 \$I125 vout.P6.pSD 0.00247053f
Cred_561 \$I125 vout.P8.nSD 2.98325e-05f
Cred_562 \$I125 vout.P8.pSD 0.00255146f
Cred_563 \$I125 VSS.$1048.Metal3 0.0045469f
Cred_564 \$I125 VSS.$14.Metal1 0.00378902f
Cred_565 \$I125 VSS.$29.Metal1 0.00680641f
Cred_566 \$I125 VSS.$31.Metal1 1.84372e-07f
Cred_567 \$I125 VSS.$490.Metal1 3.59318e-07f
Cred_568 \$I125 VSS.$496.Metal1 4.88974e-08f
Cred_569 \$I125 VSS.$500.Metal1 0.000362894f
Cred_570 \$I125 VSS.$520.Metal1 0.011314f
Cred_571 \$I125 VSS.$531.Metal2 0.00873335f
Cred_572 \$I125 VSS.$540.Metal2 5.93553e-05f
Cred_573 \$I125 VSS.$895.Metal2 5.92726e-05f
Cred_574 \$I125 VSS.$904.Metal2 0.00737084f
Cred_575 \$I125 VSS.$916.Metal3 0.0045469f
Cred_576 \$I125 VSS.P0.nSD 3.19627e-06f
Cred_577 \$I125 VSS.P0.pSD 0.150593f
Cred_578 \$I125 VSS.P1.nSD 3.19627e-06f
Cred_579 \$I125 VSS.P55.nSD 2.69046e-06f
Cred_580 \$I125 VSS.P57.nSD 2.69046e-06f
Cred_581 VSS VDD 0.0356215f
Cred_582 VSS VDD.$1002.Metal2 0.0145268f
Cred_583 VSS VDD.$1006.Metal2 0.0144301f
Cred_584 VSS VDD.$1017.Metal2 0.0214529f
Cred_585 VSS VDD.$1025.Metal2 0.0215101f
Cred_586 VSS VDD.$1036.Metal2 0.0145289f
Cred_587 VSS VDD.$1040.Metal2 0.0144284f
Cred_588 VSS VDD.$1051.Metal2 0.021659f
Cred_589 VSS VDD.$1059.Metal2 0.021659f
Cred_590 VSS VDD.$1070.Metal2 0.0144284f
Cred_591 VSS VDD.$1074.Metal2 0.0145289f
Cred_592 VSS VDD.$1085.Metal2 0.0215101f
Cred_593 VSS VDD.$1093.Metal2 0.0214529f
Cred_594 VSS VDD.$1104.Metal2 0.0144301f
Cred_595 VSS VDD.$1108.Metal2 0.0145268f
Cred_596 VSS VDD.$1119.Metal2 0.021513f
Cred_597 VSS VDD.$1127.Metal2 0.0214496f
Cred_598 VSS VDD.$1138.Metal2 0.0144317f
Cred_599 VSS VDD.$1142.Metal2 0.0145246f
Cred_600 VSS VDD.$1153.Metal2 0.0215158f
Cred_601 VSS VDD.$1161.Metal2 0.0214462f
Cred_602 VSS VDD.$1172.Metal2 0.014433f
Cred_603 VSS VDD.$1176.Metal2 0.0145221f
Cred_604 VSS VDD.$1187.Metal2 0.0215185f
Cred_605 VSS VDD.$1195.Metal2 0.0214426f
Cred_606 VSS VDD.$1206.Metal2 0.0144342f
Cred_607 VSS VDD.$1210.Metal2 0.0145194f
Cred_608 VSS VDD.$1221.Metal2 0.0215212f
Cred_609 VSS VDD.$1229.Metal2 0.0214389f
Cred_610 VSS VDD.$124.Metal1 0.0453945f
Cred_611 VSS VDD.$1240.Metal2 0.0144352f
Cred_612 VSS VDD.$1244.Metal2 0.0145166f
Cred_613 VSS VDD.$1255.Metal2 0.0215237f
Cred_614 VSS VDD.$1263.Metal2 0.0214685f
Cred_615 VSS VDD.$1274.Metal2 0.0217647f
Cred_616 VSS VDD.$1287.Metal2 0.102918f
Cred_617 VSS VDD.$1289.Metal2 0.0375874f
Cred_618 VSS VDD.$1300.Metal2 0.096769f
Cred_619 VSS VDD.$1314.Metal3 0.111337f
Cred_620 VSS VDD.$1320.Metal3 0.0384937f
Cred_621 VSS VDD.$1326.Metal3 0.0320733f
Cred_622 VSS VDD.$1330.Metal3 0.0321301f
Cred_623 VSS VDD.$1336.Metal3 0.0320733f
Cred_624 VSS VDD.$1340.Metal3 0.0321301f
Cred_625 VSS VDD.$1346.Metal3 0.0320733f
Cred_626 VSS VDD.$1350.Metal3 0.0321301f
Cred_627 VSS VDD.$1356.Metal3 0.0320733f
Cred_628 VSS VDD.$1360.Metal3 0.0321301f
Cred_629 VSS VDD.$1366.Metal3 0.0320733f
Cred_630 VSS VDD.$1370.Metal3 0.0321301f
Cred_631 VSS VDD.$1376.Metal3 0.0447533f
Cred_632 VSS VDD.$1384.Metal3 0.0447533f
Cred_633 VSS VDD.$1390.Metal3 0.0321301f
Cred_634 VSS VDD.$1394.Metal3 0.0320733f
Cred_635 VSS VDD.$1400.Metal3 0.0321301f
Cred_636 VSS VDD.$1404.Metal3 0.0320733f
Cred_637 VSS VDD.$1410.Metal3 0.0321301f
Cred_638 VSS VDD.$1414.Metal3 0.0320733f
Cred_639 VSS VDD.$1420.Metal3 0.0321301f
Cred_640 VSS VDD.$1424.Metal3 0.0320733f
Cred_641 VSS VDD.$143.Metal1 0.0352191f
Cred_642 VSS VDD.$1430.Metal3 0.0321301f
Cred_643 VSS VDD.$1434.Metal3 0.0320733f
Cred_644 VSS VDD.$1440.Metal3 0.0384937f
Cred_645 VSS VDD.$1446.Metal3 0.111341f
Cred_646 VSS VDD.$151.Metal1 0.0462869f
Cred_647 VSS VDD.$176.Metal1 0.0454044f
Cred_648 VSS VDD.$195.Metal1 0.0353643f
Cred_649 VSS VDD.$203.Metal1 0.0461296f
Cred_650 VSS VDD.$228.Metal1 0.045435f
Cred_651 VSS VDD.$247.Metal1 0.0354766f
Cred_652 VSS VDD.$255.Metal1 0.0459853f
Cred_653 VSS VDD.$280.Metal1 0.0454848f
Cred_654 VSS VDD.$299.Metal1 0.0355566f
Cred_655 VSS VDD.$3.Metal1 0.102692f
Cred_656 VSS VDD.$307.Metal1 0.0458546f
Cred_657 VSS VDD.$31.Metal1 0.0689714f
Cred_658 VSS VDD.$332.Metal1 0.0455528f
Cred_659 VSS VDD.$351.Metal1 0.0356045f
Cred_660 VSS VDD.$359.Metal1 0.0457382f
Cred_661 VSS VDD.$38.Metal1 0.0289349f
Cred_662 VSS VDD.$384.Metal1 0.0456379f
Cred_663 VSS VDD.$409.Metal1 0.0456379f
Cred_664 VSS VDD.$42.Metal1 0.0474202f
Cred_665 VSS VDD.$434.Metal1 0.0457382f
Cred_666 VSS VDD.$44.Metal1 0.0352836f
Cred_667 VSS VDD.$455.Metal1 0.0356045f
Cred_668 VSS VDD.$461.Metal1 0.0455528f
Cred_669 VSS VDD.$486.Metal1 0.0458546f
Cred_670 VSS VDD.$507.Metal1 0.0355566f
Cred_671 VSS VDD.$513.Metal1 0.0454848f
Cred_672 VSS VDD.$538.Metal1 0.0459853f
Cred_673 VSS VDD.$559.Metal1 0.0354766f
Cred_674 VSS VDD.$565.Metal1 0.045435f
Cred_675 VSS VDD.$590.Metal1 0.0461296f
Cred_676 VSS VDD.$611.Metal1 0.0353643f
Cred_677 VSS VDD.$617.Metal1 0.0454044f
Cred_678 VSS VDD.$64.Metal1 0.0383313f
Cred_679 VSS VDD.$642.Metal1 0.0462869f
Cred_680 VSS VDD.$663.Metal1 0.0352191f
Cred_681 VSS VDD.$669.Metal1 0.0453945f
Cred_682 VSS VDD.$694.Metal1 0.0464565f
Cred_683 VSS VDD.$715.Metal1 0.0327709f
Cred_684 VSS VDD.$719.Metal1 0.0381865f
Cred_685 VSS VDD.$735.Metal1 9.48613e-05f
Cred_686 VSS VDD.$742.Metal1 0.0383313f
Cred_687 VSS VDD.$746.Metal1 0.102852f
Cred_688 VSS VDD.$752.Metal1 0.0689714f
Cred_689 VSS VDD.$759.Metal1 0.0289349f
Cred_690 VSS VDD.$761.Metal1 0.0351235f
Cred_691 VSS VDD.$765.Metal1 0.0474202f
Cred_692 VSS VDD.$807.Metal2 0.0967811f
Cred_693 VSS VDD.$819.Metal2 0.102918f
Cred_694 VSS VDD.$822.Metal2 0.0375799f
Cred_695 VSS VDD.$836.Metal2 0.0217647f
Cred_696 VSS VDD.$847.Metal2 0.0214685f
Cred_697 VSS VDD.$855.Metal2 0.0215237f
Cred_698 VSS VDD.$86.Metal1 9.48613e-05f
Cred_699 VSS VDD.$866.Metal2 0.0145166f
Cred_700 VSS VDD.$87.Metal1 0.0381865f
Cred_701 VSS VDD.$870.Metal2 0.0144352f
Cred_702 VSS VDD.$881.Metal2 0.0214389f
Cred_703 VSS VDD.$889.Metal2 0.0215212f
Cred_704 VSS VDD.$900.Metal2 0.0145194f
Cred_705 VSS VDD.$904.Metal2 0.0144342f
Cred_706 VSS VDD.$91.Metal1 0.0327709f
Cred_707 VSS VDD.$915.Metal2 0.0214426f
Cred_708 VSS VDD.$923.Metal2 0.0215185f
Cred_709 VSS VDD.$934.Metal2 0.0145221f
Cred_710 VSS VDD.$938.Metal2 0.014433f
Cred_711 VSS VDD.$949.Metal2 0.0214462f
Cred_712 VSS VDD.$957.Metal2 0.0215158f
Cred_713 VSS VDD.$968.Metal2 0.0145246f
Cred_714 VSS VDD.$972.Metal2 0.0144317f
Cred_715 VSS VDD.$983.Metal2 0.0214496f
Cred_716 VSS VDD.$99.Metal1 0.0464565f
Cred_717 VSS VDD.$991.Metal2 0.021513f
Cred_718 VSS VDD.P0.GatPoly 0.00328174f
Cred_719 VSS VDD.P0.nSD 0.342771f
Cred_720 VSS VDD.P0.pSD 7.19314e-05f
Cred_721 VSS VDD.P1.GatPoly 0.00328174f
Cred_722 VSS VDD.P1.pSD 7.19314e-05f
Cred_723 VSS VDD.P55.pSD 7.19314e-05f
Cred_724 VSS VDD.P57.pSD 7.19314e-05f
Cred_725 VSS vin 0.0399503f
Cred_726 VSS vin.$102.GatPoly 0.0391029f
Cred_727 VSS vin.$103.GatPoly 0.00407941f
Cred_728 VSS vin.$108.GatPoly 0.0381796f
Cred_729 VSS vin.$109.GatPoly 0.00320862f
Cred_730 VSS vin.$112.GatPoly 0.039103f
Cred_731 VSS vin.$113.GatPoly 0.00407941f
Cred_732 VSS vin.$118.GatPoly 0.0381796f
Cred_733 VSS vin.$119.GatPoly 0.00318325f
Cred_734 VSS vin.$12.GatPoly 0.0513764f
Cred_735 VSS vin.$122.GatPoly 0.0313201f
Cred_736 VSS vin.$123.GatPoly 0.004038f
Cred_737 VSS vin.$126.GatPoly 0.0370313f
Cred_738 VSS vin.$129.GatPoly 0.00320862f
Cred_739 VSS vin.$13.GatPoly 0.00520851f
Cred_740 VSS vin.$132.GatPoly 0.0465612f
Cred_741 VSS vin.$133.GatPoly 0.00407941f
Cred_742 VSS vin.$138.GatPoly 0.0381796f
Cred_743 VSS vin.$139.GatPoly 0.00312827f
Cred_744 VSS vin.$142.GatPoly 0.0414069f
Cred_745 VSS vin.$143.GatPoly 0.00394825f
Cred_746 VSS vin.$149.GatPoly 0.00320862f
Cred_747 VSS vin.$150.GatPoly 0.0414072f
Cred_748 VSS vin.$153.GatPoly 0.00407941f
Cred_749 VSS vin.$154.GatPoly 0.0381796f
Cred_750 VSS vin.$159.GatPoly 0.00320862f
Cred_751 VSS vin.$160.GatPoly 0.0391029f
Cred_752 VSS vin.$163.GatPoly 0.00407941f
Cred_753 VSS vin.$164.GatPoly 0.0381796f
Cred_754 VSS vin.$169.GatPoly 0.00320862f
Cred_755 VSS vin.$170.GatPoly 0.0391028f
Cred_756 VSS vin.$173.GatPoly 0.00407941f
Cred_757 VSS vin.$174.GatPoly 0.0381796f
Cred_758 VSS vin.$179.GatPoly 0.00320862f
Cred_759 VSS vin.$18.GatPoly 0.0381796f
Cred_760 VSS vin.$180.GatPoly 0.039103f
Cred_761 VSS vin.$183.GatPoly 0.00407941f
Cred_762 VSS vin.$184.GatPoly 0.0381796f
Cred_763 VSS vin.$189.GatPoly 0.00320862f
Cred_764 VSS vin.$19.GatPoly 0.00320862f
Cred_765 VSS vin.$190.GatPoly 0.0513766f
Cred_766 VSS vin.$193.GatPoly 0.00407941f
Cred_767 VSS vin.$198.GatPoly 0.0450617f
Cred_768 VSS vin.$199.GatPoly 0.00318325f
Cred_769 VSS vin.$202.GatPoly 0.0414068f
Cred_770 VSS vin.$203.GatPoly 0.00416134f
Cred_771 VSS vin.$210.GatPoly 0.0536808f
Cred_772 VSS vin.$211.GatPoly 0.00420275f
Cred_773 VSS vin.$215.GatPoly 0.00392133f
Cred_774 VSS vin.$218.GatPoly 0.0450617f
Cred_775 VSS vin.$22.GatPoly 0.0391033f
Cred_776 VSS vin.$222.GatPoly 0.0414066f
Cred_777 VSS vin.$223.GatPoly 0.00517119f
Cred_778 VSS vin.$23.GatPoly 0.00407941f
Cred_779 VSS vin.$230.GatPoly 0.0414068f
Cred_780 VSS vin.$231.GatPoly 0.00420275f
Cred_781 VSS vin.$234.GatPoly 0.0381796f
Cred_782 VSS vin.$235.GatPoly 0.00394401f
Cred_783 VSS vin.$240.GatPoly 0.0391033f
Cred_784 VSS vin.$243.GatPoly 0.00533185f
Cred_785 VSS vin.$244.GatPoly 0.0381796f
Cred_786 VSS vin.$250.GatPoly 0.0513764f
Cred_787 VSS vin.$251.GatPoly 0.00533185f
Cred_788 VSS vin.$258.GatPoly 0.0670348f
Cred_789 VSS vin.$259.GatPoly 0.00639157f
Cred_790 VSS vin.$271.Metal1 0.00241174f
Cred_791 VSS vin.$274.Metal1 0.0556624f
Cred_792 VSS vin.$275.Metal1 0.000805205f
Cred_793 VSS vin.$278.Metal1 0.0157219f
Cred_794 VSS vin.$279.Metal1 0.000850251f
Cred_795 VSS vin.$28.GatPoly 0.0381796f
Cred_796 VSS vin.$284.Metal1 0.0116731f
Cred_797 VSS vin.$285.Metal1 0.000513501f
Cred_798 VSS vin.$288.Metal1 0.00902337f
Cred_799 VSS vin.$289.Metal1 0.000253084f
Cred_800 VSS vin.$29.GatPoly 0.00318325f
Cred_801 VSS vin.$296.Metal1 0.0114177f
Cred_802 VSS vin.$297.Metal1 0.000513501f
Cred_803 VSS vin.$300.Metal1 0.00926274f
Cred_804 VSS vin.$301.Metal1 0.00024973f
Cred_805 VSS vin.$306.Metal1 0.0116655f
Cred_806 VSS vin.$307.Metal1 0.000513501f
Cred_807 VSS vin.$310.Metal1 0.00903241f
Cred_808 VSS vin.$311.Metal1 0.000253084f
Cred_809 VSS vin.$318.Metal1 0.0114296f
Cred_810 VSS vin.$319.Metal1 0.000513501f
Cred_811 VSS vin.$32.GatPoly 0.0391025f
Cred_812 VSS vin.$322.Metal1 0.00924614f
Cred_813 VSS vin.$323.Metal1 0.00024246f
Cred_814 VSS vin.$328.Metal1 0.0116571f
Cred_815 VSS vin.$329.Metal1 0.000513501f
Cred_816 VSS vin.$33.GatPoly 0.004038f
Cred_817 VSS vin.$332.Metal1 0.00903937f
Cred_818 VSS vin.$333.Metal1 0.000253084f
Cred_819 VSS vin.$340.Metal1 0.0114465f
Cred_820 VSS vin.$341.Metal1 0.000513501f
Cred_821 VSS vin.$344.Metal1 0.00923997f
Cred_822 VSS vin.$345.Metal1 0.000253084f
Cred_823 VSS vin.$350.Metal1 0.0116413f
Cred_824 VSS vin.$351.Metal1 0.000513501f
Cred_825 VSS vin.$354.Metal1 0.00904383f
Cred_826 VSS vin.$355.Metal1 0.000253084f
Cred_827 VSS vin.$362.Metal1 0.0114677f
Cred_828 VSS vin.$363.Metal1 0.000513501f
Cred_829 VSS vin.$366.Metal1 0.00923979f
Cred_830 VSS vin.$367.Metal1 0.000253084f
Cred_831 VSS vin.$372.Metal1 0.011616f
Cred_832 VSS vin.$373.Metal1 0.000513501f
Cred_833 VSS vin.$376.Metal1 0.00904916f
Cred_834 VSS vin.$377.Metal1 0.000253084f
Cred_835 VSS vin.$38.GatPoly 0.0381796f
Cred_836 VSS vin.$384.Metal1 0.0114902f
Cred_837 VSS vin.$385.Metal1 0.000513501f
Cred_838 VSS vin.$388.Metal1 0.00923797f
Cred_839 VSS vin.$389.Metal1 0.000253084f
Cred_840 VSS vin.$39.GatPoly 0.00320862f
Cred_841 VSS vin.$394.Metal1 0.0115923f
Cred_842 VSS vin.$395.Metal1 0.000513501f
Cred_843 VSS vin.$398.Metal1 0.00906144f
Cred_844 VSS vin.$399.Metal1 0.00024973f
Cred_845 VSS vin.$4.GatPoly 0.0758054f
Cred_846 VSS vin.$406.Metal1 0.00725435f
Cred_847 VSS vin.$407.Metal1 0.000513501f
Cred_848 VSS vin.$410.Metal1 0.0131202f
Cred_849 VSS vin.$411.Metal1 0.000253084f
Cred_850 VSS vin.$416.Metal1 0.0115649f
Cred_851 VSS vin.$417.Metal1 0.000513501f
Cred_852 VSS vin.$42.GatPoly 0.0391032f
Cred_853 VSS vin.$420.Metal1 0.00906294f
Cred_854 VSS vin.$421.Metal1 0.00024246f
Cred_855 VSS vin.$428.Metal1 0.0152679f
Cred_856 VSS vin.$429.Metal1 0.000513501f
Cred_857 VSS vin.$43.GatPoly 0.00407941f
Cred_858 VSS vin.$433.Metal1 0.000253084f
Cred_859 VSS vin.$434.Metal1 0.00923803f
Cred_860 VSS vin.$438.Metal1 0.0114902f
Cred_861 VSS vin.$439.Metal1 0.000513501f
Cred_862 VSS vin.$443.Metal1 0.000253084f
Cred_863 VSS vin.$446.Metal1 0.00904916f
Cred_864 VSS vin.$450.Metal1 0.011616f
Cred_865 VSS vin.$451.Metal1 0.000513501f
Cred_866 VSS vin.$455.Metal1 0.000253084f
Cred_867 VSS vin.$456.Metal1 0.00923979f
Cred_868 VSS vin.$460.Metal1 0.0114677f
Cred_869 VSS vin.$461.Metal1 0.000513501f
Cred_870 VSS vin.$465.Metal1 0.000253084f
Cred_871 VSS vin.$468.Metal1 0.00904383f
Cred_872 VSS vin.$472.Metal1 0.0116413f
Cred_873 VSS vin.$473.Metal1 0.000513501f
Cred_874 VSS vin.$477.Metal1 0.000253084f
Cred_875 VSS vin.$478.Metal1 0.0157313f
Cred_876 VSS vin.$48.GatPoly 0.0381796f
Cred_877 VSS vin.$482.Metal1 0.0117162f
Cred_878 VSS vin.$483.Metal1 0.000513501f
Cred_879 VSS vin.$486.Metal1 0.00908078f
Cred_880 VSS vin.$487.Metal1 0.00024973f
Cred_881 VSS vin.$49.GatPoly 0.00312827f
Cred_882 VSS vin.$494.Metal1 0.0153464f
Cred_883 VSS vin.$495.Metal1 0.000579807f
Cred_884 VSS vin.$5.GatPoly 0.00634941f
Cred_885 VSS vin.$500.Metal1 0.0157393f
Cred_886 VSS vin.$501.Metal1 0.000253084f
Cred_887 VSS vin.$504.Metal1 0.0116889f
Cred_888 VSS vin.$505.Metal1 0.000796207f
Cred_889 VSS vin.$508.Metal1 0.00909393f
Cred_890 VSS vin.$509.Metal1 0.000824025f
Cred_891 VSS vin.$516.Metal1 0.015344f
Cred_892 VSS vin.$517.Metal1 0.000579807f
Cred_893 VSS vin.$52.GatPoly 0.0391026f
Cred_894 VSS vin.$522.Metal1 0.00926125f
Cred_895 VSS vin.$523.Metal1 0.000253084f
Cred_896 VSS vin.$526.Metal1 0.0114172f
Cred_897 VSS vin.$527.Metal1 0.000805205f
Cred_898 VSS vin.$53.GatPoly 0.00394825f
Cred_899 VSS vin.$531.Metal1 0.000850251f
Cred_900 VSS vin.$534.Metal1 0.00902337f
Cred_901 VSS vin.$538.Metal1 0.0116731f
Cred_902 VSS vin.$539.Metal1 0.000579807f
Cred_903 VSS vin.$544.Metal1 0.0157643f
Cred_904 VSS vin.$545.Metal1 0.000850251f
Cred_905 VSS vin.$548.Metal1 0.0496592f
Cred_906 VSS vin.$549.Metal1 0.00340065f
Cred_907 VSS vin.$564.Metal2 0.0411852f
Cred_908 VSS vin.$566.Metal2 0.0154896f
Cred_909 VSS vin.$569.Metal2 0.00857703f
Cred_910 VSS vin.$573.Metal2 0.00187937f
Cred_911 VSS vin.$574.Metal2 0.010485f
Cred_912 VSS vin.$578.Metal2 0.011053f
Cred_913 VSS vin.$58.GatPoly 0.0381796f
Cred_914 VSS vin.$581.Metal2 0.019001f
Cred_915 VSS vin.$583.Metal2 0.00772045f
Cred_916 VSS vin.$588.Metal2 0.0150672f
Cred_917 VSS vin.$59.GatPoly 0.00320862f
Cred_918 VSS vin.$590.Metal2 0.0116105f
Cred_919 VSS vin.$594.Metal2 0.0115212f
Cred_920 VSS vin.$597.Metal2 0.0139133f
Cred_921 VSS vin.$599.Metal2 0.00739795f
Cred_922 VSS vin.$604.Metal2 0.0149363f
Cred_923 VSS vin.$606.Metal2 0.0119551f
Cred_924 VSS vin.$610.Metal2 0.011585f
Cred_925 VSS vin.$613.Metal2 0.0135129f
Cred_926 VSS vin.$615.Metal2 0.00728816f
Cred_927 VSS vin.$62.GatPoly 0.039103f
Cred_928 VSS vin.$620.Metal2 0.0151992f
Cred_929 VSS vin.$622.Metal2 0.0117307f
Cred_930 VSS vin.$626.Metal2 0.0119242f
Cred_931 VSS vin.$629.Metal2 0.0135087f
Cred_932 VSS vin.$63.GatPoly 0.00407941f
Cred_933 VSS vin.$631.Metal2 0.00711182f
Cred_934 VSS vin.$636.Metal2 0.0152703f
Cred_935 VSS vin.$638.Metal2 0.0116517f
Cred_936 VSS vin.$642.Metal2 0.0122625f
Cred_937 VSS vin.$645.Metal2 0.0133807f
Cred_938 VSS vin.$647.Metal2 0.00689316f
Cred_939 VSS vin.$652.Metal2 0.0151833f
Cred_940 VSS vin.$654.Metal2 0.0116664f
Cred_941 VSS vin.$659.Metal2 0.0133068f
Cred_942 VSS vin.$661.Metal2 0.0139745f
Cred_943 VSS vin.$665.Metal2 0.00880774f
Cred_944 VSS vin.$668.Metal2 0.0146502f
Cred_945 VSS vin.$670.Metal2 0.00882647f
Cred_946 VSS vin.$674.Metal2 0.0123783f
Cred_947 VSS vin.$676.Metal2 0.0132268f
Cred_948 VSS vin.$679.Metal2 0.00358073f
Cred_949 VSS vin.$68.GatPoly 0.0381796f
Cred_950 VSS vin.$681.Metal2 0.00986639f
Cred_951 VSS vin.$684.Metal2 0.0152216f
Cred_952 VSS vin.$688.Metal2 0.00689679f
Cred_953 VSS vin.$69.GatPoly 0.00320862f
Cred_954 VSS vin.$691.Metal2 0.0133807f
Cred_955 VSS vin.$693.Metal2 0.0122625f
Cred_956 VSS vin.$697.Metal2 0.0116517f
Cred_957 VSS vin.$700.Metal2 0.0152703f
Cred_958 VSS vin.$704.Metal2 0.00711182f
Cred_959 VSS vin.$707.Metal2 0.0135087f
Cred_960 VSS vin.$709.Metal2 0.0119242f
Cred_961 VSS vin.$713.Metal2 0.0116817f
Cred_962 VSS vin.$716.Metal2 0.0150469f
Cred_963 VSS vin.$72.GatPoly 0.0391027f
Cred_964 VSS vin.$720.Metal2 0.0075612f
Cred_965 VSS vin.$723.Metal2 0.0136647f
Cred_966 VSS vin.$725.Metal2 0.0111311f
Cred_967 VSS vin.$729.Metal2 0.0119471f
Cred_968 VSS vin.$73.GatPoly 0.00407941f
Cred_969 VSS vin.$732.Metal2 0.0153448f
Cred_970 VSS vin.$736.Metal2 0.00722998f
Cred_971 VSS vin.$739.Metal2 0.0135014f
Cred_972 VSS vin.$741.Metal2 0.0117098f
Cred_973 VSS vin.$745.Metal2 0.011846f
Cred_974 VSS vin.$748.Metal2 0.0149359f
Cred_975 VSS vin.$752.Metal2 0.00763049f
Cred_976 VSS vin.$755.Metal2 0.0137923f
Cred_977 VSS vin.$757.Metal2 0.0111149f
Cred_978 VSS vin.$761.Metal2 0.01198f
Cred_979 VSS vin.$764.Metal2 0.0149529f
Cred_980 VSS vin.$768.Metal2 0.0339626f
Cred_981 VSS vin.$769.Metal2 0.0109759f
Cred_982 VSS vin.$771.Metal2 0.0494509f
Cred_983 VSS vin.$78.GatPoly 0.0381796f
Cred_984 VSS vin.$79.GatPoly 0.00320862f
Cred_985 VSS vin.$82.GatPoly 0.039103f
Cred_986 VSS vin.$83.GatPoly 0.00407941f
Cred_987 VSS vin.$88.GatPoly 0.0381796f
Cred_988 VSS vin.$89.GatPoly 0.00320862f
Cred_989 VSS vin.$92.GatPoly 0.0391028f
Cred_990 VSS vin.$93.GatPoly 0.00407941f
Cred_991 VSS vin.$98.GatPoly 0.0381796f
Cred_992 VSS vin.$99.GatPoly 0.00320862f
Cred_993 VSS vin.P0.GatPoly 0.0200449f
Cred_994 VSS vin.P1.GatPoly 0.0134362f
Cred_995 VSS vin.P10.GatPoly 0.0134362f
Cred_996 VSS vin.P100.GatPoly 0.00148554f
Cred_997 VSS vin.P101.GatPoly 0.00146189f
Cred_998 VSS vin.P102.GatPoly 0.00159876f
Cred_999 VSS vin.P103.GatPoly 0.00148554f
Cred_1000 VSS vin.P104.GatPoly 0.00148554f
Cred_1001 VSS vin.P105.GatPoly 0.00159876f
Cred_1002 VSS vin.P106.GatPoly 0.00146189f
Cred_1003 VSS vin.P107.GatPoly 0.00171704f
Cred_1004 VSS vin.P11.GatPoly 0.0144317f
Cred_1005 VSS vin.P12.GatPoly 0.0134362f
Cred_1006 VSS vin.P13.GatPoly 0.0144317f
Cred_1007 VSS vin.P14.GatPoly 0.0134362f
Cred_1008 VSS vin.P15.GatPoly 0.0144317f
Cred_1009 VSS vin.P16.GatPoly 0.0134362f
Cred_1010 VSS vin.P17.GatPoly 0.0144317f
Cred_1011 VSS vin.P18.GatPoly 0.0134362f
Cred_1012 VSS vin.P19.GatPoly 0.0144317f
Cred_1013 VSS vin.P2.GatPoly 0.017112f
Cred_1014 VSS vin.P20.GatPoly 0.0134362f
Cred_1015 VSS vin.P21.GatPoly 0.0144317f
Cred_1016 VSS vin.P22.GatPoly 0.0134362f
Cred_1017 VSS vin.P23.GatPoly 0.0144317f
Cred_1018 VSS vin.P24.GatPoly 0.0134362f
Cred_1019 VSS vin.P25.GatPoly 0.0140102f
Cred_1020 VSS vin.P26.GatPoly 0.0156698f
Cred_1021 VSS vin.P27.GatPoly 0.0144317f
Cred_1022 VSS vin.P28.GatPoly 0.0134362f
Cred_1023 VSS vin.P29.GatPoly 0.0145565f
Cred_1024 VSS vin.P3.GatPoly 0.0144317f
Cred_1025 VSS vin.P30.GatPoly 0.0145565f
Cred_1026 VSS vin.P31.GatPoly 0.0134362f
Cred_1027 VSS vin.P32.GatPoly 0.0144317f
Cred_1028 VSS vin.P33.GatPoly 0.0134362f
Cred_1029 VSS vin.P34.GatPoly 0.0144317f
Cred_1030 VSS vin.P35.GatPoly 0.0134362f
Cred_1031 VSS vin.P36.GatPoly 0.0144317f
Cred_1032 VSS vin.P37.GatPoly 0.0134362f
Cred_1033 VSS vin.P38.GatPoly 0.0144317f
Cred_1034 VSS vin.P39.GatPoly 0.017112f
Cred_1035 VSS vin.P4.GatPoly 0.0134362f
Cred_1036 VSS vin.P40.GatPoly 0.0134362f
Cred_1037 VSS vin.P41.GatPoly 0.0145565f
Cred_1038 VSS vin.P42.GatPoly 0.0145565f
Cred_1039 VSS vin.P43.GatPoly 0.017112f
Cred_1040 VSS vin.P44.GatPoly 0.0134362f
Cred_1041 VSS vin.P45.GatPoly 0.0145565f
Cred_1042 VSS vin.P46.GatPoly 0.0145565f
Cred_1043 VSS vin.P47.GatPoly 0.0134362f
Cred_1044 VSS vin.P48.GatPoly 0.0144317f
Cred_1045 VSS vin.P49.GatPoly 0.0134362f
Cred_1046 VSS vin.P5.GatPoly 0.0144317f
Cred_1047 VSS vin.P50.GatPoly 0.0144317f
Cred_1048 VSS vin.P51.GatPoly 0.017112f
Cred_1049 VSS vin.P52.GatPoly 0.0134362f
Cred_1050 VSS vin.P53.GatPoly 0.0181472f
Cred_1051 VSS vin.P54.GatPoly 0.00171496f
Cred_1052 VSS vin.P55.GatPoly 0.00146189f
Cred_1053 VSS vin.P56.GatPoly 0.00159876f
Cred_1054 VSS vin.P57.GatPoly 0.00148283f
Cred_1055 VSS vin.P58.GatPoly 0.00146189f
Cred_1056 VSS vin.P59.GatPoly 0.00148283f
Cred_1057 VSS vin.P6.GatPoly 0.0134362f
Cred_1058 VSS vin.P60.GatPoly 0.00146189f
Cred_1059 VSS vin.P61.GatPoly 0.00148283f
Cred_1060 VSS vin.P62.GatPoly 0.00146189f
Cred_1061 VSS vin.P63.GatPoly 0.00148283f
Cred_1062 VSS vin.P64.GatPoly 0.00146189f
Cred_1063 VSS vin.P65.GatPoly 0.00148283f
Cred_1064 VSS vin.P66.GatPoly 0.00146189f
Cred_1065 VSS vin.P67.GatPoly 0.00148283f
Cred_1066 VSS vin.P68.GatPoly 0.00146189f
Cred_1067 VSS vin.P69.GatPoly 0.00148283f
Cred_1068 VSS vin.P7.GatPoly 0.0144317f
Cred_1069 VSS vin.P70.GatPoly 0.00146189f
Cred_1070 VSS vin.P71.GatPoly 0.00148283f
Cred_1071 VSS vin.P72.GatPoly 0.00146189f
Cred_1072 VSS vin.P73.GatPoly 0.00148283f
Cred_1073 VSS vin.P74.GatPoly 0.00146189f
Cred_1074 VSS vin.P75.GatPoly 0.00148283f
Cred_1075 VSS vin.P76.GatPoly 0.00146189f
Cred_1076 VSS vin.P77.GatPoly 0.00148283f
Cred_1077 VSS vin.P78.GatPoly 0.00146189f
Cred_1078 VSS vin.P79.GatPoly 0.00148283f
Cred_1079 VSS vin.P8.GatPoly 0.0134362f
Cred_1080 VSS vin.P80.GatPoly 0.00146189f
Cred_1081 VSS vin.P81.GatPoly 0.00148283f
Cred_1082 VSS vin.P82.GatPoly 0.00146189f
Cred_1083 VSS vin.P83.GatPoly 0.00148283f
Cred_1084 VSS vin.P84.GatPoly 0.00146189f
Cred_1085 VSS vin.P85.GatPoly 0.00148283f
Cred_1086 VSS vin.P86.GatPoly 0.00146189f
Cred_1087 VSS vin.P87.GatPoly 0.00148283f
Cred_1088 VSS vin.P88.GatPoly 0.00146189f
Cred_1089 VSS vin.P89.GatPoly 0.00148283f
Cred_1090 VSS vin.P9.GatPoly 0.0144317f
Cred_1091 VSS vin.P90.GatPoly 0.00146189f
Cred_1092 VSS vin.P91.GatPoly 0.00148283f
Cred_1093 VSS vin.P92.GatPoly 0.00146189f
Cred_1094 VSS vin.P93.GatPoly 0.00148283f
Cred_1095 VSS vin.P94.GatPoly 0.00146189f
Cred_1096 VSS vin.P95.GatPoly 0.00148554f
Cred_1097 VSS vin.P96.GatPoly 0.00148554f
Cred_1098 VSS vin.P97.GatPoly 0.00146189f
Cred_1099 VSS vin.P98.GatPoly 0.00159518f
Cred_1100 VSS vin.P99.GatPoly 0.00148554f
Cred_1101 VSS vout 0.110884f
Cred_1102 VSS vout.$1008.Metal3 0.0279013f
Cred_1103 VSS vout.$1026.Metal3 0.0279013f
Cred_1104 VSS vout.$1044.Metal3 0.0279013f
Cred_1105 VSS vout.$1062.Metal3 0.0279013f
Cred_1106 VSS vout.$1080.Metal3 0.0279013f
Cred_1107 VSS vout.$1098.Metal3 0.0279013f
Cred_1108 VSS vout.$1116.Metal3 0.0279013f
Cred_1109 VSS vout.$1134.Metal3 0.0279013f
Cred_1110 VSS vout.$1152.Metal3 0.0279013f
Cred_1111 VSS vout.$1170.Metal3 0.0212142f
Cred_1112 VSS vout.$954.Metal3 0.100631f
Cred_1113 VSS vout.$972.Metal3 0.0279013f
Cred_1114 VSS vout.$990.Metal3 0.0279013f
Cred_1115 VSS vout.P0.nSD 0.00353774f
Cred_1116 VSS vout.P0.pSD 0.00158514f
Cred_1117 VSS vout.P10.nSD 0.00274419f
Cred_1118 VSS vout.P12.nSD 0.00278586f
Cred_1119 VSS vout.P12.pSD 0.000113034f
Cred_1120 VSS vout.P14.nSD 0.00274419f
Cred_1121 VSS vout.P16.nSD 0.00278586f
Cred_1122 VSS vout.P16.pSD 0.000113034f
Cred_1123 VSS vout.P18.nSD 0.00274419f
Cred_1124 VSS vout.P2.nSD 0.00274419f
Cred_1125 VSS vout.P20.nSD 0.00278586f
Cred_1126 VSS vout.P20.pSD 0.000113034f
Cred_1127 VSS vout.P22.nSD 0.00274419f
Cred_1128 VSS vout.P24.nSD 0.00278586f
Cred_1129 VSS vout.P24.pSD 0.000113034f
Cred_1130 VSS vout.P26.nSD 0.00274419f
Cred_1131 VSS vout.P28.nSD 0.00278586f
Cred_1132 VSS vout.P28.pSD 0.000113034f
Cred_1133 VSS vout.P30.nSD 0.00274419f
Cred_1134 VSS vout.P32.nSD 0.00278586f
Cred_1135 VSS vout.P32.pSD 0.000113034f
Cred_1136 VSS vout.P34.nSD 0.00274419f
Cred_1137 VSS vout.P36.nSD 0.00278586f
Cred_1138 VSS vout.P36.pSD 0.000113034f
Cred_1139 VSS vout.P38.nSD 0.00274419f
Cred_1140 VSS vout.P4.nSD 0.00278586f
Cred_1141 VSS vout.P4.pSD 0.000113034f
Cred_1142 VSS vout.P40.nSD 0.00278586f
Cred_1143 VSS vout.P40.pSD 0.000113034f
Cred_1144 VSS vout.P42.nSD 0.00274419f
Cred_1145 VSS vout.P44.nSD 0.00278586f
Cred_1146 VSS vout.P44.pSD 0.000113034f
Cred_1147 VSS vout.P46.nSD 0.00274419f
Cred_1148 VSS vout.P48.nSD 0.00278586f
Cred_1149 VSS vout.P48.pSD 0.000113034f
Cred_1150 VSS vout.P50.nSD 0.00274419f
Cred_1151 VSS vout.P52.nSD 0.0031372f
Cred_1152 VSS vout.P52.pSD 0.000550718f
Cred_1153 VSS vout.P6.nSD 0.00274419f
Cred_1154 VSS vout.P8.nSD 0.00278586f
Cred_1155 VSS vout.P8.pSD 0.000113034f
Cred_1156 VSS VSS 0.0499006f
Cred_1157 VSS VSS.$1002.Metal3 0.0377087f
Cred_1158 VSS VSS.$1008.Metal3 0.0379259f
Cred_1159 VSS VSS.$1012.Metal3 0.0377263f
Cred_1160 VSS VSS.$1018.Metal3 0.0379079f
Cred_1161 VSS VSS.$102.Metal1 0.0945159f
Cred_1162 VSS VSS.$1022.Metal3 0.0377146f
Cred_1163 VSS VSS.$1028.Metal3 0.0526213f
Cred_1164 VSS VSS.$1036.Metal3 0.0527744f
Cred_1165 VSS VSS.$1042.Metal3 0.0452923f
Cred_1166 VSS VSS.$1048.Metal3 0.121953f
Cred_1167 VSS VSS.$118.Metal1 0.0927611f
Cred_1168 VSS VSS.$128.Metal1 0.0490042f
Cred_1169 VSS VSS.$136.Metal1 0.0942061f
Cred_1170 VSS VSS.$14.Metal1 0.17263f
Cred_1171 VSS VSS.$152.Metal1 0.0928269f
Cred_1172 VSS VSS.$162.Metal1 0.0493149f
Cred_1173 VSS VSS.$170.Metal1 0.0939338f
Cred_1174 VSS VSS.$186.Metal1 0.092913f
Cred_1175 VSS VSS.$196.Metal1 0.0495076f
Cred_1176 VSS VSS.$204.Metal1 0.0936553f
Cred_1177 VSS VSS.$220.Metal1 0.0930183f
Cred_1178 VSS VSS.$230.Metal1 0.04967f
Cred_1179 VSS VSS.$238.Metal1 0.0933254f
Cred_1180 VSS VSS.$254.Metal1 0.0930382f
Cred_1181 VSS VSS.$270.Metal1 0.0930382f
Cred_1182 VSS VSS.$286.Metal1 0.0933254f
Cred_1183 VSS VSS.$29.Metal1 0.190756f
Cred_1184 VSS VSS.$298.Metal1 0.04967f
Cred_1185 VSS VSS.$304.Metal1 0.0930183f
Cred_1186 VSS VSS.$31.Metal1 0.0781054f
Cred_1187 VSS VSS.$320.Metal1 0.0936553f
Cred_1188 VSS VSS.$332.Metal1 0.0495076f
Cred_1189 VSS VSS.$338.Metal1 0.092913f
Cred_1190 VSS VSS.$354.Metal1 0.0939338f
Cred_1191 VSS VSS.$366.Metal1 0.0493149f
Cred_1192 VSS VSS.$372.Metal1 0.09277f
Cred_1193 VSS VSS.$388.Metal1 0.0941766f
Cred_1194 VSS VSS.$400.Metal1 0.0490913f
Cred_1195 VSS VSS.$406.Metal1 0.0927206f
Cred_1196 VSS VSS.$42.Metal1 0.0567156f
Cred_1197 VSS VSS.$422.Metal1 0.0944602f
Cred_1198 VSS VSS.$434.Metal1 0.0488366f
Cred_1199 VSS VSS.$440.Metal1 0.0927172f
Cred_1200 VSS VSS.$456.Metal1 0.094833f
Cred_1201 VSS VSS.$468.Metal1 0.0485469f
Cred_1202 VSS VSS.$474.Metal1 0.0808048f
Cred_1203 VSS VSS.$486.Metal1 0.0567156f
Cred_1204 VSS VSS.$490.Metal1 0.155822f
Cred_1205 VSS VSS.$496.Metal1 0.0416744f
Cred_1206 VSS VSS.$50.Metal1 0.0808048f
Cred_1207 VSS VSS.$500.Metal1 0.13483f
Cred_1208 VSS VSS.$520.Metal1 0.154379f
Cred_1209 VSS VSS.$531.Metal2 0.164576f
Cred_1210 VSS VSS.$540.Metal2 0.0392606f
Cred_1211 VSS VSS.$550.Metal2 0.0272615f
Cred_1212 VSS VSS.$557.Metal2 0.0380811f
Cred_1213 VSS VSS.$565.Metal2 0.0333896f
Cred_1214 VSS VSS.$572.Metal2 0.0223898f
Cred_1215 VSS VSS.$576.Metal2 0.0188602f
Cred_1216 VSS VSS.$583.Metal2 0.0377035f
Cred_1217 VSS VSS.$591.Metal2 0.0337936f
Cred_1218 VSS VSS.$598.Metal2 0.0222085f
Cred_1219 VSS VSS.$60.Metal1 0.0485469f
Cred_1220 VSS VSS.$602.Metal2 0.0190759f
Cred_1221 VSS VSS.$609.Metal2 0.0372506f
Cred_1222 VSS VSS.$617.Metal2 0.0341838f
Cred_1223 VSS VSS.$624.Metal2 0.0218754f
Cred_1224 VSS VSS.$628.Metal2 0.0194123f
Cred_1225 VSS VSS.$635.Metal2 0.0368586f
Cred_1226 VSS VSS.$643.Metal2 0.034574f
Cred_1227 VSS VSS.$650.Metal2 0.021542f
Cred_1228 VSS VSS.$654.Metal2 0.0197481f
Cred_1229 VSS VSS.$661.Metal2 0.0364668f
Cred_1230 VSS VSS.$669.Metal2 0.0349641f
Cred_1231 VSS VSS.$676.Metal2 0.0212083f
Cred_1232 VSS VSS.$68.Metal1 0.094833f
Cred_1233 VSS VSS.$680.Metal2 0.0200834f
Cred_1234 VSS VSS.$687.Metal2 0.0360755f
Cred_1235 VSS VSS.$695.Metal2 0.0353544f
Cred_1236 VSS VSS.$702.Metal2 0.020874f
Cred_1237 VSS VSS.$706.Metal2 0.0204181f
Cred_1238 VSS VSS.$713.Metal2 0.0356843f
Cred_1239 VSS VSS.$721.Metal2 0.0357444f
Cred_1240 VSS VSS.$728.Metal2 0.0205389f
Cred_1241 VSS VSS.$732.Metal2 0.0207527f
Cred_1242 VSS VSS.$739.Metal2 0.0352941f
Cred_1243 VSS VSS.$747.Metal2 0.0361359f
Cred_1244 VSS VSS.$754.Metal2 0.0202048f
Cred_1245 VSS VSS.$758.Metal2 0.0210872f
Cred_1246 VSS VSS.$765.Metal2 0.0349038f
Cred_1247 VSS VSS.$773.Metal2 0.0365272f
Cred_1248 VSS VSS.$780.Metal2 0.0198694f
Cred_1249 VSS VSS.$784.Metal2 0.021421f
Cred_1250 VSS VSS.$791.Metal2 0.0345137f
Cred_1251 VSS VSS.$799.Metal2 0.036919f
Cred_1252 VSS VSS.$806.Metal2 0.0195333f
Cred_1253 VSS VSS.$810.Metal2 0.0217542f
Cred_1254 VSS VSS.$817.Metal2 0.0341236f
Cred_1255 VSS VSS.$825.Metal2 0.0373108f
Cred_1256 VSS VSS.$832.Metal2 0.0191964f
Cred_1257 VSS VSS.$836.Metal2 0.0220874f
Cred_1258 VSS VSS.$84.Metal1 0.0926948f
Cred_1259 VSS VSS.$843.Metal2 0.0339715f
Cred_1260 VSS VSS.$851.Metal2 0.0378812f
Cred_1261 VSS VSS.$858.Metal2 0.0187389f
Cred_1262 VSS VSS.$862.Metal2 0.0225106f
Cred_1263 VSS VSS.$869.Metal2 0.0334498f
Cred_1264 VSS VSS.$877.Metal2 0.0380811f
Cred_1265 VSS VSS.$884.Metal2 0.0272615f
Cred_1266 VSS VSS.$895.Metal2 0.0391408f
Cred_1267 VSS VSS.$904.Metal2 0.16387f
Cred_1268 VSS VSS.$916.Metal3 0.12195f
Cred_1269 VSS VSS.$922.Metal3 0.0377889f
Cred_1270 VSS VSS.$926.Metal3 0.0378689f
Cred_1271 VSS VSS.$932.Metal3 0.0452733f
Cred_1272 VSS VSS.$938.Metal3 0.0379136f
Cred_1273 VSS VSS.$94.Metal1 0.0487611f
Cred_1274 VSS VSS.$942.Metal3 0.0375477f
Cred_1275 VSS VSS.$948.Metal3 0.0379277f
Cred_1276 VSS VSS.$952.Metal3 0.037712f
Cred_1277 VSS VSS.$958.Metal3 0.0379418f
Cred_1278 VSS VSS.$962.Metal3 0.0376982f
Cred_1279 VSS VSS.$968.Metal3 0.0379558f
Cred_1280 VSS VSS.$972.Metal3 0.0376822f
Cred_1281 VSS VSS.$978.Metal3 0.0379717f
Cred_1282 VSS VSS.$982.Metal3 0.037635f
Cred_1283 VSS VSS.$988.Metal3 0.0378164f
Cred_1284 VSS VSS.$992.Metal3 0.037688f
Cred_1285 VSS VSS.$998.Metal3 0.0379437f
Cred_1286 VSS VSS.P0.GatPoly 0.0339868f
Cred_1287 VSS VSS.P0.nSD 0.000303204f
Cred_1288 VSS VSS.P0.pSD 0.607006f
Cred_1289 VSS VSS.P1.GatPoly 0.0339868f
Cred_1290 VSS VSS.P1.nSD 0.000303204f
Cred_1291 VSS VSS.P10.nSD 0.00099373f
Cred_1292 VSS VSS.P11.nSD 0.00099254f
Cred_1293 VSS VSS.P13.nSD 0.000993646f
Cred_1294 VSS VSS.P15.nSD 0.000992721f
Cred_1295 VSS VSS.P17.nSD 0.000993551f
Cred_1296 VSS VSS.P19.nSD 0.00099289f
Cred_1297 VSS VSS.P21.nSD 0.000993443f
Cred_1298 VSS VSS.P23.nSD 0.000993046f
Cred_1299 VSS VSS.P25.nSD 0.000993323f
Cred_1300 VSS VSS.P27.nSD 0.000993191f
Cred_1301 VSS VSS.P29.nSD 0.000993191f
Cred_1302 VSS VSS.P3.nSD 0.00099214f
Cred_1303 VSS VSS.P31.nSD 0.000993323f
Cred_1304 VSS VSS.P33.nSD 0.000993046f
Cred_1305 VSS VSS.P35.nSD 0.000993443f
Cred_1306 VSS VSS.P37.nSD 0.00099289f
Cred_1307 VSS VSS.P39.nSD 0.000993551f
Cred_1308 VSS VSS.P41.nSD 0.000992721f
Cred_1309 VSS VSS.P43.nSD 0.000993646f
Cred_1310 VSS VSS.P45.nSD 0.00099254f
Cred_1311 VSS VSS.P47.nSD 0.00099373f
Cred_1312 VSS VSS.P49.nSD 0.000992346f
Cred_1313 VSS VSS.P5.nSD 0.000993789f
Cred_1314 VSS VSS.P51.nSD 0.000993789f
Cred_1315 VSS VSS.P53.nSD 0.00099214f
Cred_1316 VSS VSS.P55.nSD 0.000303204f
Cred_1317 VSS VSS.P57.nSD 0.000303204f
Cred_1318 VSS VSS.P7.nSD 0.000992346f
Cred_1319 VDD vin.$133.GatPoly 2.15117e-06f
Cred_1320 VDD vin.$407.Metal1 4.21599e-05f
Cred_1321 VDD vin.$411.Metal1 0.000548574f
Cred_1322 VDD vin.$417.Metal1 0.000223011f
Cred_1323 VDD vin.$666.Metal2 7.48394e-07f
Cred_1324 VDD vin.$671.Metal2 3.95873e-06f
Cred_1325 VDD vin.P80.GatPoly 0.00108662f
Cred_1326 VDD vin.P81.GatPoly 0.00108662f
Cred_1327 VDD vout.$1062.Metal3 0.00593381f
Cred_1328 VDD vout.P26.pSD 0.0095483f
Cred_1329 VDD.$1002.Metal2 vin.$372.Metal1 2.16723e-06f
Cred_1330 VDD.$1002.Metal2 vin.$373.Metal1 0.00164028f
Cred_1331 VDD.$1002.Metal2 vin.$376.Metal1 7.22411e-07f
Cred_1332 VDD.$1002.Metal2 vin.$377.Metal1 0.000132567f
Cred_1333 VDD.$1002.Metal2 vin.$636.Metal2 0.0003551f
Cred_1334 VDD.$1002.Metal2 vin.$638.Metal2 0.000144697f
Cred_1335 VDD.$1002.Metal2 vin.$639.Metal2 0.00338985f
Cred_1336 VDD.$1002.Metal2 vin.$642.Metal2 0.000144697f
Cred_1337 VDD.$1002.Metal2 vin.$643.Metal2 0.00278801f
Cred_1338 VDD.$1002.Metal2 vin.$645.Metal2 0.0003551f
Cred_1339 VDD.$1002.Metal2 vin.$93.GatPoly 0.000706687f
Cred_1340 VDD.$1002.Metal2 vin.$99.GatPoly 0.000957743f
Cred_1341 VDD.$1002.Metal2 vin.P73.GatPoly 0.00319288f
Cred_1342 VDD.$1002.Metal2 vin.P74.GatPoly 0.00271168f
Cred_1343 VDD.$1002.Metal2 vin.P75.GatPoly 4.47994e-06f
Cred_1344 VDD.$1002.Metal2 vout.$1026.Metal3 0.0884609f
Cred_1345 VDD.$1002.Metal2 vout.$1044.Metal3 0.0298022f
Cred_1346 VDD.$1002.Metal2 vout.P18.pSD 0.0328702f
Cred_1347 VDD.$1002.Metal2 vout.P20.nSD 0.000179023f
Cred_1348 VDD.$1002.Metal2 vout.P20.pSD 0.0353937f
Cred_1349 VDD.$1006.Metal2 vin.$103.GatPoly 0.000530243f
Cred_1350 VDD.$1006.Metal2 vin.$109.GatPoly 0.000718615f
Cred_1351 VDD.$1006.Metal2 vin.$381.Metal1 0.000105172f
Cred_1352 VDD.$1006.Metal2 vin.$385.Metal1 0.00121834f
Cred_1353 VDD.$1006.Metal2 vin.$643.Metal2 0.00198036f
Cred_1354 VDD.$1006.Metal2 vin.$645.Metal2 0.000317571f
Cred_1355 VDD.$1006.Metal2 vin.$647.Metal2 0.000205278f
Cred_1356 VDD.$1006.Metal2 vin.$650.Metal2 0.00276225f
Cred_1357 VDD.$1006.Metal2 vin.$652.Metal2 0.000266439f
Cred_1358 VDD.$1006.Metal2 vin.P74.GatPoly 5.11004e-06f
Cred_1359 VDD.$1006.Metal2 vin.P75.GatPoly 0.00201946f
Cred_1360 VDD.$1006.Metal2 vin.P76.GatPoly 0.00241903f
Cred_1361 VDD.$1006.Metal2 vout.$1026.Metal3 0.0238505f
Cred_1362 VDD.$1006.Metal2 vout.$1044.Metal3 0.0671784f
Cred_1363 VDD.$1006.Metal2 vout.P20.nSD 0.000143271f
Cred_1364 VDD.$1006.Metal2 vout.P20.pSD 0.0282418f
Cred_1365 VDD.$1006.Metal2 vout.P22.pSD 0.0243495f
Cred_1366 VDD.$1017.Metal2 vin.$103.GatPoly 0.00188531f
Cred_1367 VDD.$1017.Metal2 vin.$109.GatPoly 0.00255508f
Cred_1368 VDD.$1017.Metal2 vin.$381.Metal1 0.000373944f
Cred_1369 VDD.$1017.Metal2 vin.$385.Metal1 0.00433205f
Cred_1370 VDD.$1017.Metal2 vin.$389.Metal1 1.05718e-06f
Cred_1371 VDD.$1017.Metal2 vin.$643.Metal2 0.00704128f
Cred_1372 VDD.$1017.Metal2 vin.$645.Metal2 0.00112914f
Cred_1373 VDD.$1017.Metal2 vin.$647.Metal2 0.000729876f
Cred_1374 VDD.$1017.Metal2 vin.$650.Metal2 0.00982134f
Cred_1375 VDD.$1017.Metal2 vin.$652.Metal2 0.000947339f
Cred_1376 VDD.$1017.Metal2 vin.P75.GatPoly 0.00714171f
Cred_1377 VDD.$1017.Metal2 vin.P76.GatPoly 0.00860949f
Cred_1378 VDD.$1017.Metal2 vout.$1026.Metal3 0.077685f
Cred_1379 VDD.$1017.Metal2 vout.$1044.Metal3 0.234918f
Cred_1380 VDD.$1017.Metal2 vout.P20.nSD 0.000466658f
Cred_1381 VDD.$1017.Metal2 vout.P20.pSD 0.0892071f
Cred_1382 VDD.$1017.Metal2 vout.P22.pSD 0.0890621f
Cred_1383 VDD.$1025.Metal2 vin.$113.GatPoly 0.00176695f
Cred_1384 VDD.$1025.Metal2 vin.$119.GatPoly 0.00239467f
Cred_1385 VDD.$1025.Metal2 vin.$389.Metal1 7.58449e-07f
Cred_1386 VDD.$1025.Metal2 vin.$394.Metal1 5.2025e-06f
Cred_1387 VDD.$1025.Metal2 vin.$395.Metal1 0.00408346f
Cred_1388 VDD.$1025.Metal2 vin.$398.Metal1 2.0173e-06f
Cred_1389 VDD.$1025.Metal2 vin.$399.Metal1 0.000343789f
Cred_1390 VDD.$1025.Metal2 vin.$652.Metal2 0.000803305f
Cred_1391 VDD.$1025.Metal2 vin.$654.Metal2 0.000361624f
Cred_1392 VDD.$1025.Metal2 vin.$655.Metal2 0.00851068f
Cred_1393 VDD.$1025.Metal2 vin.$659.Metal2 0.00115693f
Cred_1394 VDD.$1025.Metal2 vin.$661.Metal2 0.000352847f
Cred_1395 VDD.$1025.Metal2 vin.$662.Metal2 0.00679329f
Cred_1396 VDD.$1025.Metal2 vin.P77.GatPoly 0.00795028f
Cred_1397 VDD.$1025.Metal2 vin.P78.GatPoly 0.00673698f
Cred_1398 VDD.$1025.Metal2 vout.$1044.Metal3 0.220127f
Cred_1399 VDD.$1025.Metal2 vout.$1062.Metal3 0.0714093f
Cred_1400 VDD.$1025.Metal2 vout.P22.pSD 0.0841979f
Cred_1401 VDD.$1025.Metal2 vout.P24.nSD 0.000428959f
Cred_1402 VDD.$1025.Metal2 vout.P24.pSD 0.0823063f
Cred_1403 VDD.$1036.Metal2 vin.$113.GatPoly 0.00064788f
Cred_1404 VDD.$1036.Metal2 vin.$119.GatPoly 0.000878044f
Cred_1405 VDD.$1036.Metal2 vin.$394.Metal1 1.90758e-06f
Cred_1406 VDD.$1036.Metal2 vin.$395.Metal1 0.00149695f
Cred_1407 VDD.$1036.Metal2 vin.$398.Metal1 7.39675e-07f
Cred_1408 VDD.$1036.Metal2 vin.$399.Metal1 0.000126056f
Cred_1409 VDD.$1036.Metal2 vin.$652.Metal2 0.000294545f
Cred_1410 VDD.$1036.Metal2 vin.$654.Metal2 0.000132596f
Cred_1411 VDD.$1036.Metal2 vin.$655.Metal2 0.00312058f
Cred_1412 VDD.$1036.Metal2 vin.$659.Metal2 0.000424209f
Cred_1413 VDD.$1036.Metal2 vin.$661.Metal2 0.000129377f
Cred_1414 VDD.$1036.Metal2 vin.$662.Metal2 0.00249087f
Cred_1415 VDD.$1036.Metal2 vin.P77.GatPoly 0.00291376f
Cred_1416 VDD.$1036.Metal2 vin.P78.GatPoly 0.00248755f
Cred_1417 VDD.$1036.Metal2 vin.P79.GatPoly 4.57398e-06f
Cred_1418 VDD.$1036.Metal2 vout.$1044.Metal3 0.0813516f
Cred_1419 VDD.$1036.Metal2 vout.$1062.Metal3 0.027979f
Cred_1420 VDD.$1036.Metal2 vout.P22.pSD 0.029961f
Cred_1421 VDD.$1036.Metal2 vout.P24.nSD 0.000168072f
Cred_1422 VDD.$1036.Metal2 vout.P24.pSD 0.033085f
Cred_1423 VDD.$1040.Metal2 vin.$122.GatPoly 4.35698e-09f
Cred_1424 VDD.$1040.Metal2 vin.$123.GatPoly 0.000589757f
Cred_1425 VDD.$1040.Metal2 vin.$129.GatPoly 0.000798336f
Cred_1426 VDD.$1040.Metal2 vin.$398.Metal1 3.6516e-07f
Cred_1427 VDD.$1040.Metal2 vin.$399.Metal1 5.79234e-05f
Cred_1428 VDD.$1040.Metal2 vin.$406.Metal1 2.02313e-06f
Cred_1429 VDD.$1040.Metal2 vin.$407.Metal1 0.0014161f
Cred_1430 VDD.$1040.Metal2 vin.$659.Metal2 0.000243679f
Cred_1431 VDD.$1040.Metal2 vin.$661.Metal2 0.000120162f
Cred_1432 VDD.$1040.Metal2 vin.$662.Metal2 0.00242083f
Cred_1433 VDD.$1040.Metal2 vin.$665.Metal2 0.000120159f
Cred_1434 VDD.$1040.Metal2 vin.$666.Metal2 0.00294011f
Cred_1435 VDD.$1040.Metal2 vin.$668.Metal2 0.000307514f
Cred_1436 VDD.$1040.Metal2 vin.P78.GatPoly 5.01276e-06f
Cred_1437 VDD.$1040.Metal2 vin.P79.GatPoly 0.0022395f
Cred_1438 VDD.$1040.Metal2 vin.P80.GatPoly 0.00268928f
Cred_1439 VDD.$1040.Metal2 vout.$1044.Metal3 0.0257972f
Cred_1440 VDD.$1040.Metal2 vout.$1062.Metal3 0.0739318f
Cred_1441 VDD.$1040.Metal2 vout.P24.nSD 0.000154965f
Cred_1442 VDD.$1040.Metal2 vout.P24.pSD 0.0306461f
Cred_1443 VDD.$1040.Metal2 vout.P26.pSD 0.0270507f
Cred_1444 VDD.$1051.Metal2 vin.$122.GatPoly 1.35066e-08f
Cred_1445 VDD.$1051.Metal2 vin.$123.GatPoly 0.00182825f
Cred_1446 VDD.$1051.Metal2 vin.$129.GatPoly 0.00247484f
Cred_1447 VDD.$1051.Metal2 vin.$398.Metal1 1.132e-06f
Cred_1448 VDD.$1051.Metal2 vin.$399.Metal1 0.000179562f
Cred_1449 VDD.$1051.Metal2 vin.$406.Metal1 6.2717e-06f
Cred_1450 VDD.$1051.Metal2 vin.$407.Metal1 0.00439007f
Cred_1451 VDD.$1051.Metal2 vin.$411.Metal1 1.26545e-06f
Cred_1452 VDD.$1051.Metal2 vin.$659.Metal2 0.000755405f
Cred_1453 VDD.$1051.Metal2 vin.$661.Metal2 0.000372503f
Cred_1454 VDD.$1051.Metal2 vin.$662.Metal2 0.00750457f
Cred_1455 VDD.$1051.Metal2 vin.$665.Metal2 0.000372492f
Cred_1456 VDD.$1051.Metal2 vin.$666.Metal2 0.00911433f
Cred_1457 VDD.$1051.Metal2 vin.$668.Metal2 0.000953294f
Cred_1458 VDD.$1051.Metal2 vin.P79.GatPoly 0.00690874f
Cred_1459 VDD.$1051.Metal2 vin.P80.GatPoly 0.00835079f
Cred_1460 VDD.$1051.Metal2 vin.P81.GatPoly 5.09055e-06f
Cred_1461 VDD.$1051.Metal2 vout.$1044.Metal3 0.0741172f
Cred_1462 VDD.$1051.Metal2 vout.$1062.Metal3 0.226686f
Cred_1463 VDD.$1051.Metal2 vout.P24.nSD 0.000445226f
Cred_1464 VDD.$1051.Metal2 vout.P24.pSD 0.0856166f
Cred_1465 VDD.$1051.Metal2 vout.P26.pSD 0.0863577f
Cred_1466 VDD.$1059.Metal2 vin.$133.GatPoly 0.00182611f
Cred_1467 VDD.$1059.Metal2 vin.$139.GatPoly 0.00247484f
Cred_1468 VDD.$1059.Metal2 vin.$411.Metal1 6.24063e-07f
Cred_1469 VDD.$1059.Metal2 vin.$416.Metal1 5.11256e-06f
Cred_1470 VDD.$1059.Metal2 vin.$417.Metal1 0.00421063f
Cred_1471 VDD.$1059.Metal2 vin.$420.Metal1 2.28434e-06f
Cred_1472 VDD.$1059.Metal2 vin.$421.Metal1 0.000364053f
Cred_1473 VDD.$1059.Metal2 vin.$668.Metal2 0.000953294f
Cred_1474 VDD.$1059.Metal2 vin.$670.Metal2 0.000370584f
Cred_1475 VDD.$1059.Metal2 vin.$671.Metal2 0.00908757f
Cred_1476 VDD.$1059.Metal2 vin.$674.Metal2 0.000370584f
Cred_1477 VDD.$1059.Metal2 vin.$676.Metal2 0.000808354f
Cred_1478 VDD.$1059.Metal2 vin.$678.Metal2 0.00747608f
Cred_1479 VDD.$1059.Metal2 vin.P80.GatPoly 5.09055e-06f
Cred_1480 VDD.$1059.Metal2 vin.P81.GatPoly 0.00829598f
Cred_1481 VDD.$1059.Metal2 vin.P82.GatPoly 0.00696355f
Cred_1482 VDD.$1059.Metal2 vout.$1062.Metal3 0.227589f
Cred_1483 VDD.$1059.Metal2 vout.$1080.Metal3 0.0737858f
Cred_1484 VDD.$1059.Metal2 vout.P26.pSD 0.0869503f
Cred_1485 VDD.$1059.Metal2 vout.P28.nSD 0.000443235f
Cred_1486 VDD.$1059.Metal2 vout.P28.pSD 0.0850596f
Cred_1487 VDD.$1070.Metal2 vin.$133.GatPoly 0.000589066f
Cred_1488 VDD.$1070.Metal2 vin.$139.GatPoly 0.000798336f
Cred_1489 VDD.$1070.Metal2 vin.$416.Metal1 1.64921e-06f
Cred_1490 VDD.$1070.Metal2 vin.$417.Metal1 0.00135802f
Cred_1491 VDD.$1070.Metal2 vin.$420.Metal1 7.36883e-07f
Cred_1492 VDD.$1070.Metal2 vin.$421.Metal1 0.000117437f
Cred_1493 VDD.$1070.Metal2 vin.$668.Metal2 0.000307514f
Cred_1494 VDD.$1070.Metal2 vin.$670.Metal2 0.000119543f
Cred_1495 VDD.$1070.Metal2 vin.$671.Metal2 0.00293147f
Cred_1496 VDD.$1070.Metal2 vin.$674.Metal2 0.000119543f
Cred_1497 VDD.$1070.Metal2 vin.$676.Metal2 0.000260759f
Cred_1498 VDD.$1070.Metal2 vin.$678.Metal2 0.00241164f
Cred_1499 VDD.$1070.Metal2 vin.P81.GatPoly 0.0026716f
Cred_1500 VDD.$1070.Metal2 vin.P82.GatPoly 0.00225718f
Cred_1501 VDD.$1070.Metal2 vin.P83.GatPoly 5.01276e-06f
Cred_1502 VDD.$1070.Metal2 vout.$1062.Metal3 0.074223f
Cred_1503 VDD.$1070.Metal2 vout.$1080.Metal3 0.0256903f
Cred_1504 VDD.$1070.Metal2 vout.P26.pSD 0.0272419f
Cred_1505 VDD.$1070.Metal2 vout.P28.nSD 0.000154323f
Cred_1506 VDD.$1070.Metal2 vout.P28.pSD 0.0304664f
Cred_1507 VDD.$1074.Metal2 vin.$143.GatPoly 0.00064788f
Cred_1508 VDD.$1074.Metal2 vin.$149.GatPoly 0.000878044f
Cred_1509 VDD.$1074.Metal2 vin.$425.Metal1 0.00012606f
Cred_1510 VDD.$1074.Metal2 vin.$429.Metal1 0.00149695f
Cred_1511 VDD.$1074.Metal2 vin.$676.Metal2 0.000392031f
Cred_1512 VDD.$1074.Metal2 vin.$678.Metal2 0.0025113f
Cred_1513 VDD.$1074.Metal2 vin.$679.Metal2 0.000267961f
Cred_1514 VDD.$1074.Metal2 vin.$682.Metal2 0.00312122f
Cred_1515 VDD.$1074.Metal2 vin.$684.Metal2 0.000302296f
Cred_1516 VDD.$1074.Metal2 vin.P82.GatPoly 4.57398e-06f
Cred_1517 VDD.$1074.Metal2 vin.P83.GatPoly 0.00246811f
Cred_1518 VDD.$1074.Metal2 vin.P84.GatPoly 0.0029332f
Cred_1519 VDD.$1074.Metal2 vout.$1062.Metal3 0.0280966f
Cred_1520 VDD.$1074.Metal2 vout.$1080.Metal3 0.0810486f
Cred_1521 VDD.$1074.Metal2 vout.P28.nSD 0.000168778f
Cred_1522 VDD.$1074.Metal2 vout.P28.pSD 0.0332826f
Cred_1523 VDD.$1074.Metal2 vout.P30.pSD 0.029752f
Cred_1524 VDD.$1085.Metal2 vin.$143.GatPoly 0.00176695f
Cred_1525 VDD.$1085.Metal2 vin.$149.GatPoly 0.00239467f
Cred_1526 VDD.$1085.Metal2 vin.$425.Metal1 0.000343799f
Cred_1527 VDD.$1085.Metal2 vin.$429.Metal1 0.00408273f
Cred_1528 VDD.$1085.Metal2 vin.$433.Metal1 1.53877e-06f
Cred_1529 VDD.$1085.Metal2 vin.$676.Metal2 0.00106918f
Cred_1530 VDD.$1085.Metal2 vin.$678.Metal2 0.006849f
Cred_1531 VDD.$1085.Metal2 vin.$679.Metal2 0.000730802f
Cred_1532 VDD.$1085.Metal2 vin.$682.Metal2 0.00851242f
Cred_1533 VDD.$1085.Metal2 vin.$684.Metal2 0.000824443f
Cred_1534 VDD.$1085.Metal2 vin.P83.GatPoly 0.00668395f
Cred_1535 VDD.$1085.Metal2 vin.P84.GatPoly 0.00800331f
Cred_1536 VDD.$1085.Metal2 vout.$1062.Metal3 0.0717299f
Cred_1537 VDD.$1085.Metal2 vout.$1080.Metal3 0.2193f
Cred_1538 VDD.$1085.Metal2 vout.P28.nSD 0.000430885f
Cred_1539 VDD.$1085.Metal2 vout.P28.pSD 0.0828453f
Cred_1540 VDD.$1085.Metal2 vout.P30.pSD 0.083628f
Cred_1541 VDD.$1093.Metal2 vin.$153.GatPoly 0.00188531f
Cred_1542 VDD.$1093.Metal2 vin.$159.GatPoly 0.00255508f
Cred_1543 VDD.$1093.Metal2 vin.$433.Metal1 5.21616e-07f
Cred_1544 VDD.$1093.Metal2 vin.$439.Metal1 0.00433257f
Cred_1545 VDD.$1093.Metal2 vin.$443.Metal1 0.000373944f
Cred_1546 VDD.$1093.Metal2 vin.$684.Metal2 0.000947339f
Cred_1547 VDD.$1093.Metal2 vin.$687.Metal2 0.00982135f
Cred_1548 VDD.$1093.Metal2 vin.$688.Metal2 0.000729876f
Cred_1549 VDD.$1093.Metal2 vin.$691.Metal2 0.00112914f
Cred_1550 VDD.$1093.Metal2 vin.$694.Metal2 0.00704128f
Cred_1551 VDD.$1093.Metal2 vin.P85.GatPoly 0.00855291f
Cred_1552 VDD.$1093.Metal2 vin.P86.GatPoly 0.00719829f
Cred_1553 VDD.$1093.Metal2 vout.$1080.Metal3 0.234637f
Cred_1554 VDD.$1093.Metal2 vout.$1098.Metal3 0.07618f
Cred_1555 VDD.$1093.Metal2 vout.P30.pSD 0.0896702f
Cred_1556 VDD.$1093.Metal2 vout.P32.nSD 0.000457617f
Cred_1557 VDD.$1093.Metal2 vout.P32.pSD 0.0878173f
Cred_1558 VDD.$1104.Metal2 vin.$153.GatPoly 0.000530243f
Cred_1559 VDD.$1104.Metal2 vin.$159.GatPoly 0.000718615f
Cred_1560 VDD.$1104.Metal2 vin.$439.Metal1 0.00121834f
Cred_1561 VDD.$1104.Metal2 vin.$443.Metal1 0.000105172f
Cred_1562 VDD.$1104.Metal2 vin.$684.Metal2 0.000266439f
Cred_1563 VDD.$1104.Metal2 vin.$687.Metal2 0.00276225f
Cred_1564 VDD.$1104.Metal2 vin.$688.Metal2 0.000205278f
Cred_1565 VDD.$1104.Metal2 vin.$691.Metal2 0.000317571f
Cred_1566 VDD.$1104.Metal2 vin.$694.Metal2 0.00198036f
Cred_1567 VDD.$1104.Metal2 vin.P85.GatPoly 0.00240311f
Cred_1568 VDD.$1104.Metal2 vin.P86.GatPoly 0.00203538f
Cred_1569 VDD.$1104.Metal2 vin.P87.GatPoly 5.11004e-06f
Cred_1570 VDD.$1104.Metal2 vout.$1080.Metal3 0.0670993f
Cred_1571 VDD.$1104.Metal2 vout.$1098.Metal3 0.0234272f
Cred_1572 VDD.$1104.Metal2 vout.P30.pSD 0.0245205f
Cred_1573 VDD.$1104.Metal2 vout.P32.nSD 0.000140728f
Cred_1574 VDD.$1104.Metal2 vout.P32.pSD 0.0278509f
Cred_1575 VDD.$1108.Metal2 vin.$163.GatPoly 0.000707467f
Cred_1576 VDD.$1108.Metal2 vin.$169.GatPoly 0.000957743f
Cred_1577 VDD.$1108.Metal2 vin.$443.Metal1 6.53416e-05f
Cred_1578 VDD.$1108.Metal2 vin.$446.Metal1 7.22411e-07f
Cred_1579 VDD.$1108.Metal2 vin.$450.Metal1 2.16723e-06f
Cred_1580 VDD.$1108.Metal2 vin.$451.Metal1 0.0017057f
Cred_1581 VDD.$1108.Metal2 vin.$691.Metal2 0.0003551f
Cred_1582 VDD.$1108.Metal2 vin.$693.Metal2 0.000144697f
Cred_1583 VDD.$1108.Metal2 vin.$694.Metal2 0.00278887f
Cred_1584 VDD.$1108.Metal2 vin.$697.Metal2 0.000144697f
Cred_1585 VDD.$1108.Metal2 vin.$698.Metal2 0.00339001f
Cred_1586 VDD.$1108.Metal2 vin.$700.Metal2 0.0003551f
Cred_1587 VDD.$1108.Metal2 vin.P86.GatPoly 4.47994e-06f
Cred_1588 VDD.$1108.Metal2 vin.P87.GatPoly 0.00269047f
Cred_1589 VDD.$1108.Metal2 vin.P88.GatPoly 0.00321409f
Cred_1590 VDD.$1108.Metal2 vout.$1080.Metal3 0.0303664f
Cred_1591 VDD.$1108.Metal2 vout.$1098.Metal3 0.0884042f
Cred_1592 VDD.$1108.Metal2 vout.P32.nSD 0.000182412f
Cred_1593 VDD.$1108.Metal2 vout.P32.pSD 0.0359147f
Cred_1594 VDD.$1108.Metal2 vout.P34.pSD 0.0324729f
Cred_1595 VDD.$1119.Metal2 vin.$163.GatPoly 0.00170971f
Cred_1596 VDD.$1119.Metal2 vin.$169.GatPoly 0.00231455f
Cred_1597 VDD.$1119.Metal2 vin.$443.Metal1 0.000157909f
Cred_1598 VDD.$1119.Metal2 vin.$446.Metal1 1.74583e-06f
Cred_1599 VDD.$1119.Metal2 vin.$450.Metal1 5.23748e-06f
Cred_1600 VDD.$1119.Metal2 vin.$451.Metal1 0.00412219f
Cred_1601 VDD.$1119.Metal2 vin.$455.Metal1 1.72146e-06f
Cred_1602 VDD.$1119.Metal2 vin.$691.Metal2 0.000858158f
Cred_1603 VDD.$1119.Metal2 vin.$693.Metal2 0.000349684f
Cred_1604 VDD.$1119.Metal2 vin.$694.Metal2 0.00673977f
Cred_1605 VDD.$1119.Metal2 vin.$697.Metal2 0.000349684f
Cred_1606 VDD.$1119.Metal2 vin.$698.Metal2 0.00819254f
Cred_1607 VDD.$1119.Metal2 vin.$700.Metal2 0.000858158f
Cred_1608 VDD.$1119.Metal2 vin.P87.GatPoly 0.00646045f
Cred_1609 VDD.$1119.Metal2 vin.P88.GatPoly 0.00777274f
Cred_1610 VDD.$1119.Metal2 vout.$1080.Metal3 0.0693317f
Cred_1611 VDD.$1119.Metal2 vout.$1098.Metal3 0.212748f
Cred_1612 VDD.$1119.Metal2 vout.P32.nSD 0.000416479f
Cred_1613 VDD.$1119.Metal2 vout.P32.pSD 0.0800738f
Cred_1614 VDD.$1119.Metal2 vout.P34.pSD 0.080961f
Cred_1615 VDD.$1127.Metal2 vin.$173.GatPoly 0.00194456f
Cred_1616 VDD.$1127.Metal2 vin.$179.GatPoly 0.00263538f
Cred_1617 VDD.$1127.Metal2 vin.$455.Metal1 4.29472e-07f
Cred_1618 VDD.$1127.Metal2 vin.$461.Metal1 0.00446305f
Cred_1619 VDD.$1127.Metal2 vin.$465.Metal1 0.000378464f
Cred_1620 VDD.$1127.Metal2 vin.$700.Metal2 0.000977111f
Cred_1621 VDD.$1127.Metal2 vin.$703.Metal2 0.0107978f
Cred_1622 VDD.$1127.Metal2 vin.$704.Metal2 0.000720409f
Cred_1623 VDD.$1127.Metal2 vin.$707.Metal2 0.00127187f
Cred_1624 VDD.$1127.Metal2 vin.$710.Metal2 0.00684969f
Cred_1625 VDD.$1127.Metal2 vin.P89.GatPoly 0.00881554f
Cred_1626 VDD.$1127.Metal2 vin.P90.GatPoly 0.0074378f
Cred_1627 VDD.$1127.Metal2 vout.$1098.Metal3 0.24138f
Cred_1628 VDD.$1127.Metal2 vout.$1116.Metal3 0.0785742f
Cred_1629 VDD.$1127.Metal2 vout.P34.pSD 0.0923698f
Cred_1630 VDD.$1127.Metal2 vout.P36.nSD 0.000471999f
Cred_1631 VDD.$1127.Metal2 vout.P36.pSD 0.0905771f
Cred_1632 VDD.$1138.Metal2 vin.$173.GatPoly 0.000471408f
Cred_1633 VDD.$1138.Metal2 vin.$179.GatPoly 0.000638879f
Cred_1634 VDD.$1138.Metal2 vin.$461.Metal1 0.00108181f
Cred_1635 VDD.$1138.Metal2 vin.$465.Metal1 9.17489e-05f
Cred_1636 VDD.$1138.Metal2 vin.$700.Metal2 0.000236875f
Cred_1637 VDD.$1138.Metal2 vin.$703.Metal2 0.00261766f
Cred_1638 VDD.$1138.Metal2 vin.$704.Metal2 0.000174645f
Cred_1639 VDD.$1138.Metal2 vin.$707.Metal2 0.000308333f
Cred_1640 VDD.$1138.Metal2 vin.$710.Metal2 0.00166053f
Cred_1641 VDD.$1138.Metal2 vin.P89.GatPoly 0.00213514f
Cred_1642 VDD.$1138.Metal2 vin.P90.GatPoly 0.00181395f
Cred_1643 VDD.$1138.Metal2 vin.P91.GatPoly 5.20332e-06f
Cred_1644 VDD.$1138.Metal2 vout.$1098.Metal3 0.0598604f
Cred_1645 VDD.$1138.Metal2 vout.$1116.Metal3 0.0211621f
Cred_1646 VDD.$1138.Metal2 vout.P34.pSD 0.0217905f
Cred_1647 VDD.$1138.Metal2 vout.P36.nSD 0.000127122f
Cred_1648 VDD.$1138.Metal2 vout.P36.pSD 0.0252346f
Cred_1649 VDD.$1142.Metal2 vin.$183.GatPoly 0.000766289f
Cred_1650 VDD.$1142.Metal2 vin.$189.GatPoly 0.00103744f
Cred_1651 VDD.$1142.Metal2 vin.$465.Metal1 6.69388e-05f
Cred_1652 VDD.$1142.Metal2 vin.$468.Metal1 6.90671e-07f
Cred_1653 VDD.$1142.Metal2 vin.$472.Metal1 2.44037e-06f
Cred_1654 VDD.$1142.Metal2 vin.$473.Metal1 0.00182099f
Cred_1655 VDD.$1142.Metal2 vin.$707.Metal2 0.000383068f
Cred_1656 VDD.$1142.Metal2 vin.$709.Metal2 0.000156736f
Cred_1657 VDD.$1142.Metal2 vin.$710.Metal2 0.00302225f
Cred_1658 VDD.$1142.Metal2 vin.$713.Metal2 0.000156736f
Cred_1659 VDD.$1142.Metal2 vin.$714.Metal2 0.00365469f
Cred_1660 VDD.$1142.Metal2 vin.$716.Metal2 0.000383473f
Cred_1661 VDD.$1142.Metal2 vin.P90.GatPoly 4.38189e-06f
Cred_1662 VDD.$1142.Metal2 vin.P91.GatPoly 0.00291494f
Cred_1663 VDD.$1142.Metal2 vin.P92.GatPoly 0.00351451f
Cred_1664 VDD.$1142.Metal2 vout.$1098.Metal3 0.0326349f
Cred_1665 VDD.$1142.Metal2 vout.$1116.Metal3 0.095514f
Cred_1666 VDD.$1142.Metal2 vout.P36.nSD 0.000196039f
Cred_1667 VDD.$1142.Metal2 vout.P36.pSD 0.0385465f
Cred_1668 VDD.$1142.Metal2 vout.P38.pSD 0.0351759f
Cred_1669 VDD.$1153.Metal2 vin.$183.GatPoly 0.00165047f
Cred_1670 VDD.$1153.Metal2 vin.$189.GatPoly 0.00223448f
Cred_1671 VDD.$1153.Metal2 vin.$465.Metal1 0.000144176f
Cred_1672 VDD.$1153.Metal2 vin.$468.Metal1 1.4876e-06f
Cred_1673 VDD.$1153.Metal2 vin.$472.Metal1 5.25618e-06f
Cred_1674 VDD.$1153.Metal2 vin.$473.Metal1 0.00392217f
Cred_1675 VDD.$1153.Metal2 vin.$477.Metal1 1.88066e-06f
Cred_1676 VDD.$1153.Metal2 vin.$707.Metal2 0.000825069f
Cred_1677 VDD.$1153.Metal2 vin.$709.Metal2 0.000337586f
Cred_1678 VDD.$1153.Metal2 vin.$710.Metal2 0.00650945f
Cred_1679 VDD.$1153.Metal2 vin.$713.Metal2 0.000337586f
Cred_1680 VDD.$1153.Metal2 vin.$714.Metal2 0.00787165f
Cred_1681 VDD.$1153.Metal2 vin.$716.Metal2 0.000825942f
Cred_1682 VDD.$1153.Metal2 vin.P91.GatPoly 0.00624168f
Cred_1683 VDD.$1153.Metal2 vin.P92.GatPoly 0.00757655f
Cred_1684 VDD.$1153.Metal2 vout.$1098.Metal3 0.0669366f
Cred_1685 VDD.$1153.Metal2 vout.$1116.Metal3 0.205528f
Cred_1686 VDD.$1153.Metal2 vout.P36.nSD 0.000402091f
Cred_1687 VDD.$1153.Metal2 vout.P36.pSD 0.0773043f
Cred_1688 VDD.$1153.Metal2 vout.P38.pSD 0.0782458f
Cred_1689 VDD.$1161.Metal2 vin.$193.GatPoly 0.00200386f
Cred_1690 VDD.$1161.Metal2 vin.$199.GatPoly 0.00271574f
Cred_1691 VDD.$1161.Metal2 vin.$477.Metal1 3.47107e-07f
Cred_1692 VDD.$1161.Metal2 vin.$483.Metal1 0.00459975f
Cred_1693 VDD.$1161.Metal2 vin.$487.Metal1 0.000375658f
Cred_1694 VDD.$1161.Metal2 vin.$716.Metal2 0.000911011f
Cred_1695 VDD.$1161.Metal2 vin.$719.Metal2 0.0114507f
Cred_1696 VDD.$1161.Metal2 vin.$720.Metal2 0.000691352f
Cred_1697 VDD.$1161.Metal2 vin.$723.Metal2 0.00171459f
Cred_1698 VDD.$1161.Metal2 vin.$726.Metal2 0.00646218f
Cred_1699 VDD.$1161.Metal2 vin.P93.GatPoly 0.00907884f
Cred_1700 VDD.$1161.Metal2 vin.P94.GatPoly 0.00768208f
Cred_1701 VDD.$1161.Metal2 vout.$1116.Metal3 0.248619f
Cred_1702 VDD.$1161.Metal2 vout.$1134.Metal3 0.0809704f
Cred_1703 VDD.$1161.Metal2 vout.P38.pSD 0.095106f
Cred_1704 VDD.$1161.Metal2 vout.P40.nSD 0.000486393f
Cred_1705 VDD.$1161.Metal2 vout.P40.pSD 0.0933392f
Cred_1706 VDD.$1172.Metal2 vin.$193.GatPoly 0.000412558f
Cred_1707 VDD.$1172.Metal2 vin.$199.GatPoly 0.000559123f
Cred_1708 VDD.$1172.Metal2 vin.$203.GatPoly 6.62976e-09f
Cred_1709 VDD.$1172.Metal2 vin.$483.Metal1 0.000946903f
Cred_1710 VDD.$1172.Metal2 vin.$487.Metal1 7.78971e-05f
Cred_1711 VDD.$1172.Metal2 vin.$495.Metal1 5.56685e-07f
Cred_1712 VDD.$1172.Metal2 vin.$716.Metal2 0.000187561f
Cred_1713 VDD.$1172.Metal2 vin.$719.Metal2 0.00235749f
Cred_1714 VDD.$1172.Metal2 vin.$720.Metal2 0.000142337f
Cred_1715 VDD.$1172.Metal2 vin.$723.Metal2 0.000353004f
Cred_1716 VDD.$1172.Metal2 vin.$726.Metal2 0.00133046f
Cred_1717 VDD.$1172.Metal2 vin.$728.Metal2 2.10598e-09f
Cred_1718 VDD.$1172.Metal2 vin.P93.GatPoly 0.00186758f
Cred_1719 VDD.$1172.Metal2 vin.P94.GatPoly 0.00159243f
Cred_1720 VDD.$1172.Metal2 vin.P95.GatPoly 5.29261e-06f
Cred_1721 VDD.$1172.Metal2 vout.$1116.Metal3 0.0527584f
Cred_1722 VDD.$1172.Metal2 vout.$1134.Metal3 0.0188952f
Cred_1723 VDD.$1172.Metal2 vout.P38.pSD 0.0190699f
Cred_1724 VDD.$1172.Metal2 vout.P40.nSD 0.000113504f
Cred_1725 VDD.$1172.Metal2 vout.P40.pSD 0.0226174f
Cred_1726 VDD.$1176.Metal2 vin.$202.GatPoly 3.79032e-09f
Cred_1727 VDD.$1176.Metal2 vin.$203.GatPoly 0.000931467f
Cred_1728 VDD.$1176.Metal2 vin.$211.GatPoly 0.000930757f
Cred_1729 VDD.$1176.Metal2 vin.$486.Metal1 3.17733e-07f
Cred_1730 VDD.$1176.Metal2 vin.$487.Metal1 6.1765e-05f
Cred_1731 VDD.$1176.Metal2 vin.$494.Metal1 3.04619e-06f
Cred_1732 VDD.$1176.Metal2 vin.$495.Metal1 0.00196854f
Cred_1733 VDD.$1176.Metal2 vin.$501.Metal1 2.34032e-06f
Cred_1734 VDD.$1176.Metal2 vin.$723.Metal2 0.000318439f
Cred_1735 VDD.$1176.Metal2 vin.$725.Metal2 0.00016878f
Cred_1736 VDD.$1176.Metal2 vin.$726.Metal2 7.36932e-07f
Cred_1737 VDD.$1176.Metal2 vin.$728.Metal2 0.00690463f
Cred_1738 VDD.$1176.Metal2 vin.$729.Metal2 0.000168776f
Cred_1739 VDD.$1176.Metal2 vin.$732.Metal2 0.000408107f
Cred_1740 VDD.$1176.Metal2 vin.$733.Metal2 0.000580789f
Cred_1741 VDD.$1176.Metal2 vin.P94.GatPoly 4.27984e-06f
Cred_1742 VDD.$1176.Metal2 vin.P95.GatPoly 0.0031446f
Cred_1743 VDD.$1176.Metal2 vin.P96.GatPoly 0.00384212f
Cred_1744 VDD.$1176.Metal2 vout.$1116.Metal3 0.0349022f
Cred_1745 VDD.$1176.Metal2 vout.$1134.Metal3 0.102625f
Cred_1746 VDD.$1176.Metal2 vout.P40.nSD 0.000209659f
Cred_1747 VDD.$1176.Metal2 vout.P40.pSD 0.041178f
Cred_1748 VDD.$1176.Metal2 vout.P42.pSD 0.0378789f
Cred_1749 VDD.$1187.Metal2 vin.$202.GatPoly 7.3099e-09f
Cred_1750 VDD.$1187.Metal2 vin.$203.GatPoly 0.00179637f
Cred_1751 VDD.$1187.Metal2 vin.$211.GatPoly 0.00179504f
Cred_1752 VDD.$1187.Metal2 vin.$486.Metal1 6.1277e-07f
Cred_1753 VDD.$1187.Metal2 vin.$487.Metal1 0.000116743f
Cred_1754 VDD.$1187.Metal2 vin.$494.Metal1 5.87479e-06f
Cred_1755 VDD.$1187.Metal2 vin.$495.Metal1 0.00379509f
Cred_1756 VDD.$1187.Metal2 vin.$501.Metal1 5.51753e-06f
Cred_1757 VDD.$1187.Metal2 vin.$723.Metal2 0.000614133f
Cred_1758 VDD.$1187.Metal2 vin.$725.Metal2 0.000325504f
Cred_1759 VDD.$1187.Metal2 vin.$726.Metal2 1.39289e-06f
Cred_1760 VDD.$1187.Metal2 vin.$728.Metal2 0.0133161f
Cred_1761 VDD.$1187.Metal2 vin.$729.Metal2 0.000325497f
Cred_1762 VDD.$1187.Metal2 vin.$732.Metal2 0.000787063f
Cred_1763 VDD.$1187.Metal2 vin.$733.Metal2 0.00112011f
Cred_1764 VDD.$1187.Metal2 vin.P95.GatPoly 0.00603211f
Cred_1765 VDD.$1187.Metal2 vin.P96.GatPoly 0.00741799f
Cred_1766 VDD.$1187.Metal2 vout.$1116.Metal3 0.0645442f
Cred_1767 VDD.$1187.Metal2 vout.$1134.Metal3 0.198312f
Cred_1768 VDD.$1187.Metal2 vout.P40.nSD 0.000387721f
Cred_1769 VDD.$1187.Metal2 vout.P40.pSD 0.0745367f
Cred_1770 VDD.$1187.Metal2 vout.P42.pSD 0.075531f
Cred_1771 VDD.$1195.Metal2 vin.$215.GatPoly 0.00321753f
Cred_1772 VDD.$1195.Metal2 vin.$223.GatPoly 0.000921118f
Cred_1773 VDD.$1195.Metal2 vin.$501.Metal1 3.1114e-05f
Cred_1774 VDD.$1195.Metal2 vin.$505.Metal1 0.00502968f
Cred_1775 VDD.$1195.Metal2 vin.$509.Metal1 0.000794098f
Cred_1776 VDD.$1195.Metal2 vin.$732.Metal2 0.00111078f
Cred_1777 VDD.$1195.Metal2 vin.$733.Metal2 0.00328457f
Cred_1778 VDD.$1195.Metal2 vin.$736.Metal2 0.000707587f
Cred_1779 VDD.$1195.Metal2 vin.$737.Metal2 0.0159229f
Cred_1780 VDD.$1195.Metal2 vin.$739.Metal2 0.000962676f
Cred_1781 VDD.$1195.Metal2 vin.P97.GatPoly 0.0092976f
Cred_1782 VDD.$1195.Metal2 vin.P98.GatPoly 0.00804279f
Cred_1783 VDD.$1195.Metal2 vout.$1134.Metal3 0.255866f
Cred_1784 VDD.$1195.Metal2 vout.$1152.Metal3 0.0833686f
Cred_1785 VDD.$1195.Metal2 vout.P42.pSD 0.0978435f
Cred_1786 VDD.$1195.Metal2 vout.P44.nSD 0.0005008f
Cred_1787 VDD.$1195.Metal2 vout.P44.pSD 0.0961037f
Cred_1788 VDD.$1206.Metal2 vin.$215.GatPoly 0.000551577f
Cred_1789 VDD.$1206.Metal2 vin.$223.GatPoly 0.000157913f
Cred_1790 VDD.$1206.Metal2 vin.$501.Metal1 5.23877e-06f
Cred_1791 VDD.$1206.Metal2 vin.$505.Metal1 0.000862204f
Cred_1792 VDD.$1206.Metal2 vin.$509.Metal1 0.000136723f
Cred_1793 VDD.$1206.Metal2 vin.$517.Metal1 5.92583e-07f
Cred_1794 VDD.$1206.Metal2 vin.$732.Metal2 0.00019042f
Cred_1795 VDD.$1206.Metal2 vin.$733.Metal2 0.000563069f
Cred_1796 VDD.$1206.Metal2 vin.$736.Metal2 0.000121301f
Cred_1797 VDD.$1206.Metal2 vin.$737.Metal2 0.00272964f
Cred_1798 VDD.$1206.Metal2 vin.$739.Metal2 0.00016503f
Cred_1799 VDD.$1206.Metal2 vin.$742.Metal2 7.40098e-09f
Cred_1800 VDD.$1206.Metal2 vin.$744.Metal2 1.89689e-09f
Cred_1801 VDD.$1206.Metal2 vin.P97.GatPoly 0.00159262f
Cred_1802 VDD.$1206.Metal2 vin.P98.GatPoly 0.00138956f
Cred_1803 VDD.$1206.Metal2 vin.P99.GatPoly 5.3779e-06f
Cred_1804 VDD.$1206.Metal2 vout.$1134.Metal3 0.0456544f
Cred_1805 VDD.$1206.Metal2 vout.$1152.Metal3 0.0166263f
Cred_1806 VDD.$1206.Metal2 vout.P42.pSD 0.0163487f
Cred_1807 VDD.$1206.Metal2 vout.P44.nSD 9.98751e-05f
Cred_1808 VDD.$1206.Metal2 vout.P44.pSD 0.0199992f
Cred_1809 VDD.$1210.Metal2 vin.$222.GatPoly 3.43639e-09f
Cred_1810 VDD.$1210.Metal2 vin.$223.GatPoly 0.000997841f
Cred_1811 VDD.$1210.Metal2 vin.$231.GatPoly 0.000997151f
Cred_1812 VDD.$1210.Metal2 vin.$508.Metal1 2.88103e-07f
Cred_1813 VDD.$1210.Metal2 vin.$509.Metal1 5.99644e-05f
Cred_1814 VDD.$1210.Metal2 vin.$516.Metal1 3.31858e-06f
Cred_1815 VDD.$1210.Metal2 vin.$517.Metal1 0.00211515f
Cred_1816 VDD.$1210.Metal2 vin.$523.Metal1 2.37482e-06f
Cred_1817 VDD.$1210.Metal2 vin.$739.Metal2 0.000475438f
Cred_1818 VDD.$1210.Metal2 vin.$741.Metal2 0.000180819f
Cred_1819 VDD.$1210.Metal2 vin.$742.Metal2 7.50349e-07f
Cred_1820 VDD.$1210.Metal2 vin.$744.Metal2 0.00726789f
Cred_1821 VDD.$1210.Metal2 vin.$745.Metal2 0.000180815f
Cred_1822 VDD.$1210.Metal2 vin.$748.Metal2 0.000412045f
Cred_1823 VDD.$1210.Metal2 vin.$749.Metal2 0.00060949f
Cred_1824 VDD.$1210.Metal2 vin.P100.GatPoly 0.00415813f
Cred_1825 VDD.$1210.Metal2 vin.P98.GatPoly 4.17377e-06f
Cred_1826 VDD.$1210.Metal2 vin.P99.GatPoly 0.00337582f
Cred_1827 VDD.$1210.Metal2 vout.$1134.Metal3 0.0371684f
Cred_1828 VDD.$1210.Metal2 vout.$1152.Metal3 0.109737f
Cred_1829 VDD.$1210.Metal2 vout.P44.nSD 0.000223273f
Cred_1830 VDD.$1210.Metal2 vout.P44.pSD 0.0438094f
Cred_1831 VDD.$1210.Metal2 vout.P46.pSD 0.0405823f
Cred_1832 VDD.$1221.Metal2 vin.$222.GatPoly 5.9564e-09f
Cred_1833 VDD.$1221.Metal2 vin.$223.GatPoly 0.00172956f
Cred_1834 VDD.$1221.Metal2 vin.$231.GatPoly 0.00172841f
Cred_1835 VDD.$1221.Metal2 vin.$508.Metal1 4.99378e-07f
Cred_1836 VDD.$1221.Metal2 vin.$509.Metal1 0.000101702f
Cred_1837 VDD.$1221.Metal2 vin.$516.Metal1 5.7522e-06f
Cred_1838 VDD.$1221.Metal2 vin.$517.Metal1 0.00366511f
Cred_1839 VDD.$1221.Metal2 vin.$523.Metal1 5.19989e-06f
Cred_1840 VDD.$1221.Metal2 vin.$739.Metal2 0.000824093f
Cred_1841 VDD.$1221.Metal2 vin.$741.Metal2 0.00031342f
Cred_1842 VDD.$1221.Metal2 vin.$742.Metal2 1.27262e-06f
Cred_1843 VDD.$1221.Metal2 vin.$744.Metal2 0.0125977f
Cred_1844 VDD.$1221.Metal2 vin.$745.Metal2 0.000313413f
Cred_1845 VDD.$1221.Metal2 vin.$748.Metal2 0.000714212f
Cred_1846 VDD.$1221.Metal2 vin.$749.Metal2 0.00105646f
Cred_1847 VDD.$1221.Metal2 vin.P100.GatPoly 0.00721683f
Cred_1848 VDD.$1221.Metal2 vin.P99.GatPoly 0.00582258f
Cred_1849 VDD.$1221.Metal2 vout.$1134.Metal3 0.0621545f
Cred_1850 VDD.$1221.Metal2 vout.$1152.Metal3 0.191102f
Cred_1851 VDD.$1221.Metal2 vout.P44.nSD 0.000373365f
Cred_1852 VDD.$1221.Metal2 vout.P44.pSD 0.0717709f
Cred_1853 VDD.$1221.Metal2 vout.P46.pSD 0.0728165f
Cred_1854 VDD.$1229.Metal2 vin.$235.GatPoly 0.00340352f
Cred_1855 VDD.$1229.Metal2 vin.$243.GatPoly 0.000947639f
Cred_1856 VDD.$1229.Metal2 vin.$523.Metal1 3.50797e-05f
Cred_1857 VDD.$1229.Metal2 vin.$527.Metal1 0.0051651f
Cred_1858 VDD.$1229.Metal2 vin.$531.Metal1 0.00078679f
Cred_1859 VDD.$1229.Metal2 vin.$748.Metal2 0.00106658f
Cred_1860 VDD.$1229.Metal2 vin.$749.Metal2 0.00376576f
Cred_1861 VDD.$1229.Metal2 vin.$752.Metal2 0.000677727f
Cred_1862 VDD.$1229.Metal2 vin.$753.Metal2 0.0160196f
Cred_1863 VDD.$1229.Metal2 vin.$755.Metal2 0.00106658f
Cred_1864 VDD.$1229.Metal2 vin.P101.GatPoly 0.00956935f
Cred_1865 VDD.$1229.Metal2 vin.P102.GatPoly 0.00829986f
Cred_1866 VDD.$1229.Metal2 vout.$1152.Metal3 0.263155f
Cred_1867 VDD.$1229.Metal2 vout.$1170.Metal3 0.0858051f
Cred_1868 VDD.$1229.Metal2 vout.P46.pSD 0.100582f
Cred_1869 VDD.$1229.Metal2 vout.P48.nSD 0.000515436f
Cred_1870 VDD.$1229.Metal2 vout.P48.pSD 0.098875f
Cred_1871 VDD.$124.Metal1 vin.$23.GatPoly 0.00394869f
Cred_1872 VDD.$124.Metal1 vin.$289.Metal1 0.000490354f
Cred_1873 VDD.$124.Metal1 vin.$29.GatPoly 0.00554674f
Cred_1874 VDD.$124.Metal1 vin.$297.Metal1 0.0111628f
Cred_1875 VDD.$124.Metal1 vin.$301.Metal1 9.42713e-06f
Cred_1876 VDD.$124.Metal1 vin.$579.Metal2 2.02167e-06f
Cred_1877 VDD.$124.Metal1 vin.$581.Metal2 0.000380655f
Cred_1878 VDD.$124.Metal1 vin.$583.Metal2 0.000267337f
Cred_1879 VDD.$124.Metal1 vin.$584.Metal2 0.00541936f
Cred_1880 VDD.$124.Metal1 vin.$588.Metal2 0.000460793f
Cred_1881 VDD.$124.Metal1 vin.$589.Metal2 0.00109812f
Cred_1882 VDD.$124.Metal1 vin.P58.GatPoly 0.000806118f
Cred_1883 VDD.$124.Metal1 vin.P59.GatPoly 0.0238114f
Cred_1884 VDD.$124.Metal1 vin.P60.GatPoly 0.0238204f
Cred_1885 VDD.$124.Metal1 vout.$954.Metal3 0.054818f
Cred_1886 VDD.$124.Metal1 vout.$972.Metal3 0.161409f
Cred_1887 VDD.$124.Metal1 vout.P4.nSD 0.000329295f
Cred_1888 VDD.$124.Metal1 vout.P4.pSD 0.120316f
Cred_1889 VDD.$124.Metal1 vout.P6.pSD 0.113154f
Cred_1890 VDD.$1240.Metal2 vin.$235.GatPoly 0.000472711f
Cred_1891 VDD.$1240.Metal2 vin.$243.GatPoly 0.000131624f
Cred_1892 VDD.$1240.Metal2 vin.$523.Metal1 4.87218e-06f
Cred_1893 VDD.$1240.Metal2 vin.$527.Metal1 0.000717376f
Cred_1894 VDD.$1240.Metal2 vin.$531.Metal1 0.000109905f
Cred_1895 VDD.$1240.Metal2 vin.$539.Metal1 6.29602e-07f
Cred_1896 VDD.$1240.Metal2 vin.$748.Metal2 0.000148136f
Cred_1897 VDD.$1240.Metal2 vin.$749.Metal2 0.000523022f
Cred_1898 VDD.$1240.Metal2 vin.$752.Metal2 9.41287e-05f
Cred_1899 VDD.$1240.Metal2 vin.$753.Metal2 0.00222494f
Cred_1900 VDD.$1240.Metal2 vin.$755.Metal2 0.000148136f
Cred_1901 VDD.$1240.Metal2 vin.$758.Metal2 8.22709e-09f
Cred_1902 VDD.$1240.Metal2 vin.$760.Metal2 1.64896e-09f
Cred_1903 VDD.$1240.Metal2 vin.P101.GatPoly 0.00132816f
Cred_1904 VDD.$1240.Metal2 vin.P102.GatPoly 0.00116353f
Cred_1905 VDD.$1240.Metal2 vin.P103.GatPoly 5.45921e-06f
Cred_1906 VDD.$1240.Metal2 vout.$1152.Metal3 0.0385531f
Cred_1907 VDD.$1240.Metal2 vout.$1170.Metal3 0.0143606f
Cred_1908 VDD.$1240.Metal2 vout.P46.pSD 0.0136266f
Cred_1909 VDD.$1240.Metal2 vout.P48.nSD 8.62647e-05f
Cred_1910 VDD.$1240.Metal2 vout.P48.pSD 0.0173805f
Cred_1911 VDD.$1244.Metal2 vin.$243.GatPoly 0.00106419f
Cred_1912 VDD.$1244.Metal2 vin.$251.GatPoly 0.00106355f
Cred_1913 VDD.$1244.Metal2 vin.$531.Metal1 5.58723e-05f
Cred_1914 VDD.$1244.Metal2 vin.$534.Metal1 5.10472e-07f
Cred_1915 VDD.$1244.Metal2 vin.$538.Metal1 3.34643e-06f
Cred_1916 VDD.$1244.Metal2 vin.$539.Metal1 0.00226421f
Cred_1917 VDD.$1244.Metal2 vin.$545.Metal1 2.38436e-06f
Cred_1918 VDD.$1244.Metal2 vin.$755.Metal2 0.000454024f
Cred_1919 VDD.$1244.Metal2 vin.$757.Metal2 0.000192855f
Cred_1920 VDD.$1244.Metal2 vin.$758.Metal2 7.31662e-07f
Cred_1921 VDD.$1244.Metal2 vin.$760.Metal2 0.00776618f
Cred_1922 VDD.$1244.Metal2 vin.$761.Metal2 0.000192855f
Cred_1923 VDD.$1244.Metal2 vin.$764.Metal2 0.00045715f
Cred_1924 VDD.$1244.Metal2 vin.$765.Metal2 0.000636001f
Cred_1925 VDD.$1244.Metal2 vin.P102.GatPoly 4.0637e-06f
Cred_1926 VDD.$1244.Metal2 vin.P103.GatPoly 0.00361178f
Cred_1927 VDD.$1244.Metal2 vin.P104.GatPoly 0.00444705f
Cred_1928 VDD.$1244.Metal2 vout.$1152.Metal3 0.0394355f
Cred_1929 VDD.$1244.Metal2 vout.$1170.Metal3 0.116862f
Cred_1930 VDD.$1244.Metal2 vout.P48.nSD 0.000236891f
Cred_1931 VDD.$1244.Metal2 vout.P48.pSD 0.0464469f
Cred_1932 VDD.$1244.Metal2 vout.P50.pSD 0.0432854f
Cred_1933 VDD.$1255.Metal2 vin.$243.GatPoly 0.00166277f
Cred_1934 VDD.$1255.Metal2 vin.$251.GatPoly 0.00166181f
Cred_1935 VDD.$1255.Metal2 vin.$531.Metal1 8.51911e-05f
Cred_1936 VDD.$1255.Metal2 vin.$534.Metal1 7.97613e-07f
Cred_1937 VDD.$1255.Metal2 vin.$538.Metal1 5.22879e-06f
Cred_1938 VDD.$1255.Metal2 vin.$539.Metal1 0.00353688f
Cred_1939 VDD.$1255.Metal2 vin.$545.Metal1 4.88936e-06f
Cred_1940 VDD.$1255.Metal2 vin.$755.Metal2 0.000709413f
Cred_1941 VDD.$1255.Metal2 vin.$757.Metal2 0.000301335f
Cred_1942 VDD.$1255.Metal2 vin.$758.Metal2 1.1156e-06f
Cred_1943 VDD.$1255.Metal2 vin.$760.Metal2 0.0121347f
Cred_1944 VDD.$1255.Metal2 vin.$761.Metal2 0.000301335f
Cred_1945 VDD.$1255.Metal2 vin.$764.Metal2 0.000714296f
Cred_1946 VDD.$1255.Metal2 vin.$765.Metal2 0.000993768f
Cred_1947 VDD.$1255.Metal2 vin.P103.GatPoly 0.00561774f
Cred_1948 VDD.$1255.Metal2 vin.P104.GatPoly 0.00695908f
Cred_1949 VDD.$1255.Metal2 vout.$1152.Metal3 0.0597701f
Cred_1950 VDD.$1255.Metal2 vout.$1170.Metal3 0.183889f
Cred_1951 VDD.$1255.Metal2 vout.P48.nSD 0.000359042f
Cred_1952 VDD.$1255.Metal2 vout.P48.pSD 0.0690164f
Cred_1953 VDD.$1255.Metal2 vout.P50.pSD 0.070067f
Cred_1954 VDD.$1263.Metal2 vin.$251.GatPoly 0.000729618f
Cred_1955 VDD.$1263.Metal2 vin.$259.GatPoly 0.00255138f
Cred_1956 VDD.$1263.Metal2 vin.$545.Metal1 0.000424051f
Cred_1957 VDD.$1263.Metal2 vin.$549.Metal1 0.00408501f
Cred_1958 VDD.$1263.Metal2 vin.$764.Metal2 0.00104401f
Cred_1959 VDD.$1263.Metal2 vin.$765.Metal2 0.0041043f
Cred_1960 VDD.$1263.Metal2 vin.$768.Metal2 0.000627209f
Cred_1961 VDD.$1263.Metal2 vin.$769.Metal2 0.0154542f
Cred_1962 VDD.$1263.Metal2 vin.$771.Metal2 0.00104577f
Cred_1963 VDD.$1263.Metal2 vin.P105.GatPoly 0.00729769f
Cred_1964 VDD.$1263.Metal2 vin.P106.GatPoly 0.00579019f
Cred_1965 VDD.$1263.Metal2 vin.P107.GatPoly 1.29877e-07f
Cred_1966 VDD.$1263.Metal2 vout 0.159216f
Cred_1967 VDD.$1263.Metal2 vout.$1170.Metal3 0.169736f
Cred_1968 VDD.$1263.Metal2 vout.P50.pSD 0.0890404f
Cred_1969 VDD.$1263.Metal2 vout.P52.pSD 0.0885019f
Cred_1970 VDD.$1274.Metal2 vin.$251.GatPoly 7.88776e-05f
Cred_1971 VDD.$1274.Metal2 vin.$259.GatPoly 0.00027693f
Cred_1972 VDD.$1274.Metal2 vin.$545.Metal1 4.58433e-05f
Cred_1973 VDD.$1274.Metal2 vin.$549.Metal1 0.000493846f
Cred_1974 VDD.$1274.Metal2 vin.$764.Metal2 0.000112866f
Cred_1975 VDD.$1274.Metal2 vin.$765.Metal2 0.000443708f
Cred_1976 VDD.$1274.Metal2 vin.$768.Metal2 6.78064e-05f
Cred_1977 VDD.$1274.Metal2 vin.$769.Metal2 0.00276269f
Cred_1978 VDD.$1274.Metal2 vin.$771.Metal2 0.00051822f
Cred_1979 VDD.$1274.Metal2 vin.P105.GatPoly 0.00079105f
Cred_1980 VDD.$1274.Metal2 vin.P106.GatPoly 0.000642483f
Cred_1981 VDD.$1274.Metal2 vin.P107.GatPoly 0.00184089f
Cred_1982 VDD.$1274.Metal2 vout 0.0236207f
Cred_1983 VDD.$1274.Metal2 vout.$1170.Metal3 0.018017f
Cred_1984 VDD.$1274.Metal2 vout.P50.pSD 0.00936334f
Cred_1985 VDD.$1274.Metal2 vout.P52.pSD 0.0144905f
Cred_1986 VDD.$1287.Metal2 vin.$258.GatPoly 1.3032e-06f
Cred_1987 VDD.$1287.Metal2 vin.$259.GatPoly 0.00085965f
Cred_1988 VDD.$1287.Metal2 vin.$548.Metal1 6.30074e-05f
Cred_1989 VDD.$1287.Metal2 vin.$549.Metal1 0.00330898f
Cred_1990 VDD.$1287.Metal2 vin.$768.Metal2 0.00099659f
Cred_1991 VDD.$1287.Metal2 vin.$769.Metal2 0.0179933f
Cred_1992 VDD.$1287.Metal2 vin.$771.Metal2 0.00705245f
Cred_1993 VDD.$1287.Metal2 vin.P107.GatPoly 0.00227178f
Cred_1994 VDD.$1287.Metal2 vin.P53.GatPoly 1.65263e-07f
Cred_1995 VDD.$1287.Metal2 vout 0.300313f
Cred_1996 VDD.$1287.Metal2 vout.P52.pSD 0.118084f
Cred_1997 VDD.$1287.Metal2 VSS.$1048.Metal3 0.00325145f
Cred_1998 VDD.$1287.Metal2 VSS.$14.Metal1 1.31201e-07f
Cred_1999 VDD.$1287.Metal2 VSS.$29.Metal1 2.20767e-07f
Cred_2000 VDD.$1287.Metal2 VSS.$490.Metal1 3.32836e-07f
Cred_2001 VDD.$1287.Metal2 VSS.$496.Metal1 4.19217e-08f
Cred_2002 VDD.$1287.Metal2 VSS.$500.Metal1 0.00121137f
Cred_2003 VDD.$1287.Metal2 VSS.$520.Metal1 0.00116735f
Cred_2004 VDD.$1287.Metal2 VSS.$895.Metal2 4.5631e-05f
Cred_2005 VDD.$1287.Metal2 VSS.$904.Metal2 0.0243046f
Cred_2006 VDD.$1287.Metal2 VSS.P0.pSD 0.00110418f
Cred_2007 VDD.$1287.Metal2 VSS.P55.nSD 8.98098e-06f
Cred_2008 VDD.$1287.Metal2 VSS.P57.nSD 8.98098e-06f
Cred_2009 VDD.$1289.Metal2 vin.$259.GatPoly 1.045e-06f
Cred_2010 VDD.$1289.Metal2 vin.$549.Metal1 4.93592e-05f
Cred_2011 VDD.$1289.Metal2 vin.$769.Metal2 0.00103206f
Cred_2012 VDD.$1289.Metal2 vin.$771.Metal2 0.000382939f
Cred_2013 VDD.$1289.Metal2 vin.P107.GatPoly 0.00173989f
Cred_2014 VDD.$1289.Metal2 vout 0.00120371f
Cred_2015 VDD.$1289.Metal2 vout.P52.pSD 0.00105229f
Cred_2016 VDD.$1300.Metal2 vin.P107.GatPoly 0.000233023f
Cred_2017 VDD.$1300.Metal2 vout 0.0129806f
Cred_2018 VDD.$1300.Metal2 vout.P52.pSD 0.00495739f
Cred_2019 VDD.$1314.Metal3 vin.$271.Metal1 1.67e-07f
Cred_2020 VDD.$1314.Metal3 vin.$5.GatPoly 9.38186e-10f
Cred_2021 VDD.$1314.Metal3 vin.$566.Metal2 1.22637e-05f
Cred_2022 VDD.$1314.Metal3 vin.P54.GatPoly 0.00142766f
Cred_2023 VDD.$1314.Metal3 vin.P55.GatPoly 0.000859548f
Cred_2024 VDD.$1314.Metal3 vin.P56.GatPoly 0.000336331f
Cred_2025 VDD.$1314.Metal3 vout.$954.Metal3 0.0158936f
Cred_2026 VDD.$1314.Metal3 vout.P0.nSD 7.00546e-05f
Cred_2027 VDD.$1314.Metal3 vout.P0.pSD 0.00176043f
Cred_2028 VDD.$1320.Metal3 vin.P55.GatPoly 0.000428058f
Cred_2029 VDD.$1320.Metal3 vin.P56.GatPoly 0.000675358f
Cred_2030 VDD.$1320.Metal3 vin.P57.GatPoly 0.000859548f
Cred_2031 VDD.$1320.Metal3 vin.P58.GatPoly 0.000428058f
Cred_2032 VDD.$1320.Metal3 vout.$954.Metal3 0.0292839f
Cred_2033 VDD.$1320.Metal3 vout.$972.Metal3 0.00149762f
Cred_2034 VDD.$1320.Metal3 vout.P0.nSD 2.56278e-05f
Cred_2035 VDD.$1320.Metal3 vout.P0.pSD 0.000493946f
Cred_2036 VDD.$1320.Metal3 vout.P2.pSD 0.00175074f
Cred_2037 VDD.$1320.Metal3 vout.P4.nSD 8.99627e-06f
Cred_2038 VDD.$1320.Metal3 vout.P4.pSD 0.000233475f
Cred_2039 VDD.$1326.Metal3 vin.P57.GatPoly 0.000428058f
Cred_2040 VDD.$1326.Metal3 vin.P58.GatPoly 0.000859548f
Cred_2041 VDD.$1326.Metal3 vin.P59.GatPoly 0.00129793f
Cred_2042 VDD.$1326.Metal3 vin.P60.GatPoly 0.000600204f
Cred_2043 VDD.$1326.Metal3 vout.$954.Metal3 0.0126387f
Cred_2044 VDD.$1326.Metal3 vout.$972.Metal3 0.0115966f
Cred_2045 VDD.$1326.Metal3 vout.P2.pSD 0.000123245f
Cred_2046 VDD.$1326.Metal3 vout.P4.nSD 6.28337e-05f
Cred_2047 VDD.$1326.Metal3 vout.P4.pSD 0.00184616f
Cred_2048 VDD.$1330.Metal3 vin.P60.GatPoly 0.000600204f
Cred_2049 VDD.$1330.Metal3 vin.P61.GatPoly 0.000859548f
Cred_2050 VDD.$1330.Metal3 vin.P62.GatPoly 0.000428058f
Cred_2051 VDD.$1330.Metal3 vout.$954.Metal3 0.000341636f
Cred_2052 VDD.$1330.Metal3 vout.$972.Metal3 0.0248314f
Cred_2053 VDD.$1330.Metal3 vout.$990.Metal3 0.00154373f
Cred_2054 VDD.$1330.Metal3 vout.P4.nSD 2.05222e-06f
Cred_2055 VDD.$1330.Metal3 vout.P4.pSD 5.567e-06f
Cred_2056 VDD.$1330.Metal3 vout.P6.pSD 0.00178767f
Cred_2057 VDD.$1330.Metal3 vout.P8.nSD 9.27327e-06f
Cred_2058 VDD.$1330.Metal3 vout.P8.pSD 0.000244948f
Cred_2059 VDD.$1336.Metal3 vin.P61.GatPoly 0.000428058f
Cred_2060 VDD.$1336.Metal3 vin.P62.GatPoly 0.000859548f
Cred_2061 VDD.$1336.Metal3 vin.P63.GatPoly 0.00129793f
Cred_2062 VDD.$1336.Metal3 vin.P64.GatPoly 0.000646374f
Cred_2063 VDD.$1336.Metal3 vout.$972.Metal3 0.0125112f
Cred_2064 VDD.$1336.Metal3 vout.$990.Metal3 0.011587f
Cred_2065 VDD.$1336.Metal3 vout.P6.pSD 0.000114895f
Cred_2066 VDD.$1336.Metal3 vout.P8.nSD 6.2642e-05f
Cred_2067 VDD.$1336.Metal3 vout.P8.pSD 0.00175919f
Cred_2068 VDD.$1340.Metal3 vin.P64.GatPoly 0.000646374f
Cred_2069 VDD.$1340.Metal3 vin.P65.GatPoly 0.000859548f
Cred_2070 VDD.$1340.Metal3 vin.P66.GatPoly 0.000428058f
Cred_2071 VDD.$1340.Metal3 vout.$1008.Metal3 0.00158984f
Cred_2072 VDD.$1340.Metal3 vout.$972.Metal3 0.000319596f
Cred_2073 VDD.$1340.Metal3 vout.$990.Metal3 0.0246626f
Cred_2074 VDD.$1340.Metal3 vout.P10.pSD 0.00176891f
Cred_2075 VDD.$1340.Metal3 vout.P12.nSD 9.55026e-06f
Cred_2076 VDD.$1340.Metal3 vout.P12.pSD 0.000256421f
Cred_2077 VDD.$1340.Metal3 vout.P8.nSD 1.91983e-06f
Cred_2078 VDD.$1340.Metal3 vout.P8.pSD 5.20786e-06f
Cred_2079 VDD.$1346.Metal3 vin.P65.GatPoly 0.000428058f
Cred_2080 VDD.$1346.Metal3 vin.P66.GatPoly 0.000859548f
Cred_2081 VDD.$1346.Metal3 vin.P67.GatPoly 0.00129793f
Cred_2082 VDD.$1346.Metal3 vin.P68.GatPoly 0.000646374f
Cred_2083 VDD.$1346.Metal3 vout.$1008.Metal3 0.0115177f
Cred_2084 VDD.$1346.Metal3 vout.$990.Metal3 0.0121698f
Cred_2085 VDD.$1346.Metal3 vout.P10.pSD 9.11333e-05f
Cred_2086 VDD.$1346.Metal3 vout.P12.nSD 6.22258e-05f
Cred_2087 VDD.$1346.Metal3 vout.P12.pSD 0.00174707f
Cred_2088 VDD.$1350.Metal3 vin.P68.GatPoly 0.000646374f
Cred_2089 VDD.$1350.Metal3 vin.P69.GatPoly 0.000859548f
Cred_2090 VDD.$1350.Metal3 vin.P70.GatPoly 0.000428058f
Cred_2091 VDD.$1350.Metal3 vout.$1008.Metal3 0.0248124f
Cred_2092 VDD.$1350.Metal3 vout.$1026.Metal3 0.00163595f
Cred_2093 VDD.$1350.Metal3 vout.$990.Metal3 0.000297553f
Cred_2094 VDD.$1350.Metal3 vout.P12.nSD 1.78742e-06f
Cred_2095 VDD.$1350.Metal3 vout.P12.pSD 4.84868e-06f
Cred_2096 VDD.$1350.Metal3 vout.P14.pSD 0.00177993f
Cred_2097 VDD.$1350.Metal3 vout.P16.nSD 9.82725e-06f
Cred_2098 VDD.$1350.Metal3 vout.P16.pSD 0.000267894f
Cred_2099 VDD.$1356.Metal3 vin.P69.GatPoly 0.000428058f
Cred_2100 VDD.$1356.Metal3 vin.P70.GatPoly 0.000859548f
Cred_2101 VDD.$1356.Metal3 vin.P71.GatPoly 0.00129793f
Cred_2102 VDD.$1356.Metal3 vin.P72.GatPoly 0.000646374f
Cred_2103 VDD.$1356.Metal3 vout.$1008.Metal3 0.0119778f
Cred_2104 VDD.$1356.Metal3 vout.$1026.Metal3 0.0119119f
Cred_2105 VDD.$1356.Metal3 vout.P14.pSD 8.04118e-05f
Cred_2106 VDD.$1356.Metal3 vout.P16.nSD 6.18099e-05f
Cred_2107 VDD.$1356.Metal3 vout.P16.pSD 0.00173497f
Cred_2108 VDD.$1356.Metal3 vout.P18.pSD 4.04743e-05f
Cred_2109 VDD.$1360.Metal3 vin.P72.GatPoly 0.000646374f
Cred_2110 VDD.$1360.Metal3 vin.P73.GatPoly 0.000859548f
Cred_2111 VDD.$1360.Metal3 vin.P74.GatPoly 0.000428058f
Cred_2112 VDD.$1360.Metal3 vout.$1008.Metal3 0.000275513f
Cred_2113 VDD.$1360.Metal3 vout.$1026.Metal3 0.024495f
Cred_2114 VDD.$1360.Metal3 vout.$1044.Metal3 0.00168206f
Cred_2115 VDD.$1360.Metal3 vout.P16.nSD 1.65502e-06f
Cred_2116 VDD.$1360.Metal3 vout.P16.pSD 4.48953e-06f
Cred_2117 VDD.$1360.Metal3 vout.P18.pSD 0.00175013f
Cred_2118 VDD.$1360.Metal3 vout.P20.nSD 1.01042e-05f
Cred_2119 VDD.$1360.Metal3 vout.P20.pSD 0.000279367f
Cred_2120 VDD.$1366.Metal3 vin.P73.GatPoly 0.000428058f
Cred_2121 VDD.$1366.Metal3 vin.P74.GatPoly 0.000859548f
Cred_2122 VDD.$1366.Metal3 vin.P75.GatPoly 0.00129793f
Cred_2123 VDD.$1366.Metal3 vin.P76.GatPoly 0.000646374f
Cred_2124 VDD.$1366.Metal3 vout.$1026.Metal3 0.0117858f
Cred_2125 VDD.$1366.Metal3 vout.$1044.Metal3 0.012028f
Cred_2126 VDD.$1366.Metal3 vout.P18.pSD 6.96902e-05f
Cred_2127 VDD.$1366.Metal3 vout.P20.nSD 6.13937e-05f
Cred_2128 VDD.$1366.Metal3 vout.P20.pSD 0.00172286f
Cred_2129 VDD.$1366.Metal3 vout.P22.pSD 5.6664e-05f
Cred_2130 VDD.$1370.Metal3 vin.P76.GatPoly 0.000646374f
Cred_2131 VDD.$1370.Metal3 vin.P77.GatPoly 0.000859548f
Cred_2132 VDD.$1370.Metal3 vin.P78.GatPoly 0.000428058f
Cred_2133 VDD.$1370.Metal3 vout.$1026.Metal3 0.000253471f
Cred_2134 VDD.$1370.Metal3 vout.$1044.Metal3 0.0244579f
Cred_2135 VDD.$1370.Metal3 vout.$1062.Metal3 0.00172817f
Cred_2136 VDD.$1370.Metal3 vout.P20.nSD 1.52261e-06f
Cred_2137 VDD.$1370.Metal3 vout.P20.pSD 4.13035e-06f
Cred_2138 VDD.$1370.Metal3 vout.P22.pSD 0.00174481f
Cred_2139 VDD.$1370.Metal3 vout.P24.nSD 1.03812e-05f
Cred_2140 VDD.$1370.Metal3 vout.P24.pSD 0.00029084f
Cred_2141 VDD.$1376.Metal3 vin.P77.GatPoly 0.000428058f
Cred_2142 VDD.$1376.Metal3 vin.P78.GatPoly 0.000859548f
Cred_2143 VDD.$1376.Metal3 vin.P79.GatPoly 0.00129793f
Cred_2144 VDD.$1376.Metal3 vin.P80.GatPoly 0.00096446f
Cred_2145 VDD.$1376.Metal3 vin.P81.GatPoly 0.000318086f
Cred_2146 VDD.$1376.Metal3 vout.$1044.Metal3 0.0113623f
Cred_2147 VDD.$1376.Metal3 vout.$1062.Metal3 0.0226353f
Cred_2148 VDD.$1376.Metal3 vout.P22.pSD 5.89686e-05f
Cred_2149 VDD.$1376.Metal3 vout.P24.nSD 5.95873e-05f
Cred_2150 VDD.$1376.Metal3 vout.P24.pSD 0.00170697f
Cred_2151 VDD.$1376.Metal3 vout.P26.pSD 0.000918383f
Cred_2152 VDD.$1384.Metal3 vin.P80.GatPoly 0.000318086f
Cred_2153 VDD.$1384.Metal3 vin.P81.GatPoly 0.00096446f
Cred_2154 VDD.$1384.Metal3 vin.P82.GatPoly 0.00129793f
Cred_2155 VDD.$1384.Metal3 vin.P83.GatPoly 0.000859548f
Cred_2156 VDD.$1384.Metal3 vin.P84.GatPoly 0.000428058f
Cred_2157 VDD.$1384.Metal3 vout.$1062.Metal3 0.0226353f
Cred_2158 VDD.$1384.Metal3 vout.$1080.Metal3 0.0113623f
Cred_2159 VDD.$1384.Metal3 vout.P26.pSD 0.000918383f
Cred_2160 VDD.$1384.Metal3 vout.P28.nSD 5.95873e-05f
Cred_2161 VDD.$1384.Metal3 vout.P28.pSD 0.00170697f
Cred_2162 VDD.$1384.Metal3 vout.P30.pSD 5.89686e-05f
Cred_2163 VDD.$1390.Metal3 vin.P83.GatPoly 0.000428058f
Cred_2164 VDD.$1390.Metal3 vin.P84.GatPoly 0.000859548f
Cred_2165 VDD.$1390.Metal3 vin.P85.GatPoly 0.000646374f
Cred_2166 VDD.$1390.Metal3 vout.$1062.Metal3 0.00172817f
Cred_2167 VDD.$1390.Metal3 vout.$1080.Metal3 0.0244579f
Cred_2168 VDD.$1390.Metal3 vout.$1098.Metal3 0.000253471f
Cred_2169 VDD.$1390.Metal3 vout.P28.nSD 1.03812e-05f
Cred_2170 VDD.$1390.Metal3 vout.P28.pSD 0.00029084f
Cred_2171 VDD.$1390.Metal3 vout.P30.pSD 0.00174481f
Cred_2172 VDD.$1390.Metal3 vout.P32.nSD 1.52261e-06f
Cred_2173 VDD.$1390.Metal3 vout.P32.pSD 4.13035e-06f
Cred_2174 VDD.$1394.Metal3 vin.P85.GatPoly 0.000646374f
Cred_2175 VDD.$1394.Metal3 vin.P86.GatPoly 0.00129793f
Cred_2176 VDD.$1394.Metal3 vin.P87.GatPoly 0.000859548f
Cred_2177 VDD.$1394.Metal3 vin.P88.GatPoly 0.000428058f
Cred_2178 VDD.$1394.Metal3 vout.$1080.Metal3 0.012028f
Cred_2179 VDD.$1394.Metal3 vout.$1098.Metal3 0.0117858f
Cred_2180 VDD.$1394.Metal3 vout.P30.pSD 5.6664e-05f
Cred_2181 VDD.$1394.Metal3 vout.P32.nSD 6.13937e-05f
Cred_2182 VDD.$1394.Metal3 vout.P32.pSD 0.00172286f
Cred_2183 VDD.$1394.Metal3 vout.P34.pSD 6.96902e-05f
Cred_2184 VDD.$1400.Metal3 vin.P87.GatPoly 0.000428058f
Cred_2185 VDD.$1400.Metal3 vin.P88.GatPoly 0.000859548f
Cred_2186 VDD.$1400.Metal3 vin.P89.GatPoly 0.000646374f
Cred_2187 VDD.$1400.Metal3 vout.$1080.Metal3 0.00168206f
Cred_2188 VDD.$1400.Metal3 vout.$1098.Metal3 0.024495f
Cred_2189 VDD.$1400.Metal3 vout.$1116.Metal3 0.000275513f
Cred_2190 VDD.$1400.Metal3 vout.P32.nSD 1.01042e-05f
Cred_2191 VDD.$1400.Metal3 vout.P32.pSD 0.000279367f
Cred_2192 VDD.$1400.Metal3 vout.P34.pSD 0.00175013f
Cred_2193 VDD.$1400.Metal3 vout.P36.nSD 1.65502e-06f
Cred_2194 VDD.$1400.Metal3 vout.P36.pSD 4.48953e-06f
Cred_2195 VDD.$1404.Metal3 vin.P89.GatPoly 0.000646374f
Cred_2196 VDD.$1404.Metal3 vin.P90.GatPoly 0.00129793f
Cred_2197 VDD.$1404.Metal3 vin.P91.GatPoly 0.000859548f
Cred_2198 VDD.$1404.Metal3 vin.P92.GatPoly 0.000428058f
Cred_2199 VDD.$1404.Metal3 vout.$1098.Metal3 0.0119119f
Cred_2200 VDD.$1404.Metal3 vout.$1116.Metal3 0.0119778f
Cred_2201 VDD.$1404.Metal3 vout.P34.pSD 4.04743e-05f
Cred_2202 VDD.$1404.Metal3 vout.P36.nSD 6.18099e-05f
Cred_2203 VDD.$1404.Metal3 vout.P36.pSD 0.00173497f
Cred_2204 VDD.$1404.Metal3 vout.P38.pSD 8.04118e-05f
Cred_2205 VDD.$1410.Metal3 vin.P91.GatPoly 0.000428058f
Cred_2206 VDD.$1410.Metal3 vin.P92.GatPoly 0.000859548f
Cred_2207 VDD.$1410.Metal3 vin.P93.GatPoly 0.000646374f
Cred_2208 VDD.$1410.Metal3 vout.$1098.Metal3 0.00163595f
Cred_2209 VDD.$1410.Metal3 vout.$1116.Metal3 0.0248124f
Cred_2210 VDD.$1410.Metal3 vout.$1134.Metal3 0.000297553f
Cred_2211 VDD.$1410.Metal3 vout.P36.nSD 9.82725e-06f
Cred_2212 VDD.$1410.Metal3 vout.P36.pSD 0.000267894f
Cred_2213 VDD.$1410.Metal3 vout.P38.pSD 0.00177993f
Cred_2214 VDD.$1410.Metal3 vout.P40.nSD 1.78742e-06f
Cred_2215 VDD.$1410.Metal3 vout.P40.pSD 4.84868e-06f
Cred_2216 VDD.$1414.Metal3 vin.P93.GatPoly 0.000646374f
Cred_2217 VDD.$1414.Metal3 vin.P94.GatPoly 0.00129793f
Cred_2218 VDD.$1414.Metal3 vin.P95.GatPoly 0.000859548f
Cred_2219 VDD.$1414.Metal3 vin.P96.GatPoly 0.000428058f
Cred_2220 VDD.$1414.Metal3 vout.$1116.Metal3 0.0115177f
Cred_2221 VDD.$1414.Metal3 vout.$1134.Metal3 0.0121698f
Cred_2222 VDD.$1414.Metal3 vout.P40.nSD 6.22258e-05f
Cred_2223 VDD.$1414.Metal3 vout.P40.pSD 0.00174707f
Cred_2224 VDD.$1414.Metal3 vout.P42.pSD 9.11333e-05f
Cred_2225 VDD.$1420.Metal3 vin.P95.GatPoly 0.000428058f
Cred_2226 VDD.$1420.Metal3 vin.P96.GatPoly 0.000859548f
Cred_2227 VDD.$1420.Metal3 vin.P97.GatPoly 0.000646374f
Cred_2228 VDD.$1420.Metal3 vout.$1116.Metal3 0.00158984f
Cred_2229 VDD.$1420.Metal3 vout.$1134.Metal3 0.0246626f
Cred_2230 VDD.$1420.Metal3 vout.$1152.Metal3 0.000319596f
Cred_2231 VDD.$1420.Metal3 vout.P40.nSD 9.55026e-06f
Cred_2232 VDD.$1420.Metal3 vout.P40.pSD 0.000256421f
Cred_2233 VDD.$1420.Metal3 vout.P42.pSD 0.00176891f
Cred_2234 VDD.$1420.Metal3 vout.P44.nSD 1.91983e-06f
Cred_2235 VDD.$1420.Metal3 vout.P44.pSD 5.20786e-06f
Cred_2236 VDD.$1424.Metal3 vin.P100.GatPoly 0.000428058f
Cred_2237 VDD.$1424.Metal3 vin.P97.GatPoly 0.000646374f
Cred_2238 VDD.$1424.Metal3 vin.P98.GatPoly 0.00129793f
Cred_2239 VDD.$1424.Metal3 vin.P99.GatPoly 0.000859548f
Cred_2240 VDD.$1424.Metal3 vout.$1134.Metal3 0.011587f
Cred_2241 VDD.$1424.Metal3 vout.$1152.Metal3 0.0125112f
Cred_2242 VDD.$1424.Metal3 vout.P44.nSD 6.2642e-05f
Cred_2243 VDD.$1424.Metal3 vout.P44.pSD 0.00175919f
Cred_2244 VDD.$1424.Metal3 vout.P46.pSD 0.000114895f
Cred_2245 VDD.$143.Metal1 vin.$301.Metal1 0.000153655f
Cred_2246 VDD.$143.Metal1 vin.$307.Metal1 0.000153782f
Cred_2247 VDD.$143.Metal1 vin.$33.GatPoly 1.82586e-06f
Cred_2248 VDD.$143.Metal1 vin.$589.Metal2 2.02485e-06f
Cred_2249 VDD.$143.Metal1 vin.$593.Metal2 8.64265e-07f
Cred_2250 VDD.$143.Metal1 vin.P60.GatPoly 0.00120537f
Cred_2251 VDD.$143.Metal1 vin.P61.GatPoly 0.00117326f
Cred_2252 VDD.$143.Metal1 vout.$972.Metal3 0.00541029f
Cred_2253 VDD.$143.Metal1 vout.P6.pSD 0.00855929f
Cred_2254 VDD.$1430.Metal3 vin.P100.GatPoly 0.000859548f
Cred_2255 VDD.$1430.Metal3 vin.P101.GatPoly 0.000600204f
Cred_2256 VDD.$1430.Metal3 vin.P99.GatPoly 0.000428058f
Cred_2257 VDD.$1430.Metal3 vout.$1134.Metal3 0.00154373f
Cred_2258 VDD.$1430.Metal3 vout.$1152.Metal3 0.0248314f
Cred_2259 VDD.$1430.Metal3 vout.$1170.Metal3 0.000341636f
Cred_2260 VDD.$1430.Metal3 vout.P44.nSD 9.27327e-06f
Cred_2261 VDD.$1430.Metal3 vout.P44.pSD 0.000244948f
Cred_2262 VDD.$1430.Metal3 vout.P46.pSD 0.00178767f
Cred_2263 VDD.$1430.Metal3 vout.P48.nSD 2.05222e-06f
Cred_2264 VDD.$1430.Metal3 vout.P48.pSD 5.567e-06f
Cred_2265 VDD.$1434.Metal3 vin.P101.GatPoly 0.000600204f
Cred_2266 VDD.$1434.Metal3 vin.P102.GatPoly 0.00129793f
Cred_2267 VDD.$1434.Metal3 vin.P103.GatPoly 0.000859548f
Cred_2268 VDD.$1434.Metal3 vin.P104.GatPoly 0.000428058f
Cred_2269 VDD.$1434.Metal3 vout.$1152.Metal3 0.0115966f
Cred_2270 VDD.$1434.Metal3 vout.$1170.Metal3 0.0126387f
Cred_2271 VDD.$1434.Metal3 vout.P48.nSD 6.28337e-05f
Cred_2272 VDD.$1434.Metal3 vout.P48.pSD 0.00184616f
Cred_2273 VDD.$1434.Metal3 vout.P50.pSD 0.000123245f
Cred_2274 VDD.$1440.Metal3 vin.P103.GatPoly 0.000428058f
Cred_2275 VDD.$1440.Metal3 vin.P104.GatPoly 0.000859548f
Cred_2276 VDD.$1440.Metal3 vin.P105.GatPoly 0.000675358f
Cred_2277 VDD.$1440.Metal3 vin.P106.GatPoly 0.000428058f
Cred_2278 VDD.$1440.Metal3 vout 0.00406024f
Cred_2279 VDD.$1440.Metal3 vout.$1152.Metal3 0.00149762f
Cred_2280 VDD.$1440.Metal3 vout.$1170.Metal3 0.0247105f
Cred_2281 VDD.$1440.Metal3 vout.P48.nSD 8.99627e-06f
Cred_2282 VDD.$1440.Metal3 vout.P48.pSD 0.000233475f
Cred_2283 VDD.$1440.Metal3 vout.P50.pSD 0.00175074f
Cred_2284 VDD.$1440.Metal3 vout.P52.pSD 0.000425117f
Cred_2285 VDD.$1446.Metal3 vin.$259.GatPoly 8.86483e-09f
Cred_2286 VDD.$1446.Metal3 vin.$549.Metal1 4.18719e-07f
Cred_2287 VDD.$1446.Metal3 vin.$769.Metal2 8.75511e-06f
Cred_2288 VDD.$1446.Metal3 vin.$771.Metal2 3.24851e-06f
Cred_2289 VDD.$1446.Metal3 vin.P105.GatPoly 0.000336331f
Cred_2290 VDD.$1446.Metal3 vin.P106.GatPoly 0.000859548f
Cred_2291 VDD.$1446.Metal3 vin.P107.GatPoly 0.00142766f
Cred_2292 VDD.$1446.Metal3 vout 0.0149416f
Cred_2293 VDD.$1446.Metal3 vout.$1170.Metal3 0.000907697f
Cred_2294 VDD.$1446.Metal3 vout.P52.pSD 0.00157228f
Cred_2295 VDD.$151.Metal1 vin.$301.Metal1 0.000384181f
Cred_2296 VDD.$151.Metal1 vin.$306.Metal1 2.88159e-06f
Cred_2297 VDD.$151.Metal1 vin.$307.Metal1 0.0108312f
Cred_2298 VDD.$151.Metal1 vin.$310.Metal1 5.56097e-07f
Cred_2299 VDD.$151.Metal1 vin.$311.Metal1 0.00147067f
Cred_2300 VDD.$151.Metal1 vin.$33.GatPoly 0.00395223f
Cred_2301 VDD.$151.Metal1 vin.$39.GatPoly 0.0053501f
Cred_2302 VDD.$151.Metal1 vin.$588.Metal2 0.000340346f
Cred_2303 VDD.$151.Metal1 vin.$589.Metal2 8.25712e-06f
Cred_2304 VDD.$151.Metal1 vin.$590.Metal2 0.000171964f
Cred_2305 VDD.$151.Metal1 vin.$593.Metal2 0.00617311f
Cred_2306 VDD.$151.Metal1 vin.$594.Metal2 0.000171964f
Cred_2307 VDD.$151.Metal1 vin.$597.Metal2 0.000408879f
Cred_2308 VDD.$151.Metal1 vin.P61.GatPoly 0.0232144f
Cred_2309 VDD.$151.Metal1 vin.P62.GatPoly 0.0247457f
Cred_2310 VDD.$151.Metal1 vin.P63.GatPoly 0.000853491f
Cred_2311 VDD.$151.Metal1 vout.$972.Metal3 0.16289f
Cred_2312 VDD.$151.Metal1 vout.$990.Metal3 0.0542625f
Cred_2313 VDD.$151.Metal1 vout.P6.pSD 0.116108f
Cred_2314 VDD.$151.Metal1 vout.P8.nSD 0.000325958f
Cred_2315 VDD.$151.Metal1 vout.P8.pSD 0.118437f
Cred_2316 VDD.$176.Metal1 vin.$311.Metal1 0.000516268f
Cred_2317 VDD.$176.Metal1 vin.$319.Metal1 0.0113598f
Cred_2318 VDD.$176.Metal1 vin.$323.Metal1 0.000500189f
Cred_2319 VDD.$176.Metal1 vin.$43.GatPoly 0.00394944f
Cred_2320 VDD.$176.Metal1 vin.$49.GatPoly 0.00534711f
Cred_2321 VDD.$176.Metal1 vin.$595.Metal2 2.42953e-06f
Cred_2322 VDD.$176.Metal1 vin.$597.Metal2 0.000450975f
Cred_2323 VDD.$176.Metal1 vin.$599.Metal2 0.000281899f
Cred_2324 VDD.$176.Metal1 vin.$600.Metal2 0.00562725f
Cred_2325 VDD.$176.Metal1 vin.$604.Metal2 0.000390844f
Cred_2326 VDD.$176.Metal1 vin.$605.Metal2 0.000881353f
Cred_2327 VDD.$176.Metal1 vin.P62.GatPoly 0.000816809f
Cred_2328 VDD.$176.Metal1 vin.P63.GatPoly 0.0238486f
Cred_2329 VDD.$176.Metal1 vin.P64.GatPoly 0.0237758f
Cred_2330 VDD.$176.Metal1 vout.$972.Metal3 0.0528429f
Cred_2331 VDD.$176.Metal1 vout.$990.Metal3 0.163481f
Cred_2332 VDD.$176.Metal1 vout.P10.pSD 0.11957f
Cred_2333 VDD.$176.Metal1 vout.P8.nSD 0.00031743f
Cred_2334 VDD.$176.Metal1 vout.P8.pSD 0.113901f
Cred_2335 VDD.$195.Metal1 vin.$319.Metal1 8.64052e-05f
Cred_2336 VDD.$195.Metal1 vin.$323.Metal1 0.000461791f
Cred_2337 VDD.$195.Metal1 vin.$329.Metal1 0.000156537f
Cred_2338 VDD.$195.Metal1 vin.$53.GatPoly 1.85857e-06f
Cred_2339 VDD.$195.Metal1 vin.$600.Metal2 5.13157e-07f
Cred_2340 VDD.$195.Metal1 vin.$605.Metal2 3.03119e-06f
Cred_2341 VDD.$195.Metal1 vin.$609.Metal2 8.12918e-07f
Cred_2342 VDD.$195.Metal1 vin.P64.GatPoly 0.00117963f
Cred_2343 VDD.$195.Metal1 vin.P65.GatPoly 0.00117488f
Cred_2344 VDD.$195.Metal1 vout.$990.Metal3 0.0055086f
Cred_2345 VDD.$195.Metal1 vout.P10.pSD 0.00870532f
Cred_2346 VDD.$203.Metal1 vin.$323.Metal1 0.00038142f
Cred_2347 VDD.$203.Metal1 vin.$328.Metal1 2.77896e-06f
Cred_2348 VDD.$203.Metal1 vin.$329.Metal1 0.0107627f
Cred_2349 VDD.$203.Metal1 vin.$332.Metal1 6.56846e-07f
Cred_2350 VDD.$203.Metal1 vin.$333.Metal1 0.0015072f
Cred_2351 VDD.$203.Metal1 vin.$53.GatPoly 0.00395205f
Cred_2352 VDD.$203.Metal1 vin.$59.GatPoly 0.0053499f
Cred_2353 VDD.$203.Metal1 vin.$604.Metal2 0.000452085f
Cred_2354 VDD.$203.Metal1 vin.$605.Metal2 8.77921e-06f
Cred_2355 VDD.$203.Metal1 vin.$606.Metal2 0.000171934f
Cred_2356 VDD.$203.Metal1 vin.$609.Metal2 0.00607749f
Cred_2357 VDD.$203.Metal1 vin.$610.Metal2 0.000171934f
Cred_2358 VDD.$203.Metal1 vin.$613.Metal2 0.000391806f
Cred_2359 VDD.$203.Metal1 vin.P65.GatPoly 0.0232125f
Cred_2360 VDD.$203.Metal1 vin.P66.GatPoly 0.0247539f
Cred_2361 VDD.$203.Metal1 vin.P67.GatPoly 0.000842747f
Cred_2362 VDD.$203.Metal1 vout.$1008.Metal3 0.0546576f
Cred_2363 VDD.$203.Metal1 vout.$990.Metal3 0.162372f
Cred_2364 VDD.$203.Metal1 vout.P10.pSD 0.114664f
Cred_2365 VDD.$203.Metal1 vout.P12.nSD 0.000328331f
Cred_2366 VDD.$203.Metal1 vout.P12.pSD 0.119719f
Cred_2367 VDD.$228.Metal1 vin.$333.Metal1 0.000176334f
Cred_2368 VDD.$228.Metal1 vin.$337.Metal1 0.000748369f
Cred_2369 VDD.$228.Metal1 vin.$341.Metal1 0.0105912f
Cred_2370 VDD.$228.Metal1 vin.$345.Metal1 0.000533957f
Cred_2371 VDD.$228.Metal1 vin.$611.Metal2 0.0025011f
Cred_2372 VDD.$228.Metal1 vin.$613.Metal2 0.000571763f
Cred_2373 VDD.$228.Metal1 vin.$615.Metal2 0.000296315f
Cred_2374 VDD.$228.Metal1 vin.$618.Metal2 0.00379892f
Cred_2375 VDD.$228.Metal1 vin.$620.Metal2 0.000421082f
Cred_2376 VDD.$228.Metal1 vin.$63.GatPoly 0.0039458f
Cred_2377 VDD.$228.Metal1 vin.$69.GatPoly 0.00534758f
Cred_2378 VDD.$228.Metal1 vin.P66.GatPoly 0.000827505f
Cred_2379 VDD.$228.Metal1 vin.P67.GatPoly 0.0238824f
Cred_2380 VDD.$228.Metal1 vin.P68.GatPoly 0.0238016f
Cred_2381 VDD.$228.Metal1 vout.$1008.Metal3 0.161489f
Cred_2382 VDD.$228.Metal1 vout.$990.Metal3 0.0548401f
Cred_2383 VDD.$228.Metal1 vout.P12.nSD 0.000329427f
Cred_2384 VDD.$228.Metal1 vout.P12.pSD 0.120348f
Cred_2385 VDD.$228.Metal1 vout.P14.pSD 0.113187f
Cred_2386 VDD.$247.Metal1 vin.$341.Metal1 7.57857e-05f
Cred_2387 VDD.$247.Metal1 vin.$345.Metal1 0.000480169f
Cred_2388 VDD.$247.Metal1 vin.$351.Metal1 0.000164328f
Cred_2389 VDD.$247.Metal1 vin.$618.Metal2 1.21297e-06f
Cred_2390 VDD.$247.Metal1 vin.$623.Metal2 3.20396e-06f
Cred_2391 VDD.$247.Metal1 vin.$73.GatPoly 1.89419e-06f
Cred_2392 VDD.$247.Metal1 vin.P68.GatPoly 0.00115495f
Cred_2393 VDD.$247.Metal1 vin.P69.GatPoly 0.00117654f
Cred_2394 VDD.$247.Metal1 vout.$1008.Metal3 0.00561053f
Cred_2395 VDD.$247.Metal1 vout.P14.pSD 0.00885901f
Cred_2396 VDD.$255.Metal1 vin.$345.Metal1 0.000378795f
Cred_2397 VDD.$255.Metal1 vin.$350.Metal1 2.67646e-06f
Cred_2398 VDD.$255.Metal1 vin.$351.Metal1 0.0107672f
Cred_2399 VDD.$255.Metal1 vin.$354.Metal1 7.57488e-07f
Cred_2400 VDD.$255.Metal1 vin.$355.Metal1 0.000741937f
Cred_2401 VDD.$255.Metal1 vin.$620.Metal2 0.000420571f
Cred_2402 VDD.$255.Metal1 vin.$622.Metal2 0.0001719f
Cred_2403 VDD.$255.Metal1 vin.$623.Metal2 0.00301942f
Cred_2404 VDD.$255.Metal1 vin.$626.Metal2 0.0001719f
Cred_2405 VDD.$255.Metal1 vin.$627.Metal2 0.00300811f
Cred_2406 VDD.$255.Metal1 vin.$629.Metal2 0.000420127f
Cred_2407 VDD.$255.Metal1 vin.$73.GatPoly 0.00395184f
Cred_2408 VDD.$255.Metal1 vin.$79.GatPoly 0.00534967f
Cred_2409 VDD.$255.Metal1 vin.P69.GatPoly 0.0232106f
Cred_2410 VDD.$255.Metal1 vin.P70.GatPoly 0.0247549f
Cred_2411 VDD.$255.Metal1 vin.P71.GatPoly 0.000832009f
Cred_2412 VDD.$255.Metal1 vout.$1008.Metal3 0.162667f
Cred_2413 VDD.$255.Metal1 vout.$1026.Metal3 0.0542498f
Cred_2414 VDD.$255.Metal1 vout.P14.pSD 0.115777f
Cred_2415 VDD.$255.Metal1 vout.P16.nSD 0.000325881f
Cred_2416 VDD.$255.Metal1 vout.P16.pSD 0.118423f
Cred_2417 VDD.$280.Metal1 vin.$359.Metal1 0.000783933f
Cred_2418 VDD.$280.Metal1 vin.$363.Metal1 0.0105596f
Cred_2419 VDD.$280.Metal1 vin.$367.Metal1 0.000578351f
Cred_2420 VDD.$280.Metal1 vin.$627.Metal2 0.00267115f
Cred_2421 VDD.$280.Metal1 vin.$629.Metal2 0.000536189f
Cred_2422 VDD.$280.Metal1 vin.$631.Metal2 0.000310576f
Cred_2423 VDD.$280.Metal1 vin.$634.Metal2 0.00364718f
Cred_2424 VDD.$280.Metal1 vin.$636.Metal2 0.000421242f
Cred_2425 VDD.$280.Metal1 vin.$83.GatPoly 0.00394612f
Cred_2426 VDD.$280.Metal1 vin.$89.GatPoly 0.00534801f
Cred_2427 VDD.$280.Metal1 vin.P70.GatPoly 0.000838207f
Cred_2428 VDD.$280.Metal1 vin.P71.GatPoly 0.0239125f
Cred_2429 VDD.$280.Metal1 vin.P72.GatPoly 0.0238264f
Cred_2430 VDD.$280.Metal1 vout.$1008.Metal3 0.0548508f
Cred_2431 VDD.$280.Metal1 vout.$1026.Metal3 0.161276f
Cred_2432 VDD.$280.Metal1 vout.P16.nSD 0.000329492f
Cred_2433 VDD.$280.Metal1 vout.P16.pSD 0.120362f
Cred_2434 VDD.$280.Metal1 vout.P18.pSD 0.113072f
Cred_2435 VDD.$299.Metal1 vin.$363.Metal1 6.48609e-05f
Cred_2436 VDD.$299.Metal1 vin.$367.Metal1 0.00049869f
Cred_2437 VDD.$299.Metal1 vin.$373.Metal1 0.00017769f
Cred_2438 VDD.$299.Metal1 vin.$634.Metal2 1.07587e-06f
Cred_2439 VDD.$299.Metal1 vin.$639.Metal2 3.36106e-06f
Cred_2440 VDD.$299.Metal1 vin.$93.GatPoly 1.93046e-06f
Cred_2441 VDD.$299.Metal1 vin.P72.GatPoly 0.00113125f
Cred_2442 VDD.$299.Metal1 vin.P73.GatPoly 0.00117824f
Cred_2443 VDD.$299.Metal1 vout.$1026.Metal3 0.00571629f
Cred_2444 VDD.$299.Metal1 vout.P18.pSD 0.00902076f
Cred_2445 VDD.$307.Metal1 vin.$367.Metal1 0.000375833f
Cred_2446 VDD.$307.Metal1 vin.$372.Metal1 2.57408e-06f
Cred_2447 VDD.$307.Metal1 vin.$373.Metal1 0.010932f
Cred_2448 VDD.$307.Metal1 vin.$376.Metal1 8.58025e-07f
Cred_2449 VDD.$307.Metal1 vin.$377.Metal1 0.000779405f
Cred_2450 VDD.$307.Metal1 vin.$636.Metal2 0.000421761f
Cred_2451 VDD.$307.Metal1 vin.$638.Metal2 0.00017186f
Cred_2452 VDD.$307.Metal1 vin.$639.Metal2 0.00301732f
Cred_2453 VDD.$307.Metal1 vin.$642.Metal2 0.00017186f
Cred_2454 VDD.$307.Metal1 vin.$643.Metal2 0.0030059f
Cred_2455 VDD.$307.Metal1 vin.$645.Metal2 0.000421761f
Cred_2456 VDD.$307.Metal1 vin.$93.GatPoly 0.00395161f
Cred_2457 VDD.$307.Metal1 vin.$99.GatPoly 0.00534941f
Cred_2458 VDD.$307.Metal1 vin.P73.GatPoly 0.0232085f
Cred_2459 VDD.$307.Metal1 vin.P74.GatPoly 0.0247494f
Cred_2460 VDD.$307.Metal1 vin.P75.GatPoly 0.000821277f
Cred_2461 VDD.$307.Metal1 vout.$1026.Metal3 0.162301f
Cred_2462 VDD.$307.Metal1 vout.$1044.Metal3 0.053747f
Cred_2463 VDD.$307.Metal1 vout.P18.pSD 0.115732f
Cred_2464 VDD.$307.Metal1 vout.P20.nSD 0.000322861f
Cred_2465 VDD.$307.Metal1 vout.P20.pSD 0.118074f
Cred_2466 VDD.$31.Metal1 vin 0.00416968f
Cred_2467 VDD.$31.Metal1 vin.$103.GatPoly 4.28993e-05f
Cred_2468 VDD.$31.Metal1 vin.$109.GatPoly 2.93708e-05f
Cred_2469 VDD.$31.Metal1 vin.$113.GatPoly 3.49974e-05f
Cred_2470 VDD.$31.Metal1 vin.$119.GatPoly 2.27091e-05f
Cred_2471 VDD.$31.Metal1 vin.$123.GatPoly 2.70328e-05f
Cred_2472 VDD.$31.Metal1 vin.$129.GatPoly 1.83627e-05f
Cred_2473 VDD.$31.Metal1 vin.$13.GatPoly 0.000582339f
Cred_2474 VDD.$31.Metal1 vin.$133.GatPoly 2.09204e-05f
Cred_2475 VDD.$31.Metal1 vin.$139.GatPoly 1.36251e-05f
Cred_2476 VDD.$31.Metal1 vin.$143.GatPoly 1.52612e-05f
Cred_2477 VDD.$31.Metal1 vin.$149.GatPoly 1.08048e-05f
Cred_2478 VDD.$31.Metal1 vin.$153.GatPoly 1.28052e-05f
Cred_2479 VDD.$31.Metal1 vin.$159.GatPoly 8.357e-06f
Cred_2480 VDD.$31.Metal1 vin.$163.GatPoly 9.91977e-06f
Cred_2481 VDD.$31.Metal1 vin.$169.GatPoly 6.4635e-06f
Cred_2482 VDD.$31.Metal1 vin.$173.GatPoly 7.66064e-06f
Cred_2483 VDD.$31.Metal1 vin.$179.GatPoly 4.99869e-06f
Cred_2484 VDD.$31.Metal1 vin.$183.GatPoly 5.93296e-06f
Cred_2485 VDD.$31.Metal1 vin.$189.GatPoly 3.86541e-06f
Cred_2486 VDD.$31.Metal1 vin.$19.GatPoly 0.000292589f
Cred_2487 VDD.$31.Metal1 vin.$193.GatPoly 4.58467e-06f
Cred_2488 VDD.$31.Metal1 vin.$199.GatPoly 2.96193e-06f
Cred_2489 VDD.$31.Metal1 vin.$203.GatPoly 3.59018e-06f
Cred_2490 VDD.$31.Metal1 vin.$211.GatPoly 3.12807e-06f
Cred_2491 VDD.$31.Metal1 vin.$215.GatPoly 2.37862e-06f
Cred_2492 VDD.$31.Metal1 vin.$223.GatPoly 2.70613e-06f
Cred_2493 VDD.$31.Metal1 vin.$23.GatPoly 0.000347471f
Cred_2494 VDD.$31.Metal1 vin.$231.GatPoly 1.86453e-06f
Cred_2495 VDD.$31.Metal1 vin.$235.GatPoly 1.4234e-06f
Cred_2496 VDD.$31.Metal1 vin.$243.GatPoly 1.65969e-06f
Cred_2497 VDD.$31.Metal1 vin.$251.GatPoly 1.35018e-06f
Cred_2498 VDD.$31.Metal1 vin.$259.GatPoly 1.35734e-06f
Cred_2499 VDD.$31.Metal1 vin.$271.Metal1 0.0147352f
Cred_2500 VDD.$31.Metal1 vin.$275.Metal1 0.00418754f
Cred_2501 VDD.$31.Metal1 vin.$279.Metal1 0.00565408f
Cred_2502 VDD.$31.Metal1 vin.$285.Metal1 0.00503734f
Cred_2503 VDD.$31.Metal1 vin.$289.Metal1 0.00422077f
Cred_2504 VDD.$31.Metal1 vin.$29.GatPoly 0.000224338f
Cred_2505 VDD.$31.Metal1 vin.$297.Metal1 0.00378781f
Cred_2506 VDD.$31.Metal1 vin.$301.Metal1 0.00334f
Cred_2507 VDD.$31.Metal1 vin.$307.Metal1 0.00300106f
Cred_2508 VDD.$31.Metal1 vin.$311.Metal1 0.00253677f
Cred_2509 VDD.$31.Metal1 vin.$319.Metal1 0.00228392f
Cred_2510 VDD.$31.Metal1 vin.$323.Metal1 0.00196269f
Cred_2511 VDD.$31.Metal1 vin.$329.Metal1 0.00182172f
Cred_2512 VDD.$31.Metal1 vin.$33.GatPoly 0.000265613f
Cred_2513 VDD.$31.Metal1 vin.$333.Metal1 0.00103216f
Cred_2514 VDD.$31.Metal1 vin.$337.Metal1 0.000977585f
Cred_2515 VDD.$31.Metal1 vin.$341.Metal1 0.000890504f
Cred_2516 VDD.$31.Metal1 vin.$345.Metal1 0.00117528f
Cred_2517 VDD.$31.Metal1 vin.$351.Metal1 0.00109648f
Cred_2518 VDD.$31.Metal1 vin.$355.Metal1 0.000639551f
Cred_2519 VDD.$31.Metal1 vin.$359.Metal1 0.000585651f
Cred_2520 VDD.$31.Metal1 vin.$363.Metal1 0.000534669f
Cred_2521 VDD.$31.Metal1 vin.$367.Metal1 0.000705748f
Cred_2522 VDD.$31.Metal1 vin.$373.Metal1 0.000653561f
Cred_2523 VDD.$31.Metal1 vin.$377.Metal1 0.000384638f
Cred_2524 VDD.$31.Metal1 vin.$381.Metal1 0.000352281f
Cred_2525 VDD.$31.Metal1 vin.$385.Metal1 0.000322535f
Cred_2526 VDD.$31.Metal1 vin.$389.Metal1 0.000422785f
Cred_2527 VDD.$31.Metal1 vin.$39.GatPoly 0.000175098f
Cred_2528 VDD.$31.Metal1 vin.$395.Metal1 0.000383644f
Cred_2529 VDD.$31.Metal1 vin.$399.Metal1 0.000337941f
Cred_2530 VDD.$31.Metal1 vin.$407.Metal1 0.000297027f
Cred_2531 VDD.$31.Metal1 vin.$411.Metal1 0.000260332f
Cred_2532 VDD.$31.Metal1 vin.$417.Metal1 0.00022661f
Cred_2533 VDD.$31.Metal1 vin.$421.Metal1 0.000141479f
Cred_2534 VDD.$31.Metal1 vin.$425.Metal1 0.000129141f
Cred_2535 VDD.$31.Metal1 vin.$429.Metal1 0.000118272f
Cred_2536 VDD.$31.Metal1 vin.$43.GatPoly 0.000208032f
Cred_2537 VDD.$31.Metal1 vin.$433.Metal1 0.000157039f
Cred_2538 VDD.$31.Metal1 vin.$439.Metal1 0.000139323f
Cred_2539 VDD.$31.Metal1 vin.$443.Metal1 0.0001234f
Cred_2540 VDD.$31.Metal1 vin.$451.Metal1 0.000111248f
Cred_2541 VDD.$31.Metal1 vin.$455.Metal1 9.56777e-05f
Cred_2542 VDD.$31.Metal1 vin.$461.Metal1 8.33502e-05f
Cred_2543 VDD.$31.Metal1 vin.$465.Metal1 7.38653e-05f
Cred_2544 VDD.$31.Metal1 vin.$473.Metal1 6.71336e-05f
Cred_2545 VDD.$31.Metal1 vin.$477.Metal1 5.73817e-05f
Cred_2546 VDD.$31.Metal1 vin.$483.Metal1 4.98779e-05f
Cred_2547 VDD.$31.Metal1 vin.$487.Metal1 4.39478e-05f
Cred_2548 VDD.$31.Metal1 vin.$49.GatPoly 0.000132154f
Cred_2549 VDD.$31.Metal1 vin.$495.Metal1 5.13831e-05f
Cred_2550 VDD.$31.Metal1 vin.$5.GatPoly 0.000788838f
Cred_2551 VDD.$31.Metal1 vin.$501.Metal1 3.25987e-05f
Cred_2552 VDD.$31.Metal1 vin.$505.Metal1 1.9342e-05f
Cred_2553 VDD.$31.Metal1 vin.$509.Metal1 2.6198e-05f
Cred_2554 VDD.$31.Metal1 vin.$517.Metal1 3.02682e-05f
Cred_2555 VDD.$31.Metal1 vin.$523.Metal1 1.97315e-05f
Cred_2556 VDD.$31.Metal1 vin.$527.Metal1 1.17995e-05f
Cred_2557 VDD.$31.Metal1 vin.$53.GatPoly 0.000155539f
Cred_2558 VDD.$31.Metal1 vin.$531.Metal1 1.5811e-05f
Cred_2559 VDD.$31.Metal1 vin.$539.Metal1 1.79931e-05f
Cred_2560 VDD.$31.Metal1 vin.$545.Metal1 1.17977e-05f
Cred_2561 VDD.$31.Metal1 vin.$549.Metal1 2.25456e-05f
Cred_2562 VDD.$31.Metal1 vin.$564.Metal2 4.37827e-06f
Cred_2563 VDD.$31.Metal1 vin.$566.Metal2 0.00582263f
Cred_2564 VDD.$31.Metal1 vin.$569.Metal2 0.000145047f
Cred_2565 VDD.$31.Metal1 vin.$573.Metal2 0.00359443f
Cred_2566 VDD.$31.Metal1 vin.$574.Metal2 0.000265086f
Cred_2567 VDD.$31.Metal1 vin.$577.Metal2 0.000483691f
Cred_2568 VDD.$31.Metal1 vin.$579.Metal2 0.00182907f
Cred_2569 VDD.$31.Metal1 vin.$581.Metal2 0.00426469f
Cred_2570 VDD.$31.Metal1 vin.$584.Metal2 0.000616847f
Cred_2571 VDD.$31.Metal1 vin.$588.Metal2 0.00225276f
Cred_2572 VDD.$31.Metal1 vin.$589.Metal2 0.00173898f
Cred_2573 VDD.$31.Metal1 vin.$59.GatPoly 0.000104828f
Cred_2574 VDD.$31.Metal1 vin.$593.Metal2 0.000308643f
Cred_2575 VDD.$31.Metal1 vin.$595.Metal2 0.00101927f
Cred_2576 VDD.$31.Metal1 vin.$597.Metal2 0.00182754f
Cred_2577 VDD.$31.Metal1 vin.$600.Metal2 0.000345482f
Cred_2578 VDD.$31.Metal1 vin.$604.Metal2 0.00129518f
Cred_2579 VDD.$31.Metal1 vin.$605.Metal2 0.00104331f
Cred_2580 VDD.$31.Metal1 vin.$609.Metal2 0.000171992f
Cred_2581 VDD.$31.Metal1 vin.$611.Metal2 0.00070397f
Cred_2582 VDD.$31.Metal1 vin.$613.Metal2 0.00103981f
Cred_2583 VDD.$31.Metal1 vin.$618.Metal2 0.000349355f
Cred_2584 VDD.$31.Metal1 vin.$620.Metal2 0.000851396f
Cred_2585 VDD.$31.Metal1 vin.$623.Metal2 0.000371672f
Cred_2586 VDD.$31.Metal1 vin.$627.Metal2 0.000480198f
Cred_2587 VDD.$31.Metal1 vin.$629.Metal2 0.000616781f
Cred_2588 VDD.$31.Metal1 vin.$63.GatPoly 0.000118812f
Cred_2589 VDD.$31.Metal1 vin.$634.Metal2 0.000209302f
Cred_2590 VDD.$31.Metal1 vin.$636.Metal2 0.000511704f
Cred_2591 VDD.$31.Metal1 vin.$639.Metal2 0.000217574f
Cred_2592 VDD.$31.Metal1 vin.$643.Metal2 0.000296087f
Cred_2593 VDD.$31.Metal1 vin.$645.Metal2 0.000366878f
Cred_2594 VDD.$31.Metal1 vin.$650.Metal2 0.000131539f
Cred_2595 VDD.$31.Metal1 vin.$652.Metal2 0.000306579f
Cred_2596 VDD.$31.Metal1 vin.$655.Metal2 0.000130099f
Cred_2597 VDD.$31.Metal1 vin.$659.Metal2 0.000233197f
Cred_2598 VDD.$31.Metal1 vin.$662.Metal2 0.000180581f
Cred_2599 VDD.$31.Metal1 vin.$666.Metal2 8.17464e-05f
Cred_2600 VDD.$31.Metal1 vin.$668.Metal2 0.000199822f
Cred_2601 VDD.$31.Metal1 vin.$671.Metal2 7.64765e-05f
Cred_2602 VDD.$31.Metal1 vin.$676.Metal2 0.000140102f
Cred_2603 VDD.$31.Metal1 vin.$678.Metal2 0.00010541f
Cred_2604 VDD.$31.Metal1 vin.$682.Metal2 4.87905e-05f
Cred_2605 VDD.$31.Metal1 vin.$684.Metal2 0.00011417f
Cred_2606 VDD.$31.Metal1 vin.$687.Metal2 4.33578e-05f
Cred_2607 VDD.$31.Metal1 vin.$69.GatPoly 8.11388e-05f
Cred_2608 VDD.$31.Metal1 vin.$691.Metal2 8.26307e-05f
Cred_2609 VDD.$31.Metal1 vin.$694.Metal2 6.27584e-05f
Cred_2610 VDD.$31.Metal1 vin.$698.Metal2 2.94098e-05f
Cred_2611 VDD.$31.Metal1 vin.$700.Metal2 6.87931e-05f
Cred_2612 VDD.$31.Metal1 vin.$703.Metal2 2.46683e-05f
Cred_2613 VDD.$31.Metal1 vin.$707.Metal2 4.99725e-05f
Cred_2614 VDD.$31.Metal1 vin.$710.Metal2 3.66034e-05f
Cred_2615 VDD.$31.Metal1 vin.$714.Metal2 1.82238e-05f
Cred_2616 VDD.$31.Metal1 vin.$716.Metal2 4.14518e-05f
Cred_2617 VDD.$31.Metal1 vin.$719.Metal2 1.51964e-05f
Cred_2618 VDD.$31.Metal1 vin.$723.Metal2 3.04146e-05f
Cred_2619 VDD.$31.Metal1 vin.$726.Metal2 1.89121e-05f
Cred_2620 VDD.$31.Metal1 vin.$728.Metal2 4.19234e-06f
Cred_2621 VDD.$31.Metal1 vin.$73.GatPoly 9.64487e-05f
Cred_2622 VDD.$31.Metal1 vin.$732.Metal2 2.24669e-05f
Cred_2623 VDD.$31.Metal1 vin.$733.Metal2 1.75575e-05f
Cred_2624 VDD.$31.Metal1 vin.$737.Metal2 3.55971e-06f
Cred_2625 VDD.$31.Metal1 vin.$739.Metal2 1.82441e-05f
Cred_2626 VDD.$31.Metal1 vin.$742.Metal2 1.0497e-05f
Cred_2627 VDD.$31.Metal1 vin.$744.Metal2 2.30574e-06f
Cred_2628 VDD.$31.Metal1 vin.$748.Metal2 1.3254e-05f
Cred_2629 VDD.$31.Metal1 vin.$749.Metal2 1.0023e-05f
Cred_2630 VDD.$31.Metal1 vin.$753.Metal2 2.49448e-06f
Cred_2631 VDD.$31.Metal1 vin.$755.Metal2 1.08089e-05f
Cred_2632 VDD.$31.Metal1 vin.$758.Metal2 6.24969e-06f
Cred_2633 VDD.$31.Metal1 vin.$760.Metal2 1.37175e-06f
Cred_2634 VDD.$31.Metal1 vin.$764.Metal2 7.89188e-06f
Cred_2635 VDD.$31.Metal1 vin.$765.Metal2 5.94598e-06f
Cred_2636 VDD.$31.Metal1 vin.$769.Metal2 5.5943e-06f
Cred_2637 VDD.$31.Metal1 vin.$771.Metal2 5.49897e-06f
Cred_2638 VDD.$31.Metal1 vin.$79.GatPoly 6.28305e-05f
Cred_2639 VDD.$31.Metal1 vin.$83.GatPoly 7.12481e-05f
Cred_2640 VDD.$31.Metal1 vin.$89.GatPoly 4.86893e-05f
Cred_2641 VDD.$31.Metal1 vin.$93.GatPoly 5.79378e-05f
Cred_2642 VDD.$31.Metal1 vin.$99.GatPoly 3.77773e-05f
Cred_2643 VDD.$31.Metal1 vin.P100.GatPoly 1.02497e-08f
Cred_2644 VDD.$31.Metal1 vin.P102.GatPoly 4.52475e-08f
Cred_2645 VDD.$31.Metal1 vin.P103.GatPoly 6.07791e-09f
Cred_2646 VDD.$31.Metal1 vin.P104.GatPoly 6.07791e-09f
Cred_2647 VDD.$31.Metal1 vin.P105.GatPoly 2.98497e-08f
Cred_2648 VDD.$31.Metal1 vin.P107.GatPoly 4.57896e-08f
Cred_2649 VDD.$31.Metal1 vin.P54.GatPoly 0.00607891f
Cred_2650 VDD.$31.Metal1 vin.P56.GatPoly 1.61286e-05f
Cred_2651 VDD.$31.Metal1 vin.P57.GatPoly 1.92584e-06f
Cred_2652 VDD.$31.Metal1 vin.P59.GatPoly 1.48976e-06f
Cred_2653 VDD.$31.Metal1 vin.P61.GatPoly 1.15248e-06f
Cred_2654 VDD.$31.Metal1 vin.P63.GatPoly 8.91637e-07f
Cred_2655 VDD.$31.Metal1 vin.P65.GatPoly 6.8993e-07f
Cred_2656 VDD.$31.Metal1 vin.P67.GatPoly 5.33981e-07f
Cred_2657 VDD.$31.Metal1 vin.P69.GatPoly 4.13447e-07f
Cred_2658 VDD.$31.Metal1 vin.P71.GatPoly 3.20335e-07f
Cred_2659 VDD.$31.Metal1 vin.P73.GatPoly 2.48468e-07f
Cred_2660 VDD.$31.Metal1 vin.P75.GatPoly 1.93081e-07f
Cred_2661 VDD.$31.Metal1 vin.P77.GatPoly 1.50499e-07f
Cred_2662 VDD.$31.Metal1 vin.P79.GatPoly 1.17898e-07f
Cred_2663 VDD.$31.Metal1 vin.P81.GatPoly 9.20327e-08f
Cred_2664 VDD.$31.Metal1 vin.P83.GatPoly 7.11852e-08f
Cred_2665 VDD.$31.Metal1 vin.P85.GatPoly 5.5059e-08f
Cred_2666 VDD.$31.Metal1 vin.P87.GatPoly 4.25844e-08f
Cred_2667 VDD.$31.Metal1 vin.P89.GatPoly 3.29341e-08f
Cred_2668 VDD.$31.Metal1 vin.P91.GatPoly 2.54682e-08f
Cred_2669 VDD.$31.Metal1 vin.P93.GatPoly 1.96913e-08f
Cred_2670 VDD.$31.Metal1 vin.P95.GatPoly 1.71858e-08f
Cred_2671 VDD.$31.Metal1 vin.P96.GatPoly 1.71858e-08f
Cred_2672 VDD.$31.Metal1 vin.P98.GatPoly 7.41233e-08f
Cred_2673 VDD.$31.Metal1 vin.P99.GatPoly 1.02497e-08f
Cred_2674 VDD.$31.Metal1 vout 2.26888e-06f
Cred_2675 VDD.$31.Metal1 vout.$1008.Metal3 0.000448996f
Cred_2676 VDD.$31.Metal1 vout.$1026.Metal3 0.000270769f
Cred_2677 VDD.$31.Metal1 vout.$1044.Metal3 0.000167111f
Cred_2678 VDD.$31.Metal1 vout.$1062.Metal3 0.000104175f
Cred_2679 VDD.$31.Metal1 vout.$1080.Metal3 6.07759e-05f
Cred_2680 VDD.$31.Metal1 vout.$1098.Metal3 3.49092e-05f
Cred_2681 VDD.$31.Metal1 vout.$1116.Metal3 2.0743e-05f
Cred_2682 VDD.$31.Metal1 vout.$1134.Metal3 1.21655e-05f
Cred_2683 VDD.$31.Metal1 vout.$1152.Metal3 7.08469e-06f
Cred_2684 VDD.$31.Metal1 vout.$1170.Metal3 3.45936e-06f
Cred_2685 VDD.$31.Metal1 vout.$954.Metal3 0.0169854f
Cred_2686 VDD.$31.Metal1 vout.$972.Metal3 0.00121053f
Cred_2687 VDD.$31.Metal1 vout.$990.Metal3 0.000733273f
Cred_2688 VDD.$31.Metal1 vout.P0.nSD 7.06e-05f
Cred_2689 VDD.$31.Metal1 vout.P0.pSD 0.0217035f
Cred_2690 VDD.$31.Metal1 vout.P12.nSD 8.75546e-07f
Cred_2691 VDD.$31.Metal1 vout.P12.pSD 2.37507e-06f
Cred_2692 VDD.$31.Metal1 vout.P16.nSD 5.29526e-07f
Cred_2693 VDD.$31.Metal1 vout.P16.pSD 1.43643e-06f
Cred_2694 VDD.$31.Metal1 vout.P20.nSD 3.21384e-07f
Cred_2695 VDD.$31.Metal1 vout.P20.pSD 8.71808e-07f
Cred_2696 VDD.$31.Metal1 vout.P24.nSD 2.14133e-07f
Cred_2697 VDD.$31.Metal1 vout.P24.pSD 5.80873e-07f
Cred_2698 VDD.$31.Metal1 vout.P28.nSD 1.30034e-07f
Cred_2699 VDD.$31.Metal1 vout.P28.pSD 3.52738e-07f
Cred_2700 VDD.$31.Metal1 vout.P32.nSD 6.9541e-08f
Cred_2701 VDD.$31.Metal1 vout.P32.pSD 1.88642e-07f
Cred_2702 VDD.$31.Metal1 vout.P36.nSD 4.11543e-08f
Cred_2703 VDD.$31.Metal1 vout.P36.pSD 1.11638e-07f
Cred_2704 VDD.$31.Metal1 vout.P4.nSD 2.30352e-06f
Cred_2705 VDD.$31.Metal1 vout.P4.pSD 6.24868e-06f
Cred_2706 VDD.$31.Metal1 vout.P40.nSD 2.42462e-08f
Cred_2707 VDD.$31.Metal1 vout.P40.pSD 6.5772e-08f
Cred_2708 VDD.$31.Metal1 vout.P44.nSD 1.34649e-08f
Cred_2709 VDD.$31.Metal1 vout.P44.pSD 3.65258e-08f
Cred_2710 VDD.$31.Metal1 vout.P48.nSD 8.02293e-09f
Cred_2711 VDD.$31.Metal1 vout.P48.pSD 2.17636e-08f
Cred_2712 VDD.$31.Metal1 vout.P52.pSD 5.71402e-09f
Cred_2713 VDD.$31.Metal1 vout.P8.nSD 1.37856e-06f
Cred_2714 VDD.$31.Metal1 vout.P8.pSD 3.73958e-06f
Cred_2715 VDD.$31.Metal1 VSS.$14.Metal1 0.00287027f
Cred_2716 VDD.$31.Metal1 VSS.$29.Metal1 0.00591101f
Cred_2717 VDD.$31.Metal1 VSS.$500.Metal1 7.86561e-07f
Cred_2718 VDD.$31.Metal1 VSS.$520.Metal1 5.25593e-05f
Cred_2719 VDD.$31.Metal1 VSS.$531.Metal2 0.000311508f
Cred_2720 VDD.$31.Metal1 VSS.$904.Metal2 1.15147e-07f
Cred_2721 VDD.$31.Metal1 VSS.P0.nSD 1.12259e-05f
Cred_2722 VDD.$31.Metal1 VSS.P0.pSD 0.0242259f
Cred_2723 VDD.$31.Metal1 VSS.P1.nSD 1.12259e-05f
Cred_2724 VDD.$31.Metal1 VSS.P55.nSD 8.1827e-09f
Cred_2725 VDD.$31.Metal1 VSS.P57.nSD 8.1827e-09f
Cred_2726 VDD.$332.Metal1 vin.$103.GatPoly 0.00394641f
Cred_2727 VDD.$332.Metal1 vin.$109.GatPoly 0.00534841f
Cred_2728 VDD.$332.Metal1 vin.$381.Metal1 0.000804989f
Cred_2729 VDD.$332.Metal1 vin.$385.Metal1 0.0105409f
Cred_2730 VDD.$332.Metal1 vin.$389.Metal1 0.000624696f
Cred_2731 VDD.$332.Metal1 vin.$643.Metal2 0.00284736f
Cred_2732 VDD.$332.Metal1 vin.$645.Metal2 0.000494908f
Cred_2733 VDD.$332.Metal1 vin.$647.Metal2 0.00032466f
Cred_2734 VDD.$332.Metal1 vin.$650.Metal2 0.00335192f
Cred_2735 VDD.$332.Metal1 vin.$652.Metal2 0.000421391f
Cred_2736 VDD.$332.Metal1 vin.P74.GatPoly 0.000848915f
Cred_2737 VDD.$332.Metal1 vin.P75.GatPoly 0.0239385f
Cred_2738 VDD.$332.Metal1 vin.P76.GatPoly 0.0238501f
Cred_2739 VDD.$332.Metal1 vout.$1026.Metal3 0.0553557f
Cred_2740 VDD.$332.Metal1 vout.$1044.Metal3 0.162055f
Cred_2741 VDD.$332.Metal1 vout.P20.nSD 0.000332525f
Cred_2742 VDD.$332.Metal1 vout.P20.pSD 0.120715f
Cred_2743 VDD.$332.Metal1 vout.P22.pSD 0.113215f
Cred_2744 VDD.$351.Metal1 vin.$113.GatPoly 1.93604e-06f
Cred_2745 VDD.$351.Metal1 vin.$385.Metal1 5.36474e-05f
Cred_2746 VDD.$351.Metal1 vin.$389.Metal1 0.000514751f
Cred_2747 VDD.$351.Metal1 vin.$395.Metal1 0.000189099f
Cred_2748 VDD.$351.Metal1 vin.$650.Metal2 9.21089e-07f
Cred_2749 VDD.$351.Metal1 vin.$655.Metal2 3.46682e-06f
Cred_2750 VDD.$351.Metal1 vin.P76.GatPoly 0.00110849f
Cred_2751 VDD.$351.Metal1 vin.P77.GatPoly 0.00117103f
Cred_2752 VDD.$351.Metal1 vout.$1044.Metal3 0.00582611f
Cred_2753 VDD.$351.Metal1 vout.P22.pSD 0.00919101f
Cred_2754 VDD.$359.Metal1 vin.$113.GatPoly 0.00395128f
Cred_2755 VDD.$359.Metal1 vin.$119.GatPoly 0.00534911f
Cred_2756 VDD.$359.Metal1 vin.$389.Metal1 0.000366688f
Cred_2757 VDD.$359.Metal1 vin.$394.Metal1 2.47069e-06f
Cred_2758 VDD.$359.Metal1 vin.$395.Metal1 0.0109071f
Cred_2759 VDD.$359.Metal1 vin.$398.Metal1 9.58021e-07f
Cred_2760 VDD.$359.Metal1 vin.$399.Metal1 0.000802512f
Cred_2761 VDD.$359.Metal1 vin.$652.Metal2 0.000381492f
Cred_2762 VDD.$359.Metal1 vin.$654.Metal2 0.000171737f
Cred_2763 VDD.$359.Metal1 vin.$655.Metal2 0.00302004f
Cred_2764 VDD.$359.Metal1 vin.$659.Metal2 0.000541931f
Cred_2765 VDD.$359.Metal1 vin.$661.Metal2 0.000167568f
Cred_2766 VDD.$359.Metal1 vin.$662.Metal2 0.00293567f
Cred_2767 VDD.$359.Metal1 vin.P77.GatPoly 0.0232057f
Cred_2768 VDD.$359.Metal1 vin.P78.GatPoly 0.0247379f
Cred_2769 VDD.$359.Metal1 vin.P79.GatPoly 0.000810552f
Cred_2770 VDD.$359.Metal1 vout.$1044.Metal3 0.162614f
Cred_2771 VDD.$359.Metal1 vout.$1062.Metal3 0.054233f
Cred_2772 VDD.$359.Metal1 vout.P22.pSD 0.115434f
Cred_2773 VDD.$359.Metal1 vout.P24.nSD 0.000325781f
Cred_2774 VDD.$359.Metal1 vout.P24.pSD 0.118403f
Cred_2775 VDD.$38.Metal1 vin 0.00185097f
Cred_2776 VDD.$38.Metal1 vin.$103.GatPoly 1.90435e-05f
Cred_2777 VDD.$38.Metal1 vin.$109.GatPoly 1.30381e-05f
Cred_2778 VDD.$38.Metal1 vin.$113.GatPoly 1.55358e-05f
Cred_2779 VDD.$38.Metal1 vin.$119.GatPoly 1.00809e-05f
Cred_2780 VDD.$38.Metal1 vin.$123.GatPoly 1.20002e-05f
Cred_2781 VDD.$38.Metal1 vin.$129.GatPoly 8.15144e-06f
Cred_2782 VDD.$38.Metal1 vin.$13.GatPoly 0.000258507f
Cred_2783 VDD.$38.Metal1 vin.$133.GatPoly 9.28682e-06f
Cred_2784 VDD.$38.Metal1 vin.$139.GatPoly 6.04835e-06f
Cred_2785 VDD.$38.Metal1 vin.$143.GatPoly 6.77465e-06f
Cred_2786 VDD.$38.Metal1 vin.$149.GatPoly 4.79636e-06f
Cred_2787 VDD.$38.Metal1 vin.$153.GatPoly 5.6844e-06f
Cred_2788 VDD.$38.Metal1 vin.$159.GatPoly 3.70977e-06f
Cred_2789 VDD.$38.Metal1 vin.$163.GatPoly 4.40351e-06f
Cred_2790 VDD.$38.Metal1 vin.$169.GatPoly 2.86923e-06f
Cred_2791 VDD.$38.Metal1 vin.$173.GatPoly 3.40065e-06f
Cred_2792 VDD.$38.Metal1 vin.$179.GatPoly 2.21898e-06f
Cred_2793 VDD.$38.Metal1 vin.$183.GatPoly 2.63371e-06f
Cred_2794 VDD.$38.Metal1 vin.$189.GatPoly 1.7159e-06f
Cred_2795 VDD.$38.Metal1 vin.$19.GatPoly 0.000129884f
Cred_2796 VDD.$38.Metal1 vin.$193.GatPoly 2.03519e-06f
Cred_2797 VDD.$38.Metal1 vin.$199.GatPoly 1.31484e-06f
Cred_2798 VDD.$38.Metal1 vin.$203.GatPoly 1.59373e-06f
Cred_2799 VDD.$38.Metal1 vin.$211.GatPoly 1.38859e-06f
Cred_2800 VDD.$38.Metal1 vin.$215.GatPoly 1.0559e-06f
Cred_2801 VDD.$38.Metal1 vin.$223.GatPoly 1.20129e-06f
Cred_2802 VDD.$38.Metal1 vin.$23.GatPoly 0.000154247f
Cred_2803 VDD.$38.Metal1 vin.$231.GatPoly 8.27686e-07f
Cred_2804 VDD.$38.Metal1 vin.$235.GatPoly 6.31867e-07f
Cred_2805 VDD.$38.Metal1 vin.$243.GatPoly 7.36758e-07f
Cred_2806 VDD.$38.Metal1 vin.$251.GatPoly 5.99363e-07f
Cred_2807 VDD.$38.Metal1 vin.$259.GatPoly 6.02539e-07f
Cred_2808 VDD.$38.Metal1 vin.$271.Metal1 0.0276122f
Cred_2809 VDD.$38.Metal1 vin.$274.Metal1 1.32855e-06f
Cred_2810 VDD.$38.Metal1 vin.$275.Metal1 0.0018589f
Cred_2811 VDD.$38.Metal1 vin.$279.Metal1 0.00250991f
Cred_2812 VDD.$38.Metal1 vin.$285.Metal1 0.00223614f
Cred_2813 VDD.$38.Metal1 vin.$289.Metal1 0.00187365f
Cred_2814 VDD.$38.Metal1 vin.$29.GatPoly 9.95862e-05f
Cred_2815 VDD.$38.Metal1 vin.$297.Metal1 0.00168145f
Cred_2816 VDD.$38.Metal1 vin.$301.Metal1 0.00148267f
Cred_2817 VDD.$38.Metal1 vin.$307.Metal1 0.00133221f
Cred_2818 VDD.$38.Metal1 vin.$311.Metal1 0.0011261f
Cred_2819 VDD.$38.Metal1 vin.$319.Metal1 0.00101386f
Cred_2820 VDD.$38.Metal1 vin.$323.Metal1 0.000871262f
Cred_2821 VDD.$38.Metal1 vin.$329.Metal1 0.000808683f
Cred_2822 VDD.$38.Metal1 vin.$33.GatPoly 0.000117909f
Cred_2823 VDD.$38.Metal1 vin.$333.Metal1 0.000458187f
Cred_2824 VDD.$38.Metal1 vin.$337.Metal1 0.000433962f
Cred_2825 VDD.$38.Metal1 vin.$341.Metal1 0.000395306f
Cred_2826 VDD.$38.Metal1 vin.$345.Metal1 0.000521723f
Cred_2827 VDD.$38.Metal1 vin.$351.Metal1 0.000486741f
Cred_2828 VDD.$38.Metal1 vin.$355.Metal1 0.000283905f
Cred_2829 VDD.$38.Metal1 vin.$359.Metal1 0.000259978f
Cred_2830 VDD.$38.Metal1 vin.$363.Metal1 0.000237346f
Cred_2831 VDD.$38.Metal1 vin.$367.Metal1 0.00031329f
Cred_2832 VDD.$38.Metal1 vin.$373.Metal1 0.000290124f
Cred_2833 VDD.$38.Metal1 vin.$377.Metal1 0.000170746f
Cred_2834 VDD.$38.Metal1 vin.$381.Metal1 0.000156382f
Cred_2835 VDD.$38.Metal1 vin.$385.Metal1 0.000143177f
Cred_2836 VDD.$38.Metal1 vin.$389.Metal1 0.00018768f
Cred_2837 VDD.$38.Metal1 vin.$39.GatPoly 7.7728e-05f
Cred_2838 VDD.$38.Metal1 vin.$395.Metal1 0.000170304f
Cred_2839 VDD.$38.Metal1 vin.$399.Metal1 0.000150016f
Cred_2840 VDD.$38.Metal1 vin.$4.GatPoly 2.7948e-08f
Cred_2841 VDD.$38.Metal1 vin.$407.Metal1 0.000131854f
Cred_2842 VDD.$38.Metal1 vin.$411.Metal1 0.000115565f
Cred_2843 VDD.$38.Metal1 vin.$417.Metal1 0.000100595f
Cred_2844 VDD.$38.Metal1 vin.$421.Metal1 6.28041e-05f
Cred_2845 VDD.$38.Metal1 vin.$425.Metal1 5.73272e-05f
Cred_2846 VDD.$38.Metal1 vin.$429.Metal1 5.25023e-05f
Cred_2847 VDD.$38.Metal1 vin.$43.GatPoly 9.23478e-05f
Cred_2848 VDD.$38.Metal1 vin.$433.Metal1 6.97115e-05f
Cred_2849 VDD.$38.Metal1 vin.$439.Metal1 6.1847e-05f
Cred_2850 VDD.$38.Metal1 vin.$443.Metal1 5.47787e-05f
Cred_2851 VDD.$38.Metal1 vin.$451.Metal1 4.93845e-05f
Cred_2852 VDD.$38.Metal1 vin.$455.Metal1 4.24725e-05f
Cred_2853 VDD.$38.Metal1 vin.$461.Metal1 3.70002e-05f
Cred_2854 VDD.$38.Metal1 vin.$465.Metal1 3.27897e-05f
Cred_2855 VDD.$38.Metal1 vin.$473.Metal1 2.98014e-05f
Cred_2856 VDD.$38.Metal1 vin.$477.Metal1 2.54724e-05f
Cred_2857 VDD.$38.Metal1 vin.$483.Metal1 2.21414e-05f
Cred_2858 VDD.$38.Metal1 vin.$487.Metal1 1.9509e-05f
Cred_2859 VDD.$38.Metal1 vin.$49.GatPoly 5.86648e-05f
Cred_2860 VDD.$38.Metal1 vin.$495.Metal1 2.28096e-05f
Cred_2861 VDD.$38.Metal1 vin.$5.GatPoly 0.00332927f
Cred_2862 VDD.$38.Metal1 vin.$501.Metal1 1.4471e-05f
Cred_2863 VDD.$38.Metal1 vin.$505.Metal1 8.58614e-06f
Cred_2864 VDD.$38.Metal1 vin.$509.Metal1 1.16296e-05f
Cred_2865 VDD.$38.Metal1 vin.$517.Metal1 1.34364e-05f
Cred_2866 VDD.$38.Metal1 vin.$523.Metal1 8.75904e-06f
Cred_2867 VDD.$38.Metal1 vin.$527.Metal1 5.23795e-06f
Cred_2868 VDD.$38.Metal1 vin.$53.GatPoly 6.90458e-05f
Cred_2869 VDD.$38.Metal1 vin.$531.Metal1 7.01868e-06f
Cred_2870 VDD.$38.Metal1 vin.$539.Metal1 7.98737e-06f
Cred_2871 VDD.$38.Metal1 vin.$545.Metal1 5.23714e-06f
Cred_2872 VDD.$38.Metal1 vin.$549.Metal1 1.00083e-05f
Cred_2873 VDD.$38.Metal1 vin.$564.Metal2 5.83641e-05f
Cred_2874 VDD.$38.Metal1 vin.$566.Metal2 0.00459199f
Cred_2875 VDD.$38.Metal1 vin.$569.Metal2 6.4394e-05f
Cred_2876 VDD.$38.Metal1 vin.$573.Metal2 0.00159561f
Cred_2877 VDD.$38.Metal1 vin.$574.Metal2 0.000117675f
Cred_2878 VDD.$38.Metal1 vin.$577.Metal2 0.000214716f
Cred_2879 VDD.$38.Metal1 vin.$579.Metal2 0.000811947f
Cred_2880 VDD.$38.Metal1 vin.$581.Metal2 0.00189315f
Cred_2881 VDD.$38.Metal1 vin.$584.Metal2 0.000273826f
Cred_2882 VDD.$38.Metal1 vin.$588.Metal2 0.00100003f
Cred_2883 VDD.$38.Metal1 vin.$589.Metal2 0.000771956f
Cred_2884 VDD.$38.Metal1 vin.$59.GatPoly 4.65346e-05f
Cred_2885 VDD.$38.Metal1 vin.$593.Metal2 0.00013701f
Cred_2886 VDD.$38.Metal1 vin.$595.Metal2 0.000452466f
Cred_2887 VDD.$38.Metal1 vin.$597.Metal2 0.000811266f
Cred_2888 VDD.$38.Metal1 vin.$600.Metal2 0.000153364f
Cred_2889 VDD.$38.Metal1 vin.$604.Metal2 0.000574944f
Cred_2890 VDD.$38.Metal1 vin.$605.Metal2 0.000463136f
Cred_2891 VDD.$38.Metal1 vin.$609.Metal2 7.63494e-05f
Cred_2892 VDD.$38.Metal1 vin.$611.Metal2 0.000312501f
Cred_2893 VDD.$38.Metal1 vin.$613.Metal2 0.000461586f
Cred_2894 VDD.$38.Metal1 vin.$618.Metal2 0.000155083f
Cred_2895 VDD.$38.Metal1 vin.$620.Metal2 0.000377945f
Cred_2896 VDD.$38.Metal1 vin.$623.Metal2 0.00016499f
Cred_2897 VDD.$38.Metal1 vin.$627.Metal2 0.000213166f
Cred_2898 VDD.$38.Metal1 vin.$629.Metal2 0.000273797f
Cred_2899 VDD.$38.Metal1 vin.$63.GatPoly 5.27421e-05f
Cred_2900 VDD.$38.Metal1 vin.$634.Metal2 9.29116e-05f
Cred_2901 VDD.$38.Metal1 vin.$636.Metal2 0.000227152f
Cred_2902 VDD.$38.Metal1 vin.$639.Metal2 9.6584e-05f
Cred_2903 VDD.$38.Metal1 vin.$643.Metal2 0.000131436f
Cred_2904 VDD.$38.Metal1 vin.$645.Metal2 0.000162862f
Cred_2905 VDD.$38.Metal1 vin.$650.Metal2 5.83916e-05f
Cred_2906 VDD.$38.Metal1 vin.$652.Metal2 0.000136094f
Cred_2907 VDD.$38.Metal1 vin.$655.Metal2 5.77525e-05f
Cred_2908 VDD.$38.Metal1 vin.$659.Metal2 0.000103519f
Cred_2909 VDD.$38.Metal1 vin.$662.Metal2 8.0162e-05f
Cred_2910 VDD.$38.Metal1 vin.$666.Metal2 3.62882e-05f
Cred_2911 VDD.$38.Metal1 vin.$668.Metal2 8.87035e-05f
Cred_2912 VDD.$38.Metal1 vin.$671.Metal2 3.39488e-05f
Cred_2913 VDD.$38.Metal1 vin.$676.Metal2 6.21932e-05f
Cred_2914 VDD.$38.Metal1 vin.$678.Metal2 4.67929e-05f
Cred_2915 VDD.$38.Metal1 vin.$682.Metal2 2.16587e-05f
Cred_2916 VDD.$38.Metal1 vin.$684.Metal2 5.06815e-05f
Cred_2917 VDD.$38.Metal1 vin.$687.Metal2 1.92471e-05f
Cred_2918 VDD.$38.Metal1 vin.$69.GatPoly 3.60185e-05f
Cred_2919 VDD.$38.Metal1 vin.$691.Metal2 3.66808e-05f
Cred_2920 VDD.$38.Metal1 vin.$694.Metal2 2.78592e-05f
Cred_2921 VDD.$38.Metal1 vin.$698.Metal2 1.30554e-05f
Cred_2922 VDD.$38.Metal1 vin.$700.Metal2 3.05381e-05f
Cred_2923 VDD.$38.Metal1 vin.$703.Metal2 1.09506e-05f
Cred_2924 VDD.$38.Metal1 vin.$707.Metal2 2.21834e-05f
Cred_2925 VDD.$38.Metal1 vin.$710.Metal2 1.62487e-05f
Cred_2926 VDD.$38.Metal1 vin.$714.Metal2 8.08976e-06f
Cred_2927 VDD.$38.Metal1 vin.$716.Metal2 1.8401e-05f
Cred_2928 VDD.$38.Metal1 vin.$719.Metal2 6.74586e-06f
Cred_2929 VDD.$38.Metal1 vin.$723.Metal2 1.35014e-05f
Cred_2930 VDD.$38.Metal1 vin.$726.Metal2 8.39533e-06f
Cred_2931 VDD.$38.Metal1 vin.$728.Metal2 1.86103e-06f
Cred_2932 VDD.$38.Metal1 vin.$73.GatPoly 4.28148e-05f
Cred_2933 VDD.$38.Metal1 vin.$732.Metal2 9.97331e-06f
Cred_2934 VDD.$38.Metal1 vin.$733.Metal2 7.794e-06f
Cred_2935 VDD.$38.Metal1 vin.$737.Metal2 1.5802e-06f
Cred_2936 VDD.$38.Metal1 vin.$739.Metal2 8.0988e-06f
Cred_2937 VDD.$38.Metal1 vin.$742.Metal2 4.65974e-06f
Cred_2938 VDD.$38.Metal1 vin.$744.Metal2 1.02355e-06f
Cred_2939 VDD.$38.Metal1 vin.$748.Metal2 5.88362e-06f
Cred_2940 VDD.$38.Metal1 vin.$749.Metal2 4.44931e-06f
Cred_2941 VDD.$38.Metal1 vin.$753.Metal2 1.10733e-06f
Cred_2942 VDD.$38.Metal1 vin.$755.Metal2 4.79822e-06f
Cred_2943 VDD.$38.Metal1 vin.$758.Metal2 2.77432e-06f
Cred_2944 VDD.$38.Metal1 vin.$760.Metal2 6.08935e-07f
Cred_2945 VDD.$38.Metal1 vin.$764.Metal2 3.5033e-06f
Cred_2946 VDD.$38.Metal1 vin.$765.Metal2 2.63949e-06f
Cred_2947 VDD.$38.Metal1 vin.$769.Metal2 2.48338e-06f
Cred_2948 VDD.$38.Metal1 vin.$771.Metal2 2.44106e-06f
Cred_2949 VDD.$38.Metal1 vin.$79.GatPoly 2.78912e-05f
Cred_2950 VDD.$38.Metal1 vin.$83.GatPoly 3.16279e-05f
Cred_2951 VDD.$38.Metal1 vin.$89.GatPoly 2.16138e-05f
Cred_2952 VDD.$38.Metal1 vin.$93.GatPoly 2.57193e-05f
Cred_2953 VDD.$38.Metal1 vin.$99.GatPoly 1.67698e-05f
Cred_2954 VDD.$38.Metal1 vin.P0.GatPoly 3.58692e-09f
Cred_2955 VDD.$38.Metal1 vin.P100.GatPoly 4.54998e-09f
Cred_2956 VDD.$38.Metal1 vin.P102.GatPoly 2.00859e-08f
Cred_2957 VDD.$38.Metal1 vin.P103.GatPoly 2.69806e-09f
Cred_2958 VDD.$38.Metal1 vin.P104.GatPoly 2.69806e-09f
Cred_2959 VDD.$38.Metal1 vin.P105.GatPoly 1.32506e-08f
Cred_2960 VDD.$38.Metal1 vin.P107.GatPoly 2.03266e-08f
Cred_2961 VDD.$38.Metal1 vin.P54.GatPoly 0.0227968f
Cred_2962 VDD.$38.Metal1 vin.P56.GatPoly 7.1597e-06f
Cred_2963 VDD.$38.Metal1 vin.P57.GatPoly 8.54906e-07f
Cred_2964 VDD.$38.Metal1 vin.P59.GatPoly 6.61322e-07f
Cred_2965 VDD.$38.Metal1 vin.P61.GatPoly 5.116e-07f
Cred_2966 VDD.$38.Metal1 vin.P63.GatPoly 3.95809e-07f
Cred_2967 VDD.$38.Metal1 vin.P65.GatPoly 3.06268e-07f
Cred_2968 VDD.$38.Metal1 vin.P67.GatPoly 2.37041e-07f
Cred_2969 VDD.$38.Metal1 vin.P69.GatPoly 1.83534e-07f
Cred_2970 VDD.$38.Metal1 vin.P71.GatPoly 1.42201e-07f
Cred_2971 VDD.$38.Metal1 vin.P73.GatPoly 1.10298e-07f
Cred_2972 VDD.$38.Metal1 vin.P75.GatPoly 8.57108e-08f
Cred_2973 VDD.$38.Metal1 vin.P77.GatPoly 6.68082e-08f
Cred_2974 VDD.$38.Metal1 vin.P79.GatPoly 5.23364e-08f
Cred_2975 VDD.$38.Metal1 vin.P81.GatPoly 4.08545e-08f
Cred_2976 VDD.$38.Metal1 vin.P83.GatPoly 3.16e-08f
Cred_2977 VDD.$38.Metal1 vin.P85.GatPoly 2.44414e-08f
Cred_2978 VDD.$38.Metal1 vin.P87.GatPoly 1.89037e-08f
Cred_2979 VDD.$38.Metal1 vin.P89.GatPoly 1.46199e-08f
Cred_2980 VDD.$38.Metal1 vin.P91.GatPoly 1.13056e-08f
Cred_2981 VDD.$38.Metal1 vin.P93.GatPoly 8.74121e-09f
Cred_2982 VDD.$38.Metal1 vin.P95.GatPoly 7.629e-09f
Cred_2983 VDD.$38.Metal1 vin.P96.GatPoly 7.629e-09f
Cred_2984 VDD.$38.Metal1 vin.P98.GatPoly 3.29043e-08f
Cred_2985 VDD.$38.Metal1 vin.P99.GatPoly 4.54998e-09f
Cred_2986 VDD.$38.Metal1 vout 1.00718e-06f
Cred_2987 VDD.$38.Metal1 vout.$1008.Metal3 0.000199315f
Cred_2988 VDD.$38.Metal1 vout.$1026.Metal3 0.000120198f
Cred_2989 VDD.$38.Metal1 vout.$1044.Metal3 7.41827e-05f
Cred_2990 VDD.$38.Metal1 vout.$1062.Metal3 4.62446e-05f
Cred_2991 VDD.$38.Metal1 vout.$1080.Metal3 2.69792e-05f
Cred_2992 VDD.$38.Metal1 vout.$1098.Metal3 1.54966e-05f
Cred_2993 VDD.$38.Metal1 vout.$1116.Metal3 9.20806e-06f
Cred_2994 VDD.$38.Metal1 vout.$1134.Metal3 5.40042e-06f
Cred_2995 VDD.$38.Metal1 vout.$1152.Metal3 3.14498e-06f
Cred_2996 VDD.$38.Metal1 vout.$1170.Metal3 1.53565e-06f
Cred_2997 VDD.$38.Metal1 vout.$954.Metal3 0.0850421f
Cred_2998 VDD.$38.Metal1 vout.$972.Metal3 0.000537368f
Cred_2999 VDD.$38.Metal1 vout.$990.Metal3 0.000325509f
Cred_3000 VDD.$38.Metal1 vout.P0.nSD 0.000380734f
Cred_3001 VDD.$38.Metal1 vout.P0.pSD 0.13098f
Cred_3002 VDD.$38.Metal1 vout.P12.nSD 3.88666e-07f
Cred_3003 VDD.$38.Metal1 vout.P12.pSD 1.05432e-06f
Cred_3004 VDD.$38.Metal1 vout.P16.nSD 2.35063e-07f
Cred_3005 VDD.$38.Metal1 vout.P16.pSD 6.37648e-07f
Cred_3006 VDD.$38.Metal1 vout.P20.nSD 1.42666e-07f
Cred_3007 VDD.$38.Metal1 vout.P20.pSD 3.87006e-07f
Cred_3008 VDD.$38.Metal1 vout.P24.nSD 9.50564e-08f
Cred_3009 VDD.$38.Metal1 vout.P24.pSD 2.57857e-07f
Cred_3010 VDD.$38.Metal1 vout.P28.nSD 5.77235e-08f
Cred_3011 VDD.$38.Metal1 vout.P28.pSD 1.56585e-07f
Cred_3012 VDD.$38.Metal1 vout.P32.nSD 3.08701e-08f
Cred_3013 VDD.$38.Metal1 vout.P32.pSD 8.37404e-08f
Cred_3014 VDD.$38.Metal1 vout.P36.nSD 1.82689e-08f
Cred_3015 VDD.$38.Metal1 vout.P36.pSD 4.95575e-08f
Cred_3016 VDD.$38.Metal1 vout.P4.nSD 1.02256e-06f
Cred_3017 VDD.$38.Metal1 vout.P4.pSD 2.77387e-06f
Cred_3018 VDD.$38.Metal1 vout.P40.nSD 1.07632e-08f
Cred_3019 VDD.$38.Metal1 vout.P40.pSD 2.9197e-08f
Cred_3020 VDD.$38.Metal1 vout.P44.nSD 5.97722e-09f
Cred_3021 VDD.$38.Metal1 vout.P44.pSD 1.62142e-08f
Cred_3022 VDD.$38.Metal1 vout.P48.nSD 3.56148e-09f
Cred_3023 VDD.$38.Metal1 vout.P48.pSD 9.66112e-09f
Cred_3024 VDD.$38.Metal1 vout.P52.pSD 2.53652e-09f
Cred_3025 VDD.$38.Metal1 vout.P8.nSD 6.11959e-07f
Cred_3026 VDD.$38.Metal1 vout.P8.pSD 1.66004e-06f
Cred_3027 VDD.$38.Metal1 VSS.$14.Metal1 0.00199531f
Cred_3028 VDD.$38.Metal1 VSS.$29.Metal1 0.0038809f
Cred_3029 VDD.$38.Metal1 VSS.$31.Metal1 4.65909e-09f
Cred_3030 VDD.$38.Metal1 VSS.$500.Metal1 3.49164e-07f
Cred_3031 VDD.$38.Metal1 VSS.$520.Metal1 2.48073e-05f
Cred_3032 VDD.$38.Metal1 VSS.$531.Metal2 0.00100957f
Cred_3033 VDD.$38.Metal1 VSS.$540.Metal2 1.27258e-06f
Cred_3034 VDD.$38.Metal1 VSS.$904.Metal2 5.11152e-08f
Cred_3035 VDD.$38.Metal1 VSS.$916.Metal3 9.05626e-05f
Cred_3036 VDD.$38.Metal1 VSS.P0.nSD 5.30558e-06f
Cred_3037 VDD.$38.Metal1 VSS.P0.pSD 0.0143841f
Cred_3038 VDD.$38.Metal1 VSS.P1.nSD 5.30558e-06f
Cred_3039 VDD.$38.Metal1 VSS.P55.nSD 3.6324e-09f
Cred_3040 VDD.$38.Metal1 VSS.P57.nSD 3.6324e-09f
Cred_3041 VDD.$384.Metal1 vin.$122.GatPoly 6.20474e-09f
Cred_3042 VDD.$384.Metal1 vin.$123.GatPoly 0.00395146f
Cred_3043 VDD.$384.Metal1 vin.$129.GatPoly 0.00534877f
Cred_3044 VDD.$384.Metal1 vin.$398.Metal1 5.20021e-07f
Cred_3045 VDD.$384.Metal1 vin.$399.Metal1 0.000400395f
Cred_3046 VDD.$384.Metal1 vin.$406.Metal1 2.88112e-06f
Cred_3047 VDD.$384.Metal1 vin.$407.Metal1 0.010937f
Cred_3048 VDD.$384.Metal1 vin.$411.Metal1 0.000672992f
Cred_3049 VDD.$384.Metal1 vin.$659.Metal2 0.000347021f
Cred_3050 VDD.$384.Metal1 vin.$661.Metal2 0.000171122f
Cred_3051 VDD.$384.Metal1 vin.$662.Metal2 0.00316075f
Cred_3052 VDD.$384.Metal1 vin.$665.Metal2 0.000171117f
Cred_3053 VDD.$384.Metal1 vin.$666.Metal2 0.00316164f
Cred_3054 VDD.$384.Metal1 vin.$668.Metal2 0.000437928f
Cred_3055 VDD.$384.Metal1 vin.P78.GatPoly 0.000859629f
Cred_3056 VDD.$384.Metal1 vin.P79.GatPoly 0.0239602f
Cred_3057 VDD.$384.Metal1 vin.P80.GatPoly 0.0238728f
Cred_3058 VDD.$384.Metal1 vout.$1044.Metal3 0.0548714f
Cred_3059 VDD.$384.Metal1 vout.$1062.Metal3 0.161593f
Cred_3060 VDD.$384.Metal1 vout.P24.nSD 0.000329616f
Cred_3061 VDD.$384.Metal1 vout.P24.pSD 0.120388f
Cred_3062 VDD.$384.Metal1 vout.P26.pSD 0.113228f
Cred_3063 VDD.$409.Metal1 vin.$133.GatPoly 0.00395062f
Cred_3064 VDD.$409.Metal1 vin.$139.GatPoly 0.00534877f
Cred_3065 VDD.$409.Metal1 vin.$411.Metal1 0.000331888f
Cred_3066 VDD.$409.Metal1 vin.$416.Metal1 2.34863e-06f
Cred_3067 VDD.$409.Metal1 vin.$417.Metal1 0.0108674f
Cred_3068 VDD.$409.Metal1 vin.$420.Metal1 1.04939e-06f
Cred_3069 VDD.$409.Metal1 vin.$421.Metal1 0.000812067f
Cred_3070 VDD.$409.Metal1 vin.$668.Metal2 0.000437928f
Cred_3071 VDD.$409.Metal1 vin.$670.Metal2 0.00017024f
Cred_3072 VDD.$409.Metal1 vin.$671.Metal2 0.00315426f
Cred_3073 VDD.$409.Metal1 vin.$674.Metal2 0.00017024f
Cred_3074 VDD.$409.Metal1 vin.$676.Metal2 0.000371345f
Cred_3075 VDD.$409.Metal1 vin.$678.Metal2 0.00314365f
Cred_3076 VDD.$409.Metal1 vin.P81.GatPoly 0.0230506f
Cred_3077 VDD.$409.Metal1 vin.P82.GatPoly 0.0247824f
Cred_3078 VDD.$409.Metal1 vin.P83.GatPoly 0.000859629f
Cred_3079 VDD.$409.Metal1 vout.$1062.Metal3 0.162431f
Cred_3080 VDD.$409.Metal1 vout.$1080.Metal3 0.0542815f
Cred_3081 VDD.$409.Metal1 vout.P26.pSD 0.115058f
Cred_3082 VDD.$409.Metal1 vout.P28.nSD 0.000326072f
Cred_3083 VDD.$409.Metal1 vout.P28.pSD 0.118565f
Cred_3084 VDD.$42.Metal1 vin.P54.GatPoly 0.0289877f
Cred_3085 VDD.$42.Metal1 vin.P55.GatPoly 0.00441274f
Cred_3086 VDD.$42.Metal1 vin.P56.GatPoly 0.00276039f
Cred_3087 VDD.$42.Metal1 vin.P57.GatPoly 0.00200836f
Cred_3088 VDD.$42.Metal1 vin.P58.GatPoly 0.00157836f
Cred_3089 VDD.$42.Metal1 vin.P59.GatPoly 0.00130002f
Cred_3090 VDD.$42.Metal1 vin.P60.GatPoly 0.00110513f
Cred_3091 VDD.$42.Metal1 vin.P61.GatPoly 0.00096106f
Cred_3092 VDD.$42.Metal1 vout.$954.Metal3 0.00431659f
Cred_3093 VDD.$42.Metal1 vout.P0.nSD 1.946e-05f
Cred_3094 VDD.$42.Metal1 vout.P0.pSD 0.00725145f
Cred_3095 VDD.$434.Metal1 vin.$143.GatPoly 0.00394693f
Cred_3096 VDD.$434.Metal1 vin.$149.GatPoly 0.00534911f
Cred_3097 VDD.$434.Metal1 vin.$425.Metal1 0.000802516f
Cred_3098 VDD.$434.Metal1 vin.$429.Metal1 0.010541f
Cred_3099 VDD.$434.Metal1 vin.$433.Metal1 0.00074395f
Cred_3100 VDD.$434.Metal1 vin.$676.Metal2 0.000502715f
Cred_3101 VDD.$434.Metal1 vin.$678.Metal2 0.00295974f
Cred_3102 VDD.$434.Metal1 vin.$679.Metal2 0.00034706f
Cred_3103 VDD.$434.Metal1 vin.$682.Metal2 0.00301409f
Cred_3104 VDD.$434.Metal1 vin.$684.Metal2 0.000391531f
Cred_3105 VDD.$434.Metal1 vin.P82.GatPoly 0.000810552f
Cred_3106 VDD.$434.Metal1 vin.P83.GatPoly 0.0239157f
Cred_3107 VDD.$434.Metal1 vin.P84.GatPoly 0.0240279f
Cred_3108 VDD.$434.Metal1 vout.$1062.Metal3 0.054823f
Cred_3109 VDD.$434.Metal1 vout.$1080.Metal3 0.161796f
Cred_3110 VDD.$434.Metal1 vout.P28.nSD 0.000329325f
Cred_3111 VDD.$434.Metal1 vout.P28.pSD 0.120226f
Cred_3112 VDD.$434.Metal1 vout.P30.pSD 0.113605f
Cred_3113 VDD.$44.Metal1 vin.$271.Metal1 0.000148037f
Cred_3114 VDD.$44.Metal1 vin.$5.GatPoly 8.95926e-07f
Cred_3115 VDD.$44.Metal1 vin.$566.Metal2 4.82531e-06f
Cred_3116 VDD.$44.Metal1 vin.P54.GatPoly 0.000426348f
Cred_3117 VDD.$455.Metal1 vin.$153.GatPoly 2.06026e-06f
Cred_3118 VDD.$455.Metal1 vin.$429.Metal1 2.62561e-05f
Cred_3119 VDD.$455.Metal1 vin.$433.Metal1 0.000504352f
Cred_3120 VDD.$455.Metal1 vin.$439.Metal1 0.000226779f
Cred_3121 VDD.$455.Metal1 vin.$682.Metal2 4.81362e-07f
Cred_3122 VDD.$455.Metal1 vin.$687.Metal2 3.89363e-06f
Cred_3123 VDD.$455.Metal1 vin.P84.GatPoly 0.00117103f
Cred_3124 VDD.$455.Metal1 vin.P85.GatPoly 0.00110849f
Cred_3125 VDD.$455.Metal1 vout.$1080.Metal3 0.00582611f
Cred_3126 VDD.$455.Metal1 vout.P30.pSD 0.00919101f
Cred_3127 VDD.$461.Metal1 vin.$153.GatPoly 0.00395007f
Cred_3128 VDD.$461.Metal1 vin.$159.GatPoly 0.00534841f
Cred_3129 VDD.$461.Metal1 vin.$433.Metal1 0.000308227f
Cred_3130 VDD.$461.Metal1 vin.$439.Metal1 0.0108484f
Cred_3131 VDD.$461.Metal1 vin.$443.Metal1 0.000804989f
Cred_3132 VDD.$461.Metal1 vin.$684.Metal2 0.000421391f
Cred_3133 VDD.$461.Metal1 vin.$687.Metal2 0.0033572f
Cred_3134 VDD.$461.Metal1 vin.$688.Metal2 0.00032466f
Cred_3135 VDD.$461.Metal1 vin.$691.Metal2 0.000494908f
Cred_3136 VDD.$461.Metal1 vin.$694.Metal2 0.00284736f
Cred_3137 VDD.$461.Metal1 vin.P85.GatPoly 0.0230279f
Cred_3138 VDD.$461.Metal1 vin.P86.GatPoly 0.0247607f
Cred_3139 VDD.$461.Metal1 vin.P87.GatPoly 0.000848915f
Cred_3140 VDD.$461.Metal1 vout.$1080.Metal3 0.162377f
Cred_3141 VDD.$461.Metal1 vout.$1098.Metal3 0.0542706f
Cred_3142 VDD.$461.Metal1 vout.P30.pSD 0.115044f
Cred_3143 VDD.$461.Metal1 vout.P32.nSD 0.000326006f
Cred_3144 VDD.$461.Metal1 vout.P32.pSD 0.118553f
Cred_3145 VDD.$486.Metal1 vin.$163.GatPoly 0.00395173f
Cred_3146 VDD.$486.Metal1 vin.$169.GatPoly 0.00534941f
Cred_3147 VDD.$486.Metal1 vin.$443.Metal1 0.000384164f
Cred_3148 VDD.$486.Metal1 vin.$446.Metal1 8.58025e-07f
Cred_3149 VDD.$486.Metal1 vin.$450.Metal1 2.57408e-06f
Cred_3150 VDD.$486.Metal1 vin.$451.Metal1 0.0109411f
Cred_3151 VDD.$486.Metal1 vin.$455.Metal1 0.000762919f
Cred_3152 VDD.$486.Metal1 vin.$691.Metal2 0.000421761f
Cred_3153 VDD.$486.Metal1 vin.$693.Metal2 0.00017186f
Cred_3154 VDD.$486.Metal1 vin.$694.Metal2 0.00301098f
Cred_3155 VDD.$486.Metal1 vin.$697.Metal2 0.00017186f
Cred_3156 VDD.$486.Metal1 vin.$698.Metal2 0.00301116f
Cred_3157 VDD.$486.Metal1 vin.$700.Metal2 0.000421761f
Cred_3158 VDD.$486.Metal1 vin.P86.GatPoly 0.000821277f
Cred_3159 VDD.$486.Metal1 vin.P87.GatPoly 0.0239271f
Cred_3160 VDD.$486.Metal1 vin.P88.GatPoly 0.0240307f
Cred_3161 VDD.$486.Metal1 vout.$1080.Metal3 0.0548327f
Cred_3162 VDD.$486.Metal1 vout.$1098.Metal3 0.161934f
Cred_3163 VDD.$486.Metal1 vout.P32.nSD 0.000329383f
Cred_3164 VDD.$486.Metal1 vout.P32.pSD 0.120237f
Cred_3165 VDD.$486.Metal1 vout.P34.pSD 0.113788f
Cred_3166 VDD.$507.Metal1 vin.$173.GatPoly 1.96989e-06f
Cred_3167 VDD.$507.Metal1 vin.$451.Metal1 1.52332e-05f
Cred_3168 VDD.$507.Metal1 vin.$455.Metal1 0.000495965f
Cred_3169 VDD.$507.Metal1 vin.$461.Metal1 0.00023033f
Cred_3170 VDD.$507.Metal1 vin.$698.Metal2 2.8814e-07f
Cred_3171 VDD.$507.Metal1 vin.$703.Metal2 3.82056e-06f
Cred_3172 VDD.$507.Metal1 vin.P88.GatPoly 0.00117824f
Cred_3173 VDD.$507.Metal1 vin.P89.GatPoly 0.00113125f
Cred_3174 VDD.$507.Metal1 vout.$1098.Metal3 0.00571629f
Cred_3175 VDD.$507.Metal1 vout.P34.pSD 0.00902076f
Cred_3176 VDD.$513.Metal1 vin.$173.GatPoly 0.00394951f
Cred_3177 VDD.$513.Metal1 vin.$179.GatPoly 0.00534801f
Cred_3178 VDD.$513.Metal1 vin.$455.Metal1 0.000285501f
Cred_3179 VDD.$513.Metal1 vin.$461.Metal1 0.0108444f
Cred_3180 VDD.$513.Metal1 vin.$465.Metal1 0.000783933f
Cred_3181 VDD.$513.Metal1 vin.$700.Metal2 0.000421242f
Cred_3182 VDD.$513.Metal1 vin.$703.Metal2 0.00365191f
Cred_3183 VDD.$513.Metal1 vin.$704.Metal2 0.000310576f
Cred_3184 VDD.$513.Metal1 vin.$707.Metal2 0.000536189f
Cred_3185 VDD.$513.Metal1 vin.$710.Metal2 0.00267115f
Cred_3186 VDD.$513.Metal1 vin.P89.GatPoly 0.0230042f
Cred_3187 VDD.$513.Metal1 vin.P90.GatPoly 0.0247347f
Cred_3188 VDD.$513.Metal1 vin.P91.GatPoly 0.000838207f
Cred_3189 VDD.$513.Metal1 vout.$1098.Metal3 0.162135f
Cred_3190 VDD.$513.Metal1 vout.$1116.Metal3 0.0542588f
Cred_3191 VDD.$513.Metal1 vout.P34.pSD 0.115016f
Cred_3192 VDD.$513.Metal1 vout.P36.nSD 0.000325935f
Cred_3193 VDD.$513.Metal1 vout.P36.pSD 0.118539f
Cred_3194 VDD.$538.Metal1 vin.$183.GatPoly 0.00395171f
Cred_3195 VDD.$538.Metal1 vin.$189.GatPoly 0.00534967f
Cred_3196 VDD.$538.Metal1 vin.$465.Metal1 0.000365653f
Cred_3197 VDD.$538.Metal1 vin.$468.Metal1 7.57488e-07f
Cred_3198 VDD.$538.Metal1 vin.$472.Metal1 2.67646e-06f
Cred_3199 VDD.$538.Metal1 vin.$473.Metal1 0.0107547f
Cred_3200 VDD.$538.Metal1 vin.$477.Metal1 0.000769363f
Cred_3201 VDD.$538.Metal1 vin.$707.Metal2 0.000420127f
Cred_3202 VDD.$538.Metal1 vin.$709.Metal2 0.0001719f
Cred_3203 VDD.$538.Metal1 vin.$710.Metal2 0.00301305f
Cred_3204 VDD.$538.Metal1 vin.$713.Metal2 0.0001719f
Cred_3205 VDD.$538.Metal1 vin.$714.Metal2 0.00301283f
Cred_3206 VDD.$538.Metal1 vin.$716.Metal2 0.000420571f
Cred_3207 VDD.$538.Metal1 vin.P90.GatPoly 0.000832009f
Cred_3208 VDD.$538.Metal1 vin.P91.GatPoly 0.0239327f
Cred_3209 VDD.$538.Metal1 vin.P92.GatPoly 0.0240328f
Cred_3210 VDD.$538.Metal1 vout.$1098.Metal3 0.054842f
Cred_3211 VDD.$538.Metal1 vout.$1116.Metal3 0.162065f
Cred_3212 VDD.$538.Metal1 vout.P36.nSD 0.000329439f
Cred_3213 VDD.$538.Metal1 vout.P36.pSD 0.120246f
Cred_3214 VDD.$538.Metal1 vout.P38.pSD 0.113964f
Cred_3215 VDD.$559.Metal1 vin.$193.GatPoly 1.88014e-06f
Cred_3216 VDD.$559.Metal1 vin.$473.Metal1 4.83631e-06f
Cred_3217 VDD.$559.Metal1 vin.$477.Metal1 0.000482387f
Cred_3218 VDD.$559.Metal1 vin.$483.Metal1 0.000233656f
Cred_3219 VDD.$559.Metal1 vin.$714.Metal2 9.42953e-08f
Cred_3220 VDD.$559.Metal1 vin.$719.Metal2 3.73974e-06f
Cred_3221 VDD.$559.Metal1 vin.P92.GatPoly 0.00117654f
Cred_3222 VDD.$559.Metal1 vin.P93.GatPoly 0.00115495f
Cred_3223 VDD.$559.Metal1 vout.$1116.Metal3 0.00561053f
Cred_3224 VDD.$559.Metal1 vout.P38.pSD 0.00885901f
Cred_3225 VDD.$565.Metal1 vin.$193.GatPoly 0.00394893f
Cred_3226 VDD.$565.Metal1 vin.$199.GatPoly 0.00534758f
Cred_3227 VDD.$565.Metal1 vin.$203.GatPoly 1.03657e-06f
Cred_3228 VDD.$565.Metal1 vin.$477.Metal1 0.000263711f
Cred_3229 VDD.$565.Metal1 vin.$483.Metal1 0.010854f
Cred_3230 VDD.$565.Metal1 vin.$487.Metal1 0.000835191f
Cred_3231 VDD.$565.Metal1 vin.$495.Metal1 8.70384e-05f
Cred_3232 VDD.$565.Metal1 vin.$716.Metal2 0.000380979f
Cred_3233 VDD.$565.Metal1 vin.$719.Metal2 0.00379421f
Cred_3234 VDD.$565.Metal1 vin.$720.Metal2 0.000289119f
Cred_3235 VDD.$565.Metal1 vin.$723.Metal2 0.000691309f
Cred_3236 VDD.$565.Metal1 vin.$726.Metal2 0.00243179f
Cred_3237 VDD.$565.Metal1 vin.$728.Metal2 3.29272e-07f
Cred_3238 VDD.$565.Metal1 vin.P93.GatPoly 0.0229795f
Cred_3239 VDD.$565.Metal1 vin.P94.GatPoly 0.0247046f
Cred_3240 VDD.$565.Metal1 vin.P95.GatPoly 0.000827505f
Cred_3241 VDD.$565.Metal1 vout.$1116.Metal3 0.162088f
Cred_3242 VDD.$565.Metal1 vout.$1134.Metal3 0.0542459f
Cred_3243 VDD.$565.Metal1 vout.P38.pSD 0.115f
Cred_3244 VDD.$565.Metal1 vout.P40.nSD 0.000325858f
Cred_3245 VDD.$565.Metal1 vout.P40.pSD 0.118524f
Cred_3246 VDD.$590.Metal1 vin.$202.GatPoly 3.86125e-09f
Cred_3247 VDD.$590.Metal1 vin.$203.GatPoly 0.00446611f
Cred_3248 VDD.$590.Metal1 vin.$211.GatPoly 0.00446178f
Cred_3249 VDD.$590.Metal1 vin.$486.Metal1 3.23679e-07f
Cred_3250 VDD.$590.Metal1 vin.$487.Metal1 0.000742709f
Cred_3251 VDD.$590.Metal1 vin.$494.Metal1 3.10319e-06f
Cred_3252 VDD.$590.Metal1 vin.$495.Metal1 0.0117806f
Cred_3253 VDD.$590.Metal1 vin.$501.Metal1 0.000381422f
Cred_3254 VDD.$590.Metal1 vin.$723.Metal2 0.000324398f
Cred_3255 VDD.$590.Metal1 vin.$725.Metal2 0.000171939f
Cred_3256 VDD.$590.Metal1 vin.$726.Metal2 8.86142e-06f
Cred_3257 VDD.$590.Metal1 vin.$728.Metal2 0.00618429f
Cred_3258 VDD.$590.Metal1 vin.$729.Metal2 0.000171935f
Cred_3259 VDD.$590.Metal1 vin.$732.Metal2 0.000415744f
Cred_3260 VDD.$590.Metal1 vin.$733.Metal2 8.54696e-06f
Cred_3261 VDD.$590.Metal1 vin.P94.GatPoly 0.000842747f
Cred_3262 VDD.$590.Metal1 vin.P95.GatPoly 0.0239429f
Cred_3263 VDD.$590.Metal1 vin.P96.GatPoly 0.0241325f
Cred_3264 VDD.$590.Metal1 vout.$1116.Metal3 0.0548512f
Cred_3265 VDD.$590.Metal1 vout.$1134.Metal3 0.16219f
Cred_3266 VDD.$590.Metal1 vout.P40.nSD 0.000329494f
Cred_3267 VDD.$590.Metal1 vout.P40.pSD 0.120254f
Cred_3268 VDD.$590.Metal1 vout.P42.pSD 0.114133f
Cred_3269 VDD.$611.Metal1 vin.$211.GatPoly 1.85857e-06f
Cred_3270 VDD.$611.Metal1 vin.$495.Metal1 0.000156538f
Cred_3271 VDD.$611.Metal1 vin.$501.Metal1 0.000461791f
Cred_3272 VDD.$611.Metal1 vin.$505.Metal1 8.64051e-05f
Cred_3273 VDD.$611.Metal1 vin.$728.Metal2 8.70555e-07f
Cred_3274 VDD.$611.Metal1 vin.$733.Metal2 2.99117e-06f
Cred_3275 VDD.$611.Metal1 vin.$737.Metal2 4.94763e-07f
Cred_3276 VDD.$611.Metal1 vin.P96.GatPoly 0.00117488f
Cred_3277 VDD.$611.Metal1 vin.P97.GatPoly 0.00117963f
Cred_3278 VDD.$611.Metal1 vout.$1134.Metal3 0.0055086f
Cred_3279 VDD.$611.Metal1 vout.P42.pSD 0.00870532f
Cred_3280 VDD.$617.Metal1 vin.$215.GatPoly 0.00615287f
Cred_3281 VDD.$617.Metal1 vin.$223.GatPoly 0.00176252f
Cred_3282 VDD.$617.Metal1 vin.$501.Metal1 0.000499877f
Cred_3283 VDD.$617.Metal1 vin.$505.Metal1 0.0113455f
Cred_3284 VDD.$617.Metal1 vin.$509.Metal1 0.00169849f
Cred_3285 VDD.$617.Metal1 vin.$517.Metal1 9.0003e-05f
Cred_3286 VDD.$617.Metal1 vin.$732.Metal2 0.000450975f
Cred_3287 VDD.$617.Metal1 vin.$733.Metal2 0.000901787f
Cred_3288 VDD.$617.Metal1 vin.$736.Metal2 0.000287278f
Cred_3289 VDD.$617.Metal1 vin.$737.Metal2 0.00560439f
Cred_3290 VDD.$617.Metal1 vin.$739.Metal2 0.000390844f
Cred_3291 VDD.$617.Metal1 vin.$742.Metal2 1.12408e-06f
Cred_3292 VDD.$617.Metal1 vin.$744.Metal2 2.88105e-07f
Cred_3293 VDD.$617.Metal1 vin.P97.GatPoly 0.0228671f
Cred_3294 VDD.$617.Metal1 vin.P98.GatPoly 0.0248843f
Cred_3295 VDD.$617.Metal1 vin.P99.GatPoly 0.000816809f
Cred_3296 VDD.$617.Metal1 vout.$1134.Metal3 0.162039f
Cred_3297 VDD.$617.Metal1 vout.$1152.Metal3 0.054232f
Cred_3298 VDD.$617.Metal1 vout.P42.pSD 0.114984f
Cred_3299 VDD.$617.Metal1 vout.P44.nSD 0.000325775f
Cred_3300 VDD.$617.Metal1 vout.P44.pSD 0.118509f
Cred_3301 VDD.$64.Metal1 vin.$271.Metal1 0.000922428f
Cred_3302 VDD.$64.Metal1 vin.$5.GatPoly 5.58248e-06f
Cred_3303 VDD.$64.Metal1 vin.$566.Metal2 4.2325e-05f
Cred_3304 VDD.$64.Metal1 vin.P54.GatPoly 0.00377508f
Cred_3305 VDD.$64.Metal1 vin.P55.GatPoly 0.00129602f
Cred_3306 VDD.$64.Metal1 vout.$954.Metal3 0.00384457f
Cred_3307 VDD.$64.Metal1 vout.P0.nSD 1.7332e-05f
Cred_3308 VDD.$64.Metal1 vout.P0.pSD 0.00589566f
Cred_3309 VDD.$642.Metal1 vin.$222.GatPoly 3.26817e-09f
Cred_3310 VDD.$642.Metal1 vin.$223.GatPoly 0.00446606f
Cred_3311 VDD.$642.Metal1 vin.$231.GatPoly 0.00446198f
Cred_3312 VDD.$642.Metal1 vin.$508.Metal1 2.73999e-07f
Cred_3313 VDD.$642.Metal1 vin.$509.Metal1 0.000724625f
Cred_3314 VDD.$642.Metal1 vin.$516.Metal1 3.15612e-06f
Cred_3315 VDD.$642.Metal1 vin.$517.Metal1 0.0118312f
Cred_3316 VDD.$642.Metal1 vin.$523.Metal1 0.000384178f
Cred_3317 VDD.$642.Metal1 vin.$739.Metal2 0.000452164f
Cred_3318 VDD.$642.Metal1 vin.$741.Metal2 0.000171967f
Cred_3319 VDD.$642.Metal1 vin.$742.Metal2 9.0674e-06f
Cred_3320 VDD.$642.Metal1 vin.$744.Metal2 0.00608034f
Cred_3321 VDD.$642.Metal1 vin.$745.Metal2 0.000171964f
Cred_3322 VDD.$642.Metal1 vin.$748.Metal2 0.000391875f
Cred_3323 VDD.$642.Metal1 vin.$749.Metal2 8.5536e-06f
Cred_3324 VDD.$642.Metal1 vin.P100.GatPoly 0.0241344f
Cred_3325 VDD.$642.Metal1 vin.P98.GatPoly 0.000853491f
Cred_3326 VDD.$642.Metal1 vin.P99.GatPoly 0.0239346f
Cred_3327 VDD.$642.Metal1 vout.$1134.Metal3 0.0548601f
Cred_3328 VDD.$642.Metal1 vout.$1152.Metal3 0.162308f
Cred_3329 VDD.$642.Metal1 vout.P44.nSD 0.000329547f
Cred_3330 VDD.$642.Metal1 vout.P44.pSD 0.120261f
Cred_3331 VDD.$642.Metal1 vout.P46.pSD 0.114295f
Cred_3332 VDD.$663.Metal1 vin.$231.GatPoly 1.82585e-06f
Cred_3333 VDD.$663.Metal1 vin.$517.Metal1 0.000153782f
Cred_3334 VDD.$663.Metal1 vin.$523.Metal1 0.000153654f
Cred_3335 VDD.$663.Metal1 vin.$744.Metal2 7.92977e-07f
Cred_3336 VDD.$663.Metal1 vin.$749.Metal2 2.09755e-06f
Cred_3337 VDD.$663.Metal1 vin.P100.GatPoly 0.00117326f
Cred_3338 VDD.$663.Metal1 vin.P101.GatPoly 0.00120537f
Cred_3339 VDD.$663.Metal1 vout.$1152.Metal3 0.00541029f
Cred_3340 VDD.$663.Metal1 vout.P46.pSD 0.00855929f
Cred_3341 VDD.$669.Metal1 vin.$235.GatPoly 0.00635242f
Cred_3342 VDD.$669.Metal1 vin.$243.GatPoly 0.00176239f
Cred_3343 VDD.$669.Metal1 vin.$523.Metal1 9.91803e-06f
Cred_3344 VDD.$669.Metal1 vin.$527.Metal1 0.0111807f
Cred_3345 VDD.$669.Metal1 vin.$531.Metal1 0.0016366f
Cred_3346 VDD.$669.Metal1 vin.$539.Metal1 9.29683e-05f
Cred_3347 VDD.$669.Metal1 vin.$748.Metal2 0.000420724f
Cred_3348 VDD.$669.Metal1 vin.$749.Metal2 0.00106469f
Cred_3349 VDD.$669.Metal1 vin.$752.Metal2 0.000267337f
Cred_3350 VDD.$669.Metal1 vin.$753.Metal2 0.00544941f
Cred_3351 VDD.$669.Metal1 vin.$755.Metal2 0.000420724f
Cred_3352 VDD.$669.Metal1 vin.$758.Metal2 1.21483e-06f
Cred_3353 VDD.$669.Metal1 vin.$760.Metal2 2.43488e-07f
Cred_3354 VDD.$669.Metal1 vin.P101.GatPoly 0.0229117f
Cred_3355 VDD.$669.Metal1 vin.P102.GatPoly 0.0248472f
Cred_3356 VDD.$669.Metal1 vin.P103.GatPoly 0.000806118f
Cred_3357 VDD.$669.Metal1 vout.$1152.Metal3 0.162001f
Cred_3358 VDD.$669.Metal1 vout.$1170.Metal3 0.0542314f
Cred_3359 VDD.$669.Metal1 vout.P46.pSD 0.114966f
Cred_3360 VDD.$669.Metal1 vout.P48.nSD 0.000325771f
Cred_3361 VDD.$669.Metal1 vout.P48.pSD 0.118493f
Cred_3362 VDD.$694.Metal1 vin.$243.GatPoly 0.00446589f
Cred_3363 VDD.$694.Metal1 vin.$251.GatPoly 0.00446215f
Cred_3364 VDD.$694.Metal1 vin.$531.Metal1 0.00069942f
Cred_3365 VDD.$694.Metal1 vin.$534.Metal1 4.55239e-07f
Cred_3366 VDD.$694.Metal1 vin.$538.Metal1 2.98435e-06f
Cred_3367 VDD.$694.Metal1 vin.$539.Metal1 0.0118893f
Cred_3368 VDD.$694.Metal1 vin.$545.Metal1 0.000386843f
Cred_3369 VDD.$694.Metal1 vin.$755.Metal2 0.000404899f
Cred_3370 VDD.$694.Metal1 vin.$757.Metal2 0.000171988f
Cred_3371 VDD.$694.Metal1 vin.$758.Metal2 9.15907e-06f
Cred_3372 VDD.$694.Metal1 vin.$760.Metal2 0.00611119f
Cred_3373 VDD.$694.Metal1 vin.$761.Metal2 0.000171988f
Cred_3374 VDD.$694.Metal1 vin.$764.Metal2 0.000407686f
Cred_3375 VDD.$694.Metal1 vin.$765.Metal2 8.53221e-06f
Cred_3376 VDD.$694.Metal1 vin.P102.GatPoly 0.000864243f
Cred_3377 VDD.$694.Metal1 vin.P103.GatPoly 0.0239182f
Cred_3378 VDD.$694.Metal1 vin.P104.GatPoly 0.0236817f
Cred_3379 VDD.$694.Metal1 vout.$1152.Metal3 0.0548919f
Cred_3380 VDD.$694.Metal1 vout.$1170.Metal3 0.162488f
Cred_3381 VDD.$694.Metal1 vout.P48.nSD 0.000329738f
Cred_3382 VDD.$694.Metal1 vout.P48.pSD 0.120342f
Cred_3383 VDD.$694.Metal1 vout.P50.pSD 0.114462f
Cred_3384 VDD.$715.Metal1 vin.$251.GatPoly 1.79422e-06f
Cred_3385 VDD.$715.Metal1 vin.$539.Metal1 0.000151117f
Cred_3386 VDD.$715.Metal1 vin.$545.Metal1 0.000150915f
Cred_3387 VDD.$715.Metal1 vin.$760.Metal2 7.19084e-07f
Cred_3388 VDD.$715.Metal1 vin.$765.Metal2 2.03327e-06f
Cred_3389 VDD.$715.Metal1 vin.P104.GatPoly 0.00117167f
Cred_3390 VDD.$715.Metal1 vin.P105.GatPoly 0.0010521f
Cred_3391 VDD.$715.Metal1 vout.$1170.Metal3 0.00531525f
Cred_3392 VDD.$715.Metal1 vout.P50.pSD 0.00847842f
Cred_3393 VDD.$719.Metal1 vin.P105.GatPoly 0.00202905f
Cred_3394 VDD.$719.Metal1 vin.P106.GatPoly 0.00285465f
Cred_3395 VDD.$719.Metal1 vout 0.00200237f
Cred_3396 VDD.$719.Metal1 vout.P52.pSD 0.00299987f
Cred_3397 VDD.$735.Metal1 vin.$251.GatPoly 0.00218842f
Cred_3398 VDD.$735.Metal1 vin.$259.GatPoly 0.00765441f
Cred_3399 VDD.$735.Metal1 vin.$545.Metal1 0.00117216f
Cred_3400 VDD.$735.Metal1 vin.$549.Metal1 0.0150777f
Cred_3401 VDD.$735.Metal1 vin.$764.Metal2 0.000544259f
Cred_3402 VDD.$735.Metal1 vin.$765.Metal2 0.00158374f
Cred_3403 VDD.$735.Metal1 vin.$768.Metal2 0.000326975f
Cred_3404 VDD.$735.Metal1 vin.$769.Metal2 0.00688236f
Cred_3405 VDD.$735.Metal1 vin.$771.Metal2 0.000550701f
Cred_3406 VDD.$735.Metal1 vin.P105.GatPoly 0.0223386f
Cred_3407 VDD.$735.Metal1 vin.P106.GatPoly 0.0220933f
Cred_3408 VDD.$735.Metal1 vin.P107.GatPoly 4.73757e-07f
Cred_3409 VDD.$735.Metal1 vout 0.134322f
Cred_3410 VDD.$735.Metal1 vout.$1170.Metal3 0.139501f
Cred_3411 VDD.$735.Metal1 vout.P50.pSD 0.148342f
Cred_3412 VDD.$735.Metal1 vout.P52.pSD 0.148527f
Cred_3413 VDD.$742.Metal1 vin.$259.GatPoly 1.91142e-05f
Cred_3414 VDD.$742.Metal1 vin.$549.Metal1 0.000869043f
Cred_3415 VDD.$742.Metal1 vin.$769.Metal2 6.17275e-05f
Cred_3416 VDD.$742.Metal1 vin.$771.Metal2 1.9816e-05f
Cred_3417 VDD.$742.Metal1 vin.P106.GatPoly 0.00129602f
Cred_3418 VDD.$742.Metal1 vin.P107.GatPoly 0.00377571f
Cred_3419 VDD.$742.Metal1 vout 0.00390845f
Cred_3420 VDD.$742.Metal1 vout.P52.pSD 0.00584911f
Cred_3421 VDD.$752.Metal1 vin 6.87907e-06f
Cred_3422 VDD.$752.Metal1 vin.$103.GatPoly 1.04949e-05f
Cred_3423 VDD.$752.Metal1 vin.$109.GatPoly 9.28234e-06f
Cred_3424 VDD.$752.Metal1 vin.$113.GatPoly 1.42036e-05f
Cred_3425 VDD.$752.Metal1 vin.$119.GatPoly 1.18768e-05f
Cred_3426 VDD.$752.Metal1 vin.$123.GatPoly 1.81662e-05f
Cred_3427 VDD.$752.Metal1 vin.$129.GatPoly 1.51263e-05f
Cred_3428 VDD.$752.Metal1 vin.$13.GatPoly 1.31848e-06f
Cred_3429 VDD.$752.Metal1 vin.$133.GatPoly 2.4112e-05f
Cred_3430 VDD.$752.Metal1 vin.$139.GatPoly 1.92701e-05f
Cred_3431 VDD.$752.Metal1 vin.$143.GatPoly 2.7893e-05f
Cred_3432 VDD.$752.Metal1 vin.$149.GatPoly 2.53487e-05f
Cred_3433 VDD.$752.Metal1 vin.$153.GatPoly 3.8594e-05f
Cred_3434 VDD.$752.Metal1 vin.$159.GatPoly 3.25455e-05f
Cred_3435 VDD.$752.Metal1 vin.$163.GatPoly 4.97172e-05f
Cred_3436 VDD.$752.Metal1 vin.$169.GatPoly 4.1901e-05f
Cred_3437 VDD.$752.Metal1 vin.$173.GatPoly 6.3959e-05f
Cred_3438 VDD.$752.Metal1 vin.$179.GatPoly 5.40354e-05f
Cred_3439 VDD.$752.Metal1 vin.$183.GatPoly 8.26678e-05f
Cred_3440 VDD.$752.Metal1 vin.$189.GatPoly 6.97536e-05f
Cred_3441 VDD.$752.Metal1 vin.$19.GatPoly 9.0873e-07f
Cred_3442 VDD.$752.Metal1 vin.$193.GatPoly 0.000106666f
Cred_3443 VDD.$752.Metal1 vin.$199.GatPoly 8.91715e-05f
Cred_3444 VDD.$752.Metal1 vin.$203.GatPoly 0.000140354f
Cred_3445 VDD.$752.Metal1 vin.$211.GatPoly 0.000165024f
Cred_3446 VDD.$752.Metal1 vin.$215.GatPoly 0.00016948f
Cred_3447 VDD.$752.Metal1 vin.$223.GatPoly 0.000281366f
Cred_3448 VDD.$752.Metal1 vin.$23.GatPoly 1.39496e-06f
Cred_3449 VDD.$752.Metal1 vin.$231.GatPoly 0.000275664f
Cred_3450 VDD.$752.Metal1 vin.$235.GatPoly 0.000285185f
Cred_3451 VDD.$752.Metal1 vin.$243.GatPoly 0.000484516f
Cred_3452 VDD.$752.Metal1 vin.$251.GatPoly 0.000593682f
Cred_3453 VDD.$752.Metal1 vin.$259.GatPoly 0.00100736f
Cred_3454 VDD.$752.Metal1 vin.$271.Metal1 1.64053e-05f
Cred_3455 VDD.$752.Metal1 vin.$275.Metal1 6.93601e-06f
Cred_3456 VDD.$752.Metal1 vin.$279.Metal1 1.18008e-05f
Cred_3457 VDD.$752.Metal1 vin.$285.Metal1 1.32791e-05f
Cred_3458 VDD.$752.Metal1 vin.$289.Metal1 1.48603e-05f
Cred_3459 VDD.$752.Metal1 vin.$29.GatPoly 1.16853e-06f
Cred_3460 VDD.$752.Metal1 vin.$297.Metal1 1.67816e-05f
Cred_3461 VDD.$752.Metal1 vin.$301.Metal1 1.97304e-05f
Cred_3462 VDD.$752.Metal1 vin.$307.Metal1 2.23652e-05f
Cred_3463 VDD.$752.Metal1 vin.$311.Metal1 2.51191e-05f
Cred_3464 VDD.$752.Metal1 vin.$319.Metal1 2.83876e-05f
Cred_3465 VDD.$752.Metal1 vin.$323.Metal1 3.25802e-05f
Cred_3466 VDD.$752.Metal1 vin.$329.Metal1 3.80023e-05f
Cred_3467 VDD.$752.Metal1 vin.$33.GatPoly 1.79111e-06f
Cred_3468 VDD.$752.Metal1 vin.$333.Metal1 2.69841e-05f
Cred_3469 VDD.$752.Metal1 vin.$337.Metal1 3.03531e-05f
Cred_3470 VDD.$752.Metal1 vin.$341.Metal1 3.27398e-05f
Cred_3471 VDD.$752.Metal1 vin.$345.Metal1 5.45271e-05f
Cred_3472 VDD.$752.Metal1 vin.$351.Metal1 6.38433e-05f
Cred_3473 VDD.$752.Metal1 vin.$355.Metal1 4.65476e-05f
Cred_3474 VDD.$752.Metal1 vin.$359.Metal1 5.07104e-05f
Cred_3475 VDD.$752.Metal1 vin.$363.Metal1 5.48003e-05f
Cred_3476 VDD.$752.Metal1 vin.$367.Metal1 9.12365e-05f
Cred_3477 VDD.$752.Metal1 vin.$373.Metal1 0.000105895f
Cred_3478 VDD.$752.Metal1 vin.$377.Metal1 7.78205e-05f
Cred_3479 VDD.$752.Metal1 vin.$381.Metal1 8.46839e-05f
Cred_3480 VDD.$752.Metal1 vin.$385.Metal1 9.16851e-05f
Cred_3481 VDD.$752.Metal1 vin.$389.Metal1 0.000150998f
Cred_3482 VDD.$752.Metal1 vin.$39.GatPoly 1.53111e-06f
Cred_3483 VDD.$752.Metal1 vin.$395.Metal1 0.000171734f
Cred_3484 VDD.$752.Metal1 vin.$399.Metal1 0.000199382f
Cred_3485 VDD.$752.Metal1 vin.$407.Metal1 0.000219438f
Cred_3486 VDD.$752.Metal1 vin.$411.Metal1 0.000246455f
Cred_3487 VDD.$752.Metal1 vin.$417.Metal1 0.000282367f
Cred_3488 VDD.$752.Metal1 vin.$421.Metal1 0.000213153f
Cred_3489 VDD.$752.Metal1 vin.$425.Metal1 0.000231823f
Cred_3490 VDD.$752.Metal1 vin.$429.Metal1 0.000249296f
Cred_3491 VDD.$752.Metal1 vin.$43.GatPoly 2.34704e-06f
Cred_3492 VDD.$752.Metal1 vin.$433.Metal1 0.000415907f
Cred_3493 VDD.$752.Metal1 vin.$439.Metal1 0.000463382f
Cred_3494 VDD.$752.Metal1 vin.$443.Metal1 0.00054313f
Cred_3495 VDD.$752.Metal1 vin.$451.Metal1 0.000615036f
Cred_3496 VDD.$752.Metal1 vin.$455.Metal1 0.000698861f
Cred_3497 VDD.$752.Metal1 vin.$461.Metal1 0.000768454f
Cred_3498 VDD.$752.Metal1 vin.$465.Metal1 0.000902942f
Cred_3499 VDD.$752.Metal1 vin.$473.Metal1 0.00103342f
Cred_3500 VDD.$752.Metal1 vin.$477.Metal1 0.00116899f
Cred_3501 VDD.$752.Metal1 vin.$483.Metal1 0.00127972f
Cred_3502 VDD.$752.Metal1 vin.$487.Metal1 0.00149739f
Cred_3503 VDD.$752.Metal1 vin.$49.GatPoly 1.92614e-06f
Cred_3504 VDD.$752.Metal1 vin.$495.Metal1 0.00232888f
Cred_3505 VDD.$752.Metal1 vin.$5.GatPoly 1.11412e-06f
Cred_3506 VDD.$752.Metal1 vin.$501.Metal1 0.00196377f
Cred_3507 VDD.$752.Metal1 vin.$505.Metal1 0.00147011f
Cred_3508 VDD.$752.Metal1 vin.$509.Metal1 0.00249335f
Cred_3509 VDD.$752.Metal1 vin.$517.Metal1 0.00384763f
Cred_3510 VDD.$752.Metal1 vin.$523.Metal1 0.0033402f
Cred_3511 VDD.$752.Metal1 vin.$527.Metal1 0.00251942f
Cred_3512 VDD.$752.Metal1 vin.$53.GatPoly 2.94548e-06f
Cred_3513 VDD.$752.Metal1 vin.$531.Metal1 0.00422324f
Cred_3514 VDD.$752.Metal1 vin.$539.Metal1 0.00645628f
Cred_3515 VDD.$752.Metal1 vin.$545.Metal1 0.00565216f
Cred_3516 VDD.$752.Metal1 vin.$549.Metal1 0.0182036f
Cred_3517 VDD.$752.Metal1 vin.$564.Metal2 4.76313e-09f
Cred_3518 VDD.$752.Metal1 vin.$566.Metal2 6.30232e-06f
Cred_3519 VDD.$752.Metal1 vin.$569.Metal2 3.18502e-07f
Cred_3520 VDD.$752.Metal1 vin.$573.Metal2 7.32181e-06f
Cred_3521 VDD.$752.Metal1 vin.$574.Metal2 5.82089e-07f
Cred_3522 VDD.$752.Metal1 vin.$577.Metal2 1.35944e-06f
Cred_3523 VDD.$752.Metal1 vin.$579.Metal2 6.19134e-06f
Cred_3524 VDD.$752.Metal1 vin.$581.Metal2 1.36736e-05f
Cred_3525 VDD.$752.Metal1 vin.$584.Metal2 2.51295e-06f
Cred_3526 VDD.$752.Metal1 vin.$588.Metal2 1.34264e-05f
Cred_3527 VDD.$752.Metal1 vin.$589.Metal2 1.00627e-05f
Cred_3528 VDD.$752.Metal1 vin.$59.GatPoly 2.56642e-06f
Cred_3529 VDD.$752.Metal1 vin.$593.Metal2 2.44001e-06f
Cred_3530 VDD.$752.Metal1 vin.$595.Metal2 9.85353e-06f
Cred_3531 VDD.$752.Metal1 vin.$597.Metal2 1.87347e-05f
Cred_3532 VDD.$752.Metal1 vin.$600.Metal2 3.99994e-06f
Cred_3533 VDD.$752.Metal1 vin.$604.Metal2 2.2548e-05f
Cred_3534 VDD.$752.Metal1 vin.$605.Metal2 1.68949e-05f
Cred_3535 VDD.$752.Metal1 vin.$609.Metal2 3.84601e-06f
Cred_3536 VDD.$752.Metal1 vin.$611.Metal2 1.93959e-05f
Cred_3537 VDD.$752.Metal1 vin.$613.Metal2 3.01796e-05f
Cred_3538 VDD.$752.Metal1 vin.$618.Metal2 1.43325e-05f
Cred_3539 VDD.$752.Metal1 vin.$620.Metal2 4.1097e-05f
Cred_3540 VDD.$752.Metal1 vin.$623.Metal2 1.82853e-05f
Cred_3541 VDD.$752.Metal1 vin.$627.Metal2 3.62958e-05f
Cred_3542 VDD.$752.Metal1 vin.$629.Metal2 4.99725e-05f
Cred_3543 VDD.$752.Metal1 vin.$63.GatPoly 3.75284e-06f
Cred_3544 VDD.$752.Metal1 vin.$634.Metal2 2.41947e-05f
Cred_3545 VDD.$752.Metal1 vin.$636.Metal2 6.87931e-05f
Cred_3546 VDD.$752.Metal1 vin.$639.Metal2 2.9936e-05f
Cred_3547 VDD.$752.Metal1 vin.$643.Metal2 6.22552e-05f
Cred_3548 VDD.$752.Metal1 vin.$645.Metal2 8.26307e-05f
Cred_3549 VDD.$752.Metal1 vin.$650.Metal2 4.2498e-05f
Cred_3550 VDD.$752.Metal1 vin.$652.Metal2 0.000113873f
Cred_3551 VDD.$752.Metal1 vin.$655.Metal2 5.02042e-05f
Cred_3552 VDD.$752.Metal1 vin.$659.Metal2 0.000138918f
Cred_3553 VDD.$752.Metal1 vin.$662.Metal2 0.000105026f
Cred_3554 VDD.$752.Metal1 vin.$666.Metal2 7.55441e-05f
Cred_3555 VDD.$752.Metal1 vin.$668.Metal2 0.00019773f
Cred_3556 VDD.$752.Metal1 vin.$671.Metal2 8.26752e-05f
Cred_3557 VDD.$752.Metal1 vin.$676.Metal2 0.000229573f
Cred_3558 VDD.$752.Metal1 vin.$678.Metal2 0.000181602f
Cred_3559 VDD.$752.Metal1 vin.$682.Metal2 0.000126926f
Cred_3560 VDD.$752.Metal1 vin.$684.Metal2 0.00030726f
Cred_3561 VDD.$752.Metal1 vin.$687.Metal2 0.000134053f
Cred_3562 VDD.$752.Metal1 vin.$69.GatPoly 3.32004e-06f
Cred_3563 VDD.$752.Metal1 vin.$691.Metal2 0.000366878f
Cred_3564 VDD.$752.Metal1 vin.$694.Metal2 0.000298573f
Cred_3565 VDD.$752.Metal1 vin.$698.Metal2 0.000213744f
Cred_3566 VDD.$752.Metal1 vin.$700.Metal2 0.000511704f
Cred_3567 VDD.$752.Metal1 vin.$703.Metal2 0.00021318f
Cred_3568 VDD.$752.Metal1 vin.$707.Metal2 0.000616781f
Cred_3569 VDD.$752.Metal1 vin.$710.Metal2 0.000484424f
Cred_3570 VDD.$752.Metal1 vin.$714.Metal2 0.000354656f
Cred_3571 VDD.$752.Metal1 vin.$716.Metal2 0.000876075f
Cred_3572 VDD.$752.Metal1 vin.$719.Metal2 0.000357718f
Cred_3573 VDD.$752.Metal1 vin.$723.Metal2 0.00107178f
Cred_3574 VDD.$752.Metal1 vin.$726.Metal2 0.000618205f
Cred_3575 VDD.$752.Metal1 vin.$728.Metal2 0.0001873f
Cred_3576 VDD.$752.Metal1 vin.$73.GatPoly 5.08582e-06f
Cred_3577 VDD.$752.Metal1 vin.$732.Metal2 0.00134492f
Cred_3578 VDD.$752.Metal1 vin.$733.Metal2 0.00102642f
Cred_3579 VDD.$752.Metal1 vin.$737.Metal2 0.000300636f
Cred_3580 VDD.$752.Metal1 vin.$739.Metal2 0.00178424f
Cred_3581 VDD.$752.Metal1 vin.$742.Metal2 0.00108455f
Cred_3582 VDD.$752.Metal1 vin.$744.Metal2 0.00028934f
Cred_3583 VDD.$752.Metal1 vin.$748.Metal2 0.00213867f
Cred_3584 VDD.$752.Metal1 vin.$749.Metal2 0.00173624f
Cred_3585 VDD.$752.Metal1 vin.$753.Metal2 0.000610689f
Cred_3586 VDD.$752.Metal1 vin.$755.Metal2 0.00293456f
Cred_3587 VDD.$752.Metal1 vin.$758.Metal2 0.00184604f
Cred_3588 VDD.$752.Metal1 vin.$760.Metal2 0.000487391f
Cred_3589 VDD.$752.Metal1 vin.$764.Metal2 0.003594f
Cred_3590 VDD.$752.Metal1 vin.$765.Metal2 0.00291168f
Cred_3591 VDD.$752.Metal1 vin.$769.Metal2 0.00499332f
Cred_3592 VDD.$752.Metal1 vin.$771.Metal2 0.00435086f
Cred_3593 VDD.$752.Metal1 vin.$79.GatPoly 4.29386e-06f
Cred_3594 VDD.$752.Metal1 vin.$83.GatPoly 6.27741e-06f
Cred_3595 VDD.$752.Metal1 vin.$89.GatPoly 5.55247e-06f
Cred_3596 VDD.$752.Metal1 vin.$93.GatPoly 8.50623e-06f
Cred_3597 VDD.$752.Metal1 vin.$99.GatPoly 7.17933e-06f
Cred_3598 VDD.$752.Metal1 vin.P100.GatPoly 1.3013e-06f
Cred_3599 VDD.$752.Metal1 vin.P102.GatPoly 1.07663e-05f
Cred_3600 VDD.$752.Metal1 vin.P103.GatPoly 2.17452e-06f
Cred_3601 VDD.$752.Metal1 vin.P104.GatPoly 2.17452e-06f
Cred_3602 VDD.$752.Metal1 vin.P105.GatPoly 1.61286e-05f
Cred_3603 VDD.$752.Metal1 vin.P107.GatPoly 0.00608919f
Cred_3604 VDD.$752.Metal1 vin.P54.GatPoly 3.43542e-08f
Cred_3605 VDD.$752.Metal1 vin.P56.GatPoly 2.98497e-08f
Cred_3606 VDD.$752.Metal1 vin.P57.GatPoly 5.38284e-09f
Cred_3607 VDD.$752.Metal1 vin.P59.GatPoly 6.99814e-09f
Cred_3608 VDD.$752.Metal1 vin.P61.GatPoly 9.07758e-09f
Cred_3609 VDD.$752.Metal1 vin.P63.GatPoly 1.17591e-08f
Cred_3610 VDD.$752.Metal1 vin.P65.GatPoly 1.52205e-08f
Cred_3611 VDD.$752.Metal1 vin.P67.GatPoly 1.96913e-08f
Cred_3612 VDD.$752.Metal1 vin.P69.GatPoly 2.54682e-08f
Cred_3613 VDD.$752.Metal1 vin.P71.GatPoly 3.29341e-08f
Cred_3614 VDD.$752.Metal1 vin.P73.GatPoly 4.25844e-08f
Cred_3615 VDD.$752.Metal1 vin.P75.GatPoly 5.5059e-08f
Cred_3616 VDD.$752.Metal1 vin.P77.GatPoly 7.11852e-08f
Cred_3617 VDD.$752.Metal1 vin.P79.GatPoly 9.20327e-08f
Cred_3618 VDD.$752.Metal1 vin.P81.GatPoly 1.17898e-07f
Cred_3619 VDD.$752.Metal1 vin.P83.GatPoly 1.50499e-07f
Cred_3620 VDD.$752.Metal1 vin.P85.GatPoly 1.93081e-07f
Cred_3621 VDD.$752.Metal1 vin.P87.GatPoly 2.48468e-07f
Cred_3622 VDD.$752.Metal1 vin.P89.GatPoly 3.20335e-07f
Cred_3623 VDD.$752.Metal1 vin.P91.GatPoly 4.13447e-07f
Cred_3624 VDD.$752.Metal1 vin.P93.GatPoly 5.33981e-07f
Cred_3625 VDD.$752.Metal1 vin.P95.GatPoly 7.79019e-07f
Cred_3626 VDD.$752.Metal1 vin.P96.GatPoly 7.79019e-07f
Cred_3627 VDD.$752.Metal1 vin.P98.GatPoly 6.25278e-06f
Cred_3628 VDD.$752.Metal1 vin.P99.GatPoly 1.3013e-06f
Cred_3629 VDD.$752.Metal1 vout 0.0152093f
Cred_3630 VDD.$752.Metal1 vout.$1008.Metal3 2.07583e-05f
Cred_3631 VDD.$752.Metal1 vout.$1026.Metal3 3.49092e-05f
Cred_3632 VDD.$752.Metal1 vout.$1044.Metal3 6.0758e-05f
Cred_3633 VDD.$752.Metal1 vout.$1062.Metal3 0.000104186f
Cred_3634 VDD.$752.Metal1 vout.$1080.Metal3 0.00016714f
Cred_3635 VDD.$752.Metal1 vout.$1098.Metal3 0.000270769f
Cred_3636 VDD.$752.Metal1 vout.$1116.Metal3 0.000448462f
Cred_3637 VDD.$752.Metal1 vout.$1134.Metal3 0.000733117f
Cred_3638 VDD.$752.Metal1 vout.$1152.Metal3 0.00121219f
Cred_3639 VDD.$752.Metal1 vout.$1170.Metal3 0.00141897f
Cred_3640 VDD.$752.Metal1 vout.$954.Metal3 5.50024e-06f
Cred_3641 VDD.$752.Metal1 vout.$972.Metal3 7.07729e-06f
Cred_3642 VDD.$752.Metal1 vout.$990.Metal3 1.21697e-05f
Cred_3643 VDD.$752.Metal1 vout.P0.nSD 9.92038e-09f
Cred_3644 VDD.$752.Metal1 vout.P0.pSD 3.23576e-08f
Cred_3645 VDD.$752.Metal1 vout.P12.nSD 2.43382e-08f
Cred_3646 VDD.$752.Metal1 vout.P12.pSD 6.60215e-08f
Cred_3647 VDD.$752.Metal1 vout.P16.nSD 4.11543e-08f
Cred_3648 VDD.$752.Metal1 vout.P16.pSD 1.11638e-07f
Cred_3649 VDD.$752.Metal1 vout.P20.nSD 6.9541e-08f
Cred_3650 VDD.$752.Metal1 vout.P20.pSD 1.88642e-07f
Cred_3651 VDD.$752.Metal1 vout.P24.nSD 1.29926e-07f
Cred_3652 VDD.$752.Metal1 vout.P24.pSD 3.52447e-07f
Cred_3653 VDD.$752.Metal1 vout.P28.nSD 2.14309e-07f
Cred_3654 VDD.$752.Metal1 vout.P28.pSD 5.8135e-07f
Cred_3655 VDD.$752.Metal1 vout.P32.nSD 3.21384e-07f
Cred_3656 VDD.$752.Metal1 vout.P32.pSD 8.71808e-07f
Cred_3657 VDD.$752.Metal1 vout.P36.nSD 5.29526e-07f
Cred_3658 VDD.$752.Metal1 vout.P36.pSD 1.43643e-06f
Cred_3659 VDD.$752.Metal1 vout.P4.nSD 8.02293e-09f
Cred_3660 VDD.$752.Metal1 vout.P4.pSD 2.17636e-08f
Cred_3661 VDD.$752.Metal1 vout.P40.nSD 8.72338e-07f
Cred_3662 VDD.$752.Metal1 vout.P40.pSD 2.36637e-06f
Cred_3663 VDD.$752.Metal1 vout.P44.nSD 1.37454e-06f
Cred_3664 VDD.$752.Metal1 vout.P44.pSD 3.72868e-06f
Cred_3665 VDD.$752.Metal1 vout.P48.nSD 2.30352e-06f
Cred_3666 VDD.$752.Metal1 vout.P48.pSD 6.24868e-06f
Cred_3667 VDD.$752.Metal1 vout.P52.pSD 0.0201811f
Cred_3668 VDD.$752.Metal1 vout.P8.nSD 1.3506e-08f
Cred_3669 VDD.$752.Metal1 vout.P8.pSD 3.66374e-08f
Cred_3670 VDD.$752.Metal1 VSS.$14.Metal1 1.75243e-05f
Cred_3671 VDD.$752.Metal1 VSS.$29.Metal1 3.02741e-05f
Cred_3672 VDD.$752.Metal1 VSS.$500.Metal1 0.0010813f
Cred_3673 VDD.$752.Metal1 VSS.$520.Metal1 0.00857462f
Cred_3674 VDD.$752.Metal1 VSS.$531.Metal2 1.15147e-07f
Cred_3675 VDD.$752.Metal1 VSS.$904.Metal2 0.000311508f
Cred_3676 VDD.$752.Metal1 VSS.P0.nSD 8.1827e-09f
Cred_3677 VDD.$752.Metal1 VSS.P0.pSD 0.0233568f
Cred_3678 VDD.$752.Metal1 VSS.P1.nSD 8.1827e-09f
Cred_3679 VDD.$752.Metal1 VSS.P55.nSD 1.12259e-05f
Cred_3680 VDD.$752.Metal1 VSS.P57.nSD 1.12259e-05f
Cred_3681 VDD.$759.Metal1 vin 3.0537e-06f
Cred_3682 VDD.$759.Metal1 vin.$103.GatPoly 4.65884e-06f
Cred_3683 VDD.$759.Metal1 vin.$109.GatPoly 4.12055e-06f
Cred_3684 VDD.$759.Metal1 vin.$113.GatPoly 6.30515e-06f
Cred_3685 VDD.$759.Metal1 vin.$119.GatPoly 5.27226e-06f
Cred_3686 VDD.$759.Metal1 vin.$123.GatPoly 8.06421e-06f
Cred_3687 VDD.$759.Metal1 vin.$129.GatPoly 6.71476e-06f
Cred_3688 VDD.$759.Metal1 vin.$13.GatPoly 5.8529e-07f
Cred_3689 VDD.$759.Metal1 vin.$133.GatPoly 1.07036e-05f
Cred_3690 VDD.$759.Metal1 vin.$139.GatPoly 8.55421e-06f
Cred_3691 VDD.$759.Metal1 vin.$143.GatPoly 1.2382e-05f
Cred_3692 VDD.$759.Metal1 vin.$149.GatPoly 1.12526e-05f
Cred_3693 VDD.$759.Metal1 vin.$153.GatPoly 1.71324e-05f
Cred_3694 VDD.$759.Metal1 vin.$159.GatPoly 1.44474e-05f
Cred_3695 VDD.$759.Metal1 vin.$163.GatPoly 2.20701e-05f
Cred_3696 VDD.$759.Metal1 vin.$169.GatPoly 1.86004e-05f
Cred_3697 VDD.$759.Metal1 vin.$173.GatPoly 2.83922e-05f
Cred_3698 VDD.$759.Metal1 vin.$179.GatPoly 2.3987e-05f
Cred_3699 VDD.$759.Metal1 vin.$183.GatPoly 3.66972e-05f
Cred_3700 VDD.$759.Metal1 vin.$189.GatPoly 3.09645e-05f
Cred_3701 VDD.$759.Metal1 vin.$19.GatPoly 4.03396e-07f
Cred_3702 VDD.$759.Metal1 vin.$193.GatPoly 4.73502e-05f
Cred_3703 VDD.$759.Metal1 vin.$199.GatPoly 3.95843e-05f
Cred_3704 VDD.$759.Metal1 vin.$203.GatPoly 6.23047e-05f
Cred_3705 VDD.$759.Metal1 vin.$211.GatPoly 7.32561e-05f
Cred_3706 VDD.$759.Metal1 vin.$215.GatPoly 7.52342e-05f
Cred_3707 VDD.$759.Metal1 vin.$223.GatPoly 0.000124902f
Cred_3708 VDD.$759.Metal1 vin.$23.GatPoly 6.19241e-07f
Cred_3709 VDD.$759.Metal1 vin.$231.GatPoly 0.000122371f
Cred_3710 VDD.$759.Metal1 vin.$235.GatPoly 0.000126597f
Cred_3711 VDD.$759.Metal1 vin.$243.GatPoly 0.000215083f
Cred_3712 VDD.$759.Metal1 vin.$251.GatPoly 0.000263543f
Cred_3713 VDD.$759.Metal1 vin.$258.GatPoly 5.20802e-08f
Cred_3714 VDD.$759.Metal1 vin.$259.GatPoly 0.00373585f
Cred_3715 VDD.$759.Metal1 vin.$271.Metal1 7.2825e-06f
Cred_3716 VDD.$759.Metal1 vin.$275.Metal1 3.07898e-06f
Cred_3717 VDD.$759.Metal1 vin.$279.Metal1 5.23851e-06f
Cred_3718 VDD.$759.Metal1 vin.$285.Metal1 5.89476e-06f
Cred_3719 VDD.$759.Metal1 vin.$289.Metal1 6.59668e-06f
Cred_3720 VDD.$759.Metal1 vin.$29.GatPoly 5.18726e-07f
Cred_3721 VDD.$759.Metal1 vin.$297.Metal1 7.44956e-06f
Cred_3722 VDD.$759.Metal1 vin.$301.Metal1 8.75855e-06f
Cred_3723 VDD.$759.Metal1 vin.$307.Metal1 9.92818e-06f
Cred_3724 VDD.$759.Metal1 vin.$311.Metal1 1.11507e-05f
Cred_3725 VDD.$759.Metal1 vin.$319.Metal1 1.26016e-05f
Cred_3726 VDD.$759.Metal1 vin.$323.Metal1 1.44627e-05f
Cred_3727 VDD.$759.Metal1 vin.$329.Metal1 1.68697e-05f
Cred_3728 VDD.$759.Metal1 vin.$33.GatPoly 7.95095e-07f
Cred_3729 VDD.$759.Metal1 vin.$333.Metal1 1.19786e-05f
Cred_3730 VDD.$759.Metal1 vin.$337.Metal1 1.34741e-05f
Cred_3731 VDD.$759.Metal1 vin.$341.Metal1 1.45336e-05f
Cred_3732 VDD.$759.Metal1 vin.$345.Metal1 2.42052e-05f
Cred_3733 VDD.$759.Metal1 vin.$351.Metal1 2.83408e-05f
Cred_3734 VDD.$759.Metal1 vin.$355.Metal1 2.06631e-05f
Cred_3735 VDD.$759.Metal1 vin.$359.Metal1 2.2511e-05f
Cred_3736 VDD.$759.Metal1 vin.$363.Metal1 2.43265e-05f
Cred_3737 VDD.$759.Metal1 vin.$367.Metal1 4.0501e-05f
Cred_3738 VDD.$759.Metal1 vin.$373.Metal1 4.70081e-05f
Cred_3739 VDD.$759.Metal1 vin.$377.Metal1 3.45455e-05f
Cred_3740 VDD.$759.Metal1 vin.$381.Metal1 3.75922e-05f
Cred_3741 VDD.$759.Metal1 vin.$385.Metal1 4.07001e-05f
Cred_3742 VDD.$759.Metal1 vin.$389.Metal1 6.70298e-05f
Cred_3743 VDD.$759.Metal1 vin.$39.GatPoly 6.79679e-07f
Cred_3744 VDD.$759.Metal1 vin.$395.Metal1 7.6235e-05f
Cred_3745 VDD.$759.Metal1 vin.$399.Metal1 8.85079e-05f
Cred_3746 VDD.$759.Metal1 vin.$407.Metal1 9.74113e-05f
Cred_3747 VDD.$759.Metal1 vin.$411.Metal1 0.000109405f
Cred_3748 VDD.$759.Metal1 vin.$417.Metal1 0.000125346f
Cred_3749 VDD.$759.Metal1 vin.$421.Metal1 9.46212e-05f
Cred_3750 VDD.$759.Metal1 vin.$425.Metal1 0.000102909f
Cred_3751 VDD.$759.Metal1 vin.$429.Metal1 0.000110665f
Cred_3752 VDD.$759.Metal1 vin.$43.GatPoly 1.04188e-06f
Cred_3753 VDD.$759.Metal1 vin.$433.Metal1 0.000184626f
Cred_3754 VDD.$759.Metal1 vin.$439.Metal1 0.000205701f
Cred_3755 VDD.$759.Metal1 vin.$443.Metal1 0.000241102f
Cred_3756 VDD.$759.Metal1 vin.$451.Metal1 0.000273022f
Cred_3757 VDD.$759.Metal1 vin.$455.Metal1 0.000310233f
Cred_3758 VDD.$759.Metal1 vin.$461.Metal1 0.000341126f
Cred_3759 VDD.$759.Metal1 vin.$465.Metal1 0.000400827f
Cred_3760 VDD.$759.Metal1 vin.$473.Metal1 0.000458749f
Cred_3761 VDD.$759.Metal1 vin.$477.Metal1 0.000518928f
Cred_3762 VDD.$759.Metal1 vin.$483.Metal1 0.000568082f
Cred_3763 VDD.$759.Metal1 vin.$487.Metal1 0.000664711f
Cred_3764 VDD.$759.Metal1 vin.$49.GatPoly 8.55037e-07f
Cred_3765 VDD.$759.Metal1 vin.$495.Metal1 0.00103382f
Cred_3766 VDD.$759.Metal1 vin.$5.GatPoly 4.94571e-07f
Cred_3767 VDD.$759.Metal1 vin.$501.Metal1 0.00087174f
Cred_3768 VDD.$759.Metal1 vin.$505.Metal1 0.000652599f
Cred_3769 VDD.$759.Metal1 vin.$509.Metal1 0.00110683f
Cred_3770 VDD.$759.Metal1 vin.$517.Metal1 0.00170801f
Cred_3771 VDD.$759.Metal1 vin.$523.Metal1 0.00148275f
Cred_3772 VDD.$759.Metal1 vin.$527.Metal1 0.0011184f
Cred_3773 VDD.$759.Metal1 vin.$53.GatPoly 1.30753e-06f
Cred_3774 VDD.$759.Metal1 vin.$531.Metal1 0.00187475f
Cred_3775 VDD.$759.Metal1 vin.$539.Metal1 0.00286602f
Cred_3776 VDD.$759.Metal1 vin.$545.Metal1 0.00250906f
Cred_3777 VDD.$759.Metal1 vin.$548.Metal1 2.51799e-06f
Cred_3778 VDD.$759.Metal1 vin.$549.Metal1 0.0279546f
Cred_3779 VDD.$759.Metal1 vin.$564.Metal2 2.11441e-09f
Cred_3780 VDD.$759.Metal1 vin.$566.Metal2 2.79768e-06f
Cred_3781 VDD.$759.Metal1 vin.$569.Metal2 1.41387e-07f
Cred_3782 VDD.$759.Metal1 vin.$573.Metal2 3.25024e-06f
Cred_3783 VDD.$759.Metal1 vin.$574.Metal2 2.58396e-07f
Cred_3784 VDD.$759.Metal1 vin.$577.Metal2 6.03474e-07f
Cred_3785 VDD.$759.Metal1 vin.$579.Metal2 2.74841e-06f
Cred_3786 VDD.$759.Metal1 vin.$581.Metal2 6.06988e-06f
Cred_3787 VDD.$759.Metal1 vin.$584.Metal2 1.11553e-06f
Cred_3788 VDD.$759.Metal1 vin.$588.Metal2 5.96016e-06f
Cred_3789 VDD.$759.Metal1 vin.$589.Metal2 4.46698e-06f
Cred_3790 VDD.$759.Metal1 vin.$59.GatPoly 1.13926e-06f
Cred_3791 VDD.$759.Metal1 vin.$593.Metal2 1.08315e-06f
Cred_3792 VDD.$759.Metal1 vin.$595.Metal2 4.3741e-06f
Cred_3793 VDD.$759.Metal1 vin.$597.Metal2 8.31654e-06f
Cred_3794 VDD.$759.Metal1 vin.$600.Metal2 1.77562e-06f
Cred_3795 VDD.$759.Metal1 vin.$604.Metal2 1.00093e-05f
Cred_3796 VDD.$759.Metal1 vin.$605.Metal2 7.49987e-06f
Cred_3797 VDD.$759.Metal1 vin.$609.Metal2 1.70729e-06f
Cred_3798 VDD.$759.Metal1 vin.$611.Metal2 8.61009e-06f
Cred_3799 VDD.$759.Metal1 vin.$613.Metal2 1.33971e-05f
Cred_3800 VDD.$759.Metal1 vin.$618.Metal2 6.36237e-06f
Cred_3801 VDD.$759.Metal1 vin.$620.Metal2 1.82435e-05f
Cred_3802 VDD.$759.Metal1 vin.$623.Metal2 8.11705e-06f
Cred_3803 VDD.$759.Metal1 vin.$627.Metal2 1.61121e-05f
Cred_3804 VDD.$759.Metal1 vin.$629.Metal2 2.21834e-05f
Cred_3805 VDD.$759.Metal1 vin.$63.GatPoly 1.66593e-06f
Cred_3806 VDD.$759.Metal1 vin.$634.Metal2 1.07403e-05f
Cred_3807 VDD.$759.Metal1 vin.$636.Metal2 3.05381e-05f
Cred_3808 VDD.$759.Metal1 vin.$639.Metal2 1.3289e-05f
Cred_3809 VDD.$759.Metal1 vin.$643.Metal2 2.76359e-05f
Cred_3810 VDD.$759.Metal1 vin.$645.Metal2 3.66808e-05f
Cred_3811 VDD.$759.Metal1 vin.$650.Metal2 1.88654e-05f
Cred_3812 VDD.$759.Metal1 vin.$652.Metal2 5.05494e-05f
Cred_3813 VDD.$759.Metal1 vin.$655.Metal2 2.22863e-05f
Cred_3814 VDD.$759.Metal1 vin.$659.Metal2 6.16674e-05f
Cred_3815 VDD.$759.Metal1 vin.$662.Metal2 4.66224e-05f
Cred_3816 VDD.$759.Metal1 vin.$666.Metal2 3.3535e-05f
Cred_3817 VDD.$759.Metal1 vin.$668.Metal2 8.77746e-05f
Cred_3818 VDD.$759.Metal1 vin.$671.Metal2 3.67005e-05f
Cred_3819 VDD.$759.Metal1 vin.$676.Metal2 0.00010191f
Cred_3820 VDD.$759.Metal1 vin.$678.Metal2 8.06155e-05f
Cred_3821 VDD.$759.Metal1 vin.$682.Metal2 5.6344e-05f
Cred_3822 VDD.$759.Metal1 vin.$684.Metal2 0.000136397f
Cred_3823 VDD.$759.Metal1 vin.$687.Metal2 5.95076e-05f
Cred_3824 VDD.$759.Metal1 vin.$69.GatPoly 1.47381e-06f
Cred_3825 VDD.$759.Metal1 vin.$691.Metal2 0.000162862f
Cred_3826 VDD.$759.Metal1 vin.$694.Metal2 0.00013254f
Cred_3827 VDD.$759.Metal1 vin.$698.Metal2 9.48837e-05f
Cred_3828 VDD.$759.Metal1 vin.$700.Metal2 0.000227152f
Cred_3829 VDD.$759.Metal1 vin.$703.Metal2 9.4633e-05f
Cred_3830 VDD.$759.Metal1 vin.$707.Metal2 0.000273797f
Cred_3831 VDD.$759.Metal1 vin.$710.Metal2 0.000215042f
Cred_3832 VDD.$759.Metal1 vin.$714.Metal2 0.000157436f
Cred_3833 VDD.$759.Metal1 vin.$716.Metal2 0.000388901f
Cred_3834 VDD.$759.Metal1 vin.$719.Metal2 0.000158795f
Cred_3835 VDD.$759.Metal1 vin.$723.Metal2 0.000475776f
Cred_3836 VDD.$759.Metal1 vin.$726.Metal2 0.000274429f
Cred_3837 VDD.$759.Metal1 vin.$728.Metal2 8.3145e-05f
Cred_3838 VDD.$759.Metal1 vin.$73.GatPoly 2.25766e-06f
Cred_3839 VDD.$759.Metal1 vin.$732.Metal2 0.000597026f
Cred_3840 VDD.$759.Metal1 vin.$733.Metal2 0.00045564f
Cred_3841 VDD.$759.Metal1 vin.$737.Metal2 0.000133456f
Cred_3842 VDD.$759.Metal1 vin.$739.Metal2 0.000792044f
Cred_3843 VDD.$759.Metal1 vin.$742.Metal2 0.000481447f
Cred_3844 VDD.$759.Metal1 vin.$744.Metal2 0.000128442f
Cred_3845 VDD.$759.Metal1 vin.$748.Metal2 0.000949381f
Cred_3846 VDD.$759.Metal1 vin.$749.Metal2 0.000770739f
Cred_3847 VDD.$759.Metal1 vin.$753.Metal2 0.000271092f
Cred_3848 VDD.$759.Metal1 vin.$755.Metal2 0.00130269f
Cred_3849 VDD.$759.Metal1 vin.$758.Metal2 0.000819479f
Cred_3850 VDD.$759.Metal1 vin.$760.Metal2 0.000216359f
Cred_3851 VDD.$759.Metal1 vin.$764.Metal2 0.00159542f
Cred_3852 VDD.$759.Metal1 vin.$765.Metal2 0.00129253f
Cred_3853 VDD.$759.Metal1 vin.$768.Metal2 3.98272e-05f
Cred_3854 VDD.$759.Metal1 vin.$769.Metal2 0.00436892f
Cred_3855 VDD.$759.Metal1 vin.$771.Metal2 0.00267491f
Cred_3856 VDD.$759.Metal1 vin.$79.GatPoly 1.9061e-06f
Cred_3857 VDD.$759.Metal1 vin.$83.GatPoly 2.78662e-06f
Cred_3858 VDD.$759.Metal1 vin.$89.GatPoly 2.46481e-06f
Cred_3859 VDD.$759.Metal1 vin.$93.GatPoly 3.77602e-06f
Cred_3860 VDD.$759.Metal1 vin.$99.GatPoly 3.18699e-06f
Cred_3861 VDD.$759.Metal1 vin.P100.GatPoly 5.77662e-07f
Cred_3862 VDD.$759.Metal1 vin.P102.GatPoly 4.77931e-06f
Cred_3863 VDD.$759.Metal1 vin.P103.GatPoly 9.65297e-07f
Cred_3864 VDD.$759.Metal1 vin.P104.GatPoly 9.65297e-07f
Cred_3865 VDD.$759.Metal1 vin.P105.GatPoly 7.1597e-06f
Cred_3866 VDD.$759.Metal1 vin.P107.GatPoly 0.0228159f
Cred_3867 VDD.$759.Metal1 vin.P53.GatPoly 6.60447e-09f
Cred_3868 VDD.$759.Metal1 vin.P54.GatPoly 1.52502e-08f
Cred_3869 VDD.$759.Metal1 vin.P56.GatPoly 1.32506e-08f
Cred_3870 VDD.$759.Metal1 vin.P57.GatPoly 2.38951e-09f
Cred_3871 VDD.$759.Metal1 vin.P59.GatPoly 3.10656e-09f
Cred_3872 VDD.$759.Metal1 vin.P61.GatPoly 4.02965e-09f
Cred_3873 VDD.$759.Metal1 vin.P63.GatPoly 5.21999e-09f
Cred_3874 VDD.$759.Metal1 vin.P65.GatPoly 6.75655e-09f
Cred_3875 VDD.$759.Metal1 vin.P67.GatPoly 8.74121e-09f
Cred_3876 VDD.$759.Metal1 vin.P69.GatPoly 1.13056e-08f
Cred_3877 VDD.$759.Metal1 vin.P71.GatPoly 1.46199e-08f
Cred_3878 VDD.$759.Metal1 vin.P73.GatPoly 1.89037e-08f
Cred_3879 VDD.$759.Metal1 vin.P75.GatPoly 2.44414e-08f
Cred_3880 VDD.$759.Metal1 vin.P77.GatPoly 3.16e-08f
Cred_3881 VDD.$759.Metal1 vin.P79.GatPoly 4.08545e-08f
Cred_3882 VDD.$759.Metal1 vin.P81.GatPoly 5.23364e-08f
Cred_3883 VDD.$759.Metal1 vin.P83.GatPoly 6.68082e-08f
Cred_3884 VDD.$759.Metal1 vin.P85.GatPoly 8.57108e-08f
Cred_3885 VDD.$759.Metal1 vin.P87.GatPoly 1.10298e-07f
Cred_3886 VDD.$759.Metal1 vin.P89.GatPoly 1.42201e-07f
Cred_3887 VDD.$759.Metal1 vin.P91.GatPoly 1.83534e-07f
Cred_3888 VDD.$759.Metal1 vin.P93.GatPoly 2.37041e-07f
Cred_3889 VDD.$759.Metal1 vin.P95.GatPoly 3.45816e-07f
Cred_3890 VDD.$759.Metal1 vin.P96.GatPoly 3.45816e-07f
Cred_3891 VDD.$759.Metal1 vin.P98.GatPoly 2.77569e-06f
Cred_3892 VDD.$759.Metal1 vin.P99.GatPoly 5.77662e-07f
Cred_3893 VDD.$759.Metal1 vout 0.0809629f
Cred_3894 VDD.$759.Metal1 vout.$1008.Metal3 9.21485e-06f
Cred_3895 VDD.$759.Metal1 vout.$1026.Metal3 1.54966e-05f
Cred_3896 VDD.$759.Metal1 vout.$1044.Metal3 2.69712e-05f
Cred_3897 VDD.$759.Metal1 vout.$1062.Metal3 4.62497e-05f
Cred_3898 VDD.$759.Metal1 vout.$1080.Metal3 7.41957e-05f
Cred_3899 VDD.$759.Metal1 vout.$1098.Metal3 0.000120198f
Cred_3900 VDD.$759.Metal1 vout.$1116.Metal3 0.000199078f
Cred_3901 VDD.$759.Metal1 vout.$1134.Metal3 0.00032544f
Cred_3902 VDD.$759.Metal1 vout.$1152.Metal3 0.000538106f
Cred_3903 VDD.$759.Metal1 vout.$1170.Metal3 0.000629898f
Cred_3904 VDD.$759.Metal1 vout.$954.Metal3 2.44163e-06f
Cred_3905 VDD.$759.Metal1 vout.$972.Metal3 3.1417e-06f
Cred_3906 VDD.$759.Metal1 vout.$990.Metal3 5.40229e-06f
Cred_3907 VDD.$759.Metal1 vout.P0.nSD 4.40378e-09f
Cred_3908 VDD.$759.Metal1 vout.P0.pSD 1.43639e-08f
Cred_3909 VDD.$759.Metal1 vout.P12.nSD 1.0804e-08f
Cred_3910 VDD.$759.Metal1 vout.P12.pSD 2.93077e-08f
Cred_3911 VDD.$759.Metal1 vout.P16.nSD 1.82689e-08f
Cred_3912 VDD.$759.Metal1 vout.P16.pSD 4.95575e-08f
Cred_3913 VDD.$759.Metal1 vout.P20.nSD 3.08701e-08f
Cred_3914 VDD.$759.Metal1 vout.P20.pSD 8.37404e-08f
Cred_3915 VDD.$759.Metal1 vout.P24.nSD 5.76758e-08f
Cred_3916 VDD.$759.Metal1 vout.P24.pSD 1.56455e-07f
Cred_3917 VDD.$759.Metal1 vout.P28.nSD 9.51345e-08f
Cred_3918 VDD.$759.Metal1 vout.P28.pSD 2.58068e-07f
Cred_3919 VDD.$759.Metal1 vout.P32.nSD 1.42666e-07f
Cred_3920 VDD.$759.Metal1 vout.P32.pSD 3.87006e-07f
Cred_3921 VDD.$759.Metal1 vout.P36.nSD 2.35063e-07f
Cred_3922 VDD.$759.Metal1 vout.P36.pSD 6.37648e-07f
Cred_3923 VDD.$759.Metal1 vout.P4.nSD 3.56148e-09f
Cred_3924 VDD.$759.Metal1 vout.P4.pSD 9.66112e-09f
Cred_3925 VDD.$759.Metal1 vout.P40.nSD 3.87242e-07f
Cred_3926 VDD.$759.Metal1 vout.P40.pSD 1.05046e-06f
Cred_3927 VDD.$759.Metal1 vout.P44.nSD 6.10176e-07f
Cred_3928 VDD.$759.Metal1 vout.P44.pSD 1.65521e-06f
Cred_3929 VDD.$759.Metal1 vout.P48.nSD 1.02256e-06f
Cred_3930 VDD.$759.Metal1 vout.P48.pSD 2.77387e-06f
Cred_3931 VDD.$759.Metal1 vout.P52.pSD 0.122023f
Cred_3932 VDD.$759.Metal1 vout.P8.nSD 5.99549e-09f
Cred_3933 VDD.$759.Metal1 vout.P8.pSD 1.62638e-08f
Cred_3934 VDD.$759.Metal1 VSS.$1048.Metal3 9.05627e-05f
Cred_3935 VDD.$759.Metal1 VSS.$14.Metal1 8.25575e-06f
Cred_3936 VDD.$759.Metal1 VSS.$29.Metal1 1.42408e-05f
Cred_3937 VDD.$759.Metal1 VSS.$490.Metal1 9.27049e-09f
Cred_3938 VDD.$759.Metal1 VSS.$496.Metal1 1.16765e-09f
Cred_3939 VDD.$759.Metal1 VSS.$500.Metal1 0.000528415f
Cred_3940 VDD.$759.Metal1 VSS.$520.Metal1 0.00596075f
Cred_3941 VDD.$759.Metal1 VSS.$531.Metal2 5.11152e-08f
Cred_3942 VDD.$759.Metal1 VSS.$895.Metal2 1.27096e-06f
Cred_3943 VDD.$759.Metal1 VSS.$904.Metal2 0.00110823f
Cred_3944 VDD.$759.Metal1 VSS.P0.nSD 3.6324e-09f
Cred_3945 VDD.$759.Metal1 VSS.P0.pSD 0.0137787f
Cred_3946 VDD.$759.Metal1 VSS.P1.nSD 3.6324e-09f
Cred_3947 VDD.$759.Metal1 VSS.P55.nSD 5.3422e-06f
Cred_3948 VDD.$759.Metal1 VSS.P57.nSD 5.3422e-06f
Cred_3949 VDD.$761.Metal1 vin.$259.GatPoly 3.0667e-06f
Cred_3950 VDD.$761.Metal1 vin.$549.Metal1 0.000139428f
Cred_3951 VDD.$761.Metal1 vin.$769.Metal2 8.50291e-06f
Cred_3952 VDD.$761.Metal1 vin.$771.Metal2 2.65935e-06f
Cred_3953 VDD.$761.Metal1 vin.P107.GatPoly 0.000426449f
Cred_3954 VDD.$765.Metal1 vin.P100.GatPoly 0.00096106f
Cred_3955 VDD.$765.Metal1 vin.P101.GatPoly 0.00110513f
Cred_3956 VDD.$765.Metal1 vin.P102.GatPoly 0.00130002f
Cred_3957 VDD.$765.Metal1 vin.P103.GatPoly 0.00157836f
Cred_3958 VDD.$765.Metal1 vin.P104.GatPoly 0.00200836f
Cred_3959 VDD.$765.Metal1 vin.P105.GatPoly 0.00276039f
Cred_3960 VDD.$765.Metal1 vin.P106.GatPoly 0.00441274f
Cred_3961 VDD.$765.Metal1 vin.P107.GatPoly 0.0289877f
Cred_3962 VDD.$765.Metal1 vout 0.00411895f
Cred_3963 VDD.$765.Metal1 vout.P52.pSD 0.00675253f
Cred_3964 VDD.$807.Metal2 vin.P54.GatPoly 0.000233023f
Cred_3965 VDD.$807.Metal2 vout.$954.Metal3 0.0129398f
Cred_3966 VDD.$807.Metal2 vout.P0.nSD 5.83349e-05f
Cred_3967 VDD.$807.Metal2 vout.P0.pSD 0.00520849f
Cred_3968 VDD.$819.Metal2 vin.$271.Metal1 0.00294758f
Cred_3969 VDD.$819.Metal2 vin.$274.Metal1 3.3244e-05f
Cred_3970 VDD.$819.Metal2 vin.$4.GatPoly 6.99338e-07f
Cred_3971 VDD.$819.Metal2 vin.$5.GatPoly 0.000805263f
Cred_3972 VDD.$819.Metal2 vin.$564.Metal2 0.0014118f
Cred_3973 VDD.$819.Metal2 vin.$566.Metal2 0.0250793f
Cred_3974 VDD.$819.Metal2 vin.$569.Metal2 1.44558e-07f
Cred_3975 VDD.$819.Metal2 vin.P0.GatPoly 8.97551e-08f
Cred_3976 VDD.$819.Metal2 vin.P54.GatPoly 0.00226906f
Cred_3977 VDD.$819.Metal2 vout.$954.Metal3 0.299781f
Cred_3978 VDD.$819.Metal2 vout.P0.nSD 0.00135147f
Cred_3979 VDD.$819.Metal2 vout.P0.pSD 0.124341f
Cred_3980 VDD.$819.Metal2 VSS.$14.Metal1 0.000390959f
Cred_3981 VDD.$819.Metal2 VSS.$29.Metal1 0.00174528f
Cred_3982 VDD.$819.Metal2 VSS.$31.Metal1 1.67274e-07f
Cred_3983 VDD.$819.Metal2 VSS.$520.Metal1 4.20178e-07f
Cred_3984 VDD.$819.Metal2 VSS.$531.Metal2 0.0218359f
Cred_3985 VDD.$819.Metal2 VSS.$540.Metal2 4.5689e-05f
Cred_3986 VDD.$819.Metal2 VSS.$916.Metal3 0.00325145f
Cred_3987 VDD.$819.Metal2 VSS.P0.nSD 8.06457e-06f
Cred_3988 VDD.$819.Metal2 VSS.P0.pSD 0.00122318f
Cred_3989 VDD.$819.Metal2 VSS.P1.nSD 8.06457e-06f
Cred_3990 VDD.$822.Metal2 vin.$271.Metal1 1.96862e-05f
Cred_3991 VDD.$822.Metal2 vin.$5.GatPoly 1.10595e-07f
Cred_3992 VDD.$822.Metal2 vin.$566.Metal2 0.00144566f
Cred_3993 VDD.$822.Metal2 vin.P54.GatPoly 0.00173984f
Cred_3994 VDD.$822.Metal2 vout.$954.Metal3 0.00118403f
Cred_3995 VDD.$822.Metal2 vout.P0.nSD 5.33785e-06f
Cred_3996 VDD.$822.Metal2 vout.P0.pSD 0.00106663f
Cred_3997 VDD.$836.Metal2 vin 0.000162006f
Cred_3998 VDD.$836.Metal2 vin.$13.GatPoly 7.88776e-05f
Cred_3999 VDD.$836.Metal2 vin.$271.Metal1 5.01699e-05f
Cred_4000 VDD.$836.Metal2 vin.$274.Metal1 5.94654e-07f
Cred_4001 VDD.$836.Metal2 vin.$275.Metal1 0.000433795f
Cred_4002 VDD.$836.Metal2 vin.$279.Metal1 5.0989e-05f
Cred_4003 VDD.$836.Metal2 vin.$4.GatPoly 4.24301e-09f
Cred_4004 VDD.$836.Metal2 vin.$5.GatPoly 0.000275642f
Cred_4005 VDD.$836.Metal2 vin.$564.Metal2 3.65013e-05f
Cred_4006 VDD.$836.Metal2 vin.$566.Metal2 0.00262075f
Cred_4007 VDD.$836.Metal2 vin.$569.Metal2 3.4827e-05f
Cred_4008 VDD.$836.Metal2 vin.$573.Metal2 0.00101062f
Cred_4009 VDD.$836.Metal2 vin.$574.Metal2 7.5319e-06f
Cred_4010 VDD.$836.Metal2 vin.$581.Metal2 3.85394e-05f
Cred_4011 VDD.$836.Metal2 vin.P0.GatPoly 3.98513e-10f
Cred_4012 VDD.$836.Metal2 vin.P54.GatPoly 0.00184082f
Cred_4013 VDD.$836.Metal2 vin.P55.GatPoly 0.000642483f
Cred_4014 VDD.$836.Metal2 vin.P56.GatPoly 0.00079105f
Cred_4015 VDD.$836.Metal2 vout.$954.Metal3 0.0411496f
Cred_4016 VDD.$836.Metal2 vout.P0.nSD 0.000105764f
Cred_4017 VDD.$836.Metal2 vout.P0.pSD 0.014754f
Cred_4018 VDD.$836.Metal2 vout.P2.pSD 0.00923297f
Cred_4019 VDD.$847.Metal2 vin 0.00149855f
Cred_4020 VDD.$847.Metal2 vin.$13.GatPoly 0.000729618f
Cred_4021 VDD.$847.Metal2 vin.$271.Metal1 0.000271406f
Cred_4022 VDD.$847.Metal2 vin.$274.Metal1 5.50055e-06f
Cred_4023 VDD.$847.Metal2 vin.$275.Metal1 0.0040126f
Cred_4024 VDD.$847.Metal2 vin.$279.Metal1 0.000471648f
Cred_4025 VDD.$847.Metal2 vin.$4.GatPoly 3.92478e-08f
Cred_4026 VDD.$847.Metal2 vin.$5.GatPoly 0.00254861f
Cred_4027 VDD.$847.Metal2 vin.$564.Metal2 0.000337637f
Cred_4028 VDD.$847.Metal2 vin.$566.Metal2 0.0100935f
Cred_4029 VDD.$847.Metal2 vin.$569.Metal2 0.000322149f
Cred_4030 VDD.$847.Metal2 vin.$573.Metal2 0.00934825f
Cred_4031 VDD.$847.Metal2 vin.$574.Metal2 6.96701e-05f
Cred_4032 VDD.$847.Metal2 vin.$581.Metal2 0.00035649f
Cred_4033 VDD.$847.Metal2 vin.P0.GatPoly 3.68624e-09f
Cred_4034 VDD.$847.Metal2 vin.P55.GatPoly 0.00579019f
Cred_4035 VDD.$847.Metal2 vin.P56.GatPoly 0.00729769f
Cred_4036 VDD.$847.Metal2 vout.$954.Metal3 0.325389f
Cred_4037 VDD.$847.Metal2 vout.P0.nSD 0.000715235f
Cred_4038 VDD.$847.Metal2 vout.P0.pSD 0.0902333f
Cred_4039 VDD.$847.Metal2 vout.P2.pSD 0.0878345f
Cred_4040 VDD.$855.Metal2 vin 0.000268541f
Cred_4041 VDD.$855.Metal2 vin.$13.GatPoly 0.00147177f
Cred_4042 VDD.$855.Metal2 vin.$19.GatPoly 0.00199456f
Cred_4043 VDD.$855.Metal2 vin.$279.Metal1 4.88936e-06f
Cred_4044 VDD.$855.Metal2 vin.$284.Metal1 5.22879e-06f
Cred_4045 VDD.$855.Metal2 vin.$285.Metal1 0.00334934f
Cred_4046 VDD.$855.Metal2 vin.$288.Metal1 7.97613e-07f
Cred_4047 VDD.$855.Metal2 vin.$289.Metal1 0.000172921f
Cred_4048 VDD.$855.Metal2 vin.$569.Metal2 2.88277e-05f
Cred_4049 VDD.$855.Metal2 vin.$573.Metal2 0.00108843f
Cred_4050 VDD.$855.Metal2 vin.$574.Metal2 0.00035402f
Cred_4051 VDD.$855.Metal2 vin.$577.Metal2 0.0121344f
Cred_4052 VDD.$855.Metal2 vin.$578.Metal2 0.000301335f
Cred_4053 VDD.$855.Metal2 vin.$581.Metal2 0.000978993f
Cred_4054 VDD.$855.Metal2 vin.P57.GatPoly 0.00691669f
Cred_4055 VDD.$855.Metal2 vin.P58.GatPoly 0.00565774f
Cred_4056 VDD.$855.Metal2 vout.$954.Metal3 0.184926f
Cred_4057 VDD.$855.Metal2 vout.$972.Metal3 0.0595034f
Cred_4058 VDD.$855.Metal2 vout.P2.pSD 0.0718136f
Cred_4059 VDD.$855.Metal2 vout.P4.nSD 0.00035744f
Cred_4060 VDD.$855.Metal2 vout.P4.pSD 0.0685572f
Cred_4061 VDD.$86.Metal1 vin 0.000781222f
Cred_4062 VDD.$86.Metal1 vin.$13.GatPoly 0.00218842f
Cred_4063 VDD.$86.Metal1 vin.$271.Metal1 0.000726634f
Cred_4064 VDD.$86.Metal1 vin.$274.Metal1 2.86754e-06f
Cred_4065 VDD.$86.Metal1 vin.$275.Metal1 0.0144751f
Cred_4066 VDD.$86.Metal1 vin.$279.Metal1 0.00119329f
Cred_4067 VDD.$86.Metal1 vin.$4.GatPoly 2.04606e-08f
Cred_4068 VDD.$86.Metal1 vin.$5.GatPoly 0.0076443f
Cred_4069 VDD.$86.Metal1 vin.$564.Metal2 0.000176016f
Cred_4070 VDD.$86.Metal1 vin.$566.Metal2 0.0044815f
Cred_4071 VDD.$86.Metal1 vin.$569.Metal2 0.000167942f
Cred_4072 VDD.$86.Metal1 vin.$573.Metal2 0.00392173f
Cred_4073 VDD.$86.Metal1 vin.$574.Metal2 3.63203e-05f
Cred_4074 VDD.$86.Metal1 vin.$581.Metal2 0.000185844f
Cred_4075 VDD.$86.Metal1 vin.P0.GatPoly 1.9217e-09f
Cred_4076 VDD.$86.Metal1 vin.P55.GatPoly 0.0220933f
Cred_4077 VDD.$86.Metal1 vin.P56.GatPoly 0.0229266f
Cred_4078 VDD.$86.Metal1 vout.$954.Metal3 0.266872f
Cred_4079 VDD.$86.Metal1 vout.P0.nSD 0.000595425f
Cred_4080 VDD.$86.Metal1 vout.P0.pSD 0.1488f
Cred_4081 VDD.$86.Metal1 vout.P2.pSD 0.14197f
Cred_4082 VDD.$866.Metal2 vin 0.000171866f
Cred_4083 VDD.$866.Metal2 vin.$13.GatPoly 0.000941924f
Cred_4084 VDD.$866.Metal2 vin.$19.GatPoly 0.00127652f
Cred_4085 VDD.$866.Metal2 vin.$279.Metal1 2.38436e-06f
Cred_4086 VDD.$866.Metal2 vin.$284.Metal1 3.34643e-06f
Cred_4087 VDD.$866.Metal2 vin.$285.Metal1 0.00214283f
Cred_4088 VDD.$866.Metal2 vin.$288.Metal1 5.10472e-07f
Cred_4089 VDD.$866.Metal2 vin.$289.Metal1 0.00011341f
Cred_4090 VDD.$866.Metal2 vin.$569.Metal2 1.84497e-05f
Cred_4091 VDD.$866.Metal2 vin.$573.Metal2 0.000696585f
Cred_4092 VDD.$866.Metal2 vin.$574.Metal2 0.000226573f
Cred_4093 VDD.$866.Metal2 vin.$577.Metal2 0.00776603f
Cred_4094 VDD.$866.Metal2 vin.$578.Metal2 0.000192855f
Cred_4095 VDD.$866.Metal2 vin.$581.Metal2 0.000626556f
Cred_4096 VDD.$866.Metal2 vin.P57.GatPoly 0.00441992f
Cred_4097 VDD.$866.Metal2 vin.P58.GatPoly 0.00363738f
Cred_4098 VDD.$866.Metal2 vin.P59.GatPoly 4.0637e-06f
Cred_4099 VDD.$866.Metal2 vout.$954.Metal3 0.117525f
Cred_4100 VDD.$866.Metal2 vout.$972.Metal3 0.0392648f
Cred_4101 VDD.$866.Metal2 vout.P2.pSD 0.0444033f
Cred_4102 VDD.$866.Metal2 vout.P4.nSD 0.000235866f
Cred_4103 VDD.$866.Metal2 vout.P4.pSD 0.046153f
Cred_4104 VDD.$87.Metal1 vin.P55.GatPoly 0.00285465f
Cred_4105 VDD.$87.Metal1 vin.P56.GatPoly 0.00202905f
Cred_4106 VDD.$87.Metal1 vout.$954.Metal3 0.00196964f
Cred_4107 VDD.$87.Metal1 vout.P0.nSD 8.87952e-06f
Cred_4108 VDD.$87.Metal1 vout.P0.pSD 0.00302372f
Cred_4109 VDD.$870.Metal2 vin.$23.GatPoly 0.00029504f
Cred_4110 VDD.$870.Metal2 vin.$289.Metal1 2.08424e-05f
Cred_4111 VDD.$870.Metal2 vin.$29.GatPoly 0.000412504f
Cred_4112 VDD.$870.Metal2 vin.$297.Metal1 0.000712971f
Cred_4113 VDD.$870.Metal2 vin.$301.Metal1 4.63103e-06f
Cred_4114 VDD.$870.Metal2 vin.$579.Metal2 1.30966e-07f
Cred_4115 VDD.$870.Metal2 vin.$581.Metal2 0.000134028f
Cred_4116 VDD.$870.Metal2 vin.$583.Metal2 9.41287e-05f
Cred_4117 VDD.$870.Metal2 vin.$584.Metal2 0.00220902f
Cred_4118 VDD.$870.Metal2 vin.$588.Metal2 0.000162244f
Cred_4119 VDD.$870.Metal2 vin.$589.Metal2 0.000539444f
Cred_4120 VDD.$870.Metal2 vin.P58.GatPoly 5.45921e-06f
Cred_4121 VDD.$870.Metal2 vin.P59.GatPoly 0.00113872f
Cred_4122 VDD.$870.Metal2 vin.P60.GatPoly 0.00134347f
Cred_4123 VDD.$870.Metal2 vout.$954.Metal3 0.0144134f
Cred_4124 VDD.$870.Metal2 vout.$972.Metal3 0.0385031f
Cred_4125 VDD.$870.Metal2 vout.P4.nSD 8.65821e-05f
Cred_4126 VDD.$870.Metal2 vout.P4.pSD 0.0174706f
Cred_4127 VDD.$870.Metal2 vout.P6.pSD 0.0135379f
Cred_4128 VDD.$881.Metal2 vin.$23.GatPoly 0.00212429f
Cred_4129 VDD.$881.Metal2 vin.$289.Metal1 0.000140884f
Cred_4130 VDD.$881.Metal2 vin.$29.GatPoly 0.00297003f
Cred_4131 VDD.$881.Metal2 vin.$297.Metal1 0.00513339f
Cred_4132 VDD.$881.Metal2 vin.$301.Metal1 3.33434e-05f
Cred_4133 VDD.$881.Metal2 vin.$579.Metal2 9.42953e-07f
Cred_4134 VDD.$881.Metal2 vin.$581.Metal2 0.000965f
Cred_4135 VDD.$881.Metal2 vin.$583.Metal2 0.000677727f
Cred_4136 VDD.$881.Metal2 vin.$584.Metal2 0.0159049f
Cred_4137 VDD.$881.Metal2 vin.$588.Metal2 0.00116816f
Cred_4138 VDD.$881.Metal2 vin.$589.Metal2 0.003884f
Cred_4139 VDD.$881.Metal2 vin.P59.GatPoly 0.00812128f
Cred_4140 VDD.$881.Metal2 vin.P60.GatPoly 0.00967959f
Cred_4141 VDD.$881.Metal2 vout.$954.Metal3 0.0861855f
Cred_4142 VDD.$881.Metal2 vout.$972.Metal3 0.262795f
Cred_4143 VDD.$881.Metal2 vout.P4.nSD 0.000517721f
Cred_4144 VDD.$881.Metal2 vout.P4.pSD 0.0995233f
Cred_4145 VDD.$881.Metal2 vout.P6.pSD 0.0999439f
Cred_4146 VDD.$889.Metal2 vin.$301.Metal1 5.56996e-06f
Cred_4147 VDD.$889.Metal2 vin.$306.Metal1 5.25185e-06f
Cred_4148 VDD.$889.Metal2 vin.$307.Metal1 0.0034573f
Cred_4149 VDD.$889.Metal2 vin.$310.Metal1 1.01352e-06f
Cred_4150 VDD.$889.Metal2 vin.$311.Metal1 0.00020641f
Cred_4151 VDD.$889.Metal2 vin.$33.GatPoly 0.00153076f
Cred_4152 VDD.$889.Metal2 vin.$39.GatPoly 0.00207449f
Cred_4153 VDD.$889.Metal2 vin.$588.Metal2 0.000620298f
Cred_4154 VDD.$889.Metal2 vin.$589.Metal2 0.00101985f
Cred_4155 VDD.$889.Metal2 vin.$590.Metal2 0.000313412f
Cred_4156 VDD.$889.Metal2 vin.$593.Metal2 0.012806f
Cred_4157 VDD.$889.Metal2 vin.$594.Metal2 0.000313412f
Cred_4158 VDD.$889.Metal2 vin.$597.Metal2 0.000745202f
Cred_4159 VDD.$889.Metal2 vin.P61.GatPoly 0.007133f
Cred_4160 VDD.$889.Metal2 vin.P62.GatPoly 0.00586419f
Cred_4161 VDD.$889.Metal2 vout.$972.Metal3 0.191343f
Cred_4162 VDD.$889.Metal2 vout.$990.Metal3 0.0618619f
Cred_4163 VDD.$889.Metal2 vout.P6.pSD 0.0732769f
Cred_4164 VDD.$889.Metal2 vout.P8.nSD 0.000371608f
Cred_4165 VDD.$889.Metal2 vout.P8.pSD 0.0713015f
Cred_4166 VDD.$900.Metal2 vin.$301.Metal1 2.58831e-06f
Cred_4167 VDD.$900.Metal2 vin.$306.Metal1 3.02991e-06f
Cred_4168 VDD.$900.Metal2 vin.$307.Metal1 0.00199397f
Cred_4169 VDD.$900.Metal2 vin.$310.Metal1 5.8472e-07f
Cred_4170 VDD.$900.Metal2 vin.$311.Metal1 0.000121701f
Cred_4171 VDD.$900.Metal2 vin.$33.GatPoly 0.000883122f
Cred_4172 VDD.$900.Metal2 vin.$39.GatPoly 0.00119682f
Cred_4173 VDD.$900.Metal2 vin.$588.Metal2 0.000357864f
Cred_4174 VDD.$900.Metal2 vin.$589.Metal2 0.000588364f
Cred_4175 VDD.$900.Metal2 vin.$590.Metal2 0.000180815f
Cred_4176 VDD.$900.Metal2 vin.$593.Metal2 0.0073881f
Cred_4177 VDD.$900.Metal2 vin.$594.Metal2 0.000180815f
Cred_4178 VDD.$900.Metal2 vin.$597.Metal2 0.000429924f
Cred_4179 VDD.$900.Metal2 vin.P61.GatPoly 0.00410976f
Cred_4180 VDD.$900.Metal2 vin.P62.GatPoly 0.00339983f
Cred_4181 VDD.$900.Metal2 vin.P63.GatPoly 4.17377e-06f
Cred_4182 VDD.$900.Metal2 vout.$972.Metal3 0.109877f
Cred_4183 VDD.$900.Metal2 vout.$990.Metal3 0.0369996f
Cred_4184 VDD.$900.Metal2 vout.P6.pSD 0.0408479f
Cred_4185 VDD.$900.Metal2 vout.P8.nSD 0.000222259f
Cred_4186 VDD.$900.Metal2 vout.P8.pSD 0.0435386f
Cred_4187 VDD.$904.Metal2 vin.$311.Metal1 2.7153e-05f
Cred_4188 VDD.$904.Metal2 vin.$319.Metal1 0.000859553f
Cred_4189 VDD.$904.Metal2 vin.$323.Metal1 5.43354e-06f
Cred_4190 VDD.$904.Metal2 vin.$43.GatPoly 0.000354002f
Cred_4191 VDD.$904.Metal2 vin.$49.GatPoly 0.000479344f
Cred_4192 VDD.$904.Metal2 vin.$595.Metal2 1.88809e-07f
Cred_4193 VDD.$904.Metal2 vin.$597.Metal2 0.00019042f
Cred_4194 VDD.$904.Metal2 vin.$599.Metal2 0.000119029f
Cred_4195 VDD.$904.Metal2 vin.$600.Metal2 0.00274237f
Cred_4196 VDD.$904.Metal2 vin.$604.Metal2 0.00016503f
Cred_4197 VDD.$904.Metal2 vin.$605.Metal2 0.00055031f
Cred_4198 VDD.$904.Metal2 vin.P62.GatPoly 5.3779e-06f
Cred_4199 VDD.$904.Metal2 vin.P63.GatPoly 0.00135981f
Cred_4200 VDD.$904.Metal2 vin.P64.GatPoly 0.00161099f
Cred_4201 VDD.$904.Metal2 vout.$972.Metal3 0.016596f
Cred_4202 VDD.$904.Metal2 vout.$990.Metal3 0.0456954f
Cred_4203 VDD.$904.Metal2 vout.P10.pSD 0.016557f
Cred_4204 VDD.$904.Metal2 vout.P8.nSD 9.96931e-05f
Cred_4205 VDD.$904.Metal2 vout.P8.pSD 0.0197911f
Cred_4206 VDD.$91.Metal1 vin.$13.GatPoly 1.79422e-06f
Cred_4207 VDD.$91.Metal1 vin.$279.Metal1 0.000150915f
Cred_4208 VDD.$91.Metal1 vin.$285.Metal1 0.000151117f
Cred_4209 VDD.$91.Metal1 vin.$573.Metal2 2.03327e-06f
Cred_4210 VDD.$91.Metal1 vin.$577.Metal2 7.19084e-07f
Cred_4211 VDD.$91.Metal1 vin.P56.GatPoly 0.0010521f
Cred_4212 VDD.$91.Metal1 vin.P57.GatPoly 0.00117167f
Cred_4213 VDD.$91.Metal1 vout.$954.Metal3 0.00531525f
Cred_4214 VDD.$91.Metal1 vout.P2.pSD 0.00847842f
Cred_4215 VDD.$915.Metal2 vin.$311.Metal1 0.00015139f
Cred_4216 VDD.$915.Metal2 vin.$319.Metal1 0.00501422f
Cred_4217 VDD.$915.Metal2 vin.$323.Metal1 3.22502e-05f
Cred_4218 VDD.$915.Metal2 vin.$43.GatPoly 0.00206501f
Cred_4219 VDD.$915.Metal2 vin.$49.GatPoly 0.00279617f
Cred_4220 VDD.$915.Metal2 vin.$595.Metal2 1.10139e-06f
Cred_4221 VDD.$915.Metal2 vin.$597.Metal2 0.00111078f
Cred_4222 VDD.$915.Metal2 vin.$599.Metal2 0.000694337f
Cred_4223 VDD.$915.Metal2 vin.$600.Metal2 0.0159971f
Cred_4224 VDD.$915.Metal2 vin.$604.Metal2 0.000962676f
Cred_4225 VDD.$915.Metal2 vin.$605.Metal2 0.00321014f
Cred_4226 VDD.$915.Metal2 vin.P63.GatPoly 0.00786921f
Cred_4227 VDD.$915.Metal2 vin.P64.GatPoly 0.00940475f
Cred_4228 VDD.$915.Metal2 vout.$972.Metal3 0.0831918f
Cred_4229 VDD.$915.Metal2 vout.$990.Metal3 0.256106f
Cred_4230 VDD.$915.Metal2 vout.P10.pSD 0.099059f
Cred_4231 VDD.$915.Metal2 vout.P8.nSD 0.000499738f
Cred_4232 VDD.$915.Metal2 vout.P8.pSD 0.0948897f
Cred_4233 VDD.$923.Metal2 vin.$323.Metal1 5.21871e-06f
Cred_4234 VDD.$923.Metal2 vin.$328.Metal1 5.26098e-06f
Cred_4235 VDD.$923.Metal2 vin.$329.Metal1 0.00356751f
Cred_4236 VDD.$923.Metal2 vin.$332.Metal1 1.2435e-06f
Cred_4237 VDD.$923.Metal2 vin.$333.Metal1 0.00023691f
Cred_4238 VDD.$923.Metal2 vin.$53.GatPoly 0.00158977f
Cred_4239 VDD.$923.Metal2 vin.$59.GatPoly 0.00215446f
Cred_4240 VDD.$923.Metal2 vin.$604.Metal2 0.000855862f
Cred_4241 VDD.$923.Metal2 vin.$605.Metal2 0.00115054f
Cred_4242 VDD.$923.Metal2 vin.$606.Metal2 0.000325496f
Cred_4243 VDD.$923.Metal2 vin.$609.Metal2 0.0130894f
Cred_4244 VDD.$923.Metal2 vin.$610.Metal2 0.000325496f
Cred_4245 VDD.$923.Metal2 vin.$613.Metal2 0.000741745f
Cred_4246 VDD.$923.Metal2 vin.P65.GatPoly 0.00733092f
Cred_4247 VDD.$923.Metal2 vin.P66.GatPoly 0.00607532f
Cred_4248 VDD.$923.Metal2 vout.$1008.Metal3 0.0643771f
Cred_4249 VDD.$923.Metal2 vout.$990.Metal3 0.198451f
Cred_4250 VDD.$923.Metal2 vout.P10.pSD 0.0755928f
Cred_4251 VDD.$923.Metal2 vout.P12.nSD 0.000386717f
Cred_4252 VDD.$923.Metal2 vout.P12.pSD 0.0744698f
Cred_4253 VDD.$934.Metal2 vin.$323.Metal1 2.18538e-06f
Cred_4254 VDD.$934.Metal2 vin.$328.Metal1 2.72791e-06f
Cred_4255 VDD.$934.Metal2 vin.$329.Metal1 0.0018493f
Cred_4256 VDD.$934.Metal2 vin.$332.Metal1 6.4478e-07f
Cred_4257 VDD.$934.Metal2 vin.$333.Metal1 0.000125341f
Cred_4258 VDD.$934.Metal2 vin.$53.GatPoly 0.000824317f
Cred_4259 VDD.$934.Metal2 vin.$59.GatPoly 0.00111713f
Cred_4260 VDD.$934.Metal2 vin.$604.Metal2 0.00044378f
Cred_4261 VDD.$934.Metal2 vin.$605.Metal2 0.00059657f
Cred_4262 VDD.$934.Metal2 vin.$606.Metal2 0.000168776f
Cred_4263 VDD.$934.Metal2 vin.$609.Metal2 0.00678707f
Cred_4264 VDD.$934.Metal2 vin.$610.Metal2 0.000168776f
Cred_4265 VDD.$934.Metal2 vin.$613.Metal2 0.000384608f
Cred_4266 VDD.$934.Metal2 vin.P65.GatPoly 0.00379698f
Cred_4267 VDD.$934.Metal2 vin.P66.GatPoly 0.00316701f
Cred_4268 VDD.$934.Metal2 vin.P67.GatPoly 4.27984e-06f
Cred_4269 VDD.$934.Metal2 vout.$1008.Metal3 0.0348156f
Cred_4270 VDD.$934.Metal2 vout.$990.Metal3 0.102696f
Cred_4271 VDD.$934.Metal2 vout.P10.pSD 0.037911f
Cred_4272 VDD.$934.Metal2 vout.P12.nSD 0.000209139f
Cred_4273 VDD.$934.Metal2 vout.P12.pSD 0.0411433f
Cred_4274 VDD.$938.Metal2 vin.$333.Metal1 1.12781e-06f
Cred_4275 VDD.$938.Metal2 vin.$337.Metal1 7.73799e-05f
Cred_4276 VDD.$938.Metal2 vin.$341.Metal1 0.000946961f
Cred_4277 VDD.$938.Metal2 vin.$611.Metal2 0.00136895f
Cred_4278 VDD.$938.Metal2 vin.$613.Metal2 0.000289778f
Cred_4279 VDD.$938.Metal2 vin.$615.Metal2 0.00014588f
Cred_4280 VDD.$938.Metal2 vin.$618.Metal2 0.00236237f
Cred_4281 VDD.$938.Metal2 vin.$620.Metal2 0.000207304f
Cred_4282 VDD.$938.Metal2 vin.$63.GatPoly 0.000412558f
Cred_4283 VDD.$938.Metal2 vin.$69.GatPoly 0.000559123f
Cred_4284 VDD.$938.Metal2 vin.P66.GatPoly 5.29261e-06f
Cred_4285 VDD.$938.Metal2 vin.P67.GatPoly 0.00158004f
Cred_4286 VDD.$938.Metal2 vin.P68.GatPoly 0.00187997f
Cred_4287 VDD.$938.Metal2 vout.$1008.Metal3 0.0526839f
Cred_4288 VDD.$938.Metal2 vout.$990.Metal3 0.0189724f
Cred_4289 VDD.$938.Metal2 vout.P12.nSD 0.000113968f
Cred_4290 VDD.$938.Metal2 vout.P12.pSD 0.0227436f
Cred_4291 VDD.$938.Metal2 vout.P14.pSD 0.0189453f
Cred_4292 VDD.$949.Metal2 vin.$337.Metal1 0.000375845f
Cred_4293 VDD.$949.Metal2 vin.$341.Metal1 0.00459969f
Cred_4294 VDD.$949.Metal2 vin.$345.Metal1 7.02815e-07f
Cred_4295 VDD.$949.Metal2 vin.$611.Metal2 0.00664921f
Cred_4296 VDD.$949.Metal2 vin.$613.Metal2 0.00140749f
Cred_4297 VDD.$949.Metal2 vin.$615.Metal2 0.00070856f
Cred_4298 VDD.$949.Metal2 vin.$618.Metal2 0.0114744f
Cred_4299 VDD.$949.Metal2 vin.$620.Metal2 0.00100691f
Cred_4300 VDD.$949.Metal2 vin.$63.GatPoly 0.00200385f
Cred_4301 VDD.$949.Metal2 vin.$69.GatPoly 0.00271574f
Cred_4302 VDD.$949.Metal2 vin.P67.GatPoly 0.00762193f
Cred_4303 VDD.$949.Metal2 vin.P68.GatPoly 0.00913898f
Cred_4304 VDD.$949.Metal2 vout.$1008.Metal3 0.248257f
Cred_4305 VDD.$949.Metal2 vout.$990.Metal3 0.0813455f
Cred_4306 VDD.$949.Metal2 vout.P12.nSD 0.000488647f
Cred_4307 VDD.$949.Metal2 vout.P12.pSD 0.0939524f
Cred_4308 VDD.$949.Metal2 vout.P14.pSD 0.0945005f
Cred_4309 VDD.$957.Metal2 vin.$345.Metal1 9.25944e-07f
Cred_4310 VDD.$957.Metal2 vin.$350.Metal1 5.25618e-06f
Cred_4311 VDD.$957.Metal2 vin.$351.Metal1 0.00377871f
Cred_4312 VDD.$957.Metal2 vin.$354.Metal1 1.4876e-06f
Cred_4313 VDD.$957.Metal2 vin.$355.Metal1 0.000292543f
Cred_4314 VDD.$957.Metal2 vin.$620.Metal2 0.000825942f
Cred_4315 VDD.$957.Metal2 vin.$622.Metal2 0.000337586f
Cred_4316 VDD.$957.Metal2 vin.$623.Metal2 0.00787135f
Cred_4317 VDD.$957.Metal2 vin.$626.Metal2 0.000337586f
Cred_4318 VDD.$957.Metal2 vin.$627.Metal2 0.0065075f
Cred_4319 VDD.$957.Metal2 vin.$629.Metal2 0.000825069f
Cred_4320 VDD.$957.Metal2 vin.$73.GatPoly 0.00164876f
Cred_4321 VDD.$957.Metal2 vin.$79.GatPoly 0.00223448f
Cred_4322 VDD.$957.Metal2 vin.P69.GatPoly 0.00752707f
Cred_4323 VDD.$957.Metal2 vin.P70.GatPoly 0.00629116f
Cred_4324 VDD.$957.Metal2 vout.$1008.Metal3 0.205831f
Cred_4325 VDD.$957.Metal2 vout.$1026.Metal3 0.0666327f
Cred_4326 VDD.$957.Metal2 vout.P14.pSD 0.078744f
Cred_4327 VDD.$957.Metal2 vout.P16.nSD 0.000400266f
Cred_4328 VDD.$957.Metal2 vout.P16.pSD 0.0768006f
Cred_4329 VDD.$968.Metal2 vin.$350.Metal1 2.44037e-06f
Cred_4330 VDD.$968.Metal2 vin.$351.Metal1 0.00175396f
Cred_4331 VDD.$968.Metal2 vin.$354.Metal1 6.90671e-07f
Cred_4332 VDD.$968.Metal2 vin.$355.Metal1 0.000135824f
Cred_4333 VDD.$968.Metal2 vin.$620.Metal2 0.000383473f
Cred_4334 VDD.$968.Metal2 vin.$622.Metal2 0.000156736f
Cred_4335 VDD.$968.Metal2 vin.$623.Metal2 0.00365455f
Cred_4336 VDD.$968.Metal2 vin.$626.Metal2 0.000156736f
Cred_4337 VDD.$968.Metal2 vin.$627.Metal2 0.00302134f
Cred_4338 VDD.$968.Metal2 vin.$629.Metal2 0.000383068f
Cred_4339 VDD.$968.Metal2 vin.$73.GatPoly 0.00076549f
Cred_4340 VDD.$968.Metal2 vin.$79.GatPoly 0.00103744f
Cred_4341 VDD.$968.Metal2 vin.P69.GatPoly 0.00349154f
Cred_4342 VDD.$968.Metal2 vin.P70.GatPoly 0.00293791f
Cred_4343 VDD.$968.Metal2 vin.P71.GatPoly 4.38189e-06f
Cred_4344 VDD.$968.Metal2 vout.$1008.Metal3 0.0956544f
Cred_4345 VDD.$968.Metal2 vout.$1026.Metal3 0.0324938f
Cred_4346 VDD.$968.Metal2 vout.P14.pSD 0.0354072f
Cred_4347 VDD.$968.Metal2 vout.P16.nSD 0.000195192f
Cred_4348 VDD.$968.Metal2 vout.P16.pSD 0.0383126f
Cred_4349 VDD.$972.Metal2 vin.$359.Metal1 9.17489e-05f
Cred_4350 VDD.$972.Metal2 vin.$363.Metal1 0.00108181f
Cred_4351 VDD.$972.Metal2 vin.$627.Metal2 0.00166053f
Cred_4352 VDD.$972.Metal2 vin.$629.Metal2 0.000308333f
Cred_4353 VDD.$972.Metal2 vin.$631.Metal2 0.000174645f
Cred_4354 VDD.$972.Metal2 vin.$634.Metal2 0.00261766f
Cred_4355 VDD.$972.Metal2 vin.$636.Metal2 0.000236875f
Cred_4356 VDD.$972.Metal2 vin.$83.GatPoly 0.000471408f
Cred_4357 VDD.$972.Metal2 vin.$89.GatPoly 0.000638879f
Cred_4358 VDD.$972.Metal2 vin.P70.GatPoly 5.20332e-06f
Cred_4359 VDD.$972.Metal2 vin.P71.GatPoly 0.0017998f
Cred_4360 VDD.$972.Metal2 vin.P72.GatPoly 0.00214928f
Cred_4361 VDD.$972.Metal2 vout.$1008.Metal3 0.021249f
Cred_4362 VDD.$972.Metal2 vout.$1026.Metal3 0.0595332f
Cred_4363 VDD.$972.Metal2 vout.P16.nSD 0.000127644f
Cred_4364 VDD.$972.Metal2 vout.P16.pSD 0.0253786f
Cred_4365 VDD.$972.Metal2 vout.P18.pSD 0.0215254f
Cred_4366 VDD.$983.Metal2 vin.$359.Metal1 0.000378464f
Cred_4367 VDD.$983.Metal2 vin.$363.Metal1 0.00446262f
Cred_4368 VDD.$983.Metal2 vin.$367.Metal1 8.69999e-07f
Cred_4369 VDD.$983.Metal2 vin.$627.Metal2 0.00684969f
Cred_4370 VDD.$983.Metal2 vin.$629.Metal2 0.00127187f
Cred_4371 VDD.$983.Metal2 vin.$631.Metal2 0.000720409f
Cred_4372 VDD.$983.Metal2 vin.$634.Metal2 0.0107978f
Cred_4373 VDD.$983.Metal2 vin.$636.Metal2 0.000977111f
Cred_4374 VDD.$983.Metal2 vin.$83.GatPoly 0.00194456f
Cred_4375 VDD.$983.Metal2 vin.$89.GatPoly 0.00263538f
Cred_4376 VDD.$983.Metal2 vin.P71.GatPoly 0.00737944f
Cred_4377 VDD.$983.Metal2 vin.P72.GatPoly 0.00887391f
Cred_4378 VDD.$983.Metal2 vout.$1008.Metal3 0.0789326f
Cred_4379 VDD.$983.Metal2 vout.$1026.Metal3 0.24003f
Cred_4380 VDD.$983.Metal2 vout.P16.nSD 0.000474152f
Cred_4381 VDD.$983.Metal2 vout.P16.pSD 0.0911712f
Cred_4382 VDD.$983.Metal2 vout.P18.pSD 0.0912766f
Cred_4383 VDD.$99.Metal1 vin 0.000153271f
Cred_4384 VDD.$99.Metal1 vin.$13.GatPoly 0.00395239f
Cred_4385 VDD.$99.Metal1 vin.$19.GatPoly 0.00535027f
Cred_4386 VDD.$99.Metal1 vin.$279.Metal1 0.000386843f
Cred_4387 VDD.$99.Metal1 vin.$284.Metal1 2.98435e-06f
Cred_4388 VDD.$99.Metal1 vin.$285.Metal1 0.0109144f
Cred_4389 VDD.$99.Metal1 vin.$288.Metal1 4.55239e-07f
Cred_4390 VDD.$99.Metal1 vin.$289.Metal1 0.00141968f
Cred_4391 VDD.$99.Metal1 vin.$569.Metal2 1.64535e-05f
Cred_4392 VDD.$99.Metal1 vin.$573.Metal2 6.2561e-05f
Cred_4393 VDD.$99.Metal1 vin.$574.Metal2 0.000202058f
Cred_4394 VDD.$99.Metal1 vin.$577.Metal2 0.00610936f
Cred_4395 VDD.$99.Metal1 vin.$578.Metal2 0.000171988f
Cred_4396 VDD.$99.Metal1 vin.$581.Metal2 0.000558763f
Cred_4397 VDD.$99.Metal1 vin.P57.GatPoly 0.023216f
Cred_4398 VDD.$99.Metal1 vin.P58.GatPoly 0.0247293f
Cred_4399 VDD.$99.Metal1 vin.P59.GatPoly 0.000864243f
Cred_4400 VDD.$99.Metal1 vout.$954.Metal3 0.166784f
Cred_4401 VDD.$99.Metal1 vout.$972.Metal3 0.0542817f
Cred_4402 VDD.$99.Metal1 vout.P2.pSD 0.122234f
Cred_4403 VDD.$99.Metal1 vout.P4.nSD 0.000326073f
Cred_4404 VDD.$99.Metal1 vout.P4.pSD 0.118444f
Cred_4405 VDD.$991.Metal2 vin.$367.Metal1 8.48034e-07f
Cred_4406 VDD.$991.Metal2 vin.$372.Metal1 5.23748e-06f
Cred_4407 VDD.$991.Metal2 vin.$373.Metal1 0.00396493f
Cred_4408 VDD.$991.Metal2 vin.$376.Metal1 1.74583e-06f
Cred_4409 VDD.$991.Metal2 vin.$377.Metal1 0.000320371f
Cred_4410 VDD.$991.Metal2 vin.$636.Metal2 0.000858158f
Cred_4411 VDD.$991.Metal2 vin.$638.Metal2 0.000349684f
Cred_4412 VDD.$991.Metal2 vin.$639.Metal2 0.00819216f
Cred_4413 VDD.$991.Metal2 vin.$642.Metal2 0.000349684f
Cred_4414 VDD.$991.Metal2 vin.$643.Metal2 0.00673769f
Cred_4415 VDD.$991.Metal2 vin.$645.Metal2 0.000858158f
Cred_4416 VDD.$991.Metal2 vin.$93.GatPoly 0.00170784f
Cred_4417 VDD.$991.Metal2 vin.$99.GatPoly 0.00231455f
Cred_4418 VDD.$991.Metal2 vin.P73.GatPoly 0.00772148f
Cred_4419 VDD.$991.Metal2 vin.P74.GatPoly 0.00651171f
Cred_4420 VDD.$991.Metal2 vout.$1026.Metal3 0.212885f
Cred_4421 VDD.$991.Metal2 vout.$1044.Metal3 0.0679683f
Cred_4422 VDD.$991.Metal2 vout.P18.pSD 0.0819212f
Cred_4423 VDD.$991.Metal2 vout.P20.nSD 0.000408289f
Cred_4424 VDD.$991.Metal2 vout.P20.pSD 0.0788147f
Cred_4425 VDD.P0.GatPoly vin.$13.GatPoly 0.00356287f
Cred_4426 VDD.P0.GatPoly vin.$19.GatPoly 0.00231449f
Cred_4427 VDD.P0.GatPoly vin.$23.GatPoly 0.00136836f
Cred_4428 VDD.P0.GatPoly vin.$271.Metal1 0.0113983f
Cred_4429 VDD.P0.GatPoly vin.$275.Metal1 0.000441957f
Cred_4430 VDD.P0.GatPoly vin.$279.Metal1 0.000766319f
Cred_4431 VDD.P0.GatPoly vin.$285.Metal1 0.000116625f
Cred_4432 VDD.P0.GatPoly vin.$29.GatPoly 0.001605f
Cred_4433 VDD.P0.GatPoly vin.$297.Metal1 7.54915e-05f
Cred_4434 VDD.P0.GatPoly vin.$307.Metal1 5.58081e-05f
Cred_4435 VDD.P0.GatPoly vin.$33.GatPoly 0.00101158f
Cred_4436 VDD.P0.GatPoly vin.$39.GatPoly 0.00122906f
Cred_4437 VDD.P0.GatPoly vin.$5.GatPoly 0.0208748f
Cred_4438 VDD.P0.GatPoly vin.$566.Metal2 0.000312742f
Cred_4439 VDD.P0.GatPoly vin.P54.GatPoly 0.105751f
Cred_4440 VDD.P0.GatPoly vin.P55.GatPoly 0.0174435f
Cred_4441 VDD.P0.GatPoly vin.P56.GatPoly 0.013942f
Cred_4442 VDD.P0.GatPoly vin.P57.GatPoly 0.00575078f
Cred_4443 VDD.P0.GatPoly vin.P58.GatPoly 0.00448308f
Cred_4444 VDD.P0.GatPoly vin.P59.GatPoly 0.00372249f
Cred_4445 VDD.P0.GatPoly vin.P60.GatPoly 0.00313894f
Cred_4446 VDD.P0.GatPoly vin.P61.GatPoly 0.00275191f
Cred_4447 VDD.P0.GatPoly vin.P62.GatPoly 0.00227392f
Cred_4448 VDD.P0.GatPoly vin.P63.GatPoly 0.00203878f
Cred_4449 VDD.P0.GatPoly vin.P64.GatPoly 0.00184772f
Cred_4450 VDD.P0.GatPoly vin.P65.GatPoly 0.00168939f
Cred_4451 VDD.P0.GatPoly vin.P66.GatPoly 0.00155606f
Cred_4452 VDD.P0.GatPoly vin.P67.GatPoly 0.00144224f
Cred_4453 VDD.P0.GatPoly vin.P68.GatPoly 0.00134393f
Cred_4454 VDD.P0.nSD vin 0.0256952f
Cred_4455 VDD.P0.nSD vin.$103.GatPoly 0.00385888f
Cred_4456 VDD.P0.nSD vin.$109.GatPoly 0.00300366f
Cred_4457 VDD.P0.nSD vin.$113.GatPoly 0.00405123f
Cred_4458 VDD.P0.nSD vin.$119.GatPoly 0.00298022f
Cred_4459 VDD.P0.nSD vin.$123.GatPoly 0.00400956f
Cred_4460 VDD.P0.nSD vin.$129.GatPoly 0.00301112f
Cred_4461 VDD.P0.nSD vin.$13.GatPoly 0.00436046f
Cred_4462 VDD.P0.nSD vin.$133.GatPoly 0.00405181f
Cred_4463 VDD.P0.nSD vin.$139.GatPoly 0.00293079f
Cred_4464 VDD.P0.nSD vin.$143.GatPoly 0.00374115f
Cred_4465 VDD.P0.nSD vin.$149.GatPoly 0.00300727f
Cred_4466 VDD.P0.nSD vin.$153.GatPoly 0.00404245f
Cred_4467 VDD.P0.nSD vin.$159.GatPoly 0.00300041f
Cred_4468 VDD.P0.nSD vin.$163.GatPoly 0.00403754f
Cred_4469 VDD.P0.nSD vin.$169.GatPoly 0.00298964f
Cred_4470 VDD.P0.nSD vin.$173.GatPoly 0.00401366f
Cred_4471 VDD.P0.nSD vin.$179.GatPoly 0.00297423f
Cred_4472 VDD.P0.nSD vin.$183.GatPoly 0.00399569f
Cred_4473 VDD.P0.nSD vin.$189.GatPoly 0.00295317f
Cred_4474 VDD.P0.nSD vin.$19.GatPoly 0.00263569f
Cred_4475 VDD.P0.nSD vin.$193.GatPoly 0.00396007f
Cred_4476 VDD.P0.nSD vin.$199.GatPoly 0.00289713f
Cred_4477 VDD.P0.nSD vin.$203.GatPoly 0.00397759f
Cred_4478 VDD.P0.nSD vin.$211.GatPoly 0.00399506f
Cred_4479 VDD.P0.nSD vin.$215.GatPoly 0.00349641f
Cred_4480 VDD.P0.nSD vin.$223.GatPoly 0.00473611f
Cred_4481 VDD.P0.nSD vin.$23.GatPoly 0.00361993f
Cred_4482 VDD.P0.nSD vin.$231.GatPoly 0.00383687f
Cred_4483 VDD.P0.nSD vin.$235.GatPoly 0.00335364f
Cred_4484 VDD.P0.nSD vin.$243.GatPoly 0.0046072f
Cred_4485 VDD.P0.nSD vin.$251.GatPoly 0.00445672f
Cred_4486 VDD.P0.nSD vin.$259.GatPoly 0.00549402f
Cred_4487 VDD.P0.nSD vin.$271.Metal1 0.0709823f
Cred_4488 VDD.P0.nSD vin.$275.Metal1 0.0261214f
Cred_4489 VDD.P0.nSD vin.$279.Metal1 0.0404344f
Cred_4490 VDD.P0.nSD vin.$285.Metal1 0.0412919f
Cred_4491 VDD.P0.nSD vin.$289.Metal1 0.0408438f
Cred_4492 VDD.P0.nSD vin.$29.GatPoly 0.00270455f
Cred_4493 VDD.P0.nSD vin.$297.Metal1 0.0417238f
Cred_4494 VDD.P0.nSD vin.$301.Metal1 0.0431728f
Cred_4495 VDD.P0.nSD vin.$307.Metal1 0.0440642f
Cred_4496 VDD.P0.nSD vin.$311.Metal1 0.0434583f
Cred_4497 VDD.P0.nSD vin.$319.Metal1 0.0442071f
Cred_4498 VDD.P0.nSD vin.$323.Metal1 0.0443158f
Cred_4499 VDD.P0.nSD vin.$329.Metal1 0.0464053f
Cred_4500 VDD.P0.nSD vin.$33.GatPoly 0.00369099f
Cred_4501 VDD.P0.nSD vin.$333.Metal1 0.0296253f
Cred_4502 VDD.P0.nSD vin.$337.Metal1 0.0306932f
Cred_4503 VDD.P0.nSD vin.$341.Metal1 0.030527f
Cred_4504 VDD.P0.nSD vin.$345.Metal1 0.0454088f
Cred_4505 VDD.P0.nSD vin.$351.Metal1 0.0476222f
Cred_4506 VDD.P0.nSD vin.$355.Metal1 0.0311718f
Cred_4507 VDD.P0.nSD vin.$359.Metal1 0.0311948f
Cred_4508 VDD.P0.nSD vin.$363.Metal1 0.031035f
Cred_4509 VDD.P0.nSD vin.$367.Metal1 0.046054f
Cred_4510 VDD.P0.nSD vin.$373.Metal1 0.0478069f
Cred_4511 VDD.P0.nSD vin.$377.Metal1 0.0314928f
Cred_4512 VDD.P0.nSD vin.$381.Metal1 0.0314503f
Cred_4513 VDD.P0.nSD vin.$385.Metal1 0.0313138f
Cred_4514 VDD.P0.nSD vin.$389.Metal1 0.0459545f
Cred_4515 VDD.P0.nSD vin.$39.GatPoly 0.00280444f
Cred_4516 VDD.P0.nSD vin.$395.Metal1 0.0466292f
Cred_4517 VDD.P0.nSD vin.$399.Metal1 0.0470495f
Cred_4518 VDD.P0.nSD vin.$407.Metal1 0.0461535f
Cred_4519 VDD.P0.nSD vin.$411.Metal1 0.0456374f
Cred_4520 VDD.P0.nSD vin.$417.Metal1 0.0457106f
Cred_4521 VDD.P0.nSD vin.$421.Metal1 0.0314627f
Cred_4522 VDD.P0.nSD vin.$425.Metal1 0.031408f
Cred_4523 VDD.P0.nSD vin.$429.Metal1 0.0312096f
Cred_4524 VDD.P0.nSD vin.$43.GatPoly 0.00382148f
Cred_4525 VDD.P0.nSD vin.$433.Metal1 0.0464738f
Cred_4526 VDD.P0.nSD vin.$439.Metal1 0.0462257f
Cred_4527 VDD.P0.nSD vin.$443.Metal1 0.0470964f
Cred_4528 VDD.P0.nSD vin.$451.Metal1 0.0475594f
Cred_4529 VDD.P0.nSD vin.$455.Metal1 0.04695f
Cred_4530 VDD.P0.nSD vin.$461.Metal1 0.0458686f
Cred_4531 VDD.P0.nSD vin.$465.Metal1 0.0466799f
Cred_4532 VDD.P0.nSD vin.$473.Metal1 0.0474814f
Cred_4533 VDD.P0.nSD vin.$477.Metal1 0.0465f
Cred_4534 VDD.P0.nSD vin.$483.Metal1 0.0451792f
Cred_4535 VDD.P0.nSD vin.$487.Metal1 0.0456169f
Cred_4536 VDD.P0.nSD vin.$49.GatPoly 0.00278468f
Cred_4537 VDD.P0.nSD vin.$495.Metal1 0.0610369f
Cred_4538 VDD.P0.nSD vin.$5.GatPoly 0.00444152f
Cred_4539 VDD.P0.nSD vin.$501.Metal1 0.0443407f
Cred_4540 VDD.P0.nSD vin.$505.Metal1 0.0293579f
Cred_4541 VDD.P0.nSD vin.$509.Metal1 0.044101f
Cred_4542 VDD.P0.nSD vin.$517.Metal1 0.0581254f
Cred_4543 VDD.P0.nSD vin.$523.Metal1 0.0431752f
Cred_4544 VDD.P0.nSD vin.$527.Metal1 0.0286537f
Cred_4545 VDD.P0.nSD vin.$53.GatPoly 0.00376363f
Cred_4546 VDD.P0.nSD vin.$531.Metal1 0.0423143f
Cred_4547 VDD.P0.nSD vin.$539.Metal1 0.054589f
Cred_4548 VDD.P0.nSD vin.$545.Metal1 0.0404226f
Cred_4549 VDD.P0.nSD vin.$549.Metal1 0.0936543f
Cred_4550 VDD.P0.nSD vin.$564.Metal2 2.09361e-05f
Cred_4551 VDD.P0.nSD vin.$566.Metal2 0.0275884f
Cred_4552 VDD.P0.nSD vin.$569.Metal2 0.00106753f
Cred_4553 VDD.P0.nSD vin.$573.Metal2 0.0252232f
Cred_4554 VDD.P0.nSD vin.$574.Metal2 0.00195101f
Cred_4555 VDD.P0.nSD vin.$577.Metal2 0.00411787f
Cred_4556 VDD.P0.nSD vin.$579.Metal2 0.0172338f
Cred_4557 VDD.P0.nSD vin.$581.Metal2 0.0387903f
Cred_4558 VDD.P0.nSD vin.$584.Metal2 0.0064596f
Cred_4559 VDD.P0.nSD vin.$588.Metal2 0.0292172f
Cred_4560 VDD.P0.nSD vin.$589.Metal2 0.0221238f
Cred_4561 VDD.P0.nSD vin.$59.GatPoly 0.0029044f
Cred_4562 VDD.P0.nSD vin.$593.Metal2 0.00468385f
Cred_4563 VDD.P0.nSD vin.$595.Metal2 0.0171575f
Cred_4564 VDD.P0.nSD vin.$597.Metal2 0.0318447f
Cred_4565 VDD.P0.nSD vin.$600.Metal2 0.00641838f
Cred_4566 VDD.P0.nSD vin.$604.Metal2 0.0299587f
Cred_4567 VDD.P0.nSD vin.$605.Metal2 0.0231484f
Cred_4568 VDD.P0.nSD vin.$609.Metal2 0.00454782f
Cred_4569 VDD.P0.nSD vin.$611.Metal2 0.0206589f
Cred_4570 VDD.P0.nSD vin.$613.Metal2 0.0314558f
Cred_4571 VDD.P0.nSD vin.$618.Metal2 0.0126009f
Cred_4572 VDD.P0.nSD vin.$620.Metal2 0.0335272f
Cred_4573 VDD.P0.nSD vin.$623.Metal2 0.0147275f
Cred_4574 VDD.P0.nSD vin.$627.Metal2 0.0237419f
Cred_4575 VDD.P0.nSD vin.$629.Metal2 0.0316955f
Cred_4576 VDD.P0.nSD vin.$63.GatPoly 0.003759f
Cred_4577 VDD.P0.nSD vin.$634.Metal2 0.0128435f
Cred_4578 VDD.P0.nSD vin.$636.Metal2 0.0340131f
Cred_4579 VDD.P0.nSD vin.$639.Metal2 0.0145816f
Cred_4580 VDD.P0.nSD vin.$643.Metal2 0.0245931f
Cred_4581 VDD.P0.nSD vin.$645.Metal2 0.0316416f
Cred_4582 VDD.P0.nSD vin.$650.Metal2 0.0135463f
Cred_4583 VDD.P0.nSD vin.$652.Metal2 0.0339301f
Cred_4584 VDD.P0.nSD vin.$655.Metal2 0.0146149f
Cred_4585 VDD.P0.nSD vin.$659.Metal2 0.0325759f
Cred_4586 VDD.P0.nSD vin.$662.Metal2 0.0248653f
Cred_4587 VDD.P0.nSD vin.$666.Metal2 0.0141027f
Cred_4588 VDD.P0.nSD vin.$668.Metal2 0.0357649f
Cred_4589 VDD.P0.nSD vin.$671.Metal2 0.0142714f
Cred_4590 VDD.P0.nSD vin.$676.Metal2 0.0324496f
Cred_4591 VDD.P0.nSD vin.$678.Metal2 0.024981f
Cred_4592 VDD.P0.nSD vin.$682.Metal2 0.014232f
Cred_4593 VDD.P0.nSD vin.$684.Metal2 0.034012f
Cred_4594 VDD.P0.nSD vin.$687.Metal2 0.0138139f
Cred_4595 VDD.P0.nSD vin.$69.GatPoly 0.00293752f
Cred_4596 VDD.P0.nSD vin.$691.Metal2 0.0316416f
Cred_4597 VDD.P0.nSD vin.$694.Metal2 0.0247967f
Cred_4598 VDD.P0.nSD vin.$698.Metal2 0.0143229f
Cred_4599 VDD.P0.nSD vin.$700.Metal2 0.0340131f
Cred_4600 VDD.P0.nSD vin.$703.Metal2 0.0130895f
Cred_4601 VDD.P0.nSD vin.$707.Metal2 0.0316955f
Cred_4602 VDD.P0.nSD vin.$710.Metal2 0.0239478f
Cred_4603 VDD.P0.nSD vin.$714.Metal2 0.0144185f
Cred_4604 VDD.P0.nSD vin.$716.Metal2 0.0341575f
Cred_4605 VDD.P0.nSD vin.$719.Metal2 0.013157f
Cred_4606 VDD.P0.nSD vin.$723.Metal2 0.0320415f
Cred_4607 VDD.P0.nSD vin.$726.Metal2 0.0191647f
Cred_4608 VDD.P0.nSD vin.$728.Metal2 0.00495491f
Cred_4609 VDD.P0.nSD vin.$73.GatPoly 0.00397914f
Cred_4610 VDD.P0.nSD vin.$732.Metal2 0.0304243f
Cred_4611 VDD.P0.nSD vin.$733.Metal2 0.02335f
Cred_4612 VDD.P0.nSD vin.$737.Metal2 0.00565755f
Cred_4613 VDD.P0.nSD vin.$739.Metal2 0.0310483f
Cred_4614 VDD.P0.nSD vin.$742.Metal2 0.0182707f
Cred_4615 VDD.P0.nSD vin.$744.Metal2 0.0044099f
Cred_4616 VDD.P0.nSD vin.$748.Metal2 0.0283537f
Cred_4617 VDD.P0.nSD vin.$749.Metal2 0.0220594f
Cred_4618 VDD.P0.nSD vin.$753.Metal2 0.00640412f
Cred_4619 VDD.P0.nSD vin.$755.Metal2 0.0290937f
Cred_4620 VDD.P0.nSD vin.$758.Metal2 0.0173957f
Cred_4621 VDD.P0.nSD vin.$760.Metal2 0.00415256f
Cred_4622 VDD.P0.nSD vin.$764.Metal2 0.0264514f
Cred_4623 VDD.P0.nSD vin.$765.Metal2 0.020457f
Cred_4624 VDD.P0.nSD vin.$769.Metal2 0.0241607f
Cred_4625 VDD.P0.nSD vin.$771.Metal2 0.0228193f
Cred_4626 VDD.P0.nSD vin.$79.GatPoly 0.00296255f
Cred_4627 VDD.P0.nSD vin.$83.GatPoly 0.00382403f
Cred_4628 VDD.P0.nSD vin.$89.GatPoly 0.00298115f
Cred_4629 VDD.P0.nSD vin.$93.GatPoly 0.00403069f
Cred_4630 VDD.P0.nSD vin.$99.GatPoly 0.00299456f
Cred_4631 VDD.P0.nSD vin.P100.GatPoly 2.2397e-05f
Cred_4632 VDD.P0.nSD vin.P101.GatPoly 1.67989e-06f
Cred_4633 VDD.P0.nSD vin.P102.GatPoly 0.000120778f
Cred_4634 VDD.P0.nSD vin.P103.GatPoly 2.41167e-05f
Cred_4635 VDD.P0.nSD vin.P104.GatPoly 2.12552e-05f
Cred_4636 VDD.P0.nSD vin.P105.GatPoly 0.000108824f
Cred_4637 VDD.P0.nSD vin.P106.GatPoly 4.66503e-06f
Cred_4638 VDD.P0.nSD vin.P107.GatPoly 0.000204134f
Cred_4639 VDD.P0.nSD vin.P54.GatPoly 0.000154644f
Cred_4640 VDD.P0.nSD vin.P55.GatPoly 4.66503e-06f
Cred_4641 VDD.P0.nSD vin.P56.GatPoly 0.000108824f
Cred_4642 VDD.P0.nSD vin.P57.GatPoly 1.91447e-05f
Cred_4643 VDD.P0.nSD vin.P58.GatPoly 5.6614e-06f
Cred_4644 VDD.P0.nSD vin.P59.GatPoly 2.26197e-05f
Cred_4645 VDD.P0.nSD vin.P60.GatPoly 1.67989e-06f
Cred_4646 VDD.P0.nSD vin.P61.GatPoly 2.01429e-05f
Cred_4647 VDD.P0.nSD vin.P62.GatPoly 5.68721e-06f
Cred_4648 VDD.P0.nSD vin.P63.GatPoly 2.34474e-05f
Cred_4649 VDD.P0.nSD vin.P64.GatPoly 1.70273e-06f
Cred_4650 VDD.P0.nSD vin.P65.GatPoly 2.06886e-05f
Cred_4651 VDD.P0.nSD vin.P66.GatPoly 5.71304e-06f
Cred_4652 VDD.P0.nSD vin.P67.GatPoly 2.39233e-05f
Cred_4653 VDD.P0.nSD vin.P68.GatPoly 1.72458e-06f
Cred_4654 VDD.P0.nSD vin.P69.GatPoly 2.09594e-05f
Cred_4655 VDD.P0.nSD vin.P70.GatPoly 5.73888e-06f
Cred_4656 VDD.P0.nSD vin.P71.GatPoly 2.41836e-05f
Cred_4657 VDD.P0.nSD vin.P72.GatPoly 1.74551e-06f
Cred_4658 VDD.P0.nSD vin.P73.GatPoly 2.10591e-05f
Cred_4659 VDD.P0.nSD vin.P74.GatPoly 5.76472e-06f
Cred_4660 VDD.P0.nSD vin.P75.GatPoly 2.43064e-05f
Cred_4661 VDD.P0.nSD vin.P76.GatPoly 1.76556e-06f
Cred_4662 VDD.P0.nSD vin.P77.GatPoly 2.10282e-05f
Cred_4663 VDD.P0.nSD vin.P78.GatPoly 5.79057e-06f
Cred_4664 VDD.P0.nSD vin.P79.GatPoly 2.43325e-05f
Cred_4665 VDD.P0.nSD vin.P80.GatPoly 1.78478e-06f
Cred_4666 VDD.P0.nSD vin.P81.GatPoly 2.06149e-05f
Cred_4667 VDD.P0.nSD vin.P82.GatPoly 5.50241e-06f
Cred_4668 VDD.P0.nSD vin.P83.GatPoly 2.46037e-05f
Cred_4669 VDD.P0.nSD vin.P84.GatPoly 2.21508e-06f
Cred_4670 VDD.P0.nSD vin.P85.GatPoly 2.05405e-05f
Cred_4671 VDD.P0.nSD vin.P86.GatPoly 5.53144e-06f
Cred_4672 VDD.P0.nSD vin.P87.GatPoly 2.44777e-05f
Cred_4673 VDD.P0.nSD vin.P88.GatPoly 2.34612e-06f
Cred_4674 VDD.P0.nSD vin.P89.GatPoly 2.03687e-05f
Cred_4675 VDD.P0.nSD vin.P90.GatPoly 5.56047e-06f
Cred_4676 VDD.P0.nSD vin.P91.GatPoly 2.42384e-05f
Cred_4677 VDD.P0.nSD vin.P92.GatPoly 2.45995e-06f
Cred_4678 VDD.P0.nSD vin.P93.GatPoly 2.00584e-05f
Cred_4679 VDD.P0.nSD vin.P94.GatPoly 5.58951e-06f
Cred_4680 VDD.P0.nSD vin.P95.GatPoly 2.61673e-05f
Cred_4681 VDD.P0.nSD vin.P96.GatPoly 2.30277e-05f
Cred_4682 VDD.P0.nSD vin.P97.GatPoly 1.70273e-06f
Cred_4683 VDD.P0.nSD vin.P98.GatPoly 0.000123612f
Cred_4684 VDD.P0.nSD vin.P99.GatPoly 2.53973e-05f
Cred_4685 VDD.P0.nSD vout 0.0108007f
Cred_4686 VDD.P0.nSD vout.$1008.Metal3 0.0169586f
Cred_4687 VDD.P0.nSD vout.$1026.Metal3 0.0172837f
Cred_4688 VDD.P0.nSD vout.$1044.Metal3 0.017932f
Cred_4689 VDD.P0.nSD vout.$1062.Metal3 0.0184557f
Cred_4690 VDD.P0.nSD vout.$1080.Metal3 0.0179362f
Cred_4691 VDD.P0.nSD vout.$1098.Metal3 0.0172837f
Cred_4692 VDD.P0.nSD vout.$1116.Metal3 0.0169425f
Cred_4693 VDD.P0.nSD vout.$1134.Metal3 0.0161996f
Cred_4694 VDD.P0.nSD vout.$1152.Metal3 0.0152447f
Cred_4695 VDD.P0.nSD vout.$1170.Metal3 0.0109746f
Cred_4696 VDD.P0.nSD vout.$954.Metal3 0.0207586f
Cred_4697 VDD.P0.nSD vout.$972.Metal3 0.0152256f
Cred_4698 VDD.P0.nSD vout.$990.Metal3 0.0162033f
Cred_4699 VDD.P0.nSD vout.P0.nSD 4.67917e-05f
Cred_4700 VDD.P0.nSD vout.P0.pSD 0.000193113f
Cred_4701 VDD.P0.nSD vout.P10.pSD 2.85178e-06f
Cred_4702 VDD.P0.nSD vout.P12.nSD 2.58597e-05f
Cred_4703 VDD.P0.nSD vout.P12.pSD 8.86416e-05f
Cred_4704 VDD.P0.nSD vout.P14.pSD 2.32191e-06f
Cred_4705 VDD.P0.nSD vout.P16.nSD 2.66009e-05f
Cred_4706 VDD.P0.nSD vout.P16.pSD 9.06527e-05f
Cred_4707 VDD.P0.nSD vout.P18.pSD 1.77338e-06f
Cred_4708 VDD.P0.nSD vout.P2.pSD 3.88791e-06f
Cred_4709 VDD.P0.nSD vout.P20.nSD 2.71263e-05f
Cred_4710 VDD.P0.nSD vout.P20.pSD 9.20782e-05f
Cred_4711 VDD.P0.nSD vout.P22.pSD 1.20466e-06f
Cred_4712 VDD.P0.nSD vout.P24.nSD 3.01499e-05f
Cred_4713 VDD.P0.nSD vout.P24.pSD 0.000100281f
Cred_4714 VDD.P0.nSD vout.P28.nSD 3.01749e-05f
Cred_4715 VDD.P0.nSD vout.P28.pSD 0.000100348f
Cred_4716 VDD.P0.nSD vout.P30.pSD 1.20466e-06f
Cred_4717 VDD.P0.nSD vout.P32.nSD 2.71263e-05f
Cred_4718 VDD.P0.nSD vout.P32.pSD 9.20782e-05f
Cred_4719 VDD.P0.nSD vout.P34.pSD 1.77338e-06f
Cred_4720 VDD.P0.nSD vout.P36.nSD 2.66009e-05f
Cred_4721 VDD.P0.nSD vout.P36.pSD 9.06527e-05f
Cred_4722 VDD.P0.nSD vout.P38.pSD 2.32191e-06f
Cred_4723 VDD.P0.nSD vout.P4.nSD 2.20933e-05f
Cred_4724 VDD.P0.nSD vout.P4.pSD 7.84235e-05f
Cred_4725 VDD.P0.nSD vout.P40.nSD 2.5763e-05f
Cred_4726 VDD.P0.nSD vout.P40.pSD 8.83793e-05f
Cred_4727 VDD.P0.nSD vout.P42.pSD 2.85178e-06f
Cred_4728 VDD.P0.nSD vout.P44.nSD 2.33507e-05f
Cred_4729 VDD.P0.nSD vout.P44.pSD 8.1835e-05f
Cred_4730 VDD.P0.nSD vout.P46.pSD 3.36443e-06f
Cred_4731 VDD.P0.nSD vout.P48.nSD 2.20933e-05f
Cred_4732 VDD.P0.nSD vout.P48.pSD 7.84235e-05f
Cred_4733 VDD.P0.nSD vout.P50.pSD 3.88791e-06f
Cred_4734 VDD.P0.nSD vout.P52.pSD 6.63737e-05f
Cred_4735 VDD.P0.nSD vout.P6.pSD 3.36443e-06f
Cred_4736 VDD.P0.nSD vout.P8.nSD 2.34209e-05f
Cred_4737 VDD.P0.nSD vout.P8.pSD 8.20255e-05f
Cred_4738 VDD.P0.nSD VSS.$14.Metal1 0.017144f
Cred_4739 VDD.P0.nSD VSS.$29.Metal1 0.0328619f
Cred_4740 VDD.P0.nSD VSS.$500.Metal1 0.00401426f
Cred_4741 VDD.P0.nSD VSS.$520.Metal1 0.051217f
Cred_4742 VDD.P0.nSD VSS.$531.Metal2 0.000721233f
Cred_4743 VDD.P0.nSD VSS.$904.Metal2 0.000721233f
Cred_4744 VDD.P0.nSD VSS.P0.nSD 4.17408e-05f
Cred_4745 VDD.P0.nSD VSS.P0.pSD 0.743288f
Cred_4746 VDD.P0.nSD VSS.P1.nSD 4.17408e-05f
Cred_4747 VDD.P0.nSD VSS.P55.nSD 4.17408e-05f
Cred_4748 VDD.P0.nSD VSS.P57.nSD 4.17408e-05f
Cred_4749 VDD.P0.pSD vin.$271.Metal1 0.000720752f
Cred_4750 VDD.P0.pSD vin.$274.Metal1 3.71723e-08f
Cred_4751 VDD.P0.pSD vin.$4.GatPoly 7.81975e-10f
Cred_4752 VDD.P0.pSD vin.$5.GatPoly 0.000100246f
Cred_4753 VDD.P0.pSD vin.$564.Metal2 1.57863e-06f
Cred_4754 VDD.P0.pSD vin.$566.Metal2 6.24847e-05f
Cred_4755 VDD.P0.pSD vin.$569.Metal2 1.61639e-10f
Cred_4756 VDD.P0.pSD vin.P0.GatPoly 1.00361e-10f
Cred_4757 VDD.P0.pSD vin.P54.GatPoly 0.000410075f
Cred_4758 VDD.P0.pSD vout.$954.Metal3 0.00180098f
Cred_4759 VDD.P0.pSD vout.P0.nSD 8.11917e-06f
Cred_4760 VDD.P0.pSD vout.P0.pSD 0.00279319f
Cred_4761 VDD.P0.pSD VSS.$14.Metal1 2.46447e-05f
Cred_4762 VDD.P0.pSD VSS.$29.Metal1 4.26849e-05f
Cred_4763 VDD.P0.pSD VSS.$31.Metal1 1.23357e-10f
Cred_4764 VDD.P0.pSD VSS.$520.Metal1 5.05222e-08f
Cred_4765 VDD.P0.pSD VSS.$531.Metal2 2.43738e-05f
Cred_4766 VDD.P0.pSD VSS.$540.Metal2 3.36936e-08f
Cred_4767 VDD.P0.pSD VSS.$916.Metal3 2.3978e-06f
Cred_4768 VDD.P0.pSD VSS.P0.nSD 9.01751e-09f
Cred_4769 VDD.P0.pSD VSS.P0.pSD 0.000124236f
Cred_4770 VDD.P0.pSD VSS.P1.nSD 9.01751e-09f
Cred_4771 VDD.P1.GatPoly vin.$223.GatPoly 0.00102399f
Cred_4772 VDD.P1.GatPoly vin.$231.GatPoly 0.00112868f
Cred_4773 VDD.P1.GatPoly vin.$235.GatPoly 0.00188446f
Cred_4774 VDD.P1.GatPoly vin.$243.GatPoly 0.00253921f
Cred_4775 VDD.P1.GatPoly vin.$251.GatPoly 0.00378339f
Cred_4776 VDD.P1.GatPoly vin.$259.GatPoly 0.0210419f
Cred_4777 VDD.P1.GatPoly vin.$517.Metal1 0.000118761f
Cred_4778 VDD.P1.GatPoly vin.$527.Metal1 0.000186341f
Cred_4779 VDD.P1.GatPoly vin.$531.Metal1 0.000323101f
Cred_4780 VDD.P1.GatPoly vin.$539.Metal1 0.000235174f
Cred_4781 VDD.P1.GatPoly vin.$545.Metal1 0.000766319f
Cred_4782 VDD.P1.GatPoly vin.$549.Metal1 0.0111761f
Cred_4783 VDD.P1.GatPoly vin.$769.Metal2 0.000612749f
Cred_4784 VDD.P1.GatPoly vin.$771.Metal2 0.000189195f
Cred_4785 VDD.P1.GatPoly vin.P100.GatPoly 0.00275448f
Cred_4786 VDD.P1.GatPoly vin.P101.GatPoly 0.00313894f
Cred_4787 VDD.P1.GatPoly vin.P102.GatPoly 0.00376655f
Cred_4788 VDD.P1.GatPoly vin.P103.GatPoly 0.00452536f
Cred_4789 VDD.P1.GatPoly vin.P104.GatPoly 0.00575561f
Cred_4790 VDD.P1.GatPoly vin.P105.GatPoly 0.013942f
Cred_4791 VDD.P1.GatPoly vin.P106.GatPoly 0.0174435f
Cred_4792 VDD.P1.GatPoly vin.P107.GatPoly 0.0768647f
Cred_4793 VDD.P1.GatPoly vin.P93.GatPoly 0.00134393f
Cred_4794 VDD.P1.GatPoly vin.P94.GatPoly 0.00144224f
Cred_4795 VDD.P1.GatPoly vin.P95.GatPoly 0.00155606f
Cred_4796 VDD.P1.GatPoly vin.P96.GatPoly 0.00168939f
Cred_4797 VDD.P1.GatPoly vin.P97.GatPoly 0.00184772f
Cred_4798 VDD.P1.GatPoly vin.P98.GatPoly 0.00203878f
Cred_4799 VDD.P1.GatPoly vin.P99.GatPoly 0.00229637f
Cred_4800 VDD.P1.pSD vin.$271.Metal1 0.0033253f
Cred_4801 VDD.P1.pSD vin.$274.Metal1 3.71723e-08f
Cred_4802 VDD.P1.pSD vin.$4.GatPoly 7.81975e-10f
Cred_4803 VDD.P1.pSD vin.$5.GatPoly 0.000115997f
Cred_4804 VDD.P1.pSD vin.$564.Metal2 1.57863e-06f
Cred_4805 VDD.P1.pSD vin.$566.Metal2 0.00223937f
Cred_4806 VDD.P1.pSD vin.$569.Metal2 1.61639e-10f
Cred_4807 VDD.P1.pSD vin.P0.GatPoly 1.00361e-10f
Cred_4808 VDD.P1.pSD vin.P54.GatPoly 0.000411732f
Cred_4809 VDD.P1.pSD vout.$954.Metal3 0.00180098f
Cred_4810 VDD.P1.pSD vout.P0.nSD 8.11917e-06f
Cred_4811 VDD.P1.pSD vout.P0.pSD 0.00279319f
Cred_4812 VDD.P1.pSD VSS.$14.Metal1 2.46447e-05f
Cred_4813 VDD.P1.pSD VSS.$29.Metal1 4.26849e-05f
Cred_4814 VDD.P1.pSD VSS.$31.Metal1 1.23357e-10f
Cred_4815 VDD.P1.pSD VSS.$520.Metal1 5.05222e-08f
Cred_4816 VDD.P1.pSD VSS.$531.Metal2 2.43738e-05f
Cred_4817 VDD.P1.pSD VSS.$540.Metal2 3.36936e-08f
Cred_4818 VDD.P1.pSD VSS.$916.Metal3 2.3978e-06f
Cred_4819 VDD.P1.pSD VSS.P0.nSD 9.01751e-09f
Cred_4820 VDD.P1.pSD VSS.P0.pSD 0.000124236f
Cred_4821 VDD.P1.pSD VSS.P1.nSD 9.01751e-09f
Cred_4822 VDD.P10.pSD vin.$301.Metal1 5.69751e-09f
Cred_4823 VDD.P10.pSD vin.$306.Metal1 1.33808e-06f
Cred_4824 VDD.P10.pSD vin.$307.Metal1 0.0108695f
Cred_4825 VDD.P10.pSD vin.$310.Metal1 2.58226e-07f
Cred_4826 VDD.P10.pSD vin.$311.Metal1 0.000835454f
Cred_4827 VDD.P10.pSD vin.$33.GatPoly 0.00211806f
Cred_4828 VDD.P10.pSD vin.$39.GatPoly 0.00287052f
Cred_4829 VDD.P10.pSD vin.$588.Metal2 0.000158041f
Cred_4830 VDD.P10.pSD vin.$589.Metal2 1.29513e-06f
Cred_4831 VDD.P10.pSD vin.$590.Metal2 7.98521e-05f
Cred_4832 VDD.P10.pSD vin.$593.Metal2 0.00707326f
Cred_4833 VDD.P10.pSD vin.$594.Metal2 7.98521e-05f
Cred_4834 VDD.P10.pSD vin.$597.Metal2 0.000189865f
Cred_4835 VDD.P10.pSD vin.P61.GatPoly 0.00619419f
Cred_4836 VDD.P10.pSD vin.P62.GatPoly 0.00634539f
Cred_4837 VDD.P10.pSD vout.$972.Metal3 0.0694908f
Cred_4838 VDD.P10.pSD vout.$990.Metal3 0.0228361f
Cred_4839 VDD.P10.pSD vout.P6.pSD 0.0470066f
Cred_4840 VDD.P10.pSD vout.P8.nSD 0.000137177f
Cred_4841 VDD.P10.pSD vout.P8.pSD 0.0466392f
Cred_4842 VDD.P11.pSD vin.$311.Metal1 0.0007926f
Cred_4843 VDD.P11.pSD vin.$319.Metal1 0.00949265f
Cred_4844 VDD.P11.pSD vin.$323.Metal1 0.00147807f
Cred_4845 VDD.P11.pSD vin.$43.GatPoly 0.00212662f
Cred_4846 VDD.P11.pSD vin.$49.GatPoly 0.0028693f
Cred_4847 VDD.P11.pSD vin.$595.Metal2 5.76627e-06f
Cred_4848 VDD.P11.pSD vin.$597.Metal2 0.000209482f
Cred_4849 VDD.P11.pSD vin.$599.Metal2 0.000130945f
Cred_4850 VDD.P11.pSD vin.$600.Metal2 0.00554378f
Cred_4851 VDD.P11.pSD vin.$604.Metal2 0.000181551f
Cred_4852 VDD.P11.pSD vin.$605.Metal2 0.00168745f
Cred_4853 VDD.P11.pSD vin.P63.GatPoly 0.00624162f
Cred_4854 VDD.P11.pSD vin.P64.GatPoly 0.00641834f
Cred_4855 VDD.P11.pSD vout.$972.Metal3 0.0222995f
Cred_4856 VDD.P11.pSD vout.$990.Metal3 0.0699046f
Cred_4857 VDD.P11.pSD vout.P10.pSD 0.0486078f
Cred_4858 VDD.P11.pSD vout.P8.nSD 0.000133955f
Cred_4859 VDD.P11.pSD vout.P8.pSD 0.0449476f
Cred_4860 VDD.P13.pSD vin.$323.Metal1 3.29971e-06f
Cred_4861 VDD.P13.pSD vin.$328.Metal1 1.29045e-06f
Cred_4862 VDD.P13.pSD vin.$329.Metal1 0.010749f
Cred_4863 VDD.P13.pSD vin.$332.Metal1 3.05016e-07f
Cred_4864 VDD.P13.pSD vin.$333.Metal1 0.000957497f
Cred_4865 VDD.P13.pSD vin.$53.GatPoly 0.00211804f
Cred_4866 VDD.P13.pSD vin.$59.GatPoly 0.00287044f
Cred_4867 VDD.P13.pSD vin.$604.Metal2 0.000209932f
Cred_4868 VDD.P13.pSD vin.$605.Metal2 0.000900764f
Cred_4869 VDD.P13.pSD vin.$606.Metal2 7.98402e-05f
Cred_4870 VDD.P13.pSD vin.$609.Metal2 0.00612425f
Cred_4871 VDD.P13.pSD vin.$610.Metal2 7.98402e-05f
Cred_4872 VDD.P13.pSD vin.$613.Metal2 0.000181941f
Cred_4873 VDD.P13.pSD vin.P65.GatPoly 0.00619382f
Cred_4874 VDD.P13.pSD vin.P66.GatPoly 0.00634818f
Cred_4875 VDD.P13.pSD vout.$1008.Metal3 0.0230554f
Cred_4876 VDD.P13.pSD vout.$990.Metal3 0.06926f
Cred_4877 VDD.P13.pSD vout.P10.pSD 0.0462948f
Cred_4878 VDD.P13.pSD vout.P12.nSD 0.000138495f
Cred_4879 VDD.P13.pSD vout.P12.pSD 0.0473493f
Cred_4880 VDD.P15.pSD vin.$337.Metal1 0.00157535f
Cred_4881 VDD.P15.pSD vin.$341.Metal1 0.0094972f
Cred_4882 VDD.P15.pSD vin.$345.Metal1 0.00138515f
Cred_4883 VDD.P15.pSD vin.$611.Metal2 0.00215119f
Cred_4884 VDD.P15.pSD vin.$613.Metal2 0.000325187f
Cred_4885 VDD.P15.pSD vin.$615.Metal2 0.000137634f
Cred_4886 VDD.P15.pSD vin.$618.Metal2 0.00491215f
Cred_4887 VDD.P15.pSD vin.$620.Metal2 0.000195587f
Cred_4888 VDD.P15.pSD vin.$63.GatPoly 0.0021173f
Cred_4889 VDD.P15.pSD vin.$69.GatPoly 0.00286949f
Cred_4890 VDD.P15.pSD vin.P67.GatPoly 0.00624554f
Cred_4891 VDD.P15.pSD vin.P68.GatPoly 0.00641898f
Cred_4892 VDD.P15.pSD vout.$1008.Metal3 0.0691637f
Cred_4893 VDD.P15.pSD vout.$990.Metal3 0.023044f
Cred_4894 VDD.P15.pSD vout.P12.nSD 0.000138427f
Cred_4895 VDD.P15.pSD vout.P12.pSD 0.0473478f
Cred_4896 VDD.P15.pSD vout.P14.pSD 0.0462324f
Cred_4897 VDD.P17.pSD vin.$350.Metal1 1.24289e-06f
Cred_4898 VDD.P17.pSD vin.$351.Metal1 0.0105925f
Cred_4899 VDD.P17.pSD vin.$354.Metal1 3.5176e-07f
Cred_4900 VDD.P17.pSD vin.$355.Metal1 0.00108252f
Cred_4901 VDD.P17.pSD vin.$620.Metal2 0.000195304f
Cred_4902 VDD.P17.pSD vin.$622.Metal2 7.98262e-05f
Cred_4903 VDD.P17.pSD vin.$623.Metal2 0.0042309f
Cred_4904 VDD.P17.pSD vin.$626.Metal2 7.98262e-05f
Cred_4905 VDD.P17.pSD vin.$627.Metal2 0.00274743f
Cred_4906 VDD.P17.pSD vin.$629.Metal2 0.000195097f
Cred_4907 VDD.P17.pSD vin.$73.GatPoly 0.00211793f
Cred_4908 VDD.P17.pSD vin.$79.GatPoly 0.00287034f
Cred_4909 VDD.P17.pSD vin.P69.GatPoly 0.00619342f
Cred_4910 VDD.P17.pSD vin.P70.GatPoly 0.00634982f
Cred_4911 VDD.P17.pSD vout.$1008.Metal3 0.0694814f
Cred_4912 VDD.P17.pSD vout.$1026.Metal3 0.0228308f
Cred_4913 VDD.P17.pSD vout.P14.pSD 0.0470011f
Cred_4914 VDD.P17.pSD vout.P16.nSD 0.000137146f
Cred_4915 VDD.P17.pSD vout.P16.pSD 0.0466332f
Cred_4916 VDD.P19.pSD vin.$359.Metal1 0.00151595f
Cred_4917 VDD.P19.pSD vin.$363.Metal1 0.009655f
Cred_4918 VDD.P19.pSD vin.$367.Metal1 0.00129929f
Cred_4919 VDD.P19.pSD vin.$627.Metal2 0.00224514f
Cred_4920 VDD.P19.pSD vin.$629.Metal2 0.000292266f
Cred_4921 VDD.P19.pSD vin.$631.Metal2 0.000144251f
Cred_4922 VDD.P19.pSD vin.$634.Metal2 0.00484165f
Cred_4923 VDD.P19.pSD vin.$636.Metal2 0.000195652f
Cred_4924 VDD.P19.pSD vin.$83.GatPoly 0.00211743f
Cred_4925 VDD.P19.pSD vin.$89.GatPoly 0.00286967f
Cred_4926 VDD.P19.pSD vin.P71.GatPoly 0.00624887f
Cred_4927 VDD.P19.pSD vin.P72.GatPoly 0.00641957f
Cred_4928 VDD.P19.pSD vout.$1008.Metal3 0.0230483f
Cred_4929 VDD.P19.pSD vout.$1026.Metal3 0.0690756f
Cred_4930 VDD.P19.pSD vout.P16.nSD 0.000138452f
Cred_4931 VDD.P19.pSD vout.P16.pSD 0.0473537f
Cred_4932 VDD.P19.pSD vout.P18.pSD 0.0461851f
Cred_4933 VDD.P21.pSD vin.$372.Metal1 1.19538e-06f
Cred_4934 VDD.P21.pSD vin.$373.Metal1 0.0104354f
Cred_4935 VDD.P21.pSD vin.$376.Metal1 3.98459e-07f
Cred_4936 VDD.P21.pSD vin.$377.Metal1 0.00118733f
Cred_4937 VDD.P21.pSD vin.$636.Metal2 0.000195862f
Cred_4938 VDD.P21.pSD vin.$638.Metal2 7.98101e-05f
Cred_4939 VDD.P21.pSD vin.$639.Metal2 0.00435505f
Cred_4940 VDD.P21.pSD vin.$642.Metal2 7.98101e-05f
Cred_4941 VDD.P21.pSD vin.$643.Metal2 0.0026246f
Cred_4942 VDD.P21.pSD vin.$645.Metal2 0.000195862f
Cred_4943 VDD.P21.pSD vin.$93.GatPoly 0.00211785f
Cred_4944 VDD.P21.pSD vin.$99.GatPoly 0.00287023f
Cred_4945 VDD.P21.pSD vin.P73.GatPoly 0.00619298f
Cred_4946 VDD.P21.pSD vin.P74.GatPoly 0.00635042f
Cred_4947 VDD.P21.pSD vout.$1026.Metal3 0.0693513f
Cred_4948 VDD.P21.pSD vout.$1044.Metal3 0.0226009f
Cred_4949 VDD.P21.pSD vout.P18.pSD 0.047051f
Cred_4950 VDD.P21.pSD vout.P20.nSD 0.000135765f
Cred_4951 VDD.P21.pSD vout.P20.pSD 0.0464753f
Cred_4952 VDD.P23.pSD vin.$103.GatPoly 0.00211755f
Cred_4953 VDD.P23.pSD vin.$109.GatPoly 0.00286983f
Cred_4954 VDD.P23.pSD vin.$381.Metal1 0.00144745f
Cred_4955 VDD.P23.pSD vin.$385.Metal1 0.0098316f
Cred_4956 VDD.P23.pSD vin.$389.Metal1 0.00120381f
Cred_4957 VDD.P23.pSD vin.$643.Metal2 0.00234278f
Cred_4958 VDD.P23.pSD vin.$645.Metal2 0.000256201f
Cred_4959 VDD.P23.pSD vin.$647.Metal2 0.000150786f
Cred_4960 VDD.P23.pSD vin.$650.Metal2 0.00470417f
Cred_4961 VDD.P23.pSD vin.$652.Metal2 0.000195712f
Cred_4962 VDD.P23.pSD vin.P75.GatPoly 0.00625155f
Cred_4963 VDD.P23.pSD vin.P76.GatPoly 0.00642012f
Cred_4964 VDD.P23.pSD vout.$1026.Metal3 0.023279f
Cred_4965 VDD.P23.pSD vout.$1044.Metal3 0.0694189f
Cred_4966 VDD.P23.pSD vout.P20.nSD 0.000139838f
Cred_4967 VDD.P23.pSD vout.P20.pSD 0.0475133f
Cred_4968 VDD.P23.pSD vout.P22.pSD 0.0462438f
Cred_4969 VDD.P25.pSD vin.$113.GatPoly 0.00212352f
Cred_4970 VDD.P25.pSD vin.$119.GatPoly 0.00287011f
Cred_4971 VDD.P25.pSD vin.$389.Metal1 0.000484945f
Cred_4972 VDD.P25.pSD vin.$394.Metal1 1.1474e-06f
Cred_4973 VDD.P25.pSD vin.$395.Metal1 0.0107252f
Cred_4974 VDD.P25.pSD vin.$398.Metal1 4.44911e-07f
Cred_4975 VDD.P25.pSD vin.$399.Metal1 0.00128293f
Cred_4976 VDD.P25.pSD vin.$652.Metal2 0.000177167f
Cred_4977 VDD.P25.pSD vin.$654.Metal2 7.97556e-05f
Cred_4978 VDD.P25.pSD vin.$655.Metal2 0.00449125f
Cred_4979 VDD.P25.pSD vin.$659.Metal2 0.000279547f
Cred_4980 VDD.P25.pSD vin.$661.Metal2 7.78198e-05f
Cred_4981 VDD.P25.pSD vin.$662.Metal2 0.00244278f
Cred_4982 VDD.P25.pSD vin.P77.GatPoly 0.00619766f
Cred_4983 VDD.P25.pSD vin.P78.GatPoly 0.00635008f
Cred_4984 VDD.P25.pSD vout.$1044.Metal3 0.0695559f
Cred_4985 VDD.P25.pSD vout.$1062.Metal3 0.022824f
Cred_4986 VDD.P25.pSD vout.P22.pSD 0.0470002f
Cred_4987 VDD.P25.pSD vout.P24.nSD 0.000137105f
Cred_4988 VDD.P25.pSD vout.P24.pSD 0.0466253f
Cred_4989 VDD.P27.pSD vin.$122.GatPoly 2.88163e-09f
Cred_4990 VDD.P27.pSD vin.$123.GatPoly 0.00212572f
Cred_4991 VDD.P27.pSD vin.$129.GatPoly 0.00286998f
Cred_4992 VDD.P27.pSD vin.$398.Metal1 2.4151e-07f
Cred_4993 VDD.P27.pSD vin.$399.Metal1 0.00067548f
Cred_4994 VDD.P27.pSD vin.$406.Metal1 1.33806e-06f
Cred_4995 VDD.P27.pSD vin.$407.Metal1 0.0107036f
Cred_4996 VDD.P27.pSD vin.$411.Metal1 0.00109867f
Cred_4997 VDD.P27.pSD vin.$659.Metal2 0.000161165f
Cred_4998 VDD.P27.pSD vin.$661.Metal2 7.94732e-05f
Cred_4999 VDD.P27.pSD vin.$662.Metal2 0.00252007f
Cred_5000 VDD.P27.pSD vin.$665.Metal2 7.94708e-05f
Cred_5001 VDD.P27.pSD vin.$666.Metal2 0.00461664f
Cred_5002 VDD.P27.pSD vin.$668.Metal2 0.000203384f
Cred_5003 VDD.P27.pSD vin.P79.GatPoly 0.00625351f
Cred_5004 VDD.P27.pSD vin.P80.GatPoly 0.00642063f
Cred_5005 VDD.P27.pSD vout.$1044.Metal3 0.0230566f
Cred_5006 VDD.P27.pSD vout.$1062.Metal3 0.0692055f
Cred_5007 VDD.P27.pSD vout.P24.nSD 0.000138502f
Cred_5008 VDD.P27.pSD vout.P24.pSD 0.0473643f
Cred_5009 VDD.P27.pSD vout.P26.pSD 0.0462489f
Cred_5010 VDD.P29.pSD vin.$133.GatPoly 0.00212409f
Cred_5011 VDD.P29.pSD vin.$139.GatPoly 0.00286998f
Cred_5012 VDD.P29.pSD vin.$411.Metal1 0.000541815f
Cred_5013 VDD.P29.pSD vin.$416.Metal1 1.09076e-06f
Cred_5014 VDD.P29.pSD vin.$417.Metal1 0.0105684f
Cred_5015 VDD.P29.pSD vin.$420.Metal1 4.8736e-07f
Cred_5016 VDD.P29.pSD vin.$421.Metal1 0.00137007f
Cred_5017 VDD.P29.pSD vin.$668.Metal2 0.000203384f
Cred_5018 VDD.P29.pSD vin.$670.Metal2 7.90636e-05f
Cred_5019 VDD.P29.pSD vin.$671.Metal2 0.0046186f
Cred_5020 VDD.P29.pSD vin.$674.Metal2 7.90636e-05f
Cred_5021 VDD.P29.pSD vin.$676.Metal2 0.000172461f
Cred_5022 VDD.P29.pSD vin.$678.Metal2 0.00250594f
Cred_5023 VDD.P29.pSD vin.P81.GatPoly 0.00632524f
Cred_5024 VDD.P29.pSD vin.P82.GatPoly 0.0063489f
Cred_5025 VDD.P29.pSD vout.$1062.Metal3 0.0695527f
Cred_5026 VDD.P29.pSD vout.$1080.Metal3 0.02282f
Cred_5027 VDD.P29.pSD vout.P26.pSD 0.0469962f
Cred_5028 VDD.P29.pSD vout.P28.nSD 0.000137081f
Cred_5029 VDD.P29.pSD vout.P28.pSD 0.0466207f
Cred_5030 VDD.P3.pSD vin 0.00018624f
Cred_5031 VDD.P3.pSD vin.$13.GatPoly 0.000637014f
Cred_5032 VDD.P3.pSD vin.$271.Metal1 0.00162013f
Cred_5033 VDD.P3.pSD vin.$274.Metal1 6.83608e-07f
Cred_5034 VDD.P3.pSD vin.$275.Metal1 0.00716601f
Cred_5035 VDD.P3.pSD vin.$279.Metal1 0.00195148f
Cred_5036 VDD.P3.pSD vin.$4.GatPoly 4.87772e-09f
Cred_5037 VDD.P3.pSD vin.$5.GatPoly 0.00222514f
Cred_5038 VDD.P3.pSD vin.$564.Metal2 4.19616e-05f
Cred_5039 VDD.P3.pSD vin.$566.Metal2 0.00298619f
Cred_5040 VDD.P3.pSD vin.$569.Metal2 4.00367e-05f
Cred_5041 VDD.P3.pSD vin.$573.Metal2 0.00317806f
Cred_5042 VDD.P3.pSD vin.$574.Metal2 8.6586e-06f
Cred_5043 VDD.P3.pSD vin.$581.Metal2 4.43045e-05f
Cred_5044 VDD.P3.pSD vin.P0.GatPoly 4.58126e-10f
Cred_5045 VDD.P3.pSD vin.P55.GatPoly 0.00300389f
Cred_5046 VDD.P3.pSD vin.P56.GatPoly 0.0030814f
Cred_5047 VDD.P3.pSD vout.$954.Metal3 0.0570952f
Cred_5048 VDD.P3.pSD vout.P0.nSD 0.000128771f
Cred_5049 VDD.P3.pSD vout.P0.pSD 0.0291176f
Cred_5050 VDD.P3.pSD vout.P2.pSD 0.0276949f
Cred_5051 VDD.P31.pSD vin.$143.GatPoly 0.00211776f
Cred_5052 VDD.P31.pSD vin.$149.GatPoly 0.00287011f
Cred_5053 VDD.P31.pSD vin.$425.Metal1 0.00128293f
Cred_5054 VDD.P31.pSD vin.$429.Metal1 0.010241f
Cred_5055 VDD.P31.pSD vin.$433.Metal1 0.000983873f
Cred_5056 VDD.P31.pSD vin.$676.Metal2 0.000252197f
Cred_5057 VDD.P31.pSD vin.$678.Metal2 0.00246281f
Cred_5058 VDD.P31.pSD vin.$679.Metal2 0.000161177f
Cred_5059 VDD.P31.pSD vin.$682.Metal2 0.004483f
Cred_5060 VDD.P31.pSD vin.$684.Metal2 0.00018183f
Cred_5061 VDD.P31.pSD vin.P83.GatPoly 0.0062547f
Cred_5062 VDD.P31.pSD vin.P84.GatPoly 0.00629304f
Cred_5063 VDD.P31.pSD vout.$1062.Metal3 0.0230607f
Cred_5064 VDD.P31.pSD vout.$1080.Metal3 0.0692177f
Cred_5065 VDD.P31.pSD vout.P28.nSD 0.000138527f
Cred_5066 VDD.P31.pSD vout.P28.pSD 0.047369f
Cred_5067 VDD.P31.pSD vout.P30.pSD 0.0462534f
Cred_5068 VDD.P33.pSD vin.$153.GatPoly 0.0021246f
Cred_5069 VDD.P33.pSD vin.$159.GatPoly 0.00286983f
Cred_5070 VDD.P33.pSD vin.$433.Metal1 0.000593963f
Cred_5071 VDD.P33.pSD vin.$439.Metal1 0.0104242f
Cred_5072 VDD.P33.pSD vin.$443.Metal1 0.00144745f
Cred_5073 VDD.P33.pSD vin.$684.Metal2 0.000195712f
Cred_5074 VDD.P33.pSD vin.$687.Metal2 0.00471434f
Cred_5075 VDD.P33.pSD vin.$688.Metal2 0.000150786f
Cred_5076 VDD.P33.pSD vin.$691.Metal2 0.000256201f
Cred_5077 VDD.P33.pSD vin.$694.Metal2 0.00234278f
Cred_5078 VDD.P33.pSD vin.P85.GatPoly 0.00632474f
Cred_5079 VDD.P33.pSD vin.P86.GatPoly 0.00634692f
Cred_5080 VDD.P33.pSD vout.$1080.Metal3 0.0695302f
Cred_5081 VDD.P33.pSD vout.$1098.Metal3 0.0228156f
Cred_5082 VDD.P33.pSD vout.P30.pSD 0.0469905f
Cred_5083 VDD.P33.pSD vout.P32.nSD 0.000137054f
Cred_5084 VDD.P33.pSD vout.P32.pSD 0.0466156f
Cred_5085 VDD.P35.pSD vin.$163.GatPoly 0.00212483f
Cred_5086 VDD.P35.pSD vin.$169.GatPoly 0.00287023f
Cred_5087 VDD.P35.pSD vin.$443.Metal1 0.00058523f
Cred_5088 VDD.P35.pSD vin.$446.Metal1 3.98459e-07f
Cred_5089 VDD.P35.pSD vin.$450.Metal1 1.19538e-06f
Cred_5090 VDD.P35.pSD vin.$451.Metal1 0.0110213f
Cred_5091 VDD.P35.pSD vin.$691.Metal2 0.000195862f
Cred_5092 VDD.P35.pSD vin.$693.Metal2 7.98101e-05f
Cred_5093 VDD.P35.pSD vin.$694.Metal2 0.00263234f
Cred_5094 VDD.P35.pSD vin.$697.Metal2 7.98101e-05f
Cred_5095 VDD.P35.pSD vin.$698.Metal2 0.00435649f
Cred_5096 VDD.P35.pSD vin.$700.Metal2 0.000195862f
Cred_5097 VDD.P35.pSD vin.P87.GatPoly 0.00625503f
Cred_5098 VDD.P35.pSD vin.P88.GatPoly 0.00628837f
Cred_5099 VDD.P35.pSD vout.$1080.Metal3 0.0230646f
Cred_5100 VDD.P35.pSD vout.$1098.Metal3 0.0692297f
Cred_5101 VDD.P35.pSD vout.P32.nSD 0.00013855f
Cred_5102 VDD.P35.pSD vout.P32.pSD 0.0473732f
Cred_5103 VDD.P35.pSD vout.P34.pSD 0.0462576f
Cred_5104 VDD.P37.pSD vin.$173.GatPoly 0.00212505f
Cred_5105 VDD.P37.pSD vin.$179.GatPoly 0.00286967f
Cred_5106 VDD.P37.pSD vin.$455.Metal1 0.000641391f
Cred_5107 VDD.P37.pSD vin.$461.Metal1 0.0102947f
Cred_5108 VDD.P37.pSD vin.$465.Metal1 0.00151595f
Cred_5109 VDD.P37.pSD vin.$700.Metal2 0.000195652f
Cred_5110 VDD.P37.pSD vin.$703.Metal2 0.00485226f
Cred_5111 VDD.P37.pSD vin.$704.Metal2 0.000144251f
Cred_5112 VDD.P37.pSD vin.$707.Metal2 0.000292266f
Cred_5113 VDD.P37.pSD vin.$710.Metal2 0.00224514f
Cred_5114 VDD.P37.pSD vin.P89.GatPoly 0.0063242f
Cred_5115 VDD.P37.pSD vin.P90.GatPoly 0.00634425f
Cred_5116 VDD.P37.pSD vout.$1098.Metal3 0.069423f
Cred_5117 VDD.P37.pSD vout.$1116.Metal3 0.0228107f
Cred_5118 VDD.P37.pSD vout.P34.pSD 0.0469783f
Cred_5119 VDD.P37.pSD vout.P36.nSD 0.000137025f
Cred_5120 VDD.P37.pSD vout.P36.pSD 0.04661f
Cred_5121 VDD.P39.pSD vin.$183.GatPoly 0.00212429f
Cred_5122 VDD.P39.pSD vin.$189.GatPoly 0.00287034f
Cred_5123 VDD.P39.pSD vin.$465.Metal1 0.000533505f
Cred_5124 VDD.P39.pSD vin.$468.Metal1 3.5176e-07f
Cred_5125 VDD.P39.pSD vin.$472.Metal1 1.24289e-06f
Cred_5126 VDD.P39.pSD vin.$473.Metal1 0.0111268f
Cred_5127 VDD.P39.pSD vin.$707.Metal2 0.000195097f
Cred_5128 VDD.P39.pSD vin.$709.Metal2 7.98262e-05f
Cred_5129 VDD.P39.pSD vin.$710.Metal2 0.00275464f
Cred_5130 VDD.P39.pSD vin.$713.Metal2 7.98262e-05f
Cred_5131 VDD.P39.pSD vin.$714.Metal2 0.00423205f
Cred_5132 VDD.P39.pSD vin.$716.Metal2 0.000195304f
Cred_5133 VDD.P39.pSD vin.P91.GatPoly 0.00625443f
Cred_5134 VDD.P39.pSD vin.P92.GatPoly 0.00628881f
Cred_5135 VDD.P39.pSD vout.$1098.Metal3 0.0230685f
Cred_5136 VDD.P39.pSD vout.$1116.Metal3 0.0692401f
Cred_5137 VDD.P39.pSD vout.P36.nSD 0.000138574f
Cred_5138 VDD.P39.pSD vout.P36.pSD 0.0473771f
Cred_5139 VDD.P39.pSD vout.P38.pSD 0.0462612f
Cred_5140 VDD.P41.pSD vin.$193.GatPoly 0.00212543f
Cred_5141 VDD.P41.pSD vin.$199.GatPoly 0.00286949f
Cred_5142 VDD.P41.pSD vin.$477.Metal1 0.0006841f
Cred_5143 VDD.P41.pSD vin.$483.Metal1 0.0101791f
Cred_5144 VDD.P41.pSD vin.$487.Metal1 0.00157529f
Cred_5145 VDD.P41.pSD vin.$716.Metal2 0.000176959f
Cred_5146 VDD.P41.pSD vin.$719.Metal2 0.00491539f
Cred_5147 VDD.P41.pSD vin.$720.Metal2 0.000134292f
Cred_5148 VDD.P41.pSD vin.$723.Metal2 0.000412143f
Cred_5149 VDD.P41.pSD vin.$726.Metal2 0.00209068f
Cred_5150 VDD.P41.pSD vin.P93.GatPoly 0.00632361f
Cred_5151 VDD.P41.pSD vin.P94.GatPoly 0.00634092f
Cred_5152 VDD.P41.pSD vout.$1116.Metal3 0.0694038f
Cred_5153 VDD.P41.pSD vout.$1134.Metal3 0.0228055f
Cred_5154 VDD.P41.pSD vout.P38.pSD 0.046972f
Cred_5155 VDD.P41.pSD vout.P40.nSD 0.000136994f
Cred_5156 VDD.P41.pSD vout.P40.pSD 0.046604f
Cred_5157 VDD.P43.pSD vin.$202.GatPoly 1.79303e-09f
Cred_5158 VDD.P43.pSD vin.$203.GatPoly 0.00239712f
Cred_5159 VDD.P43.pSD vin.$211.GatPoly 0.00239153f
Cred_5160 VDD.P43.pSD vin.$486.Metal1 1.50305e-07f
Cred_5161 VDD.P43.pSD vin.$487.Metal1 0.000471831f
Cred_5162 VDD.P43.pSD vin.$494.Metal1 1.44101e-06f
Cred_5163 VDD.P43.pSD vin.$495.Metal1 0.0113689f
Cred_5164 VDD.P43.pSD vin.$501.Metal1 3.53366e-06f
Cred_5165 VDD.P43.pSD vin.$723.Metal2 0.000150639f
Cred_5166 VDD.P43.pSD vin.$725.Metal2 7.98422e-05f
Cred_5167 VDD.P43.pSD vin.$726.Metal2 5.62952e-06f
Cred_5168 VDD.P43.pSD vin.$728.Metal2 0.00619758f
Cred_5169 VDD.P43.pSD vin.$729.Metal2 7.98404e-05f
Cred_5170 VDD.P43.pSD vin.$732.Metal2 0.000193057f
Cred_5171 VDD.P43.pSD vin.$733.Metal2 0.000876935f
Cred_5172 VDD.P43.pSD vin.P95.GatPoly 0.00625878f
Cred_5173 VDD.P43.pSD vin.P96.GatPoly 0.00634165f
Cred_5174 VDD.P43.pSD vout.$1116.Metal3 0.0230723f
Cred_5175 VDD.P43.pSD vout.$1134.Metal3 0.0692497f
Cred_5176 VDD.P43.pSD vout.P40.nSD 0.000138597f
Cred_5177 VDD.P43.pSD vout.P40.pSD 0.0473805f
Cred_5178 VDD.P43.pSD vout.P42.pSD 0.0462644f
Cred_5179 VDD.P45.pSD vin.$215.GatPoly 0.00330168f
Cred_5180 VDD.P45.pSD vin.$223.GatPoly 0.000945208f
Cred_5181 VDD.P45.pSD vin.$501.Metal1 0.00147747f
Cred_5182 VDD.P45.pSD vin.$505.Metal1 0.00887158f
Cred_5183 VDD.P45.pSD vin.$509.Metal1 0.00210683f
Cred_5184 VDD.P45.pSD vin.$732.Metal2 0.000209482f
Cred_5185 VDD.P45.pSD vin.$733.Metal2 0.00172657f
Cred_5186 VDD.P45.pSD vin.$736.Metal2 0.000133444f
Cred_5187 VDD.P45.pSD vin.$737.Metal2 0.00549874f
Cred_5188 VDD.P45.pSD vin.$739.Metal2 0.000181551f
Cred_5189 VDD.P45.pSD vin.P97.GatPoly 0.00627656f
Cred_5190 VDD.P45.pSD vin.P98.GatPoly 0.00645156f
Cred_5191 VDD.P45.pSD vout.$1134.Metal3 0.0693835f
Cred_5192 VDD.P45.pSD vout.$1152.Metal3 0.0227999f
Cred_5193 VDD.P45.pSD vout.P42.pSD 0.0469654f
Cred_5194 VDD.P45.pSD vout.P44.nSD 0.00013696f
Cred_5195 VDD.P45.pSD vout.P44.pSD 0.0465975f
Cred_5196 VDD.P47.pSD vin.$222.GatPoly 1.51759e-09f
Cred_5197 VDD.P47.pSD vin.$223.GatPoly 0.00239647f
Cred_5198 VDD.P47.pSD vin.$231.GatPoly 0.00239156f
Cred_5199 VDD.P47.pSD vin.$508.Metal1 1.27233e-07f
Cred_5200 VDD.P47.pSD vin.$509.Metal1 0.000411643f
Cred_5201 VDD.P47.pSD vin.$516.Metal1 1.46556e-06f
Cred_5202 VDD.P47.pSD vin.$517.Metal1 0.0114289f
Cred_5203 VDD.P47.pSD vin.$523.Metal1 5.22756e-09f
Cred_5204 VDD.P47.pSD vin.$739.Metal2 0.000209965f
Cred_5205 VDD.P47.pSD vin.$741.Metal2 7.98539e-05f
Cred_5206 VDD.P47.pSD vin.$742.Metal2 5.15098e-06f
Cred_5207 VDD.P47.pSD vin.$744.Metal2 0.00703052f
Cred_5208 VDD.P47.pSD vin.$745.Metal2 7.98523e-05f
Cred_5209 VDD.P47.pSD vin.$748.Metal2 0.000181969f
Cred_5210 VDD.P47.pSD vin.$749.Metal2 1.34164e-06f
Cred_5211 VDD.P47.pSD vin.P100.GatPoly 0.00634202f
Cred_5212 VDD.P47.pSD vin.P99.GatPoly 0.00625599f
Cred_5213 VDD.P47.pSD vout.$1134.Metal3 0.0230761f
Cred_5214 VDD.P47.pSD vout.$1152.Metal3 0.0692584f
Cred_5215 VDD.P47.pSD vout.P44.nSD 0.000138619f
Cred_5216 VDD.P47.pSD vout.P44.pSD 0.0473835f
Cred_5217 VDD.P47.pSD vout.P46.pSD 0.0462672f
Cred_5218 VDD.P49.pSD vin.$235.GatPoly 0.00342753f
Cred_5219 VDD.P49.pSD vin.$243.GatPoly 0.000945141f
Cred_5220 VDD.P49.pSD vin.$523.Metal1 0.00154468f
Cred_5221 VDD.P49.pSD vin.$527.Metal1 0.00887021f
Cred_5222 VDD.P49.pSD vin.$531.Metal1 0.00214734f
Cred_5223 VDD.P49.pSD vin.$748.Metal2 0.000195441f
Cred_5224 VDD.P49.pSD vin.$749.Metal2 0.00178371f
Cred_5225 VDD.P49.pSD vin.$752.Metal2 0.000124188f
Cred_5226 VDD.P49.pSD vin.$753.Metal2 0.00544726f
Cred_5227 VDD.P49.pSD vin.$755.Metal2 0.000195441f
Cred_5228 VDD.P49.pSD vin.P101.GatPoly 0.00628706f
Cred_5229 VDD.P49.pSD vin.P102.GatPoly 0.00644707f
Cred_5230 VDD.P49.pSD vout.$1152.Metal3 0.0693686f
Cred_5231 VDD.P49.pSD vout.$1170.Metal3 0.0228004f
Cred_5232 VDD.P49.pSD vout.P46.pSD 0.0469582f
Cred_5233 VDD.P49.pSD vout.P48.nSD 0.000136963f
Cred_5234 VDD.P49.pSD vout.P48.pSD 0.0465913f
Cred_5235 VDD.P5.pSD vin 7.11706e-05f
Cred_5236 VDD.P5.pSD vin.$13.GatPoly 0.00211811f
Cred_5237 VDD.P5.pSD vin.$19.GatPoly 0.00287058f
Cred_5238 VDD.P5.pSD vin.$279.Metal1 5.04669e-09f
Cred_5239 VDD.P5.pSD vin.$284.Metal1 1.38577e-06f
Cred_5240 VDD.P5.pSD vin.$285.Metal1 0.0110026f
Cred_5241 VDD.P5.pSD vin.$288.Metal1 2.11389e-07f
Cred_5242 VDD.P5.pSD vin.$289.Metal1 0.000704263f
Cred_5243 VDD.P5.pSD vin.$569.Metal2 7.6401e-06f
Cred_5244 VDD.P5.pSD vin.$573.Metal2 2.64342e-05f
Cred_5245 VDD.P5.pSD vin.$574.Metal2 9.38249e-05f
Cred_5246 VDD.P5.pSD vin.$577.Metal2 0.00704246f
Cred_5247 VDD.P5.pSD vin.$578.Metal2 7.98619e-05f
Cred_5248 VDD.P5.pSD vin.$581.Metal2 0.000259459f
Cred_5249 VDD.P5.pSD vin.P57.GatPoly 0.0061945f
Cred_5250 VDD.P5.pSD vin.P58.GatPoly 0.0063413f
Cred_5251 VDD.P5.pSD vout.$954.Metal3 0.0710092f
Cred_5252 VDD.P5.pSD vout.$972.Metal3 0.0228447f
Cred_5253 VDD.P5.pSD vout.P2.pSD 0.0493852f
Cred_5254 VDD.P5.pSD vout.P4.nSD 0.000137229f
Cred_5255 VDD.P5.pSD vout.P4.pSD 0.0466423f
Cred_5256 VDD.P51.pSD vin.$243.GatPoly 0.00239575f
Cred_5257 VDD.P51.pSD vin.$251.GatPoly 0.00239161f
Cred_5258 VDD.P51.pSD vin.$531.Metal1 0.000346962f
Cred_5259 VDD.P51.pSD vin.$534.Metal1 2.11389e-07f
Cred_5260 VDD.P51.pSD vin.$538.Metal1 1.38577e-06f
Cred_5261 VDD.P51.pSD vin.$539.Metal1 0.0114973f
Cred_5262 VDD.P51.pSD vin.$545.Metal1 5.04669e-09f
Cred_5263 VDD.P51.pSD vin.$755.Metal2 0.000188013f
Cred_5264 VDD.P51.pSD vin.$757.Metal2 7.98619e-05f
Cred_5265 VDD.P51.pSD vin.$758.Metal2 4.54355e-06f
Cred_5266 VDD.P51.pSD vin.$760.Metal2 0.00704337f
Cred_5267 VDD.P51.pSD vin.$761.Metal2 7.98619e-05f
Cred_5268 VDD.P51.pSD vin.$764.Metal2 0.000189308f
Cred_5269 VDD.P51.pSD vin.$765.Metal2 1.34615e-06f
Cred_5270 VDD.P51.pSD vin.P103.GatPoly 0.0062519f
Cred_5271 VDD.P51.pSD vin.P104.GatPoly 0.00627142f
Cred_5272 VDD.P51.pSD vout.$1152.Metal3 0.023085f
Cred_5273 VDD.P51.pSD vout.$1170.Metal3 0.0692919f
Cred_5274 VDD.P51.pSD vout.P48.nSD 0.000138673f
Cred_5275 VDD.P51.pSD vout.P48.pSD 0.0474031f
Cred_5276 VDD.P51.pSD vout.P50.pSD 0.0462705f
Cred_5277 VDD.P53.pSD vin.$251.GatPoly 0.000637014f
Cred_5278 VDD.P53.pSD vin.$259.GatPoly 0.00224851f
Cred_5279 VDD.P53.pSD vin.$545.Metal1 0.0019374f
Cred_5280 VDD.P53.pSD vin.$549.Metal1 0.00863665f
Cred_5281 VDD.P53.pSD vin.$764.Metal2 0.000129749f
Cred_5282 VDD.P53.pSD vin.$765.Metal2 0.0016481f
Cred_5283 VDD.P53.pSD vin.$768.Metal2 7.79495e-05f
Cred_5284 VDD.P53.pSD vin.$769.Metal2 0.00462481f
Cred_5285 VDD.P53.pSD vin.$771.Metal2 0.000144645f
Cred_5286 VDD.P53.pSD vin.P105.GatPoly 0.0030814f
Cred_5287 VDD.P53.pSD vin.P106.GatPoly 0.00300389f
Cred_5288 VDD.P53.pSD vin.P107.GatPoly 1.09548e-06f
Cred_5289 VDD.P53.pSD vout 0.0286938f
Cred_5290 VDD.P53.pSD vout.$1170.Metal3 0.0297664f
Cred_5291 VDD.P53.pSD vout.P50.pSD 0.0289413f
Cred_5292 VDD.P53.pSD vout.P52.pSD 0.0289815f
Cred_5293 VDD.P55.pSD vin.$258.GatPoly 1.45719e-09f
Cred_5294 VDD.P55.pSD vin.$259.GatPoly 0.00016571f
Cred_5295 VDD.P55.pSD vin.$548.Metal1 7.04525e-08f
Cred_5296 VDD.P55.pSD vin.$549.Metal1 0.00317736f
Cred_5297 VDD.P55.pSD vin.$768.Metal2 1.11435e-06f
Cred_5298 VDD.P55.pSD vin.$769.Metal2 0.00171132f
Cred_5299 VDD.P55.pSD vin.$771.Metal2 0.000624366f
Cred_5300 VDD.P55.pSD vin.P107.GatPoly 0.000414077f
Cred_5301 VDD.P55.pSD vin.P53.GatPoly 1.84791e-10f
Cred_5302 VDD.P55.pSD vout 0.00172569f
Cred_5303 VDD.P55.pSD vout.P52.pSD 0.00260261f
Cred_5304 VDD.P55.pSD VSS.$1048.Metal3 2.3978e-06f
Cred_5305 VDD.P55.pSD VSS.$14.Metal1 1.63158e-08f
Cred_5306 VDD.P55.pSD VSS.$29.Metal1 2.74541e-08f
Cred_5307 VDD.P55.pSD VSS.$490.Metal1 2.45452e-10f
Cred_5308 VDD.P55.pSD VSS.$496.Metal1 3.09154e-11f
Cred_5309 VDD.P55.pSD VSS.$500.Metal1 1.35451e-06f
Cred_5310 VDD.P55.pSD VSS.$520.Metal1 7.36228e-05f
Cred_5311 VDD.P55.pSD VSS.$895.Metal2 3.36508e-08f
Cred_5312 VDD.P55.pSD VSS.$904.Metal2 2.71342e-05f
Cred_5313 VDD.P55.pSD VSS.P0.pSD 0.000116733f
Cred_5314 VDD.P55.pSD VSS.P55.nSD 1.00422e-08f
Cred_5315 VDD.P55.pSD VSS.P57.nSD 1.00422e-08f
Cred_5316 VDD.P57.pSD vin.$258.GatPoly 1.45719e-09f
Cred_5317 VDD.P57.pSD vin.$259.GatPoly 0.000110833f
Cred_5318 VDD.P57.pSD vin.$548.Metal1 7.04525e-08f
Cred_5319 VDD.P57.pSD vin.$549.Metal1 0.000679666f
Cred_5320 VDD.P57.pSD vin.$768.Metal2 1.11435e-06f
Cred_5321 VDD.P57.pSD vin.$769.Metal2 6.92163e-05f
Cred_5322 VDD.P57.pSD vin.$771.Metal2 2.37015e-05f
Cred_5323 VDD.P57.pSD vin.P107.GatPoly 0.000410572f
Cred_5324 VDD.P57.pSD vin.P53.GatPoly 1.84791e-10f
Cred_5325 VDD.P57.pSD vout 0.00172569f
Cred_5326 VDD.P57.pSD vout.P52.pSD 0.00260261f
Cred_5327 VDD.P57.pSD VSS.$1048.Metal3 2.3978e-06f
Cred_5328 VDD.P57.pSD VSS.$14.Metal1 1.63158e-08f
Cred_5329 VDD.P57.pSD VSS.$29.Metal1 2.74541e-08f
Cred_5330 VDD.P57.pSD VSS.$490.Metal1 2.45452e-10f
Cred_5331 VDD.P57.pSD VSS.$496.Metal1 3.09154e-11f
Cred_5332 VDD.P57.pSD VSS.$500.Metal1 1.35451e-06f
Cred_5333 VDD.P57.pSD VSS.$520.Metal1 7.36228e-05f
Cred_5334 VDD.P57.pSD VSS.$895.Metal2 3.36508e-08f
Cred_5335 VDD.P57.pSD VSS.$904.Metal2 2.71342e-05f
Cred_5336 VDD.P57.pSD VSS.P0.pSD 0.000116733f
Cred_5337 VDD.P57.pSD VSS.P55.nSD 1.00422e-08f
Cred_5338 VDD.P57.pSD VSS.P57.nSD 1.00422e-08f
Cred_5339 VDD.P7.pSD vin.$23.GatPoly 0.00212671f
Cred_5340 VDD.P7.pSD vin.$289.Metal1 0.000812695f
Cred_5341 VDD.P7.pSD vin.$29.GatPoly 0.00299519f
Cred_5342 VDD.P7.pSD vin.$297.Metal1 0.00951075f
Cred_5343 VDD.P7.pSD vin.$301.Metal1 0.00154386f
Cred_5344 VDD.P7.pSD vin.$579.Metal2 5.43947e-06f
Cred_5345 VDD.P7.pSD vin.$581.Metal2 0.000176828f
Cred_5346 VDD.P7.pSD vin.$583.Metal2 0.000124188f
Cred_5347 VDD.P7.pSD vin.$584.Metal2 0.00539968f
Cred_5348 VDD.P7.pSD vin.$588.Metal2 0.000214055f
Cred_5349 VDD.P7.pSD vin.$589.Metal2 0.00183972f
Cred_5350 VDD.P7.pSD vin.P59.GatPoly 0.00623713f
Cred_5351 VDD.P7.pSD vin.P60.GatPoly 0.00642884f
Cred_5352 VDD.P7.pSD vout.$954.Metal3 0.0230353f
Cred_5353 VDD.P7.pSD vout.$972.Metal3 0.0691313f
Cred_5354 VDD.P7.pSD vout.P4.nSD 0.000138375f
Cred_5355 VDD.P7.pSD vout.P4.pSD 0.0473348f
Cred_5356 VDD.P7.pSD vout.P6.pSD 0.0462191f
Cred_5357 vin vout.$954.Metal3 0.0908522f
Cred_5358 vin vout.P0.nSD 0.000270593f
Cred_5359 vin vout.P0.pSD 0.000726743f
Cred_5360 vin vout.P2.nSD 9.84849e-05f
Cred_5361 vin VSS.$14.Metal1 0.00464444f
Cred_5362 vin VSS.$29.Metal1 0.00781505f
Cred_5363 vin VSS.$50.Metal1 0.000290327f
Cred_5364 vin VSS.$520.Metal1 1.99195e-05f
Cred_5365 vin VSS.$550.Metal2 0.000385994f
Cred_5366 vin VSS.$557.Metal2 0.00357044f
Cred_5367 vin VSS.$565.Metal2 0.000689929f
Cred_5368 vin VSS.$572.Metal2 0.000441555f
Cred_5369 vin VSS.$68.Metal1 7.44646e-05f
Cred_5370 vin VSS.P0.pSD 0.037336f
Cred_5371 vin VSS.P3.nSD 3.36182e-05f
Cred_5372 vin VSS.P5.nSD 8.62097e-06f
Cred_5373 vin.$102.GatPoly vout.$1026.Metal3 0.00050693f
Cred_5374 vin.$102.GatPoly vout.$1044.Metal3 0.00050693f
Cred_5375 vin.$102.GatPoly vout.P20.nSD 0.00168149f
Cred_5376 vin.$102.GatPoly vout.P20.pSD 8.2605e-06f
Cred_5377 vin.$102.GatPoly VSS.$14.Metal1 1.23333e-05f
Cred_5378 vin.$102.GatPoly VSS.$204.Metal1 1.18418e-06f
Cred_5379 vin.$102.GatPoly VSS.$220.Metal1 0.00258069f
Cred_5380 vin.$102.GatPoly VSS.$29.Metal1 2.07529e-05f
Cred_5381 vin.$102.GatPoly VSS.$520.Metal1 8.53441e-06f
Cred_5382 vin.$102.GatPoly VSS.$676.Metal2 6.4595e-09f
Cred_5383 vin.$102.GatPoly VSS.$680.Metal2 4.26361e-05f
Cred_5384 vin.$102.GatPoly VSS.$687.Metal2 0.000151539f
Cred_5385 vin.$102.GatPoly VSS.P0.pSD 0.00161247f
Cred_5386 vin.$102.GatPoly VSS.P23.nSD 0.000182065f
Cred_5387 vin.$103.GatPoly vout.$1026.Metal3 0.00249847f
Cred_5388 vin.$103.GatPoly vout.$1044.Metal3 0.00249847f
Cred_5389 vin.$103.GatPoly vout.P20.nSD 1.50084e-05f
Cred_5390 vin.$103.GatPoly vout.P20.pSD 0.00539117f
Cred_5391 vin.$108.GatPoly vout.$1026.Metal3 3.7194e-05f
Cred_5392 vin.$108.GatPoly vout.$1044.Metal3 0.000988791f
Cred_5393 vin.$108.GatPoly vout.P20.nSD 0.000123433f
Cred_5394 vin.$108.GatPoly vout.P20.pSD 6.06082e-07f
Cred_5395 vin.$108.GatPoly vout.P22.nSD 0.00155781f
Cred_5396 vin.$108.GatPoly VSS.$14.Metal1 3.38773e-06f
Cred_5397 vin.$108.GatPoly VSS.$220.Metal1 0.00356094f
Cred_5398 vin.$108.GatPoly VSS.$29.Metal1 5.70041e-06f
Cred_5399 vin.$108.GatPoly VSS.$520.Metal1 2.66452e-06f
Cred_5400 vin.$108.GatPoly VSS.$680.Metal2 5.8794e-05f
Cred_5401 vin.$108.GatPoly VSS.$687.Metal2 0.000209045f
Cred_5402 vin.$108.GatPoly VSS.P0.pSD 0.000472641f
Cred_5403 vin.$108.GatPoly VSS.P23.nSD 0.000246087f
Cred_5404 vin.$109.GatPoly vout.$1026.Metal3 0.000303925f
Cred_5405 vin.$109.GatPoly vout.$1044.Metal3 0.00606653f
Cred_5406 vin.$109.GatPoly vout.P20.nSD 1.8257e-06f
Cred_5407 vin.$109.GatPoly vout.P20.pSD 0.000610584f
Cred_5408 vin.$109.GatPoly vout.P22.pSD 0.00590601f
Cred_5409 vin.$112.GatPoly vout.$1044.Metal3 0.00101831f
Cred_5410 vin.$112.GatPoly vout.P22.nSD 0.00167639f
Cred_5411 vin.$112.GatPoly VSS.$14.Metal1 9.59761e-06f
Cred_5412 vin.$112.GatPoly VSS.$230.Metal1 3.57798e-06f
Cred_5413 vin.$112.GatPoly VSS.$238.Metal1 0.00257452f
Cred_5414 vin.$112.GatPoly VSS.$29.Metal1 1.61496e-05f
Cred_5415 vin.$112.GatPoly VSS.$520.Metal1 1.10326e-05f
Cred_5416 vin.$112.GatPoly VSS.$695.Metal2 0.000141241f
Cred_5417 vin.$112.GatPoly VSS.$702.Metal2 5.17824e-05f
Cred_5418 vin.$112.GatPoly VSS.P0.pSD 0.00161697f
Cred_5419 vin.$112.GatPoly VSS.P25.nSD 0.000177363f
Cred_5420 vin.$113.GatPoly vout.$1044.Metal3 0.00508352f
Cred_5421 vin.$113.GatPoly vout.P22.pSD 0.00540665f
Cred_5422 vin.$118.GatPoly vout.$1044.Metal3 0.000545769f
Cred_5423 vin.$118.GatPoly vout.$1062.Metal3 0.000470552f
Cred_5424 vin.$118.GatPoly vout.P22.nSD 0.00012321f
Cred_5425 vin.$118.GatPoly vout.P24.nSD 0.00156064f
Cred_5426 vin.$118.GatPoly vout.P24.pSD 7.66771e-06f
Cred_5427 vin.$118.GatPoly VSS.$14.Metal1 2.63902e-06f
Cred_5428 vin.$118.GatPoly VSS.$238.Metal1 0.00356098f
Cred_5429 vin.$118.GatPoly VSS.$29.Metal1 4.44059e-06f
Cred_5430 vin.$118.GatPoly VSS.$520.Metal1 3.44515e-06f
Cred_5431 vin.$118.GatPoly VSS.$695.Metal2 0.000195949f
Cred_5432 vin.$118.GatPoly VSS.$702.Metal2 7.18481e-05f
Cred_5433 vin.$118.GatPoly VSS.P0.pSD 0.000473869f
Cred_5434 vin.$118.GatPoly VSS.P25.nSD 0.000246092f
Cred_5435 vin.$119.GatPoly vout.$1044.Metal3 0.00346416f
Cred_5436 vin.$119.GatPoly vout.$1062.Metal3 0.00284953f
Cred_5437 vin.$119.GatPoly vout.P22.pSD 0.000605631f
Cred_5438 vin.$119.GatPoly vout.P24.nSD 1.71173e-05f
Cred_5439 vin.$119.GatPoly vout.P24.pSD 0.00595245f
Cred_5440 vin.$12.GatPoly vout.$954.Metal3 0.00135038f
Cred_5441 vin.$12.GatPoly vout.P2.nSD 0.00221631f
Cred_5442 vin.$12.GatPoly VSS.$14.Metal1 0.000136734f
Cred_5443 vin.$12.GatPoly VSS.$29.Metal1 0.000230078f
Cred_5444 vin.$12.GatPoly VSS.$50.Metal1 0.00110389f
Cred_5445 vin.$12.GatPoly VSS.$520.Metal1 8.76741e-07f
Cred_5446 vin.$12.GatPoly VSS.$550.Metal2 8.10497e-06f
Cred_5447 vin.$12.GatPoly VSS.$557.Metal2 7.4971e-05f
Cred_5448 vin.$12.GatPoly VSS.$565.Metal2 0.000105197f
Cred_5449 vin.$12.GatPoly VSS.$572.Metal2 6.73097e-05f
Cred_5450 vin.$12.GatPoly VSS.$60.Metal1 3.31573e-06f
Cred_5451 vin.$12.GatPoly VSS.$68.Metal1 0.00243216f
Cred_5452 vin.$12.GatPoly VSS.P0.GatPoly 0.00132634f
Cred_5453 vin.$12.GatPoly VSS.P0.pSD 0.00143528f
Cred_5454 vin.$12.GatPoly VSS.P3.nSD 7.6285e-05f
Cred_5455 vin.$12.GatPoly VSS.P5.nSD 0.000158547f
Cred_5456 vin.$122.GatPoly vout.$1044.Metal3 0.00048022f
Cred_5457 vin.$122.GatPoly vout.$1062.Metal3 0.000480292f
Cred_5458 vin.$122.GatPoly vout.P24.nSD 0.00159266f
Cred_5459 vin.$122.GatPoly vout.P24.pSD 7.82525e-06f
Cred_5460 vin.$122.GatPoly vout.P26.nSD 1.15464e-09f
Cred_5461 vin.$122.GatPoly VSS.$14.Metal1 5.32239e-07f
Cred_5462 vin.$122.GatPoly VSS.$238.Metal1 1.24184e-06f
Cred_5463 vin.$122.GatPoly VSS.$254.Metal1 0.00122589f
Cred_5464 vin.$122.GatPoly VSS.$29.Metal1 8.9558e-07f
Cred_5465 vin.$122.GatPoly VSS.$520.Metal1 1.0575e-06f
Cred_5466 vin.$122.GatPoly VSS.$702.Metal2 7.00777e-09f
Cred_5467 vin.$122.GatPoly VSS.$706.Metal2 4.27815e-05f
Cred_5468 vin.$122.GatPoly VSS.$713.Metal2 0.000132571f
Cred_5469 vin.$122.GatPoly VSS.P0.pSD 0.00011737f
Cred_5470 vin.$122.GatPoly VSS.P27.nSD 0.000163986f
Cred_5471 vin.$123.GatPoly vout.$1044.Metal3 0.00251641f
Cred_5472 vin.$123.GatPoly vout.$1062.Metal3 0.00251648f
Cred_5473 vin.$123.GatPoly vout.P24.nSD 1.51162e-05f
Cred_5474 vin.$123.GatPoly vout.P24.pSD 0.00545011f
Cred_5475 vin.$123.GatPoly vout.P26.pSD 3.55446e-09f
Cred_5476 vin.$123.GatPoly VSS.$254.Metal1 2.9217e-09f
Cred_5477 vin.$123.GatPoly VSS.$706.Metal2 5.64586e-09f
Cred_5478 vin.$123.GatPoly VSS.$713.Metal2 1.75022e-08f
Cred_5479 vin.$123.GatPoly VSS.P27.nSD 3.3831e-10f
Cred_5480 vin.$126.GatPoly vout.$1044.Metal3 8.02062e-05f
Cred_5481 vin.$126.GatPoly vout.$1062.Metal3 0.000557896f
Cred_5482 vin.$126.GatPoly vout.P24.nSD 0.000266175f
Cred_5483 vin.$126.GatPoly vout.P24.pSD 1.30697e-06f
Cred_5484 vin.$126.GatPoly vout.P26.nSD 0.000782001f
Cred_5485 vin.$126.GatPoly VSS.$14.Metal1 7.33641e-06f
Cred_5486 vin.$126.GatPoly VSS.$254.Metal1 0.0048986f
Cred_5487 vin.$126.GatPoly VSS.$29.Metal1 1.23447e-05f
Cred_5488 vin.$126.GatPoly VSS.$520.Metal1 1.69437e-05f
Cred_5489 vin.$126.GatPoly VSS.$706.Metal2 4.36233e-05f
Cred_5490 vin.$126.GatPoly VSS.$713.Metal2 0.000135232f
Cred_5491 vin.$126.GatPoly VSS.P0.pSD 0.00174048f
Cred_5492 vin.$126.GatPoly VSS.P27.nSD 0.000164345f
Cred_5493 vin.$129.GatPoly vout.$1044.Metal3 0.000303925f
Cred_5494 vin.$129.GatPoly vout.$1062.Metal3 0.00606653f
Cred_5495 vin.$129.GatPoly vout.P24.nSD 1.8257e-06f
Cred_5496 vin.$129.GatPoly vout.P24.pSD 0.000610584f
Cred_5497 vin.$129.GatPoly vout.P26.pSD 0.00590601f
Cred_5498 vin.$13.GatPoly vout.$954.Metal3 0.00720389f
Cred_5499 vin.$13.GatPoly vout.P2.pSD 0.00758096f
Cred_5500 vin.$132.GatPoly vout.$1062.Metal3 0.0012776f
Cred_5501 vin.$132.GatPoly vout.P26.nSD 0.0021015f
Cred_5502 vin.$132.GatPoly VSS 3.97555e-06f
Cred_5503 vin.$132.GatPoly VSS.$14.Metal1 1.12455e-05f
Cred_5504 vin.$132.GatPoly VSS.$254.Metal1 0.000457746f
Cred_5505 vin.$132.GatPoly VSS.$270.Metal1 0.00257374f
Cred_5506 vin.$132.GatPoly VSS.$29.Metal1 1.89224e-05f
Cred_5507 vin.$132.GatPoly VSS.$520.Metal1 3.72247e-05f
Cred_5508 vin.$132.GatPoly VSS.$706.Metal2 1.60088e-05f
Cred_5509 vin.$132.GatPoly VSS.$713.Metal2 4.96272e-05f
Cred_5510 vin.$132.GatPoly VSS.$721.Metal2 0.000145957f
Cred_5511 vin.$132.GatPoly VSS.$728.Metal2 4.70784e-05f
Cred_5512 vin.$132.GatPoly VSS.P0.pSD 0.00318262f
Cred_5513 vin.$132.GatPoly VSS.P27.nSD 6.0311e-05f
Cred_5514 vin.$132.GatPoly VSS.P29.nSD 0.000177362f
Cred_5515 vin.$133.GatPoly vout.$1062.Metal3 0.0050839f
Cred_5516 vin.$133.GatPoly vout.P26.pSD 0.00540767f
Cred_5517 vin.$138.GatPoly vout.$1062.Metal3 0.000545769f
Cred_5518 vin.$138.GatPoly vout.$1080.Metal3 0.000470552f
Cred_5519 vin.$138.GatPoly vout.P26.nSD 0.00012321f
Cred_5520 vin.$138.GatPoly vout.P28.nSD 0.00156064f
Cred_5521 vin.$138.GatPoly vout.P28.pSD 7.66771e-06f
Cred_5522 vin.$138.GatPoly VSS.$14.Metal1 1.49098e-06f
Cred_5523 vin.$138.GatPoly VSS.$270.Metal1 0.00356096f
Cred_5524 vin.$138.GatPoly VSS.$29.Metal1 2.50882e-06f
Cred_5525 vin.$138.GatPoly VSS.$520.Metal1 6.1701e-06f
Cred_5526 vin.$138.GatPoly VSS.$721.Metal2 0.000202496f
Cred_5527 vin.$138.GatPoly VSS.$728.Metal2 6.53213e-05f
Cred_5528 vin.$138.GatPoly VSS.P0.pSD 0.000474224f
Cred_5529 vin.$138.GatPoly VSS.P29.nSD 0.00024609f
Cred_5530 vin.$139.GatPoly vout.$1062.Metal3 0.00346416f
Cred_5531 vin.$139.GatPoly vout.$1080.Metal3 0.00284953f
Cred_5532 vin.$139.GatPoly vout.P26.pSD 0.000605631f
Cred_5533 vin.$139.GatPoly vout.P28.nSD 1.71173e-05f
Cred_5534 vin.$139.GatPoly vout.P28.pSD 0.00595245f
Cred_5535 vin.$142.GatPoly vout.$1062.Metal3 0.00051035f
Cred_5536 vin.$142.GatPoly vout.$1080.Metal3 0.000571358f
Cred_5537 vin.$142.GatPoly vout.P28.nSD 0.001693f
Cred_5538 vin.$142.GatPoly vout.P28.pSD 8.31623e-06f
Cred_5539 vin.$142.GatPoly vout.P30.nSD 9.99332e-05f
Cred_5540 vin.$142.GatPoly VSS.$14.Metal1 1.2534e-06f
Cred_5541 vin.$142.GatPoly VSS.$270.Metal1 1.72176e-06f
Cred_5542 vin.$142.GatPoly VSS.$286.Metal1 0.00290416f
Cred_5543 vin.$142.GatPoly VSS.$29.Metal1 2.10905e-06f
Cred_5544 vin.$142.GatPoly VSS.$520.Metal1 8.10086e-06f
Cred_5545 vin.$142.GatPoly VSS.$728.Metal2 1.00401e-08f
Cred_5546 vin.$142.GatPoly VSS.$732.Metal2 5.85992e-05f
Cred_5547 vin.$142.GatPoly VSS.$739.Metal2 0.000159752f
Cred_5548 vin.$142.GatPoly VSS.P0.pSD 0.000499389f
Cred_5549 vin.$142.GatPoly VSS.P31.nSD 0.000203667f
Cred_5550 vin.$143.GatPoly vout.$1062.Metal3 0.00249847f
Cred_5551 vin.$143.GatPoly vout.$1080.Metal3 0.00249847f
Cred_5552 vin.$143.GatPoly vout.P28.nSD 1.50084e-05f
Cred_5553 vin.$143.GatPoly vout.P28.pSD 0.00539117f
Cred_5554 vin.$149.GatPoly vout.$1062.Metal3 0.000303925f
Cred_5555 vin.$149.GatPoly vout.$1080.Metal3 0.00606653f
Cred_5556 vin.$149.GatPoly vout.P28.nSD 1.8257e-06f
Cred_5557 vin.$149.GatPoly vout.P28.pSD 0.000610584f
Cred_5558 vin.$149.GatPoly vout.P30.pSD 0.00590601f
Cred_5559 vin.$150.GatPoly vout.$1062.Metal3 3.01674e-05f
Cred_5560 vin.$150.GatPoly vout.$1080.Metal3 0.00105936f
Cred_5561 vin.$150.GatPoly vout.P28.nSD 0.000100114f
Cred_5562 vin.$150.GatPoly vout.P28.pSD 4.91582e-07f
Cred_5563 vin.$150.GatPoly vout.P30.nSD 0.0016942f
Cred_5564 vin.$150.GatPoly VSS.$14.Metal1 3.79701e-06f
Cred_5565 vin.$150.GatPoly VSS.$286.Metal1 0.00289628f
Cred_5566 vin.$150.GatPoly VSS.$29.Metal1 6.3891e-06f
Cred_5567 vin.$150.GatPoly VSS.$298.Metal1 3.57798e-06f
Cred_5568 vin.$150.GatPoly VSS.$520.Metal1 2.93844e-05f
Cred_5569 vin.$150.GatPoly VSS.$732.Metal2 5.82746e-05f
Cred_5570 vin.$150.GatPoly VSS.$739.Metal2 0.000158947f
Cred_5571 vin.$150.GatPoly VSS.P0.pSD 0.00165794f
Cred_5572 vin.$150.GatPoly VSS.P31.nSD 0.0001996f
Cred_5573 vin.$153.GatPoly vout.$1080.Metal3 0.00508428f
Cred_5574 vin.$153.GatPoly vout.P30.pSD 0.00540964f
Cred_5575 vin.$154.GatPoly vout.$1080.Metal3 0.000988791f
Cred_5576 vin.$154.GatPoly vout.$1098.Metal3 3.7194e-05f
Cred_5577 vin.$154.GatPoly vout.P30.nSD 0.00155781f
Cred_5578 vin.$154.GatPoly vout.P32.nSD 0.000123433f
Cred_5579 vin.$154.GatPoly vout.P32.pSD 6.06082e-07f
Cred_5580 vin.$154.GatPoly VSS.$14.Metal1 8.9184e-07f
Cred_5581 vin.$154.GatPoly VSS.$29.Metal1 1.50067e-06f
Cred_5582 vin.$154.GatPoly VSS.$304.Metal1 0.00356094f
Cred_5583 vin.$154.GatPoly VSS.$520.Metal1 1.01205e-05f
Cred_5584 vin.$154.GatPoly VSS.$747.Metal2 0.000209045f
Cred_5585 vin.$154.GatPoly VSS.$754.Metal2 5.8794e-05f
Cred_5586 vin.$154.GatPoly VSS.P0.pSD 0.000471881f
Cred_5587 vin.$154.GatPoly VSS.P33.nSD 0.000246087f
Cred_5588 vin.$159.GatPoly vout.$1080.Metal3 0.00346416f
Cred_5589 vin.$159.GatPoly vout.$1098.Metal3 0.00284953f
Cred_5590 vin.$159.GatPoly vout.P30.pSD 0.000605631f
Cred_5591 vin.$159.GatPoly vout.P32.nSD 1.71173e-05f
Cred_5592 vin.$159.GatPoly vout.P32.pSD 0.00595245f
Cred_5593 vin.$160.GatPoly vout.$1080.Metal3 0.00050693f
Cred_5594 vin.$160.GatPoly vout.$1098.Metal3 0.00050693f
Cred_5595 vin.$160.GatPoly vout.P32.nSD 0.00168149f
Cred_5596 vin.$160.GatPoly vout.P32.pSD 8.2605e-06f
Cred_5597 vin.$160.GatPoly VSS.$14.Metal1 2.85651e-06f
Cred_5598 vin.$160.GatPoly VSS.$29.Metal1 4.80656e-06f
Cred_5599 vin.$160.GatPoly VSS.$304.Metal1 0.00258069f
Cred_5600 vin.$160.GatPoly VSS.$320.Metal1 1.18418e-06f
Cred_5601 vin.$160.GatPoly VSS.$520.Metal1 3.68447e-05f
Cred_5602 vin.$160.GatPoly VSS.$747.Metal2 0.000151539f
Cred_5603 vin.$160.GatPoly VSS.$754.Metal2 4.26361e-05f
Cred_5604 vin.$160.GatPoly VSS.$758.Metal2 6.4595e-09f
Cred_5605 vin.$160.GatPoly VSS.P0.pSD 0.00160958f
Cred_5606 vin.$160.GatPoly VSS.P33.nSD 0.000182065f
Cred_5607 vin.$163.GatPoly vout.$1080.Metal3 0.00251645f
Cred_5608 vin.$163.GatPoly vout.$1098.Metal3 0.0025165f
Cred_5609 vin.$163.GatPoly vout.P32.nSD 1.51164e-05f
Cred_5610 vin.$163.GatPoly vout.P32.pSD 0.0054503f
Cred_5611 vin.$163.GatPoly vout.P34.pSD 2.87809e-09f
Cred_5612 vin.$163.GatPoly VSS.$320.Metal1 2.42589e-09f
Cred_5613 vin.$163.GatPoly VSS.$758.Metal2 5.61887e-09f
Cred_5614 vin.$163.GatPoly VSS.$765.Metal2 1.35789e-08f
Cred_5615 vin.$163.GatPoly VSS.P35.nSD 2.80895e-10f
Cred_5616 vin.$164.GatPoly vout.$1080.Metal3 0.000470552f
Cred_5617 vin.$164.GatPoly vout.$1098.Metal3 0.000545769f
Cred_5618 vin.$164.GatPoly vout.P32.nSD 0.00156064f
Cred_5619 vin.$164.GatPoly vout.P32.pSD 7.66771e-06f
Cred_5620 vin.$164.GatPoly vout.P34.nSD 0.00012321f
Cred_5621 vin.$164.GatPoly VSS.$14.Metal1 6.89661e-07f
Cred_5622 vin.$164.GatPoly VSS.$29.Metal1 1.16047e-06f
Cred_5623 vin.$164.GatPoly VSS.$320.Metal1 0.00356099f
Cred_5624 vin.$164.GatPoly VSS.$520.Metal1 1.30284e-05f
Cred_5625 vin.$164.GatPoly VSS.$758.Metal2 7.83745e-05f
Cred_5626 vin.$164.GatPoly VSS.$765.Metal2 0.000189405f
Cred_5627 vin.$164.GatPoly VSS.P0.pSD 0.000469515f
Cred_5628 vin.$164.GatPoly VSS.P35.nSD 0.000246094f
Cred_5629 vin.$169.GatPoly vout.$1080.Metal3 0.000303925f
Cred_5630 vin.$169.GatPoly vout.$1098.Metal3 0.00606653f
Cred_5631 vin.$169.GatPoly vout.P32.nSD 1.8257e-06f
Cred_5632 vin.$169.GatPoly vout.P32.pSD 0.000610584f
Cred_5633 vin.$169.GatPoly vout.P34.pSD 0.00590601f
Cred_5634 vin.$170.GatPoly vout.$1098.Metal3 0.0010223f
Cred_5635 vin.$170.GatPoly vout.P34.nSD 0.00168227f
Cred_5636 vin.$170.GatPoly VSS.$14.Metal1 2.20756e-06f
Cred_5637 vin.$170.GatPoly VSS.$29.Metal1 3.71459e-06f
Cred_5638 vin.$170.GatPoly VSS.$320.Metal1 0.00257473f
Cred_5639 vin.$170.GatPoly VSS.$332.Metal1 3.56767e-06f
Cred_5640 vin.$170.GatPoly VSS.$520.Metal1 4.74249e-05f
Cred_5641 vin.$170.GatPoly VSS.$758.Metal2 5.64861e-05f
Cred_5642 vin.$170.GatPoly VSS.$765.Metal2 0.000136527f
Cred_5643 vin.$170.GatPoly VSS.P0.pSD 0.00159972f
Cred_5644 vin.$170.GatPoly VSS.P35.nSD 0.000177365f
Cred_5645 vin.$173.GatPoly vout.$1098.Metal3 0.00508466f
Cred_5646 vin.$173.GatPoly vout.P34.pSD 0.00541066f
Cred_5647 vin.$174.GatPoly vout.$1098.Metal3 0.000988791f
Cred_5648 vin.$174.GatPoly vout.$1116.Metal3 3.7194e-05f
Cred_5649 vin.$174.GatPoly vout.P34.nSD 0.00155781f
Cred_5650 vin.$174.GatPoly vout.P36.nSD 0.000123433f
Cred_5651 vin.$174.GatPoly vout.P36.pSD 6.06082e-07f
Cred_5652 vin.$174.GatPoly VSS.$14.Metal1 5.33223e-07f
Cred_5653 vin.$174.GatPoly VSS.$29.Metal1 8.97236e-07f
Cred_5654 vin.$174.GatPoly VSS.$338.Metal1 0.00356092f
Cred_5655 vin.$174.GatPoly VSS.$520.Metal1 1.68003e-05f
Cred_5656 vin.$174.GatPoly VSS.$773.Metal2 0.000215597f
Cred_5657 vin.$174.GatPoly VSS.$780.Metal2 5.2266e-05f
Cred_5658 vin.$174.GatPoly VSS.P0.pSD 0.000466163f
Cred_5659 vin.$174.GatPoly VSS.P37.nSD 0.000246085f
Cred_5660 vin.$179.GatPoly vout.$1098.Metal3 0.00346416f
Cred_5661 vin.$179.GatPoly vout.$1116.Metal3 0.00284953f
Cred_5662 vin.$179.GatPoly vout.P34.pSD 0.000605631f
Cred_5663 vin.$179.GatPoly vout.P36.nSD 1.71173e-05f
Cred_5664 vin.$179.GatPoly vout.P36.pSD 0.00595245f
Cred_5665 vin.$18.GatPoly vout.$954.Metal3 0.000545769f
Cred_5666 vin.$18.GatPoly vout.$972.Metal3 0.000470552f
Cred_5667 vin.$18.GatPoly vout.P2.nSD 0.00012321f
Cred_5668 vin.$18.GatPoly vout.P4.nSD 0.00156064f
Cred_5669 vin.$18.GatPoly vout.P4.pSD 7.66771e-06f
Cred_5670 vin.$18.GatPoly VSS.$14.Metal1 3.38205e-05f
Cred_5671 vin.$18.GatPoly VSS.$29.Metal1 5.69086e-05f
Cred_5672 vin.$18.GatPoly VSS.$520.Metal1 2.56214e-07f
Cred_5673 vin.$18.GatPoly VSS.$565.Metal2 0.000161512f
Cred_5674 vin.$18.GatPoly VSS.$572.Metal2 0.000103368f
Cred_5675 vin.$18.GatPoly VSS.$68.Metal1 0.00354117f
Cred_5676 vin.$18.GatPoly VSS.P0.GatPoly 0.000115931f
Cred_5677 vin.$18.GatPoly VSS.P0.pSD 0.000393409f
Cred_5678 vin.$18.GatPoly VSS.P5.nSD 0.000243481f
Cred_5679 vin.$180.GatPoly vout.$1098.Metal3 0.00050726f
Cred_5680 vin.$180.GatPoly vout.$1116.Metal3 0.00050726f
Cred_5681 vin.$180.GatPoly vout.P36.nSD 0.00168251f
Cred_5682 vin.$180.GatPoly vout.P36.pSD 8.26589e-06f
Cred_5683 vin.$180.GatPoly VSS.$14.Metal1 1.7057e-06f
Cred_5684 vin.$180.GatPoly VSS.$29.Metal1 2.87013e-06f
Cred_5685 vin.$180.GatPoly VSS.$338.Metal1 0.00258202f
Cred_5686 vin.$180.GatPoly VSS.$354.Metal1 1.47399e-06f
Cred_5687 vin.$180.GatPoly VSS.$520.Metal1 6.115e-05f
Cred_5688 vin.$180.GatPoly VSS.$773.Metal2 0.000156264f
Cred_5689 vin.$180.GatPoly VSS.$780.Metal2 3.79014e-05f
Cred_5690 vin.$180.GatPoly VSS.$784.Metal2 7.76299e-09f
Cred_5691 vin.$180.GatPoly VSS.P0.pSD 0.00158653f
Cred_5692 vin.$180.GatPoly VSS.P37.nSD 0.000182354f
Cred_5693 vin.$183.GatPoly vout.$1098.Metal3 0.00251607f
Cred_5694 vin.$183.GatPoly vout.$1116.Metal3 0.00251612f
Cred_5695 vin.$183.GatPoly vout.P36.nSD 1.51142e-05f
Cred_5696 vin.$183.GatPoly vout.P36.pSD 0.00544911f
Cred_5697 vin.$183.GatPoly vout.P38.pSD 2.53979e-09f
Cred_5698 vin.$183.GatPoly VSS.$354.Metal1 2.14164e-09f
Cred_5699 vin.$183.GatPoly VSS.$784.Metal2 5.37129e-09f
Cred_5700 vin.$183.GatPoly VSS.$791.Metal2 1.15689e-08f
Cred_5701 vin.$183.GatPoly VSS.P39.nSD 2.4798e-10f
Cred_5702 vin.$184.GatPoly vout.$1098.Metal3 0.000470552f
Cred_5703 vin.$184.GatPoly vout.$1116.Metal3 0.000545769f
Cred_5704 vin.$184.GatPoly vout.P36.nSD 0.00156064f
Cred_5705 vin.$184.GatPoly vout.P36.pSD 7.66771e-06f
Cred_5706 vin.$184.GatPoly vout.P38.nSD 0.00012321f
Cred_5707 vin.$184.GatPoly VSS.$14.Metal1 4.12149e-07f
Cred_5708 vin.$184.GatPoly VSS.$29.Metal1 6.9351e-07f
Cred_5709 vin.$184.GatPoly VSS.$354.Metal1 0.00356101f
Cred_5710 vin.$184.GatPoly VSS.$520.Metal1 2.16866e-05f
Cred_5711 vin.$184.GatPoly VSS.$784.Metal2 8.49006e-05f
Cred_5712 vin.$184.GatPoly VSS.$791.Metal2 0.000182863f
Cred_5713 vin.$184.GatPoly VSS.P0.pSD 0.000461602f
Cred_5714 vin.$184.GatPoly VSS.P39.nSD 0.000246095f
Cred_5715 vin.$189.GatPoly vout.$1098.Metal3 0.000303925f
Cred_5716 vin.$189.GatPoly vout.$1116.Metal3 0.00606653f
Cred_5717 vin.$189.GatPoly vout.P36.nSD 1.8257e-06f
Cred_5718 vin.$189.GatPoly vout.P36.pSD 0.000610584f
Cred_5719 vin.$189.GatPoly vout.P38.pSD 0.00590601f
Cred_5720 vin.$19.GatPoly vout.$954.Metal3 0.00346416f
Cred_5721 vin.$19.GatPoly vout.$972.Metal3 0.00284953f
Cred_5722 vin.$19.GatPoly vout.P2.pSD 0.000605631f
Cred_5723 vin.$19.GatPoly vout.P4.nSD 1.71173e-05f
Cred_5724 vin.$19.GatPoly vout.P4.pSD 0.00595245f
Cred_5725 vin.$190.GatPoly vout.$1116.Metal3 0.00135007f
Cred_5726 vin.$190.GatPoly vout.P38.nSD 0.00221821f
Cred_5727 vin.$190.GatPoly VSS.$14.Metal1 1.41604e-06f
Cred_5728 vin.$190.GatPoly VSS.$29.Metal1 2.38272e-06f
Cred_5729 vin.$190.GatPoly VSS.$354.Metal1 0.0025748f
Cred_5730 vin.$190.GatPoly VSS.$366.Metal1 3.50063e-06f
Cred_5731 vin.$190.GatPoly VSS.$372.Metal1 0.00110391f
Cred_5732 vin.$190.GatPoly VSS.$520.Metal1 8.75581e-05f
Cred_5733 vin.$190.GatPoly VSS.$784.Metal2 6.11897e-05f
Cred_5734 vin.$190.GatPoly VSS.$791.Metal2 0.000131813f
Cred_5735 vin.$190.GatPoly VSS.$799.Metal2 6.88692e-05f
Cred_5736 vin.$190.GatPoly VSS.$806.Metal2 1.4179e-05f
Cred_5737 vin.$190.GatPoly VSS.P0.pSD 0.00170968f
Cred_5738 vin.$190.GatPoly VSS.P39.nSD 0.000177366f
Cred_5739 vin.$190.GatPoly VSS.P41.nSD 7.62879e-05f
Cred_5740 vin.$193.GatPoly vout.$1116.Metal3 0.00508504f
Cred_5741 vin.$193.GatPoly vout.P38.pSD 0.00541168f
Cred_5742 vin.$198.GatPoly vout.$1116.Metal3 0.000722673f
Cred_5743 vin.$198.GatPoly vout.$1134.Metal3 0.000470552f
Cred_5744 vin.$198.GatPoly vout.P38.nSD 0.000412735f
Cred_5745 vin.$198.GatPoly vout.P40.nSD 0.00156064f
Cred_5746 vin.$198.GatPoly vout.P40.pSD 7.66771e-06f
Cred_5747 vin.$198.GatPoly VSS.$14.Metal1 3.62399e-07f
Cred_5748 vin.$198.GatPoly VSS.$29.Metal1 6.09797e-07f
Cred_5749 vin.$198.GatPoly VSS.$372.Metal1 0.00405283f
Cred_5750 vin.$198.GatPoly VSS.$520.Metal1 3.18808e-05f
Cred_5751 vin.$198.GatPoly VSS.$799.Metal2 0.000252842f
Cred_5752 vin.$198.GatPoly VSS.$806.Metal2 5.20557e-05f
Cred_5753 vin.$198.GatPoly VSS.P0.pSD 0.000518459f
Cred_5754 vin.$198.GatPoly VSS.P41.nSD 0.000280078f
Cred_5755 vin.$199.GatPoly vout.$1116.Metal3 0.00346416f
Cred_5756 vin.$199.GatPoly vout.$1134.Metal3 0.00284953f
Cred_5757 vin.$199.GatPoly vout.P38.pSD 0.000605631f
Cred_5758 vin.$199.GatPoly vout.P40.nSD 1.71173e-05f
Cred_5759 vin.$199.GatPoly vout.P40.pSD 0.00595245f
Cred_5760 vin.$202.GatPoly vout.$1116.Metal3 0.000510385f
Cred_5761 vin.$202.GatPoly vout.$1134.Metal3 0.000571437f
Cred_5762 vin.$202.GatPoly vout.P40.nSD 0.0016932f
Cred_5763 vin.$202.GatPoly vout.P40.pSD 8.3168e-06f
Cred_5764 vin.$202.GatPoly vout.P42.nSD 9.99339e-05f
Cred_5765 vin.$202.GatPoly VSS.$14.Metal1 2.66678e-07f
Cred_5766 vin.$202.GatPoly VSS.$29.Metal1 4.4873e-07f
Cred_5767 vin.$202.GatPoly VSS.$372.Metal1 1.91569e-06f
Cred_5768 vin.$202.GatPoly VSS.$388.Metal1 0.00290407f
Cred_5769 vin.$202.GatPoly VSS.$520.Metal1 3.70856e-05f
Cred_5770 vin.$202.GatPoly VSS.$806.Metal2 1.22525e-08f
Cred_5771 vin.$202.GatPoly VSS.$810.Metal2 7.46228e-05f
Cred_5772 vin.$202.GatPoly VSS.$817.Metal2 0.000143863f
Cred_5773 vin.$202.GatPoly VSS.P0.pSD 0.000472067f
Cred_5774 vin.$202.GatPoly VSS.P43.nSD 0.000202592f
Cred_5775 vin.$203.GatPoly vout.$1116.Metal3 0.00254525f
Cred_5776 vin.$203.GatPoly vout.$1134.Metal3 0.00305732f
Cred_5777 vin.$203.GatPoly vout.P40.nSD 1.52894e-05f
Cred_5778 vin.$203.GatPoly vout.P40.pSD 0.00550811f
Cred_5779 vin.$203.GatPoly vout.P42.pSD 0.000504579f
Cred_5780 vin.$210.GatPoly vout.$1116.Metal3 3.01674e-05f
Cred_5781 vin.$210.GatPoly vout.$1134.Metal3 0.00138709f
Cred_5782 vin.$210.GatPoly vout.P40.nSD 0.000100114f
Cred_5783 vin.$210.GatPoly vout.P40.pSD 4.91582e-07f
Cred_5784 vin.$210.GatPoly vout.P42.nSD 0.00222868f
Cred_5785 vin.$210.GatPoly VSS.$14.Metal1 8.65268e-07f
Cred_5786 vin.$210.GatPoly VSS.$29.Metal1 1.45596e-06f
Cred_5787 vin.$210.GatPoly VSS.$388.Metal1 0.00289664f
Cred_5788 vin.$210.GatPoly VSS.$400.Metal1 3.43463e-06f
Cred_5789 vin.$210.GatPoly VSS.$406.Metal1 0.0011039f
Cred_5790 vin.$210.GatPoly VSS.$520.Metal1 0.000149267f
Cred_5791 vin.$210.GatPoly VSS.$810.Metal2 7.41544e-05f
Cred_5792 vin.$210.GatPoly VSS.$817.Metal2 0.000143034f
Cred_5793 vin.$210.GatPoly VSS.$825.Metal2 7.09021e-05f
Cred_5794 vin.$210.GatPoly VSS.$832.Metal2 1.21547e-05f
Cred_5795 vin.$210.GatPoly VSS.P0.pSD 0.00169121f
Cred_5796 vin.$210.GatPoly VSS.P43.nSD 0.000199604f
Cred_5797 vin.$210.GatPoly VSS.P45.nSD 7.6287e-05f
Cred_5798 vin.$211.GatPoly vout.$1116.Metal3 0.000253214f
Cred_5799 vin.$211.GatPoly vout.$1134.Metal3 0.0053994f
Cred_5800 vin.$211.GatPoly vout.P40.nSD 1.52107e-06f
Cred_5801 vin.$211.GatPoly vout.P40.pSD 0.000508705f
Cred_5802 vin.$211.GatPoly vout.P42.pSD 0.00546639f
Cred_5803 vin.$215.GatPoly vout.$1134.Metal3 0.00656698f
Cred_5804 vin.$215.GatPoly vout.$1152.Metal3 0.000804375f
Cred_5805 vin.$215.GatPoly vout.P42.pSD 0.00590601f
Cred_5806 vin.$215.GatPoly vout.P44.nSD 4.83192e-06f
Cred_5807 vin.$215.GatPoly vout.P44.pSD 0.00168028f
Cred_5808 vin.$218.GatPoly vout.$1134.Metal3 0.000722673f
Cred_5809 vin.$218.GatPoly vout.$1152.Metal3 0.000470552f
Cred_5810 vin.$218.GatPoly vout.P42.nSD 0.000412735f
Cred_5811 vin.$218.GatPoly vout.P44.nSD 0.00156064f
Cred_5812 vin.$218.GatPoly vout.P44.pSD 7.66771e-06f
Cred_5813 vin.$218.GatPoly VSS.$14.Metal1 2.15647e-07f
Cred_5814 vin.$218.GatPoly VSS.$29.Metal1 3.62862e-07f
Cred_5815 vin.$218.GatPoly VSS.$406.Metal1 0.0040528f
Cred_5816 vin.$218.GatPoly VSS.$520.Metal1 5.32382e-05f
Cred_5817 vin.$218.GatPoly VSS.$825.Metal2 0.000260305f
Cred_5818 vin.$218.GatPoly VSS.$832.Metal2 4.46238e-05f
Cred_5819 vin.$218.GatPoly VSS.P0.pSD 0.000497496f
Cred_5820 vin.$218.GatPoly VSS.P45.nSD 0.000280075f
Cred_5821 vin.$22.GatPoly vout.$954.Metal3 0.000506542f
Cred_5822 vin.$22.GatPoly vout.$972.Metal3 0.000506542f
Cred_5823 vin.$22.GatPoly vout.P4.nSD 0.00167992f
Cred_5824 vin.$22.GatPoly vout.P4.pSD 8.25418e-06f
Cred_5825 vin.$22.GatPoly VSS.$14.Metal1 9.5294e-05f
Cred_5826 vin.$22.GatPoly VSS.$29.Metal1 0.000160348f
Cred_5827 vin.$22.GatPoly VSS.$520.Metal1 1.07058e-06f
Cred_5828 vin.$22.GatPoly VSS.$572.Metal2 6.87739e-09f
Cred_5829 vin.$22.GatPoly VSS.$576.Metal2 2.36756e-05f
Cred_5830 vin.$22.GatPoly VSS.$583.Metal2 0.000170333f
Cred_5831 vin.$22.GatPoly VSS.$68.Metal1 1.46264e-06f
Cred_5832 vin.$22.GatPoly VSS.$84.Metal1 0.0025804f
Cred_5833 vin.$22.GatPoly VSS.P0.pSD 0.00139602f
Cred_5834 vin.$22.GatPoly VSS.P7.nSD 0.000183105f
Cred_5835 vin.$222.GatPoly vout.$1134.Metal3 0.00051065f
Cred_5836 vin.$222.GatPoly vout.$1152.Metal3 0.000571695f
Cred_5837 vin.$222.GatPoly vout.P44.nSD 0.001694f
Cred_5838 vin.$222.GatPoly vout.P44.pSD 8.32112e-06f
Cred_5839 vin.$222.GatPoly vout.P46.nSD 9.99338e-05f
Cred_5840 vin.$222.GatPoly VSS.$14.Metal1 1.58065e-07f
Cred_5841 vin.$222.GatPoly VSS.$29.Metal1 2.65971e-07f
Cred_5842 vin.$222.GatPoly VSS.$406.Metal1 2.02068e-06f
Cred_5843 vin.$222.GatPoly VSS.$422.Metal1 0.00290392f
Cred_5844 vin.$222.GatPoly VSS.$520.Metal1 6.19065e-05f
Cred_5845 vin.$222.GatPoly VSS.$832.Metal2 1.33042e-08f
Cred_5846 vin.$222.GatPoly VSS.$836.Metal2 7.98959e-05f
Cred_5847 vin.$222.GatPoly VSS.$843.Metal2 0.000138436f
Cred_5848 vin.$222.GatPoly VSS.P0.pSD 0.00044717f
Cred_5849 vin.$222.GatPoly VSS.P47.nSD 0.000202186f
Cred_5850 vin.$223.GatPoly vout.$1134.Metal3 0.00359153f
Cred_5851 vin.$223.GatPoly vout.$1152.Metal3 0.0041036f
Cred_5852 vin.$223.GatPoly vout.P44.nSD 2.15745e-05f
Cred_5853 vin.$223.GatPoly vout.P44.pSD 0.0076938f
Cred_5854 vin.$223.GatPoly vout.P46.pSD 0.000504579f
Cred_5855 vin.$23.GatPoly vout.$954.Metal3 0.0025161f
Cred_5856 vin.$23.GatPoly vout.$972.Metal3 0.0025161f
Cred_5857 vin.$23.GatPoly vout.P4.nSD 1.51143e-05f
Cred_5858 vin.$23.GatPoly vout.P4.pSD 0.0054493f
Cred_5859 vin.$230.GatPoly vout.$1134.Metal3 3.01674e-05f
Cred_5860 vin.$230.GatPoly vout.$1152.Metal3 0.00105938f
Cred_5861 vin.$230.GatPoly vout.P44.nSD 0.000100114f
Cred_5862 vin.$230.GatPoly vout.P44.pSD 4.91582e-07f
Cred_5863 vin.$230.GatPoly vout.P46.nSD 0.00169136f
Cred_5864 vin.$230.GatPoly VSS.$14.Metal1 4.77103e-07f
Cred_5865 vin.$230.GatPoly VSS.$29.Metal1 8.02806e-07f
Cred_5866 vin.$230.GatPoly VSS.$422.Metal1 0.00289672f
Cred_5867 vin.$230.GatPoly VSS.$434.Metal1 3.37418e-06f
Cred_5868 vin.$230.GatPoly VSS.$520.Metal1 0.000224903f
Cred_5869 vin.$230.GatPoly VSS.$836.Metal2 7.94476e-05f
Cred_5870 vin.$230.GatPoly VSS.$843.Metal2 0.000137733f
Cred_5871 vin.$230.GatPoly VSS.P0.pSD 0.00146473f
Cred_5872 vin.$230.GatPoly VSS.P47.nSD 0.000199605f
Cred_5873 vin.$231.GatPoly vout.$1134.Metal3 0.000253214f
Cred_5874 vin.$231.GatPoly vout.$1152.Metal3 0.0053999f
Cred_5875 vin.$231.GatPoly vout.P44.nSD 1.52107e-06f
Cred_5876 vin.$231.GatPoly vout.P44.pSD 0.000508705f
Cred_5877 vin.$231.GatPoly vout.P46.pSD 0.00546541f
Cred_5878 vin.$234.GatPoly vout.$1152.Metal3 0.000988791f
Cred_5879 vin.$234.GatPoly vout.$1170.Metal3 3.7194e-05f
Cred_5880 vin.$234.GatPoly vout.P46.nSD 0.00155781f
Cred_5881 vin.$234.GatPoly vout.P48.nSD 0.000123433f
Cred_5882 vin.$234.GatPoly vout.P48.pSD 6.06082e-07f
Cred_5883 vin.$234.GatPoly VSS.$14.Metal1 1.11631e-07f
Cred_5884 vin.$234.GatPoly VSS.$29.Metal1 1.87839e-07f
Cred_5885 vin.$234.GatPoly VSS.$440.Metal1 0.00364081f
Cred_5886 vin.$234.GatPoly VSS.$520.Metal1 7.81563e-05f
Cred_5887 vin.$234.GatPoly VSS.$851.Metal2 0.000245343f
Cred_5888 vin.$234.GatPoly VSS.$858.Metal2 3.40755e-05f
Cred_5889 vin.$234.GatPoly VSS.P0.pSD 0.000405938f
Cred_5890 vin.$234.GatPoly VSS.P49.nSD 0.000256612f
Cred_5891 vin.$235.GatPoly vout.$1152.Metal3 0.00656698f
Cred_5892 vin.$235.GatPoly vout.$1170.Metal3 0.000804375f
Cred_5893 vin.$235.GatPoly vout.P46.pSD 0.00590601f
Cred_5894 vin.$235.GatPoly vout.P48.nSD 4.83192e-06f
Cred_5895 vin.$235.GatPoly vout.P48.pSD 0.00168028f
Cred_5896 vin.$240.GatPoly vout.$1152.Metal3 0.000506542f
Cred_5897 vin.$240.GatPoly vout.$1170.Metal3 0.000506542f
Cred_5898 vin.$240.GatPoly vout.P48.nSD 0.00167992f
Cred_5899 vin.$240.GatPoly vout.P48.pSD 8.25418e-06f
Cred_5900 vin.$240.GatPoly VSS.$14.Metal1 3.56061e-07f
Cred_5901 vin.$240.GatPoly VSS.$29.Metal1 5.99131e-07f
Cred_5902 vin.$240.GatPoly VSS.$440.Metal1 0.0025804f
Cred_5903 vin.$240.GatPoly VSS.$456.Metal1 1.46264e-06f
Cred_5904 vin.$240.GatPoly VSS.$520.Metal1 0.00028468f
Cred_5905 vin.$240.GatPoly VSS.$851.Metal2 0.000170333f
Cred_5906 vin.$240.GatPoly VSS.$858.Metal2 2.36756e-05f
Cred_5907 vin.$240.GatPoly VSS.$862.Metal2 6.87739e-09f
Cred_5908 vin.$240.GatPoly VSS.P0.pSD 0.0013671f
Cred_5909 vin.$240.GatPoly VSS.P49.nSD 0.000183105f
Cred_5910 vin.$243.GatPoly vout.$1152.Metal3 0.00359174f
Cred_5911 vin.$243.GatPoly vout.$1170.Metal3 0.00410382f
Cred_5912 vin.$243.GatPoly vout.P48.nSD 2.15758e-05f
Cred_5913 vin.$243.GatPoly vout.P48.pSD 0.00769412f
Cred_5914 vin.$243.GatPoly vout.P50.pSD 0.000504579f
Cred_5915 vin.$244.GatPoly vout.$1152.Metal3 0.000470552f
Cred_5916 vin.$244.GatPoly vout.$1170.Metal3 0.000545769f
Cred_5917 vin.$244.GatPoly vout.P48.nSD 0.00156064f
Cred_5918 vin.$244.GatPoly vout.P48.pSD 7.66771e-06f
Cred_5919 vin.$244.GatPoly vout.P50.nSD 0.00012321f
Cred_5920 vin.$244.GatPoly VSS.$14.Metal1 8.49473e-08f
Cred_5921 vin.$244.GatPoly VSS.$29.Metal1 1.42938e-07f
Cred_5922 vin.$244.GatPoly VSS.$456.Metal1 0.00354117f
Cred_5923 vin.$244.GatPoly VSS.$520.Metal1 0.000101035f
Cred_5924 vin.$244.GatPoly VSS.$862.Metal2 0.000103368f
Cred_5925 vin.$244.GatPoly VSS.$869.Metal2 0.000161512f
Cred_5926 vin.$244.GatPoly VSS.P0.pSD 0.000383131f
Cred_5927 vin.$244.GatPoly VSS.P1.GatPoly 0.000115931f
Cred_5928 vin.$244.GatPoly VSS.P51.nSD 0.000243481f
Cred_5929 vin.$250.GatPoly vout.$1170.Metal3 0.00135038f
Cred_5930 vin.$250.GatPoly vout.P50.nSD 0.00221631f
Cred_5931 vin.$250.GatPoly VSS.$14.Metal1 2.90174e-07f
Cred_5932 vin.$250.GatPoly VSS.$29.Metal1 4.88266e-07f
Cred_5933 vin.$250.GatPoly VSS.$456.Metal1 0.00243216f
Cred_5934 vin.$250.GatPoly VSS.$468.Metal1 3.31573e-06f
Cred_5935 vin.$250.GatPoly VSS.$474.Metal1 0.00110389f
Cred_5936 vin.$250.GatPoly VSS.$520.Metal1 0.000408478f
Cred_5937 vin.$250.GatPoly VSS.$862.Metal2 6.73097e-05f
Cred_5938 vin.$250.GatPoly VSS.$869.Metal2 0.000105197f
Cred_5939 vin.$250.GatPoly VSS.$877.Metal2 7.4971e-05f
Cred_5940 vin.$250.GatPoly VSS.$884.Metal2 8.10497e-06f
Cred_5941 vin.$250.GatPoly VSS.P0.pSD 0.00139371f
Cred_5942 vin.$250.GatPoly VSS.P1.GatPoly 0.00132634f
Cred_5943 vin.$250.GatPoly VSS.P51.nSD 0.000158547f
Cred_5944 vin.$250.GatPoly VSS.P53.nSD 7.6285e-05f
Cred_5945 vin.$251.GatPoly vout.$1152.Metal3 0.000253214f
Cred_5946 vin.$251.GatPoly vout.$1170.Metal3 0.00751575f
Cred_5947 vin.$251.GatPoly vout.P48.nSD 1.52107e-06f
Cred_5948 vin.$251.GatPoly vout.P48.pSD 0.000508705f
Cred_5949 vin.$251.GatPoly vout.P50.pSD 0.00763867f
Cred_5950 vin.$258.GatPoly vout 0.00163314f
Cred_5951 vin.$258.GatPoly vout.$1170.Metal3 0.000252122f
Cred_5952 vin.$258.GatPoly vout.P50.nSD 0.000412735f
Cred_5953 vin.$258.GatPoly vout.P52.nSD 0.00268466f
Cred_5954 vin.$258.GatPoly VSS.$1048.Metal3 1.76925e-08f
Cred_5955 vin.$258.GatPoly VSS.$14.Metal1 3.12974e-07f
Cred_5956 vin.$258.GatPoly VSS.$29.Metal1 5.2663e-07f
Cred_5957 vin.$258.GatPoly VSS.$474.Metal1 0.00380545f
Cred_5958 vin.$258.GatPoly VSS.$486.Metal1 5.30084e-05f
Cred_5959 vin.$258.GatPoly VSS.$496.Metal1 8.21354e-06f
Cred_5960 vin.$258.GatPoly VSS.$500.Metal1 0.000422727f
Cred_5961 vin.$258.GatPoly VSS.$520.Metal1 0.000818631f
Cred_5962 vin.$258.GatPoly VSS.$877.Metal2 0.000242306f
Cred_5963 vin.$258.GatPoly VSS.$884.Metal2 2.84159e-05f
Cred_5964 vin.$258.GatPoly VSS.$895.Metal2 2.08562e-06f
Cred_5965 vin.$258.GatPoly VSS.$904.Metal2 3.5393e-05f
Cred_5966 vin.$258.GatPoly VSS.P0.pSD 0.00185819f
Cred_5967 vin.$258.GatPoly VSS.P1.GatPoly 0.00749084f
Cred_5968 vin.$258.GatPoly VSS.P53.nSD 0.000259349f
Cred_5969 vin.$258.GatPoly VSS.P55.nSD 3.85014e-05f
Cred_5970 vin.$258.GatPoly VSS.P57.nSD 4.40168e-06f
Cred_5971 vin.$259.GatPoly vout 0.00910347f
Cred_5972 vin.$259.GatPoly vout.$1170.Metal3 0.0016272f
Cred_5973 vin.$259.GatPoly vout.P50.pSD 0.00166717f
Cred_5974 vin.$259.GatPoly vout.P52.pSD 0.00975111f
Cred_5975 vin.$259.GatPoly VSS.$500.Metal1 6.72427e-08f
Cred_5976 vin.$259.GatPoly VSS.$904.Metal2 1.34297e-06f
Cred_5977 vin.$259.GatPoly VSS.P55.nSD 4.98531e-10f
Cred_5978 vin.$259.GatPoly VSS.P57.nSD 4.98531e-10f
Cred_5979 vin.$271.Metal1 vout.$954.Metal3 0.0143276f
Cred_5980 vin.$271.Metal1 vout.P0.nSD 6.43647e-05f
Cred_5981 vin.$271.Metal1 vout.P0.pSD 0.0223099f
Cred_5982 vin.$271.Metal1 vout.P2.pSD 9.29777e-06f
Cred_5983 vin.$271.Metal1 VSS.$29.Metal1 1.75635e-06f
Cred_5984 vin.$271.Metal1 VSS.$50.Metal1 6.10049e-07f
Cred_5985 vin.$271.Metal1 VSS.$531.Metal2 3.50779e-05f
Cred_5986 vin.$271.Metal1 VSS.$550.Metal2 4.73853e-07f
Cred_5987 vin.$271.Metal1 VSS.$557.Metal2 4.38314e-06f
Cred_5988 vin.$271.Metal1 VSS.P0.nSD 1.30214e-08f
Cred_5989 vin.$271.Metal1 VSS.P1.nSD 1.30214e-08f
Cred_5990 vin.$271.Metal1 VSS.P3.nSD 7.0643e-08f
Cred_5991 vin.$274.Metal1 vout.$954.Metal3 0.0111046f
Cred_5992 vin.$274.Metal1 vout.P0.nSD 0.0176313f
Cred_5993 vin.$274.Metal1 vout.P0.pSD 0.000132813f
Cred_5994 vin.$274.Metal1 vout.P2.nSD 0.000164282f
Cred_5995 vin.$274.Metal1 VSS.$14.Metal1 0.00832656f
Cred_5996 vin.$274.Metal1 VSS.$29.Metal1 0.0338193f
Cred_5997 vin.$274.Metal1 VSS.$31.Metal1 0.000385492f
Cred_5998 vin.$274.Metal1 VSS.$42.Metal1 0.00265685f
Cred_5999 vin.$274.Metal1 VSS.$50.Metal1 0.0215353f
Cred_6000 vin.$274.Metal1 VSS.$520.Metal1 2.83878e-05f
Cred_6001 vin.$274.Metal1 VSS.$531.Metal2 0.00112774f
Cred_6002 vin.$274.Metal1 VSS.$540.Metal2 3.56165e-05f
Cred_6003 vin.$274.Metal1 VSS.$550.Metal2 0.000344035f
Cred_6004 vin.$274.Metal1 VSS.$557.Metal2 0.002697f
Cred_6005 vin.$274.Metal1 VSS.$60.Metal1 0.000197083f
Cred_6006 vin.$274.Metal1 VSS.$916.Metal3 3.02139e-07f
Cred_6007 vin.$274.Metal1 VSS.P0.GatPoly 0.0036175f
Cred_6008 vin.$274.Metal1 VSS.P0.nSD 0.000206337f
Cred_6009 vin.$274.Metal1 VSS.P0.pSD 0.0575819f
Cred_6010 vin.$274.Metal1 VSS.P1.nSD 0.00180636f
Cred_6011 vin.$274.Metal1 VSS.P3.nSD 0.00476831f
Cred_6012 vin.$275.Metal1 vout.$954.Metal3 0.000814844f
Cred_6013 vin.$275.Metal1 vout.P0.nSD 3.32742e-07f
Cred_6014 vin.$275.Metal1 vout.P0.pSD 1.37721e-05f
Cred_6015 vin.$275.Metal1 vout.P2.pSD 0.000681901f
Cred_6016 vin.$275.Metal1 VSS.$50.Metal1 7.83974e-07f
Cred_6017 vin.$275.Metal1 VSS.$550.Metal2 6.08949e-07f
Cred_6018 vin.$275.Metal1 VSS.$557.Metal2 5.63278e-06f
Cred_6019 vin.$275.Metal1 VSS.P3.nSD 9.07833e-08f
Cred_6020 vin.$278.Metal1 vout.$954.Metal3 0.00726768f
Cred_6021 vin.$278.Metal1 vout.P2.nSD 0.0150734f
Cred_6022 vin.$278.Metal1 VSS.$14.Metal1 0.00238382f
Cred_6023 vin.$278.Metal1 VSS.$29.Metal1 0.00401118f
Cred_6024 vin.$278.Metal1 VSS.$50.Metal1 0.00134579f
Cred_6025 vin.$278.Metal1 VSS.$520.Metal1 1.46395e-05f
Cred_6026 vin.$278.Metal1 VSS.$550.Metal2 4.28663e-06f
Cred_6027 vin.$278.Metal1 VSS.$557.Metal2 4.02244e-05f
Cred_6028 vin.$278.Metal1 VSS.$565.Metal2 2.1507e-06f
Cred_6029 vin.$278.Metal1 VSS.$60.Metal1 0.000787157f
Cred_6030 vin.$278.Metal1 VSS.$68.Metal1 0.000714862f
Cred_6031 vin.$278.Metal1 VSS.P0.GatPoly 0.000260634f
Cred_6032 vin.$278.Metal1 VSS.P0.pSD 0.0243878f
Cred_6033 vin.$278.Metal1 VSS.P3.nSD 0.0010972f
Cred_6034 vin.$279.Metal1 vout.$954.Metal3 0.00991692f
Cred_6035 vin.$279.Metal1 vout.P0.nSD 1.49906e-07f
Cred_6036 vin.$279.Metal1 vout.P0.pSD 6.20458e-06f
Cred_6037 vin.$279.Metal1 vout.P2.pSD 0.0163153f
Cred_6038 vin.$279.Metal1 VSS.$50.Metal1 3.53193e-07f
Cred_6039 vin.$279.Metal1 VSS.$550.Metal2 2.74342e-07f
Cred_6040 vin.$279.Metal1 VSS.$557.Metal2 2.53766e-06f
Cred_6041 vin.$279.Metal1 VSS.P3.nSD 4.08994e-08f
Cred_6042 vin.$28.GatPoly vout.$954.Metal3 3.7194e-05f
Cred_6043 vin.$28.GatPoly vout.$972.Metal3 0.000988791f
Cred_6044 vin.$28.GatPoly vout.P4.nSD 0.000123433f
Cred_6045 vin.$28.GatPoly vout.P4.pSD 6.06082e-07f
Cred_6046 vin.$28.GatPoly vout.P6.nSD 0.00155781f
Cred_6047 vin.$28.GatPoly VSS.$14.Metal1 2.61621e-05f
Cred_6048 vin.$28.GatPoly VSS.$29.Metal1 4.40221e-05f
Cred_6049 vin.$28.GatPoly VSS.$520.Metal1 3.35377e-07f
Cred_6050 vin.$28.GatPoly VSS.$576.Metal2 3.40755e-05f
Cred_6051 vin.$28.GatPoly VSS.$583.Metal2 0.000245343f
Cred_6052 vin.$28.GatPoly VSS.$84.Metal1 0.00364081f
Cred_6053 vin.$28.GatPoly VSS.P0.pSD 0.000413874f
Cred_6054 vin.$28.GatPoly VSS.P7.nSD 0.000256612f
Cred_6055 vin.$284.Metal1 vout.$954.Metal3 0.002655f
Cred_6056 vin.$284.Metal1 vout.$972.Metal3 2.21257e-05f
Cred_6057 vin.$284.Metal1 vout.P2.nSD 0.00477896f
Cred_6058 vin.$284.Metal1 vout.P4.nSD 6.85438e-07f
Cred_6059 vin.$284.Metal1 vout.P4.pSD 3.60541e-07f
Cred_6060 vin.$284.Metal1 VSS.$14.Metal1 0.0020368f
Cred_6061 vin.$284.Metal1 VSS.$29.Metal1 0.00342726f
Cred_6062 vin.$284.Metal1 VSS.$520.Metal1 1.57982e-05f
Cred_6063 vin.$284.Metal1 VSS.$565.Metal2 0.0018462f
Cred_6064 vin.$284.Metal1 VSS.$572.Metal2 0.00118019f
Cred_6065 vin.$284.Metal1 VSS.$60.Metal1 0.000279266f
Cred_6066 vin.$284.Metal1 VSS.$68.Metal1 0.0206318f
Cred_6067 vin.$284.Metal1 VSS.P0.GatPoly 4.59859e-05f
Cred_6068 vin.$284.Metal1 VSS.P0.pSD 0.0239772f
Cred_6069 vin.$284.Metal1 VSS.P5.nSD 0.0055722f
Cred_6070 vin.$285.Metal1 vout.$954.Metal3 0.0032611f
Cred_6071 vin.$285.Metal1 vout.P2.pSD 0.00549943f
Cred_6072 vin.$288.Metal1 vout.$954.Metal3 0.00378169f
Cred_6073 vin.$288.Metal1 vout.$972.Metal3 0.00377642f
Cred_6074 vin.$288.Metal1 vout.P2.nSD 8.4284e-08f
Cred_6075 vin.$288.Metal1 vout.P4.nSD 0.0142488f
Cred_6076 vin.$288.Metal1 vout.P4.pSD 6.15373e-05f
Cred_6077 vin.$288.Metal1 VSS.$14.Metal1 0.00178497f
Cred_6078 vin.$288.Metal1 VSS.$29.Metal1 0.0030035f
Cred_6079 vin.$288.Metal1 VSS.$520.Metal1 1.85193e-05f
Cred_6080 vin.$288.Metal1 VSS.$565.Metal2 0.000104313f
Cred_6081 vin.$288.Metal1 VSS.$572.Metal2 7.25013e-05f
Cred_6082 vin.$288.Metal1 VSS.$576.Metal2 1.28882e-05f
Cred_6083 vin.$288.Metal1 VSS.$583.Metal2 6.44862e-05f
Cred_6084 vin.$288.Metal1 VSS.$68.Metal1 0.00270056f
Cred_6085 vin.$288.Metal1 VSS.$84.Metal1 0.00153128f
Cred_6086 vin.$288.Metal1 VSS.P0.pSD 0.0249408f
Cred_6087 vin.$288.Metal1 VSS.P5.nSD 0.000366895f
Cred_6088 vin.$288.Metal1 VSS.P7.nSD 0.000482409f
Cred_6089 vin.$289.Metal1 vout.$954.Metal3 0.00461484f
Cred_6090 vin.$289.Metal1 vout.$972.Metal3 0.00461484f
Cred_6091 vin.$289.Metal1 vout.P4.nSD 2.77216e-05f
Cred_6092 vin.$289.Metal1 vout.P4.pSD 0.0151118f
Cred_6093 vin.$29.GatPoly vout.$954.Metal3 0.000303925f
Cred_6094 vin.$29.GatPoly vout.$972.Metal3 0.00606653f
Cred_6095 vin.$29.GatPoly vout.P4.nSD 1.8257e-06f
Cred_6096 vin.$29.GatPoly vout.P4.pSD 0.000610584f
Cred_6097 vin.$29.GatPoly vout.P6.pSD 0.00590601f
Cred_6098 vin.$296.Metal1 vout.$954.Metal3 0.00135603f
Cred_6099 vin.$296.Metal1 vout.$972.Metal3 0.00140213f
Cred_6100 vin.$296.Metal1 vout.P4.nSD 0.00453699f
Cred_6101 vin.$296.Metal1 vout.P4.pSD 2.20967e-05f
Cred_6102 vin.$296.Metal1 vout.P6.nSD 5.12011e-06f
Cred_6103 vin.$296.Metal1 VSS.$14.Metal1 0.00158047f
Cred_6104 vin.$296.Metal1 VSS.$29.Metal1 0.00265941f
Cred_6105 vin.$296.Metal1 VSS.$520.Metal1 2.06944e-05f
Cred_6106 vin.$296.Metal1 VSS.$572.Metal2 1.06238e-06f
Cred_6107 vin.$296.Metal1 VSS.$576.Metal2 0.000339108f
Cred_6108 vin.$296.Metal1 VSS.$583.Metal2 0.00242353f
Cred_6109 vin.$296.Metal1 VSS.$591.Metal2 1.96436e-06f
Cred_6110 vin.$296.Metal1 VSS.$68.Metal1 0.000225941f
Cred_6111 vin.$296.Metal1 VSS.$84.Metal1 0.0211977f
Cred_6112 vin.$296.Metal1 VSS.$932.Metal3 1.57498e-08f
Cred_6113 vin.$296.Metal1 VSS.$94.Metal1 0.000178724f
Cred_6114 vin.$296.Metal1 VSS.P0.pSD 0.0252587f
Cred_6115 vin.$296.Metal1 VSS.P7.nSD 0.00426491f
Cred_6116 vin.$297.Metal1 vout.$954.Metal3 0.00159818f
Cred_6117 vin.$297.Metal1 vout.$972.Metal3 0.00162481f
Cred_6118 vin.$297.Metal1 vout.P4.nSD 9.60032e-06f
Cred_6119 vin.$297.Metal1 vout.P4.pSD 0.00511451f
Cred_6120 vin.$297.Metal1 vout.P6.pSD 7.35731e-06f
Cred_6121 vin.$300.Metal1 vout.$972.Metal3 0.00723371f
Cred_6122 vin.$300.Metal1 vout.P6.nSD 0.014737f
Cred_6123 vin.$300.Metal1 VSS.$102.Metal1 0.000709934f
Cred_6124 vin.$300.Metal1 VSS.$14.Metal1 0.00139709f
Cred_6125 vin.$300.Metal1 VSS.$29.Metal1 0.00235083f
Cred_6126 vin.$300.Metal1 VSS.$520.Metal1 2.45586e-05f
Cred_6127 vin.$300.Metal1 VSS.$576.Metal2 1.04473e-05f
Cred_6128 vin.$300.Metal1 VSS.$583.Metal2 8.1897e-05f
Cred_6129 vin.$300.Metal1 VSS.$591.Metal2 7.89545e-06f
Cred_6130 vin.$300.Metal1 VSS.$84.Metal1 0.000839694f
Cred_6131 vin.$300.Metal1 VSS.$932.Metal3 4.72494e-08f
Cred_6132 vin.$300.Metal1 VSS.$94.Metal1 0.000820123f
Cred_6133 vin.$300.Metal1 VSS.P0.pSD 0.0263932f
Cred_6134 vin.$300.Metal1 VSS.P7.nSD 0.00101955f
Cred_6135 vin.$301.Metal1 vout.$972.Metal3 0.00867426f
Cred_6136 vin.$301.Metal1 vout.P6.pSD 0.0156356f
Cred_6137 vin.$306.Metal1 vout.$972.Metal3 0.00263801f
Cred_6138 vin.$306.Metal1 vout.$990.Metal3 2.15606e-05f
Cred_6139 vin.$306.Metal1 vout.P6.nSD 0.00482185f
Cred_6140 vin.$306.Metal1 vout.P8.nSD 6.63097e-07f
Cred_6141 vin.$306.Metal1 vout.P8.pSD 3.51333e-07f
Cred_6142 vin.$306.Metal1 VSS.$102.Metal1 0.0207171f
Cred_6143 vin.$306.Metal1 VSS.$14.Metal1 0.00118725f
Cred_6144 vin.$306.Metal1 VSS.$29.Metal1 0.00199775f
Cred_6145 vin.$306.Metal1 VSS.$520.Metal1 2.62657e-05f
Cred_6146 vin.$306.Metal1 VSS.$591.Metal2 0.00191055f
Cred_6147 vin.$306.Metal1 VSS.$598.Metal2 0.00110109f
Cred_6148 vin.$306.Metal1 VSS.$94.Metal1 0.000284189f
Cred_6149 vin.$306.Metal1 VSS.P0.pSD 0.0255072f
Cred_6150 vin.$306.Metal1 VSS.P10.nSD 0.00552768f
Cred_6151 vin.$307.Metal1 vout.$972.Metal3 0.00322211f
Cred_6152 vin.$307.Metal1 vout.P6.pSD 0.00505179f
Cred_6153 vin.$310.Metal1 vout.$972.Metal3 0.00423614f
Cred_6154 vin.$310.Metal1 vout.$990.Metal3 0.0042297f
Cred_6155 vin.$310.Metal1 vout.P6.nSD 1.02972e-07f
Cred_6156 vin.$310.Metal1 vout.P8.nSD 0.0142296f
Cred_6157 vin.$310.Metal1 vout.P8.pSD 6.89236e-05f
Cred_6158 vin.$310.Metal1 VSS.$102.Metal1 0.00278365f
Cred_6159 vin.$310.Metal1 VSS.$118.Metal1 0.00157431f
Cred_6160 vin.$310.Metal1 VSS.$14.Metal1 0.0010701f
Cred_6161 vin.$310.Metal1 VSS.$29.Metal1 0.00180062f
Cred_6162 vin.$310.Metal1 VSS.$520.Metal1 3.14401e-05f
Cred_6163 vin.$310.Metal1 VSS.$591.Metal2 0.000124172f
Cred_6164 vin.$310.Metal1 VSS.$598.Metal2 7.71759e-05f
Cred_6165 vin.$310.Metal1 VSS.$602.Metal2 1.56961e-05f
Cred_6166 vin.$310.Metal1 VSS.$609.Metal2 6.93024e-05f
Cred_6167 vin.$310.Metal1 VSS.P0.pSD 0.0268886f
Cred_6168 vin.$310.Metal1 VSS.P10.nSD 0.000439224f
Cred_6169 vin.$310.Metal1 VSS.P11.nSD 0.000462735f
Cred_6170 vin.$311.Metal1 vout.$972.Metal3 0.00459107f
Cred_6171 vin.$311.Metal1 vout.$990.Metal3 0.00459107f
Cred_6172 vin.$311.Metal1 vout.P8.nSD 2.75788e-05f
Cred_6173 vin.$311.Metal1 vout.P8.pSD 0.0151017f
Cred_6174 vin.$318.Metal1 vout.$972.Metal3 0.00137141f
Cred_6175 vin.$318.Metal1 vout.$990.Metal3 0.0014145f
Cred_6176 vin.$318.Metal1 vout.P10.nSD 5.49693e-06f
Cred_6177 vin.$318.Metal1 vout.P8.nSD 0.004594f
Cred_6178 vin.$318.Metal1 vout.P8.pSD 2.23473e-05f
Cred_6179 vin.$318.Metal1 VSS.$102.Metal1 0.000225972f
Cred_6180 vin.$318.Metal1 VSS.$118.Metal1 0.0212546f
Cred_6181 vin.$318.Metal1 VSS.$128.Metal1 0.0001597f
Cred_6182 vin.$318.Metal1 VSS.$14.Metal1 0.000945135f
Cred_6183 vin.$318.Metal1 VSS.$29.Metal1 0.00159035f
Cred_6184 vin.$318.Metal1 VSS.$520.Metal1 3.49567e-05f
Cred_6185 vin.$318.Metal1 VSS.$598.Metal2 1.10506e-06f
Cred_6186 vin.$318.Metal1 VSS.$602.Metal2 0.000407238f
Cred_6187 vin.$318.Metal1 VSS.$609.Metal2 0.0023609f
Cred_6188 vin.$318.Metal1 VSS.$617.Metal2 1.7318e-06f
Cred_6189 vin.$318.Metal1 VSS.$942.Metal3 1.38852e-08f
Cred_6190 vin.$318.Metal1 VSS.P0.pSD 0.0269237f
Cred_6191 vin.$318.Metal1 VSS.P11.nSD 0.00423895f
Cred_6192 vin.$319.Metal1 vout.$972.Metal3 0.00160915f
Cred_6193 vin.$319.Metal1 vout.$990.Metal3 0.00163786f
Cred_6194 vin.$319.Metal1 vout.P10.pSD 8.12445e-06f
Cred_6195 vin.$319.Metal1 vout.P8.nSD 9.66622e-06f
Cred_6196 vin.$319.Metal1 vout.P8.pSD 0.00515064f
Cred_6197 vin.$32.GatPoly vout.$972.Metal3 0.00102233f
Cred_6198 vin.$32.GatPoly vout.P6.nSD 0.00168008f
Cred_6199 vin.$32.GatPoly VSS.$102.Metal1 0.00257494f
Cred_6200 vin.$32.GatPoly VSS.$14.Metal1 1.95321e-05f
Cred_6201 vin.$32.GatPoly VSS.$29.Metal1 3.2866e-05f
Cred_6202 vin.$32.GatPoly VSS.$520.Metal1 4.12606e-07f
Cred_6203 vin.$32.GatPoly VSS.$591.Metal2 0.000122391f
Cred_6204 vin.$32.GatPoly VSS.$598.Metal2 7.05966e-05f
Cred_6205 vin.$32.GatPoly VSS.$94.Metal1 3.37418e-06f
Cred_6206 vin.$32.GatPoly VSS.P0.pSD 0.000409573f
Cred_6207 vin.$32.GatPoly VSS.P10.nSD 0.000177368f
Cred_6208 vin.$322.Metal1 vout.$990.Metal3 0.00726614f
Cred_6209 vin.$322.Metal1 vout.P10.nSD 0.0146983f
Cred_6210 vin.$322.Metal1 VSS.$118.Metal1 0.000913958f
Cred_6211 vin.$322.Metal1 VSS.$128.Metal1 0.000853471f
Cred_6212 vin.$322.Metal1 VSS.$136.Metal1 0.000704839f
Cred_6213 vin.$322.Metal1 VSS.$14.Metal1 0.00083693f
Cred_6214 vin.$322.Metal1 VSS.$29.Metal1 0.00140827f
Cred_6215 vin.$322.Metal1 VSS.$520.Metal1 4.14367e-05f
Cred_6216 vin.$322.Metal1 VSS.$602.Metal2 1.20759e-05f
Cred_6217 vin.$322.Metal1 VSS.$609.Metal2 7.75864e-05f
Cred_6218 vin.$322.Metal1 VSS.$617.Metal2 7.9745e-06f
Cred_6219 vin.$322.Metal1 VSS.$942.Metal3 4.9061e-08f
Cred_6220 vin.$322.Metal1 VSS.P0.pSD 0.0279051f
Cred_6221 vin.$322.Metal1 VSS.P11.nSD 0.000975022f
Cred_6222 vin.$323.Metal1 vout.$990.Metal3 0.00863506f
Cred_6223 vin.$323.Metal1 vout.P10.pSD 0.0155927f
Cred_6224 vin.$328.Metal1 vout.$1008.Metal3 2.30365e-05f
Cred_6225 vin.$328.Metal1 vout.$990.Metal3 0.00262575f
Cred_6226 vin.$328.Metal1 vout.P10.nSD 0.00487233f
Cred_6227 vin.$328.Metal1 vout.P12.nSD 7.02996e-07f
Cred_6228 vin.$328.Metal1 vout.P12.pSD 3.75384e-07f
Cred_6229 vin.$328.Metal1 VSS.$128.Metal1 0.00028928f
Cred_6230 vin.$328.Metal1 VSS.$136.Metal1 0.0198327f
Cred_6231 vin.$328.Metal1 VSS.$14.Metal1 0.000737524f
Cred_6232 vin.$328.Metal1 VSS.$29.Metal1 0.00124101f
Cred_6233 vin.$328.Metal1 VSS.$520.Metal1 4.60388e-05f
Cred_6234 vin.$328.Metal1 VSS.$617.Metal2 0.00189252f
Cred_6235 vin.$328.Metal1 VSS.$624.Metal2 0.000980342f
Cred_6236 vin.$328.Metal1 VSS.P0.pSD 0.0278308f
Cred_6237 vin.$328.Metal1 VSS.P13.nSD 0.00535557f
Cred_6238 vin.$329.Metal1 vout.$990.Metal3 0.00317068f
Cred_6239 vin.$329.Metal1 vout.P10.pSD 0.00513322f
Cred_6240 vin.$33.GatPoly vout.$972.Metal3 0.00508801f
Cred_6241 vin.$33.GatPoly vout.P6.pSD 0.00540758f
Cred_6242 vin.$332.Metal1 vout.$1008.Metal3 0.00420352f
Cred_6243 vin.$332.Metal1 vout.$990.Metal3 0.00421113f
Cred_6244 vin.$332.Metal1 vout.P10.nSD 1.21649e-07f
Cred_6245 vin.$332.Metal1 vout.P12.nSD 0.0141643f
Cred_6246 vin.$332.Metal1 vout.P12.pSD 6.8497e-05f
Cred_6247 vin.$332.Metal1 VSS.$136.Metal1 0.00281001f
Cred_6248 vin.$332.Metal1 VSS.$14.Metal1 0.000641754f
Cred_6249 vin.$332.Metal1 VSS.$152.Metal1 0.0016f
Cred_6250 vin.$332.Metal1 VSS.$29.Metal1 0.00107986f
Cred_6251 vin.$332.Metal1 VSS.$520.Metal1 5.28825e-05f
Cred_6252 vin.$332.Metal1 VSS.$617.Metal2 0.000144171f
Cred_6253 vin.$332.Metal1 VSS.$624.Metal2 7.99985e-05f
Cred_6254 vin.$332.Metal1 VSS.$628.Metal2 1.85515e-05f
Cred_6255 vin.$332.Metal1 VSS.$635.Metal2 7.23137e-05f
Cred_6256 vin.$332.Metal1 VSS.P0.pSD 0.0280584f
Cred_6257 vin.$332.Metal1 VSS.P13.nSD 0.000508209f
Cred_6258 vin.$332.Metal1 VSS.P15.nSD 0.000441496f
Cred_6259 vin.$333.Metal1 vout.$1008.Metal3 0.00306184f
Cred_6260 vin.$333.Metal1 vout.$990.Metal3 0.00306184f
Cred_6261 vin.$333.Metal1 vout.P12.nSD 1.83926e-05f
Cred_6262 vin.$333.Metal1 vout.P12.pSD 0.0100934f
Cred_6263 vin.$337.Metal1 vout.$1008.Metal3 0.00308986f
Cred_6264 vin.$337.Metal1 vout.$990.Metal3 0.00307459f
Cred_6265 vin.$337.Metal1 vout.P12.nSD 1.84673e-05f
Cred_6266 vin.$337.Metal1 vout.P12.pSD 0.0100667f
Cred_6267 vin.$337.Metal1 vout.P14.pSD 7.74625e-07f
Cred_6268 vin.$337.Metal1 VSS.$152.Metal1 5.61783e-07f
Cred_6269 vin.$337.Metal1 VSS.$628.Metal2 7.6156e-07f
Cred_6270 vin.$337.Metal1 VSS.$635.Metal2 3.69901e-06f
Cred_6271 vin.$337.Metal1 VSS.P15.nSD 6.50517e-08f
Cred_6272 vin.$340.Metal1 vout.$1008.Metal3 0.00143043f
Cred_6273 vin.$340.Metal1 vout.$990.Metal3 0.00139144f
Cred_6274 vin.$340.Metal1 vout.P12.nSD 0.00466644f
Cred_6275 vin.$340.Metal1 vout.P12.pSD 2.26737e-05f
Cred_6276 vin.$340.Metal1 vout.P14.nSD 5.88129e-06f
Cred_6277 vin.$340.Metal1 VSS.$136.Metal1 0.000225716f
Cred_6278 vin.$340.Metal1 VSS.$14.Metal1 0.000565713f
Cred_6279 vin.$340.Metal1 VSS.$152.Metal1 0.0213194f
Cred_6280 vin.$340.Metal1 VSS.$162.Metal1 0.000140075f
Cred_6281 vin.$340.Metal1 VSS.$29.Metal1 0.000951906f
Cred_6282 vin.$340.Metal1 VSS.$520.Metal1 5.86328e-05f
Cred_6283 vin.$340.Metal1 VSS.$624.Metal2 1.14628e-06f
Cred_6284 vin.$340.Metal1 VSS.$628.Metal2 0.000475939f
Cred_6285 vin.$340.Metal1 VSS.$635.Metal2 0.00229943f
Cred_6286 vin.$340.Metal1 VSS.$643.Metal2 1.49335e-06f
Cred_6287 vin.$340.Metal1 VSS.$952.Metal3 1.19734e-08f
Cred_6288 vin.$340.Metal1 VSS.P0.pSD 0.0279027f
Cred_6289 vin.$340.Metal1 VSS.P15.nSD 0.00422104f
Cred_6290 vin.$341.Metal1 vout.$1008.Metal3 0.000177575f
Cred_6291 vin.$341.Metal1 vout.$990.Metal3 0.000154399f
Cred_6292 vin.$341.Metal1 vout.P12.nSD 9.24506e-07f
Cred_6293 vin.$341.Metal1 vout.P12.pSD 0.000245529f
Cred_6294 vin.$341.Metal1 vout.P14.pSD 1.17628e-06f
Cred_6295 vin.$341.Metal1 VSS.$152.Metal1 8.53078e-07f
Cred_6296 vin.$341.Metal1 VSS.$628.Metal2 1.15644e-06f
Cred_6297 vin.$341.Metal1 VSS.$635.Metal2 5.61701e-06f
Cred_6298 vin.$341.Metal1 VSS.P15.nSD 9.87822e-08f
Cred_6299 vin.$344.Metal1 vout.$1008.Metal3 0.00764546f
Cred_6300 vin.$344.Metal1 vout.P14.nSD 0.0152392f
Cred_6301 vin.$344.Metal1 VSS.$14.Metal1 0.000502255f
Cred_6302 vin.$344.Metal1 VSS.$152.Metal1 0.000991537f
Cred_6303 vin.$344.Metal1 VSS.$162.Metal1 0.000887463f
Cred_6304 vin.$344.Metal1 VSS.$170.Metal1 0.000700047f
Cred_6305 vin.$344.Metal1 VSS.$29.Metal1 0.000845128f
Cred_6306 vin.$344.Metal1 VSS.$520.Metal1 6.96131e-05f
Cred_6307 vin.$344.Metal1 VSS.$628.Metal2 1.30793e-05f
Cred_6308 vin.$344.Metal1 VSS.$635.Metal2 7.11448e-05f
Cred_6309 vin.$344.Metal1 VSS.$643.Metal2 8.02925e-06f
Cred_6310 vin.$344.Metal1 VSS.$952.Metal3 5.06565e-08f
Cred_6311 vin.$344.Metal1 VSS.P0.pSD 0.028834f
Cred_6312 vin.$344.Metal1 VSS.P15.nSD 0.000924067f
Cred_6313 vin.$345.Metal1 vout.$1008.Metal3 0.00850148f
Cred_6314 vin.$345.Metal1 vout.P14.pSD 0.0156354f
Cred_6315 vin.$350.Metal1 vout.$1008.Metal3 0.00228357f
Cred_6316 vin.$350.Metal1 vout.$1026.Metal3 2.43499e-05f
Cred_6317 vin.$350.Metal1 vout.P14.nSD 0.00437514f
Cred_6318 vin.$350.Metal1 vout.P16.nSD 7.38284e-07f
Cred_6319 vin.$350.Metal1 vout.P16.pSD 3.96785e-07f
Cred_6320 vin.$350.Metal1 VSS.$14.Metal1 0.000444843f
Cred_6321 vin.$350.Metal1 VSS.$162.Metal1 0.000303693f
Cred_6322 vin.$350.Metal1 VSS.$170.Metal1 0.0197371f
Cred_6323 vin.$350.Metal1 VSS.$29.Metal1 0.000748523f
Cred_6324 vin.$350.Metal1 VSS.$520.Metal1 7.75577e-05f
Cred_6325 vin.$350.Metal1 VSS.$643.Metal2 0.00194582f
Cred_6326 vin.$350.Metal1 VSS.$650.Metal2 0.000902596f
Cred_6327 vin.$350.Metal1 VSS.P0.pSD 0.0287641f
Cred_6328 vin.$350.Metal1 VSS.P17.nSD 0.0052302f
Cred_6329 vin.$351.Metal1 vout.$1008.Metal3 0.00306592f
Cred_6330 vin.$351.Metal1 vout.$1026.Metal3 2.18371e-05f
Cred_6331 vin.$351.Metal1 vout.P14.pSD 0.0050787f
Cred_6332 vin.$351.Metal1 vout.P16.nSD 1.31177e-07f
Cred_6333 vin.$351.Metal1 vout.P16.pSD 1.98241e-06f
Cred_6334 vin.$351.Metal1 VSS.$170.Metal1 1.28698e-06f
Cred_6335 vin.$351.Metal1 VSS.$643.Metal2 6.95213e-06f
Cred_6336 vin.$351.Metal1 VSS.$650.Metal2 3.22777e-06f
Cred_6337 vin.$351.Metal1 VSS.P17.nSD 1.49019e-07f
Cred_6338 vin.$354.Metal1 vout.$1008.Metal3 0.00418696f
Cred_6339 vin.$354.Metal1 vout.$1026.Metal3 0.00417818f
Cred_6340 vin.$354.Metal1 vout.P14.nSD 1.40317e-07f
Cred_6341 vin.$354.Metal1 vout.P16.nSD 0.0140693f
Cred_6342 vin.$354.Metal1 vout.P16.pSD 6.80841e-05f
Cred_6343 vin.$354.Metal1 VSS.$14.Metal1 0.000385302f
Cred_6344 vin.$354.Metal1 VSS.$170.Metal1 0.00284468f
Cred_6345 vin.$354.Metal1 VSS.$186.Metal1 0.00162213f
Cred_6346 vin.$354.Metal1 VSS.$29.Metal1 0.000648335f
Cred_6347 vin.$354.Metal1 VSS.$520.Metal1 8.86563e-05f
Cred_6348 vin.$354.Metal1 VSS.$643.Metal2 0.000163459f
Cred_6349 vin.$354.Metal1 VSS.$650.Metal2 8.09445e-05f
Cred_6350 vin.$354.Metal1 VSS.$654.Metal2 2.14182e-05f
Cred_6351 vin.$354.Metal1 VSS.$661.Metal2 7.36469e-05f
Cred_6352 vin.$354.Metal1 VSS.P0.pSD 0.0287508f
Cred_6353 vin.$354.Metal1 VSS.P17.nSD 0.000573894f
Cred_6354 vin.$354.Metal1 VSS.P19.nSD 0.00041869f
Cred_6355 vin.$355.Metal1 vout.$1008.Metal3 0.00302846f
Cred_6356 vin.$355.Metal1 vout.$1026.Metal3 0.00301997f
Cred_6357 vin.$355.Metal1 vout.P14.pSD 4.31954e-07f
Cred_6358 vin.$355.Metal1 vout.P16.nSD 1.81411e-05f
Cred_6359 vin.$355.Metal1 vout.P16.pSD 0.00993573f
Cred_6360 vin.$355.Metal1 VSS.$170.Metal1 3.6424e-07f
Cred_6361 vin.$355.Metal1 VSS.$643.Metal2 1.96758e-06f
Cred_6362 vin.$355.Metal1 VSS.$650.Metal2 9.13521e-07f
Cred_6363 vin.$355.Metal1 VSS.P17.nSD 4.21752e-08f
Cred_6364 vin.$359.Metal1 vout.$1008.Metal3 0.00311821f
Cred_6365 vin.$359.Metal1 vout.$1026.Metal3 0.00313233f
Cred_6366 vin.$359.Metal1 vout.P16.nSD 1.87298e-05f
Cred_6367 vin.$359.Metal1 vout.P16.pSD 0.0102218f
Cred_6368 vin.$359.Metal1 vout.P18.pSD 7.18177e-07f
Cred_6369 vin.$359.Metal1 VSS.$186.Metal1 5.44321e-07f
Cred_6370 vin.$359.Metal1 VSS.$654.Metal2 8.42639e-07f
Cred_6371 vin.$359.Metal1 VSS.$661.Metal2 3.47589e-06f
Cred_6372 vin.$359.Metal1 VSS.P19.nSD 6.30291e-08f
Cred_6373 vin.$362.Metal1 vout.$1008.Metal3 0.00141667f
Cred_6374 vin.$362.Metal1 vout.$1026.Metal3 0.00145483f
Cred_6375 vin.$362.Metal1 vout.P16.nSD 0.00475616f
Cred_6376 vin.$362.Metal1 vout.P16.pSD 2.30849e-05f
Cred_6377 vin.$362.Metal1 vout.P18.nSD 5.58477e-06f
Cred_6378 vin.$362.Metal1 VSS.$14.Metal1 0.00033926f
Cred_6379 vin.$362.Metal1 VSS.$170.Metal1 0.000225174f
Cred_6380 vin.$362.Metal1 VSS.$186.Metal1 0.0213919f
Cred_6381 vin.$362.Metal1 VSS.$196.Metal1 0.000119882f
Cred_6382 vin.$362.Metal1 VSS.$29.Metal1 0.000570862f
Cred_6383 vin.$362.Metal1 VSS.$520.Metal1 9.81159e-05f
Cred_6384 vin.$362.Metal1 VSS.$650.Metal2 1.18591e-06f
Cred_6385 vin.$362.Metal1 VSS.$654.Metal2 0.000545556f
Cred_6386 vin.$362.Metal1 VSS.$661.Metal2 0.00223984f
Cred_6387 vin.$362.Metal1 VSS.$669.Metal2 1.22062e-06f
Cred_6388 vin.$362.Metal1 VSS.$962.Metal3 9.78667e-09f
Cred_6389 vin.$362.Metal1 VSS.P0.pSD 0.0284645f
Cred_6390 vin.$362.Metal1 VSS.P19.nSD 0.00421119f
Cred_6391 vin.$363.Metal1 vout.$1008.Metal3 0.000152707f
Cred_6392 vin.$363.Metal1 vout.$1026.Metal3 0.00017699f
Cred_6393 vin.$363.Metal1 vout.P16.nSD 9.14816e-07f
Cred_6394 vin.$363.Metal1 vout.P16.pSD 0.000245367f
Cred_6395 vin.$363.Metal1 vout.P18.pSD 1.23526e-06f
Cred_6396 vin.$363.Metal1 VSS.$186.Metal1 9.36233e-07f
Cred_6397 vin.$363.Metal1 VSS.$654.Metal2 1.44934e-06f
Cred_6398 vin.$363.Metal1 VSS.$661.Metal2 5.97853e-06f
Cred_6399 vin.$363.Metal1 VSS.P19.nSD 1.0841e-07f
Cred_6400 vin.$366.Metal1 vout.$1026.Metal3 0.00767253f
Cred_6401 vin.$366.Metal1 vout.P18.nSD 0.015179f
Cred_6402 vin.$366.Metal1 VSS.$14.Metal1 0.000302229f
Cred_6403 vin.$366.Metal1 VSS.$186.Metal1 0.0010716f
Cred_6404 vin.$366.Metal1 VSS.$196.Metal1 0.00092169f
Cred_6405 vin.$366.Metal1 VSS.$204.Metal1 0.000694577f
Cred_6406 vin.$366.Metal1 VSS.$29.Metal1 0.00050855f
Cred_6407 vin.$366.Metal1 VSS.$520.Metal1 0.000116803f
Cred_6408 vin.$366.Metal1 VSS.$654.Metal2 1.40478e-05f
Cred_6409 vin.$366.Metal1 VSS.$661.Metal2 6.588e-05f
Cred_6410 vin.$366.Metal1 VSS.$669.Metal2 7.89229e-06f
Cred_6411 vin.$366.Metal1 VSS.$962.Metal3 5.07128e-08f
Cred_6412 vin.$366.Metal1 VSS.P0.pSD 0.029402f
Cred_6413 vin.$366.Metal1 VSS.P19.nSD 0.000866593f
Cred_6414 vin.$367.Metal1 vout.$1026.Metal3 0.0079896f
Cred_6415 vin.$367.Metal1 vout.P18.pSD 0.0155368f
Cred_6416 vin.$372.Metal1 vout.$1026.Metal3 0.00228998f
Cred_6417 vin.$372.Metal1 vout.$1044.Metal3 2.52164e-05f
Cred_6418 vin.$372.Metal1 vout.P18.nSD 0.00443984f
Cred_6419 vin.$372.Metal1 vout.P20.nSD 7.66957e-07f
Cred_6420 vin.$372.Metal1 vout.P20.pSD 4.10905e-07f
Cred_6421 vin.$372.Metal1 VSS.$14.Metal1 0.000269254f
Cred_6422 vin.$372.Metal1 VSS.$196.Metal1 0.000328388f
Cred_6423 vin.$372.Metal1 VSS.$204.Metal1 0.0196636f
Cred_6424 vin.$372.Metal1 VSS.$29.Metal1 0.000453064f
Cred_6425 vin.$372.Metal1 VSS.$520.Metal1 0.00013056f
Cred_6426 vin.$372.Metal1 VSS.$669.Metal2 0.00199785f
Cred_6427 vin.$372.Metal1 VSS.$676.Metal2 0.000825986f
Cred_6428 vin.$372.Metal1 VSS.P0.pSD 0.0293879f
Cred_6429 vin.$372.Metal1 VSS.P21.nSD 0.00505045f
Cred_6430 vin.$373.Metal1 vout.$1026.Metal3 0.00260333f
Cred_6431 vin.$373.Metal1 vout.$1044.Metal3 2.53606e-05f
Cred_6432 vin.$373.Metal1 vout.P18.pSD 0.00514507f
Cred_6433 vin.$373.Metal1 vout.P20.nSD 1.52342e-07f
Cred_6434 vin.$373.Metal1 vout.P20.pSD 2.54282e-06f
Cred_6435 vin.$373.Metal1 VSS.$204.Metal1 1.23752e-06f
Cred_6436 vin.$373.Metal1 VSS.$669.Metal2 6.92701e-06f
Cred_6437 vin.$373.Metal1 VSS.$676.Metal2 2.86635e-06f
Cred_6438 vin.$373.Metal1 VSS.P21.nSD 1.43293e-07f
Cred_6439 vin.$376.Metal1 vout.$1026.Metal3 0.00421836f
Cred_6440 vin.$376.Metal1 vout.$1044.Metal3 0.00420841f
Cred_6441 vin.$376.Metal1 vout.P18.nSD 1.58977e-07f
Cred_6442 vin.$376.Metal1 vout.P20.nSD 0.0141585f
Cred_6443 vin.$376.Metal1 vout.P20.pSD 6.85767e-05f
Cred_6444 vin.$376.Metal1 VSS.$14.Metal1 0.000233318f
Cred_6445 vin.$376.Metal1 VSS.$204.Metal1 0.00283005f
Cred_6446 vin.$376.Metal1 VSS.$220.Metal1 0.00149747f
Cred_6447 vin.$376.Metal1 VSS.$29.Metal1 0.000392597f
Cred_6448 vin.$376.Metal1 VSS.$520.Metal1 0.000149365f
Cred_6449 vin.$376.Metal1 VSS.$669.Metal2 0.000181201f
Cred_6450 vin.$376.Metal1 VSS.$676.Metal2 7.97109e-05f
Cred_6451 vin.$376.Metal1 VSS.$680.Metal2 2.37928e-05f
Cred_6452 vin.$376.Metal1 VSS.$687.Metal2 7.3429e-05f
Cred_6453 vin.$376.Metal1 VSS.P0.pSD 0.0293038f
Cred_6454 vin.$376.Metal1 VSS.P21.nSD 0.000636275f
Cred_6455 vin.$376.Metal1 VSS.P23.nSD 0.000394314f
Cred_6456 vin.$377.Metal1 vout.$1026.Metal3 0.00309276f
Cred_6457 vin.$377.Metal1 vout.$1044.Metal3 0.00308314f
Cred_6458 vin.$377.Metal1 vout.P18.pSD 4.89399e-07f
Cred_6459 vin.$377.Metal1 vout.P20.nSD 1.85206e-05f
Cred_6460 vin.$377.Metal1 vout.P20.pSD 0.0101366f
Cred_6461 vin.$377.Metal1 VSS.$204.Metal1 4.12505e-07f
Cred_6462 vin.$377.Metal1 VSS.$669.Metal2 2.309e-06f
Cred_6463 vin.$377.Metal1 VSS.$676.Metal2 9.5545e-07f
Cred_6464 vin.$377.Metal1 VSS.P21.nSD 4.77642e-08f
Cred_6465 vin.$38.GatPoly vout.$972.Metal3 0.000545769f
Cred_6466 vin.$38.GatPoly vout.$990.Metal3 0.000470552f
Cred_6467 vin.$38.GatPoly vout.P6.nSD 0.00012321f
Cred_6468 vin.$38.GatPoly vout.P8.nSD 0.00156064f
Cred_6469 vin.$38.GatPoly vout.P8.pSD 7.66771e-06f
Cred_6470 vin.$38.GatPoly VSS.$102.Metal1 0.00356103f
Cred_6471 vin.$38.GatPoly VSS.$14.Metal1 2.02388e-05f
Cred_6472 vin.$38.GatPoly VSS.$29.Metal1 3.40552e-05f
Cred_6473 vin.$38.GatPoly VSS.$520.Metal1 4.36782e-07f
Cred_6474 vin.$38.GatPoly VSS.$591.Metal2 0.000169785f
Cred_6475 vin.$38.GatPoly VSS.$598.Metal2 9.79528e-05f
Cred_6476 vin.$38.GatPoly VSS.P0.pSD 0.000429663f
Cred_6477 vin.$38.GatPoly VSS.P10.nSD 0.000246098f
Cred_6478 vin.$381.Metal1 vout.$1026.Metal3 0.00305432f
Cred_6479 vin.$381.Metal1 vout.$1044.Metal3 0.00306733f
Cred_6480 vin.$381.Metal1 vout.P20.nSD 1.83467e-05f
Cred_6481 vin.$381.Metal1 vout.P20.pSD 0.0100225f
Cred_6482 vin.$381.Metal1 vout.P22.pSD 6.61357e-07f
Cred_6483 vin.$381.Metal1 VSS.$220.Metal1 5.22497e-07f
Cred_6484 vin.$381.Metal1 VSS.$680.Metal2 9.09302e-07f
Cred_6485 vin.$381.Metal1 VSS.$687.Metal2 3.23307e-06f
Cred_6486 vin.$381.Metal1 VSS.P23.nSD 6.05015e-08f
Cred_6487 vin.$384.Metal1 vout.$1026.Metal3 0.00138918f
Cred_6488 vin.$384.Metal1 vout.$1044.Metal3 0.00142198f
Cred_6489 vin.$384.Metal1 vout.P20.nSD 0.00467089f
Cred_6490 vin.$384.Metal1 vout.P20.pSD 2.26369e-05f
Cred_6491 vin.$384.Metal1 vout.P22.nSD 5.02106e-06f
Cred_6492 vin.$384.Metal1 VSS.$14.Metal1 0.000210811f
Cred_6493 vin.$384.Metal1 VSS.$204.Metal1 9.9297e-05f
Cred_6494 vin.$384.Metal1 VSS.$220.Metal1 0.0207952f
Cred_6495 vin.$384.Metal1 VSS.$230.Metal1 9.91546e-05f
Cred_6496 vin.$384.Metal1 VSS.$29.Metal1 0.000354725f
Cred_6497 vin.$384.Metal1 VSS.$520.Metal1 0.000169222f
Cred_6498 vin.$384.Metal1 VSS.$676.Metal2 5.4165e-07f
Cred_6499 vin.$384.Metal1 VSS.$680.Metal2 0.000614492f
Cred_6500 vin.$384.Metal1 VSS.$687.Metal2 0.00218145f
Cred_6501 vin.$384.Metal1 VSS.$695.Metal2 9.62582e-07f
Cred_6502 vin.$384.Metal1 VSS.$972.Metal3 7.71777e-09f
Cred_6503 vin.$384.Metal1 VSS.P0.pSD 0.0296628f
Cred_6504 vin.$384.Metal1 VSS.P23.nSD 0.00408702f
Cred_6505 vin.$385.Metal1 vout.$1026.Metal3 0.000150343f
Cred_6506 vin.$385.Metal1 vout.$1044.Metal3 0.00017578f
Cred_6507 vin.$385.Metal1 vout.P20.nSD 9.01522e-07f
Cred_6508 vin.$385.Metal1 vout.P20.pSD 0.000245167f
Cred_6509 vin.$385.Metal1 vout.P22.pSD 1.29396e-06f
Cred_6510 vin.$385.Metal1 VSS.$220.Metal1 1.02228e-06f
Cred_6511 vin.$385.Metal1 VSS.$680.Metal2 1.77907e-06f
Cred_6512 vin.$385.Metal1 VSS.$687.Metal2 6.32558e-06f
Cred_6513 vin.$385.Metal1 VSS.P23.nSD 1.18372e-07f
Cred_6514 vin.$388.Metal1 vout.$1044.Metal3 0.00768415f
Cred_6515 vin.$388.Metal1 vout.P22.nSD 0.0151187f
Cred_6516 vin.$388.Metal1 VSS.$14.Metal1 0.000187363f
Cred_6517 vin.$388.Metal1 VSS.$220.Metal1 0.00115622f
Cred_6518 vin.$388.Metal1 VSS.$230.Metal1 0.000951368f
Cred_6519 vin.$388.Metal1 VSS.$238.Metal1 0.000677673f
Cred_6520 vin.$388.Metal1 VSS.$29.Metal1 0.000315269f
Cred_6521 vin.$388.Metal1 VSS.$520.Metal1 0.000199767f
Cred_6522 vin.$388.Metal1 VSS.$680.Metal2 1.44296e-05f
Cred_6523 vin.$388.Metal1 VSS.$687.Metal2 5.95693e-05f
Cred_6524 vin.$388.Metal1 VSS.$695.Metal2 7.71194e-06f
Cred_6525 vin.$388.Metal1 VSS.$972.Metal3 5.05943e-08f
Cred_6526 vin.$388.Metal1 VSS.P0.pSD 0.0303777f
Cred_6527 vin.$388.Metal1 VSS.P23.nSD 1.97874e-07f
Cred_6528 vin.$389.Metal1 vout.$1044.Metal3 0.00821975f
Cred_6529 vin.$389.Metal1 vout.P22.pSD 0.0151934f
Cred_6530 vin.$39.GatPoly vout.$972.Metal3 0.00346416f
Cred_6531 vin.$39.GatPoly vout.$990.Metal3 0.00284953f
Cred_6532 vin.$39.GatPoly vout.P6.pSD 0.000605631f
Cred_6533 vin.$39.GatPoly vout.P8.nSD 1.71173e-05f
Cred_6534 vin.$39.GatPoly vout.P8.pSD 0.00595245f
Cred_6535 vin.$394.Metal1 vout.$1044.Metal3 0.00229785f
Cred_6536 vin.$394.Metal1 vout.$1062.Metal3 2.7486e-05f
Cred_6537 vin.$394.Metal1 vout.P22.nSD 0.00450465f
Cred_6538 vin.$394.Metal1 vout.P24.nSD 8.18551e-07f
Cred_6539 vin.$394.Metal1 vout.P24.pSD 4.47889e-07f
Cred_6540 vin.$394.Metal1 VSS.$14.Metal1 0.000163506f
Cred_6541 vin.$394.Metal1 VSS.$230.Metal1 0.000349472f
Cred_6542 vin.$394.Metal1 VSS.$238.Metal1 0.0196037f
Cred_6543 vin.$394.Metal1 VSS.$29.Metal1 0.000275126f
Cred_6544 vin.$394.Metal1 VSS.$520.Metal1 0.00021886f
Cred_6545 vin.$394.Metal1 VSS.$695.Metal2 0.00205126f
Cred_6546 vin.$394.Metal1 VSS.$702.Metal2 0.000751532f
Cred_6547 vin.$394.Metal1 VSS.P0.pSD 0.0296717f
Cred_6548 vin.$394.Metal1 VSS.P25.nSD 0.0048741f
Cred_6549 vin.$395.Metal1 vout.$1044.Metal3 0.00289561f
Cred_6550 vin.$395.Metal1 vout.$1062.Metal3 2.80467e-05f
Cred_6551 vin.$395.Metal1 vout.P22.pSD 0.00496814f
Cred_6552 vin.$395.Metal1 vout.P24.nSD 1.66785e-07f
Cred_6553 vin.$395.Metal1 vout.P24.pSD 2.73813e-06f
Cred_6554 vin.$395.Metal1 VSS.$238.Metal1 1.18756e-06f
Cred_6555 vin.$395.Metal1 VSS.$695.Metal2 6.88032e-06f
Cred_6556 vin.$395.Metal1 VSS.$702.Metal2 2.52278e-06f
Cred_6557 vin.$395.Metal1 VSS.P25.nSD 1.37509e-07f
Cred_6558 vin.$398.Metal1 vout.$1044.Metal3 0.00421721f
Cred_6559 vin.$398.Metal1 vout.$1062.Metal3 0.00421215f
Cred_6560 vin.$398.Metal1 vout.P22.nSD 1.77551e-07f
Cred_6561 vin.$398.Metal1 vout.P24.nSD 0.0141195f
Cred_6562 vin.$398.Metal1 vout.P24.pSD 6.8539e-05f
Cred_6563 vin.$398.Metal1 vout.P26.nSD 9.67705e-08f
Cred_6564 vin.$398.Metal1 VSS.$14.Metal1 0.000141743f
Cred_6565 vin.$398.Metal1 VSS.$238.Metal1 0.00282021f
Cred_6566 vin.$398.Metal1 VSS.$254.Metal1 0.0015237f
Cred_6567 vin.$398.Metal1 VSS.$29.Metal1 0.000238506f
Cred_6568 vin.$398.Metal1 VSS.$520.Metal1 0.00025023f
Cred_6569 vin.$398.Metal1 VSS.$695.Metal2 0.000197167f
Cred_6570 vin.$398.Metal1 VSS.$702.Metal2 7.68638e-05f
Cred_6571 vin.$398.Metal1 VSS.$706.Metal2 3.70937e-05f
Cred_6572 vin.$398.Metal1 VSS.$713.Metal2 0.000105371f
Cred_6573 vin.$398.Metal1 VSS.P0.pSD 0.0294761f
Cred_6574 vin.$398.Metal1 VSS.P25.nSD 0.000695365f
Cred_6575 vin.$398.Metal1 VSS.P27.nSD 0.000368969f
Cred_6576 vin.$399.Metal1 vout.$1044.Metal3 0.00459285f
Cred_6577 vin.$399.Metal1 vout.$1062.Metal3 0.00458796f
Cred_6578 vin.$399.Metal1 vout.P22.pSD 5.46578e-07f
Cred_6579 vin.$399.Metal1 vout.P24.nSD 2.75243e-05f
Cred_6580 vin.$399.Metal1 vout.P24.pSD 0.015052f
Cred_6581 vin.$399.Metal1 vout.P26.pSD 2.97901e-07f
Cred_6582 vin.$399.Metal1 VSS.$238.Metal1 4.60482e-07f
Cred_6583 vin.$399.Metal1 VSS.$254.Metal1 2.44869e-07f
Cred_6584 vin.$399.Metal1 VSS.$695.Metal2 2.66788e-06f
Cred_6585 vin.$399.Metal1 VSS.$702.Metal2 9.78222e-07f
Cred_6586 vin.$399.Metal1 VSS.$706.Metal2 4.73182e-07f
Cred_6587 vin.$399.Metal1 VSS.$713.Metal2 1.46686e-06f
Cred_6588 vin.$399.Metal1 VSS.P25.nSD 5.33197e-08f
Cred_6589 vin.$399.Metal1 VSS.P27.nSD 2.83539e-08f
Cred_6590 vin.$4.GatPoly vout.$954.Metal3 0.00185732f
Cred_6591 vin.$4.GatPoly vout.P0.nSD 0.00268731f
Cred_6592 vin.$4.GatPoly vout.P0.pSD 1.94324e-05f
Cred_6593 vin.$4.GatPoly vout.P2.nSD 0.00041274f
Cred_6594 vin.$4.GatPoly VSS.$14.Metal1 0.000273227f
Cred_6595 vin.$4.GatPoly VSS.$29.Metal1 0.000881138f
Cred_6596 vin.$4.GatPoly VSS.$31.Metal1 8.20082e-06f
Cred_6597 vin.$4.GatPoly VSS.$42.Metal1 5.2916e-05f
Cred_6598 vin.$4.GatPoly VSS.$50.Metal1 0.00380558f
Cred_6599 vin.$4.GatPoly VSS.$520.Metal1 9.52293e-07f
Cred_6600 vin.$4.GatPoly VSS.$531.Metal2 2.38404e-05f
Cred_6601 vin.$4.GatPoly VSS.$540.Metal2 7.4011e-07f
Cred_6602 vin.$4.GatPoly VSS.$550.Metal2 2.722e-05f
Cred_6603 vin.$4.GatPoly VSS.$557.Metal2 0.000243564f
Cred_6604 vin.$4.GatPoly VSS.$916.Metal3 6.27843e-09f
Cred_6605 vin.$4.GatPoly VSS.P0.GatPoly 0.00749074f
Cred_6606 vin.$4.GatPoly VSS.P0.nSD 4.38947e-06f
Cred_6607 vin.$4.GatPoly VSS.P0.pSD 0.00193632f
Cred_6608 vin.$4.GatPoly VSS.P1.nSD 3.84277e-05f
Cred_6609 vin.$4.GatPoly VSS.P3.nSD 0.000259353f
Cred_6610 vin.$406.Metal1 vout.$1044.Metal3 0.00140992f
Cred_6611 vin.$406.Metal1 vout.$1062.Metal3 0.00144348f
Cred_6612 vin.$406.Metal1 vout.P24.nSD 0.00463528f
Cred_6613 vin.$406.Metal1 vout.P24.pSD 2.29748e-05f
Cred_6614 vin.$406.Metal1 vout.P26.nSD 5.36146e-07f
Cred_6615 vin.$406.Metal1 VSS 7.79153e-05f
Cred_6616 vin.$406.Metal1 VSS.$14.Metal1 0.000127318f
Cred_6617 vin.$406.Metal1 VSS.$238.Metal1 0.000104158f
Cred_6618 vin.$406.Metal1 VSS.$254.Metal1 0.0193856f
Cred_6619 vin.$406.Metal1 VSS.$29.Metal1 0.000214233f
Cred_6620 vin.$406.Metal1 VSS.$520.Metal1 0.000280815f
Cred_6621 vin.$406.Metal1 VSS.$702.Metal2 5.87768e-07f
Cred_6622 vin.$406.Metal1 VSS.$706.Metal2 0.000713688f
Cred_6623 vin.$406.Metal1 VSS.$713.Metal2 0.00220837f
Cred_6624 vin.$406.Metal1 VSS.P0.pSD 0.0295164f
Cred_6625 vin.$406.Metal1 VSS.P27.nSD 0.00505442f
Cred_6626 vin.$407.Metal1 vout.$1044.Metal3 0.0016534f
Cred_6627 vin.$407.Metal1 vout.$1062.Metal3 0.00168585f
Cred_6628 vin.$407.Metal1 vout.P24.nSD 9.93206e-06f
Cred_6629 vin.$407.Metal1 vout.P24.pSD 0.00518898f
Cred_6630 vin.$407.Metal1 vout.P26.pSD 1.65049e-06f
Cred_6631 vin.$407.Metal1 VSS.$254.Metal1 1.35667e-06f
Cred_6632 vin.$407.Metal1 VSS.$706.Metal2 2.62161e-06f
Cred_6633 vin.$407.Metal1 VSS.$713.Metal2 8.127e-06f
Cred_6634 vin.$407.Metal1 VSS.P27.nSD 1.57092e-07f
Cred_6635 vin.$410.Metal1 vout.$1062.Metal3 0.00760047f
Cred_6636 vin.$410.Metal1 vout.P26.nSD 0.015246f
Cred_6637 vin.$410.Metal1 VSS 0.00101381f
Cred_6638 vin.$410.Metal1 VSS.$14.Metal1 0.0001176f
Cred_6639 vin.$410.Metal1 VSS.$254.Metal1 0.00148585f
Cred_6640 vin.$410.Metal1 VSS.$270.Metal1 0.000613359f
Cred_6641 vin.$410.Metal1 VSS.$29.Metal1 0.000197881f
Cred_6642 vin.$410.Metal1 VSS.$520.Metal1 0.000332333f
Cred_6643 vin.$410.Metal1 VSS.$706.Metal2 8.46686e-06f
Cred_6644 vin.$410.Metal1 VSS.$713.Metal2 2.85859e-05f
Cred_6645 vin.$410.Metal1 VSS.$721.Metal2 1.15332e-06f
Cred_6646 vin.$410.Metal1 VSS.P0.pSD 0.0307522f
Cred_6647 vin.$410.Metal1 VSS.P27.nSD 3.18978e-05f
Cred_6648 vin.$411.Metal1 vout.$1062.Metal3 0.00818964f
Cred_6649 vin.$411.Metal1 vout.P26.pSD 0.0151104f
Cred_6650 vin.$416.Metal1 vout.$1062.Metal3 0.00230288f
Cred_6651 vin.$416.Metal1 vout.$1080.Metal3 2.68834e-05f
Cred_6652 vin.$416.Metal1 vout.P26.nSD 0.00456951f
Cred_6653 vin.$416.Metal1 vout.P28.nSD 8.13231e-07f
Cred_6654 vin.$416.Metal1 vout.P28.pSD 4.38069e-07f
Cred_6655 vin.$416.Metal1 VSS 0.000412144f
Cred_6656 vin.$416.Metal1 VSS.$14.Metal1 9.91623e-05f
Cred_6657 vin.$416.Metal1 VSS.$270.Metal1 0.0195117f
Cred_6658 vin.$416.Metal1 VSS.$29.Metal1 0.000166857f
Cred_6659 vin.$416.Metal1 VSS.$520.Metal1 0.000369562f
Cred_6660 vin.$416.Metal1 VSS.$721.Metal2 0.00211164f
Cred_6661 vin.$416.Metal1 VSS.$728.Metal2 0.000680717f
Cred_6662 vin.$416.Metal1 VSS.P0.pSD 0.0298611f
Cred_6663 vin.$416.Metal1 VSS.P29.nSD 0.00469494f
Cred_6664 vin.$417.Metal1 vout.$1062.Metal3 0.00292454f
Cred_6665 vin.$417.Metal1 vout.$1080.Metal3 2.7406e-05f
Cred_6666 vin.$417.Metal1 vout.P26.pSD 0.00505141f
Cred_6667 vin.$417.Metal1 vout.P28.nSD 1.64629e-07f
Cred_6668 vin.$417.Metal1 vout.P28.pSD 2.81346e-06f
Cred_6669 vin.$417.Metal1 VSS.$270.Metal1 1.11162e-06f
Cred_6670 vin.$417.Metal1 VSS.$721.Metal2 6.65902e-06f
Cred_6671 vin.$417.Metal1 VSS.$728.Metal2 2.14807e-06f
Cred_6672 vin.$417.Metal1 VSS.P29.nSD 1.28716e-07f
Cred_6673 vin.$42.GatPoly vout.$972.Metal3 0.000506724f
Cred_6674 vin.$42.GatPoly vout.$990.Metal3 0.000506724f
Cred_6675 vin.$42.GatPoly vout.P8.nSD 0.00168059f
Cred_6676 vin.$42.GatPoly vout.P8.pSD 8.25715e-06f
Cred_6677 vin.$42.GatPoly VSS.$102.Metal1 1.46308e-06f
Cred_6678 vin.$42.GatPoly VSS.$118.Metal1 0.00258107f
Cred_6679 vin.$42.GatPoly VSS.$14.Metal1 5.70235e-05f
Cred_6680 vin.$42.GatPoly VSS.$29.Metal1 9.59515e-05f
Cred_6681 vin.$42.GatPoly VSS.$520.Metal1 1.8132e-06f
Cred_6682 vin.$42.GatPoly VSS.$598.Metal2 7.15481e-09f
Cred_6683 vin.$42.GatPoly VSS.$602.Metal2 2.84178e-05f
Cred_6684 vin.$42.GatPoly VSS.$609.Metal2 0.000165662f
Cred_6685 vin.$42.GatPoly VSS.P0.pSD 0.00149774f
Cred_6686 vin.$42.GatPoly VSS.P11.nSD 0.000182874f
Cred_6687 vin.$420.Metal1 vout.$1062.Metal3 0.00421248f
Cred_6688 vin.$420.Metal1 vout.$1080.Metal3 0.0042002f
Cred_6689 vin.$420.Metal1 vout.P26.nSD 1.96284e-07f
Cred_6690 vin.$420.Metal1 vout.P28.nSD 0.0141057f
Cred_6691 vin.$420.Metal1 vout.P28.pSD 6.84428e-05f
Cred_6692 vin.$420.Metal1 VSS.$14.Metal1 8.6833e-05f
Cred_6693 vin.$420.Metal1 VSS.$270.Metal1 0.0026411f
Cred_6694 vin.$420.Metal1 VSS.$286.Metal1 0.00154562f
Cred_6695 vin.$420.Metal1 VSS.$29.Metal1 0.000146111f
Cred_6696 vin.$420.Metal1 VSS.$520.Metal1 0.000413312f
Cred_6697 vin.$420.Metal1 VSS.$721.Metal2 0.000213516f
Cred_6698 vin.$420.Metal1 VSS.$728.Metal2 7.25491e-05f
Cred_6699 vin.$420.Metal1 VSS.$732.Metal2 2.83966e-05f
Cred_6700 vin.$420.Metal1 VSS.$739.Metal2 6.88431e-05f
Cred_6701 vin.$420.Metal1 VSS.P0.pSD 0.0296157f
Cred_6702 vin.$420.Metal1 VSS.P29.nSD 0.000748394f
Cred_6703 vin.$420.Metal1 VSS.P31.nSD 0.000340843f
Cred_6704 vin.$421.Metal1 vout.$1062.Metal3 0.00308904f
Cred_6705 vin.$421.Metal1 vout.$1080.Metal3 0.00307716f
Cred_6706 vin.$421.Metal1 vout.P26.pSD 6.04246e-07f
Cred_6707 vin.$421.Metal1 vout.P28.nSD 1.84847e-05f
Cred_6708 vin.$421.Metal1 vout.P28.pSD 0.0101048f
Cred_6709 vin.$421.Metal1 VSS.$270.Metal1 4.96679e-07f
Cred_6710 vin.$421.Metal1 VSS.$721.Metal2 2.97531e-06f
Cred_6711 vin.$421.Metal1 VSS.$728.Metal2 9.59777e-07f
Cred_6712 vin.$421.Metal1 VSS.P29.nSD 5.75115e-08f
Cred_6713 vin.$425.Metal1 vout.$1062.Metal3 0.00305338f
Cred_6714 vin.$425.Metal1 vout.$1080.Metal3 0.00306413f
Cred_6715 vin.$425.Metal1 vout.P28.nSD 1.83414e-05f
Cred_6716 vin.$425.Metal1 vout.P28.pSD 0.0100341f
Cred_6717 vin.$425.Metal1 vout.P30.pSD 5.46716e-07f
Cred_6718 vin.$425.Metal1 VSS.$286.Metal1 4.60598e-07f
Cred_6719 vin.$425.Metal1 VSS.$732.Metal2 9.78469e-07f
Cred_6720 vin.$425.Metal1 VSS.$739.Metal2 2.66855e-06f
Cred_6721 vin.$425.Metal1 VSS.P31.nSD 5.33332e-08f
Cred_6722 vin.$428.Metal1 vout.$1062.Metal3 0.00139663f
Cred_6723 vin.$428.Metal1 vout.$1080.Metal3 0.00398511f
Cred_6724 vin.$428.Metal1 vout.P28.nSD 0.00470894f
Cred_6725 vin.$428.Metal1 vout.P28.pSD 2.27583e-05f
Cred_6726 vin.$428.Metal1 vout.P30.nSD 0.00507224f
Cred_6727 vin.$428.Metal1 VSS.$14.Metal1 9.9969e-05f
Cred_6728 vin.$428.Metal1 VSS.$270.Metal1 0.000144439f
Cred_6729 vin.$428.Metal1 VSS.$286.Metal1 0.0210936f
Cred_6730 vin.$428.Metal1 VSS.$29.Metal1 0.000168215f
Cred_6731 vin.$428.Metal1 VSS.$298.Metal1 0.000349472f
Cred_6732 vin.$428.Metal1 VSS.$520.Metal1 0.000631836f
Cred_6733 vin.$428.Metal1 VSS.$728.Metal2 8.42267e-07f
Cred_6734 vin.$428.Metal1 VSS.$732.Metal2 0.000727953f
Cred_6735 vin.$428.Metal1 VSS.$739.Metal2 0.00198159f
Cred_6736 vin.$428.Metal1 VSS.P0.pSD 0.0393385f
Cred_6737 vin.$428.Metal1 VSS.P31.nSD 0.00521737f
Cred_6738 vin.$429.Metal1 vout.$1062.Metal3 0.000147948f
Cred_6739 vin.$429.Metal1 vout.$1080.Metal3 0.000175674f
Cred_6740 vin.$429.Metal1 vout.P28.nSD 8.87589e-07f
Cred_6741 vin.$429.Metal1 vout.P28.pSD 0.000244917f
Cred_6742 vin.$429.Metal1 vout.P30.pSD 1.40995e-06f
Cred_6743 vin.$429.Metal1 VSS.$286.Metal1 1.18786e-06f
Cred_6744 vin.$429.Metal1 VSS.$732.Metal2 2.52342e-06f
Cred_6745 vin.$429.Metal1 VSS.$739.Metal2 6.88205e-06f
Cred_6746 vin.$429.Metal1 VSS.P31.nSD 1.37543e-07f
Cred_6747 vin.$43.GatPoly vout.$972.Metal3 0.00251622f
Cred_6748 vin.$43.GatPoly vout.$990.Metal3 0.00251622f
Cred_6749 vin.$43.GatPoly vout.P8.nSD 1.51151e-05f
Cred_6750 vin.$43.GatPoly vout.P8.pSD 0.00544973f
Cred_6751 vin.$433.Metal1 vout.$1080.Metal3 0.0081595f
Cred_6752 vin.$433.Metal1 vout.P30.pSD 0.0149444f
Cred_6753 vin.$434.Metal1 vout.$1080.Metal3 0.00733073f
Cred_6754 vin.$434.Metal1 vout.P30.nSD 0.0145398f
Cred_6755 vin.$434.Metal1 VSS.$14.Metal1 6.68656e-05f
Cred_6756 vin.$434.Metal1 VSS.$286.Metal1 0.000677673f
Cred_6757 vin.$434.Metal1 VSS.$29.Metal1 0.000112512f
Cred_6758 vin.$434.Metal1 VSS.$298.Metal1 0.000951368f
Cred_6759 vin.$434.Metal1 VSS.$304.Metal1 0.00115622f
Cred_6760 vin.$434.Metal1 VSS.$520.Metal1 0.00055973f
Cred_6761 vin.$434.Metal1 VSS.$739.Metal2 7.71194e-06f
Cred_6762 vin.$434.Metal1 VSS.$747.Metal2 5.95693e-05f
Cred_6763 vin.$434.Metal1 VSS.$754.Metal2 1.44296e-05f
Cred_6764 vin.$434.Metal1 VSS.$992.Metal3 5.05943e-08f
Cred_6765 vin.$434.Metal1 VSS.P0.pSD 0.0303411f
Cred_6766 vin.$434.Metal1 VSS.P33.nSD 1.97874e-07f
Cred_6767 vin.$438.Metal1 vout.$1080.Metal3 0.00142198f
Cred_6768 vin.$438.Metal1 vout.$1098.Metal3 0.00138918f
Cred_6769 vin.$438.Metal1 vout.P30.nSD 5.02106e-06f
Cred_6770 vin.$438.Metal1 vout.P32.nSD 0.00467089f
Cred_6771 vin.$438.Metal1 vout.P32.pSD 2.26369e-05f
Cred_6772 vin.$438.Metal1 VSS.$14.Metal1 5.66403e-05f
Cred_6773 vin.$438.Metal1 VSS.$29.Metal1 9.53067e-05f
Cred_6774 vin.$438.Metal1 VSS.$298.Metal1 9.91546e-05f
Cred_6775 vin.$438.Metal1 VSS.$304.Metal1 0.0207952f
Cred_6776 vin.$438.Metal1 VSS.$320.Metal1 9.9297e-05f
Cred_6777 vin.$438.Metal1 VSS.$520.Metal1 0.00062978f
Cred_6778 vin.$438.Metal1 VSS.$739.Metal2 9.62582e-07f
Cred_6779 vin.$438.Metal1 VSS.$747.Metal2 0.00218145f
Cred_6780 vin.$438.Metal1 VSS.$754.Metal2 0.000614492f
Cred_6781 vin.$438.Metal1 VSS.$758.Metal2 5.4165e-07f
Cred_6782 vin.$438.Metal1 VSS.$992.Metal3 7.71777e-09f
Cred_6783 vin.$438.Metal1 VSS.P0.pSD 0.0296158f
Cred_6784 vin.$438.Metal1 VSS.P33.nSD 0.00408702f
Cred_6785 vin.$439.Metal1 vout.$1080.Metal3 0.00295654f
Cred_6786 vin.$439.Metal1 vout.$1098.Metal3 2.97858e-05f
Cred_6787 vin.$439.Metal1 vout.P30.pSD 0.00521531f
Cred_6788 vin.$439.Metal1 vout.P32.nSD 1.77329e-07f
Cred_6789 vin.$439.Metal1 vout.P32.pSD 2.96836e-06f
Cred_6790 vin.$439.Metal1 VSS.$304.Metal1 1.02228e-06f
Cred_6791 vin.$439.Metal1 VSS.$747.Metal2 6.32558e-06f
Cred_6792 vin.$439.Metal1 VSS.$754.Metal2 1.77907e-06f
Cred_6793 vin.$439.Metal1 VSS.P33.nSD 1.18372e-07f
Cred_6794 vin.$443.Metal1 vout.$1080.Metal3 0.00459985f
Cred_6795 vin.$443.Metal1 vout.$1098.Metal3 0.00459159f
Cred_6796 vin.$443.Metal1 vout.P30.pSD 6.61357e-07f
Cred_6797 vin.$443.Metal1 vout.P32.nSD 2.75526e-05f
Cred_6798 vin.$443.Metal1 vout.P32.pSD 0.0150599f
Cred_6799 vin.$443.Metal1 vout.P34.pSD 2.41222e-07f
Cred_6800 vin.$443.Metal1 VSS.$304.Metal1 5.22497e-07f
Cred_6801 vin.$443.Metal1 VSS.$320.Metal1 2.03321e-07f
Cred_6802 vin.$443.Metal1 VSS.$747.Metal2 3.23307e-06f
Cred_6803 vin.$443.Metal1 VSS.$754.Metal2 9.09302e-07f
Cred_6804 vin.$443.Metal1 VSS.$758.Metal2 4.70936e-07f
Cred_6805 vin.$443.Metal1 VSS.$765.Metal2 1.13809e-06f
Cred_6806 vin.$443.Metal1 VSS.P33.nSD 6.05015e-08f
Cred_6807 vin.$443.Metal1 VSS.P35.nSD 2.35427e-08f
Cred_6808 vin.$446.Metal1 vout.$1080.Metal3 0.00420841f
Cred_6809 vin.$446.Metal1 vout.$1098.Metal3 0.00421836f
Cred_6810 vin.$446.Metal1 vout.P32.nSD 0.0141585f
Cred_6811 vin.$446.Metal1 vout.P32.pSD 6.85767e-05f
Cred_6812 vin.$446.Metal1 vout.P34.nSD 1.58977e-07f
Cred_6813 vin.$446.Metal1 VSS.$14.Metal1 4.99929e-05f
Cred_6814 vin.$446.Metal1 VSS.$29.Metal1 8.41215e-05f
Cred_6815 vin.$446.Metal1 VSS.$304.Metal1 0.00149747f
Cred_6816 vin.$446.Metal1 VSS.$320.Metal1 0.00283005f
Cred_6817 vin.$446.Metal1 VSS.$520.Metal1 0.000697015f
Cred_6818 vin.$446.Metal1 VSS.$747.Metal2 7.3429e-05f
Cred_6819 vin.$446.Metal1 VSS.$754.Metal2 2.37928e-05f
Cred_6820 vin.$446.Metal1 VSS.$758.Metal2 7.97109e-05f
Cred_6821 vin.$446.Metal1 VSS.$765.Metal2 0.000181201f
Cred_6822 vin.$446.Metal1 VSS.P0.pSD 0.0292479f
Cred_6823 vin.$446.Metal1 VSS.P33.nSD 0.000394314f
Cred_6824 vin.$446.Metal1 VSS.P35.nSD 0.000636275f
Cred_6825 vin.$450.Metal1 vout.$1080.Metal3 2.52164e-05f
Cred_6826 vin.$450.Metal1 vout.$1098.Metal3 0.00263303f
Cred_6827 vin.$450.Metal1 vout.P32.nSD 7.66957e-07f
Cred_6828 vin.$450.Metal1 vout.P32.pSD 4.10905e-07f
Cred_6829 vin.$450.Metal1 vout.P34.nSD 0.00500178f
Cred_6830 vin.$450.Metal1 VSS.$14.Metal1 4.36972e-05f
Cred_6831 vin.$450.Metal1 VSS.$29.Metal1 7.35279e-05f
Cred_6832 vin.$450.Metal1 VSS.$320.Metal1 0.0196636f
Cred_6833 vin.$450.Metal1 VSS.$332.Metal1 0.000328388f
Cred_6834 vin.$450.Metal1 VSS.$520.Metal1 0.000804368f
Cred_6835 vin.$450.Metal1 VSS.$758.Metal2 0.000825986f
Cred_6836 vin.$450.Metal1 VSS.$765.Metal2 0.00199785f
Cred_6837 vin.$450.Metal1 VSS.P0.pSD 0.0293192f
Cred_6838 vin.$450.Metal1 VSS.P35.nSD 0.00505045f
Cred_6839 vin.$451.Metal1 vout.$1080.Metal3 0.00165493f
Cred_6840 vin.$451.Metal1 vout.$1098.Metal3 0.00168854f
Cred_6841 vin.$451.Metal1 vout.P32.nSD 9.94123e-06f
Cred_6842 vin.$451.Metal1 vout.P32.pSD 0.00520712f
Cred_6843 vin.$451.Metal1 vout.P34.pSD 1.70972e-06f
Cred_6844 vin.$451.Metal1 VSS.$320.Metal1 1.44109e-06f
Cred_6845 vin.$451.Metal1 VSS.$758.Metal2 3.33786e-06f
Cred_6846 vin.$451.Metal1 VSS.$765.Metal2 8.0665e-06f
Cred_6847 vin.$451.Metal1 VSS.P35.nSD 1.66864e-07f
Cred_6848 vin.$455.Metal1 vout.$1098.Metal3 0.00760096f
Cred_6849 vin.$455.Metal1 vout.P34.pSD 0.0153898f
Cred_6850 vin.$456.Metal1 vout.$1098.Metal3 0.00731892f
Cred_6851 vin.$456.Metal1 vout.P34.nSD 0.0145998f
Cred_6852 vin.$456.Metal1 VSS.$1002.Metal3 5.07128e-08f
Cred_6853 vin.$456.Metal1 VSS.$14.Metal1 3.90912e-05f
Cred_6854 vin.$456.Metal1 VSS.$29.Metal1 6.57775e-05f
Cred_6855 vin.$456.Metal1 VSS.$320.Metal1 0.000694577f
Cred_6856 vin.$456.Metal1 VSS.$332.Metal1 0.00092169f
Cred_6857 vin.$456.Metal1 VSS.$338.Metal1 0.0010716f
Cred_6858 vin.$456.Metal1 VSS.$520.Metal1 0.000902877f
Cred_6859 vin.$456.Metal1 VSS.$765.Metal2 7.89229e-06f
Cred_6860 vin.$456.Metal1 VSS.$773.Metal2 6.588e-05f
Cred_6861 vin.$456.Metal1 VSS.$780.Metal2 1.40478e-05f
Cred_6862 vin.$456.Metal1 VSS.P0.pSD 0.0293218f
Cred_6863 vin.$456.Metal1 VSS.P37.nSD 0.000866593f
Cred_6864 vin.$460.Metal1 vout.$1098.Metal3 0.00145483f
Cred_6865 vin.$460.Metal1 vout.$1116.Metal3 0.00141667f
Cred_6866 vin.$460.Metal1 vout.P34.nSD 5.58477e-06f
Cred_6867 vin.$460.Metal1 vout.P36.nSD 0.00475616f
Cred_6868 vin.$460.Metal1 vout.P36.pSD 2.30849e-05f
Cred_6869 vin.$460.Metal1 VSS.$1002.Metal3 9.78667e-09f
Cred_6870 vin.$460.Metal1 VSS.$14.Metal1 3.28352e-05f
Cred_6871 vin.$460.Metal1 VSS.$29.Metal1 5.52506e-05f
Cred_6872 vin.$460.Metal1 VSS.$332.Metal1 0.000119882f
Cred_6873 vin.$460.Metal1 VSS.$338.Metal1 0.0213919f
Cred_6874 vin.$460.Metal1 VSS.$354.Metal1 0.000225174f
Cred_6875 vin.$460.Metal1 VSS.$520.Metal1 0.00101351f
Cred_6876 vin.$460.Metal1 VSS.$765.Metal2 1.22062e-06f
Cred_6877 vin.$460.Metal1 VSS.$773.Metal2 0.00223984f
Cred_6878 vin.$460.Metal1 VSS.$780.Metal2 0.000545556f
Cred_6879 vin.$460.Metal1 VSS.$784.Metal2 1.18591e-06f
Cred_6880 vin.$460.Metal1 VSS.P0.pSD 0.0283711f
Cred_6881 vin.$460.Metal1 VSS.P37.nSD 0.00421119f
Cred_6882 vin.$461.Metal1 vout.$1098.Metal3 0.00298855f
Cred_6883 vin.$461.Metal1 vout.$1116.Metal3 3.21496e-05f
Cred_6884 vin.$461.Metal1 vout.P34.pSD 0.00529874f
Cred_6885 vin.$461.Metal1 vout.P36.nSD 1.90623e-07f
Cred_6886 vin.$461.Metal1 vout.P36.pSD 3.16875e-06f
Cred_6887 vin.$461.Metal1 VSS.$338.Metal1 9.36233e-07f
Cred_6888 vin.$461.Metal1 VSS.$773.Metal2 5.97853e-06f
Cred_6889 vin.$461.Metal1 VSS.$780.Metal2 1.44934e-06f
Cred_6890 vin.$461.Metal1 VSS.P37.nSD 1.0841e-07f
Cred_6891 vin.$465.Metal1 vout.$1098.Metal3 0.00463355f
Cred_6892 vin.$465.Metal1 vout.$1116.Metal3 0.00462361f
Cred_6893 vin.$465.Metal1 vout.P34.pSD 7.18177e-07f
Cred_6894 vin.$465.Metal1 vout.P36.nSD 2.77477e-05f
Cred_6895 vin.$465.Metal1 vout.P36.pSD 0.0151596f
Cred_6896 vin.$465.Metal1 vout.P38.pSD 2.12882e-07f
Cred_6897 vin.$465.Metal1 VSS.$338.Metal1 5.44321e-07f
Cred_6898 vin.$465.Metal1 VSS.$354.Metal1 1.7951e-07f
Cred_6899 vin.$465.Metal1 VSS.$773.Metal2 3.47589e-06f
Cred_6900 vin.$465.Metal1 VSS.$780.Metal2 8.42639e-07f
Cred_6901 vin.$465.Metal1 VSS.$784.Metal2 4.50215e-07f
Cred_6902 vin.$465.Metal1 VSS.$791.Metal2 9.69695e-07f
Cred_6903 vin.$465.Metal1 VSS.P37.nSD 6.30291e-08f
Cred_6904 vin.$465.Metal1 VSS.P39.nSD 2.07854e-08f
Cred_6905 vin.$468.Metal1 vout.$1098.Metal3 0.00417818f
Cred_6906 vin.$468.Metal1 vout.$1116.Metal3 0.00418696f
Cred_6907 vin.$468.Metal1 vout.P36.nSD 0.0140693f
Cred_6908 vin.$468.Metal1 vout.P36.pSD 6.80841e-05f
Cred_6909 vin.$468.Metal1 vout.P38.nSD 1.40317e-07f
Cred_6910 vin.$468.Metal1 VSS.$14.Metal1 2.96675e-05f
Cred_6911 vin.$468.Metal1 VSS.$29.Metal1 4.99206e-05f
Cred_6912 vin.$468.Metal1 VSS.$338.Metal1 0.00162213f
Cred_6913 vin.$468.Metal1 VSS.$354.Metal1 0.00284468f
Cred_6914 vin.$468.Metal1 VSS.$520.Metal1 0.00115105f
Cred_6915 vin.$468.Metal1 VSS.$773.Metal2 7.36469e-05f
Cred_6916 vin.$468.Metal1 VSS.$780.Metal2 2.14182e-05f
Cred_6917 vin.$468.Metal1 VSS.$784.Metal2 8.09445e-05f
Cred_6918 vin.$468.Metal1 VSS.$791.Metal2 0.000163459f
Cred_6919 vin.$468.Metal1 VSS.P0.pSD 0.0286425f
Cred_6920 vin.$468.Metal1 VSS.P37.nSD 0.00041869f
Cred_6921 vin.$468.Metal1 VSS.P39.nSD 0.000573894f
Cred_6922 vin.$472.Metal1 vout.$1098.Metal3 2.43499e-05f
Cred_6923 vin.$472.Metal1 vout.$1116.Metal3 0.0026266f
Cred_6924 vin.$472.Metal1 vout.P36.nSD 7.38284e-07f
Cred_6925 vin.$472.Metal1 vout.P36.pSD 3.96785e-07f
Cred_6926 vin.$472.Metal1 vout.P38.nSD 0.00493704f
Cred_6927 vin.$472.Metal1 VSS.$14.Metal1 2.5951e-05f
Cred_6928 vin.$472.Metal1 VSS.$29.Metal1 4.36668e-05f
Cred_6929 vin.$472.Metal1 VSS.$354.Metal1 0.0197371f
Cred_6930 vin.$472.Metal1 VSS.$366.Metal1 0.000303693f
Cred_6931 vin.$472.Metal1 VSS.$520.Metal1 0.00132892f
Cred_6932 vin.$472.Metal1 VSS.$784.Metal2 0.000902596f
Cred_6933 vin.$472.Metal1 VSS.$791.Metal2 0.00194582f
Cred_6934 vin.$472.Metal1 VSS.P0.pSD 0.0286365f
Cred_6935 vin.$472.Metal1 VSS.P39.nSD 0.0052302f
Cred_6936 vin.$473.Metal1 vout.$1098.Metal3 0.0016204f
Cred_6937 vin.$473.Metal1 vout.$1116.Metal3 0.00166866f
Cred_6938 vin.$473.Metal1 vout.P36.nSD 9.73385e-06f
Cred_6939 vin.$473.Metal1 vout.P36.pSD 0.00510802f
Cred_6940 vin.$473.Metal1 vout.P38.pSD 2.76014e-06f
Cred_6941 vin.$473.Metal1 VSS.$354.Metal1 1.46675e-06f
Cred_6942 vin.$473.Metal1 VSS.$784.Metal2 3.67865e-06f
Cred_6943 vin.$473.Metal1 VSS.$791.Metal2 7.92324e-06f
Cred_6944 vin.$473.Metal1 VSS.P39.nSD 1.69835e-07f
Cred_6945 vin.$477.Metal1 vout.$1116.Metal3 0.00854913f
Cred_6946 vin.$477.Metal1 vout.P38.pSD 0.0153387f
Cred_6947 vin.$478.Metal1 vout.$1116.Metal3 0.00746508f
Cred_6948 vin.$478.Metal1 vout.P38.nSD 0.0149435f
Cred_6949 vin.$478.Metal1 VSS.$1012.Metal3 5.06565e-08f
Cred_6950 vin.$478.Metal1 VSS.$14.Metal1 2.33427e-05f
Cred_6951 vin.$478.Metal1 VSS.$29.Metal1 3.92781e-05f
Cred_6952 vin.$478.Metal1 VSS.$354.Metal1 0.000700047f
Cred_6953 vin.$478.Metal1 VSS.$366.Metal1 0.000887463f
Cred_6954 vin.$478.Metal1 VSS.$372.Metal1 0.00157538f
Cred_6955 vin.$478.Metal1 VSS.$520.Metal1 0.00150498f
Cred_6956 vin.$478.Metal1 VSS.$791.Metal2 8.02925e-06f
Cred_6957 vin.$478.Metal1 VSS.$799.Metal2 0.000107569f
Cred_6958 vin.$478.Metal1 VSS.$806.Metal2 2.05784e-05f
Cred_6959 vin.$478.Metal1 VSS.P0.pSD 0.0287627f
Cred_6960 vin.$478.Metal1 VSS.P41.nSD 0.000964415f
Cred_6961 vin.$48.GatPoly vout.$972.Metal3 3.7194e-05f
Cred_6962 vin.$48.GatPoly vout.$990.Metal3 0.000988791f
Cred_6963 vin.$48.GatPoly vout.P10.nSD 0.00155781f
Cred_6964 vin.$48.GatPoly vout.P8.nSD 0.000123433f
Cred_6965 vin.$48.GatPoly vout.P8.pSD 6.06082e-07f
Cred_6966 vin.$48.GatPoly VSS.$118.Metal1 0.00356087f
Cred_6967 vin.$48.GatPoly VSS.$14.Metal1 1.56579e-05f
Cred_6968 vin.$48.GatPoly VSS.$29.Metal1 2.6347e-05f
Cred_6969 vin.$48.GatPoly VSS.$520.Metal1 5.67157e-07f
Cred_6970 vin.$48.GatPoly VSS.$602.Metal2 3.92073e-05f
Cred_6971 vin.$48.GatPoly VSS.$609.Metal2 0.000228709f
Cred_6972 vin.$48.GatPoly VSS.P0.pSD 0.000441822f
Cred_6973 vin.$48.GatPoly VSS.P11.nSD 0.000246079f
Cred_6974 vin.$482.Metal1 vout.$1116.Metal3 0.000138997f
Cred_6975 vin.$482.Metal1 vout.P38.nSD 0.0001696f
Cred_6976 vin.$482.Metal1 VSS.$1012.Metal3 1.19734e-08f
Cred_6977 vin.$482.Metal1 VSS.$14.Metal1 1.33965e-05f
Cred_6978 vin.$482.Metal1 VSS.$29.Metal1 2.25418e-05f
Cred_6979 vin.$482.Metal1 VSS.$366.Metal1 0.000140075f
Cred_6980 vin.$482.Metal1 VSS.$372.Metal1 0.0202404f
Cred_6981 vin.$482.Metal1 VSS.$388.Metal1 0.000102753f
Cred_6982 vin.$482.Metal1 VSS.$520.Metal1 0.00108929f
Cred_6983 vin.$482.Metal1 VSS.$791.Metal2 1.49335e-06f
Cred_6984 vin.$482.Metal1 VSS.$799.Metal2 0.00223929f
Cred_6985 vin.$482.Metal1 VSS.$806.Metal2 0.000461978f
Cred_6986 vin.$482.Metal1 VSS.$810.Metal2 5.21823e-07f
Cred_6987 vin.$482.Metal1 VSS.P0.pSD 0.0184478f
Cred_6988 vin.$482.Metal1 VSS.P41.nSD 0.00379303f
Cred_6989 vin.$483.Metal1 vout.$1116.Metal3 0.00302127f
Cred_6990 vin.$483.Metal1 vout.$1134.Metal3 3.51995e-05f
Cred_6991 vin.$483.Metal1 vout.P38.pSD 0.0053823f
Cred_6992 vin.$483.Metal1 vout.P40.nSD 2.06556e-07f
Cred_6993 vin.$483.Metal1 vout.P40.pSD 3.36542e-06f
Cred_6994 vin.$483.Metal1 VSS.$372.Metal1 8.22175e-07f
Cred_6995 vin.$483.Metal1 VSS.$799.Metal2 5.41353e-06f
Cred_6996 vin.$483.Metal1 VSS.$806.Metal2 1.11455e-06f
Cred_6997 vin.$483.Metal1 VSS.P41.nSD 9.52038e-08f
Cred_6998 vin.$486.Metal1 vout.$1116.Metal3 0.00418728f
Cred_6999 vin.$486.Metal1 vout.$1134.Metal3 0.00419103f
Cred_7000 vin.$486.Metal1 vout.P40.nSD 0.0140799f
Cred_7001 vin.$486.Metal1 vout.P40.pSD 6.82324e-05f
Cred_7002 vin.$486.Metal1 vout.P42.nSD 5.99458e-08f
Cred_7003 vin.$486.Metal1 VSS.$14.Metal1 1.82841e-05f
Cred_7004 vin.$486.Metal1 VSS.$29.Metal1 3.07661e-05f
Cred_7005 vin.$486.Metal1 VSS.$372.Metal1 0.00274404f
Cred_7006 vin.$486.Metal1 VSS.$388.Metal1 0.00157349f
Cred_7007 vin.$486.Metal1 VSS.$520.Metal1 0.0018691f
Cred_7008 vin.$486.Metal1 VSS.$799.Metal2 0.000146626f
Cred_7009 vin.$486.Metal1 VSS.$806.Metal2 3.44166e-05f
Cred_7010 vin.$486.Metal1 VSS.$810.Metal2 4.05276e-05f
Cred_7011 vin.$486.Metal1 VSS.$817.Metal2 7.13291e-05f
Cred_7012 vin.$486.Metal1 VSS.P0.pSD 0.0280278f
Cred_7013 vin.$486.Metal1 VSS.P41.nSD 0.000895196f
Cred_7014 vin.$486.Metal1 VSS.P43.nSD 0.00025044f
Cred_7015 vin.$487.Metal1 vout.$1116.Metal3 0.00460707f
Cred_7016 vin.$487.Metal1 vout.$1134.Metal3 0.00459187f
Cred_7017 vin.$487.Metal1 vout.P38.pSD 7.72008e-07f
Cred_7018 vin.$487.Metal1 vout.P40.nSD 2.75804e-05f
Cred_7019 vin.$487.Metal1 vout.P40.pSD 0.0150642f
Cred_7020 vin.$487.Metal1 VSS.$372.Metal1 5.41433e-07f
Cred_7021 vin.$487.Metal1 VSS.$799.Metal2 3.56501e-06f
Cred_7022 vin.$487.Metal1 VSS.$806.Metal2 7.33972e-07f
Cred_7023 vin.$487.Metal1 VSS.P41.nSD 6.26952e-08f
Cred_7024 vin.$49.GatPoly vout.$972.Metal3 0.000303925f
Cred_7025 vin.$49.GatPoly vout.$990.Metal3 0.00606653f
Cred_7026 vin.$49.GatPoly vout.P10.pSD 0.00590601f
Cred_7027 vin.$49.GatPoly vout.P8.nSD 1.8257e-06f
Cred_7028 vin.$49.GatPoly vout.P8.pSD 0.000610584f
Cred_7029 vin.$494.Metal1 vout.$1116.Metal3 0.00142393f
Cred_7030 vin.$494.Metal1 vout.$1134.Metal3 0.00404033f
Cred_7031 vin.$494.Metal1 vout.P40.nSD 0.00473122f
Cred_7032 vin.$494.Metal1 vout.P40.pSD 2.32031e-05f
Cred_7033 vin.$494.Metal1 vout.P42.nSD 0.00488866f
Cred_7034 vin.$494.Metal1 VSS.$14.Metal1 2.10589e-05f
Cred_7035 vin.$494.Metal1 VSS.$29.Metal1 3.54352e-05f
Cred_7036 vin.$494.Metal1 VSS.$372.Metal1 0.000160861f
Cred_7037 vin.$494.Metal1 VSS.$388.Metal1 0.0213367f
Cred_7038 vin.$494.Metal1 VSS.$400.Metal1 0.00028928f
Cred_7039 vin.$494.Metal1 VSS.$520.Metal1 0.0028542f
Cred_7040 vin.$494.Metal1 VSS.$806.Metal2 1.02884e-06f
Cred_7041 vin.$494.Metal1 VSS.$810.Metal2 0.00102548f
Cred_7042 vin.$494.Metal1 VSS.$817.Metal2 0.00197518f
Cred_7043 vin.$494.Metal1 VSS.P0.pSD 0.0367929f
Cred_7044 vin.$494.Metal1 VSS.P43.nSD 0.00561873f
Cred_7045 vin.$495.Metal1 vout.$1116.Metal3 0.00163265f
Cred_7046 vin.$495.Metal1 vout.$1134.Metal3 0.00485337f
Cred_7047 vin.$495.Metal1 vout.P40.nSD 9.80744e-06f
Cred_7048 vin.$495.Metal1 vout.P40.pSD 0.00520808f
Cred_7049 vin.$495.Metal1 vout.P42.pSD 0.00517607f
Cred_7050 vin.$5.GatPoly vout.$954.Metal3 0.0103488f
Cred_7051 vin.$5.GatPoly vout.P0.nSD 3.93208e-05f
Cred_7052 vin.$5.GatPoly vout.P0.pSD 0.00952626f
Cred_7053 vin.$5.GatPoly vout.P2.pSD 0.00166717f
Cred_7054 vin.$5.GatPoly VSS.$29.Metal1 1.02156e-08f
Cred_7055 vin.$5.GatPoly VSS.$531.Metal2 2.04026e-07f
Cred_7056 vin.$5.GatPoly VSS.P0.nSD 7.57373e-11f
Cred_7057 vin.$5.GatPoly VSS.P1.nSD 7.57373e-11f
Cred_7058 vin.$500.Metal1 vout.$1116.Metal3 1.28189e-06f
Cred_7059 vin.$500.Metal1 vout.$1134.Metal3 0.00744668f
Cred_7060 vin.$500.Metal1 vout.P40.nSD 7.70041e-09f
Cred_7061 vin.$500.Metal1 vout.P40.pSD 2.08887e-08f
Cred_7062 vin.$500.Metal1 vout.P42.nSD 0.0149913f
Cred_7063 vin.$500.Metal1 VSS.$1022.Metal3 5.0426e-08f
Cred_7064 vin.$500.Metal1 VSS.$14.Metal1 1.38827e-05f
Cred_7065 vin.$500.Metal1 VSS.$29.Metal1 2.33599e-05f
Cred_7066 vin.$500.Metal1 VSS.$388.Metal1 0.000704839f
Cred_7067 vin.$500.Metal1 VSS.$400.Metal1 0.000853472f
Cred_7068 vin.$500.Metal1 VSS.$406.Metal1 0.00149776f
Cred_7069 vin.$500.Metal1 VSS.$520.Metal1 0.00250804f
Cred_7070 vin.$500.Metal1 VSS.$817.Metal2 8.14475e-06f
Cred_7071 vin.$500.Metal1 VSS.$825.Metal2 0.000114706f
Cred_7072 vin.$500.Metal1 VSS.$832.Metal2 1.841e-05f
Cred_7073 vin.$500.Metal1 VSS.P0.pSD 0.027728f
Cred_7074 vin.$500.Metal1 VSS.P45.nSD 0.00101536f
Cred_7075 vin.$501.Metal1 vout.$1134.Metal3 0.00862877f
Cred_7076 vin.$501.Metal1 vout.P42.pSD 0.0156005f
Cred_7077 vin.$504.Metal1 vout.$1116.Metal3 3.628e-07f
Cred_7078 vin.$504.Metal1 vout.$1134.Metal3 0.000143495f
Cred_7079 vin.$504.Metal1 vout.P40.nSD 2.17936e-09f
Cred_7080 vin.$504.Metal1 vout.P40.pSD 5.91189e-09f
Cred_7081 vin.$504.Metal1 vout.P42.nSD 0.000169123f
Cred_7082 vin.$504.Metal1 VSS.$1022.Metal3 1.42715e-08f
Cred_7083 vin.$504.Metal1 VSS.$14.Metal1 7.97681e-06f
Cred_7084 vin.$504.Metal1 VSS.$29.Metal1 1.34223e-05f
Cred_7085 vin.$504.Metal1 VSS.$400.Metal1 0.000159701f
Cred_7086 vin.$504.Metal1 VSS.$406.Metal1 0.0202196f
Cred_7087 vin.$504.Metal1 VSS.$422.Metal1 0.000103338f
Cred_7088 vin.$504.Metal1 VSS.$520.Metal1 0.00181903f
Cred_7089 vin.$504.Metal1 VSS.$817.Metal2 1.77998e-06f
Cred_7090 vin.$504.Metal1 VSS.$825.Metal2 0.00230404f
Cred_7091 vin.$504.Metal1 VSS.$832.Metal2 0.000395931f
Cred_7092 vin.$504.Metal1 VSS.$836.Metal2 5.05348e-07f
Cred_7093 vin.$504.Metal1 VSS.P0.pSD 0.0177356f
Cred_7094 vin.$504.Metal1 VSS.P45.nSD 0.00378981f
Cred_7095 vin.$505.Metal1 vout.$1134.Metal3 0.000340785f
Cred_7096 vin.$505.Metal1 vout.$1152.Metal3 0.000319069f
Cred_7097 vin.$505.Metal1 vout.P42.pSD 7.18712e-06f
Cred_7098 vin.$505.Metal1 vout.P44.nSD 1.91666e-06f
Cred_7099 vin.$505.Metal1 vout.P44.pSD 0.000666511f
Cred_7100 vin.$508.Metal1 vout.$1134.Metal3 0.00417217f
Cred_7101 vin.$508.Metal1 vout.$1152.Metal3 0.00417535f
Cred_7102 vin.$508.Metal1 vout.P44.nSD 0.0140049f
Cred_7103 vin.$508.Metal1 vout.P44.pSD 6.79862e-05f
Cred_7104 vin.$508.Metal1 vout.P46.nSD 5.07362e-08f
Cred_7105 vin.$508.Metal1 VSS.$14.Metal1 1.08716e-05f
Cred_7106 vin.$508.Metal1 VSS.$29.Metal1 1.82933e-05f
Cred_7107 vin.$508.Metal1 VSS.$406.Metal1 0.00266409f
Cred_7108 vin.$508.Metal1 VSS.$422.Metal1 0.00155976f
Cred_7109 vin.$508.Metal1 VSS.$520.Metal1 0.00312101f
Cred_7110 vin.$508.Metal1 VSS.$825.Metal2 0.000140504f
Cred_7111 vin.$508.Metal1 VSS.$832.Metal2 2.83481e-05f
Cred_7112 vin.$508.Metal1 VSS.$836.Metal2 3.88018e-05f
Cred_7113 vin.$508.Metal1 VSS.$843.Metal2 6.0931e-05f
Cred_7114 vin.$508.Metal1 VSS.P0.pSD 0.0267946f
Cred_7115 vin.$508.Metal1 VSS.P45.nSD 0.000938149f
Cred_7116 vin.$508.Metal1 VSS.P47.nSD 0.000216408f
Cred_7117 vin.$509.Metal1 vout.$1134.Metal3 0.00510917f
Cred_7118 vin.$509.Metal1 vout.$1152.Metal3 0.00510917f
Cred_7119 vin.$509.Metal1 vout.P44.nSD 3.0691e-05f
Cred_7120 vin.$509.Metal1 vout.P44.pSD 0.0161589f
Cred_7121 vin.$516.Metal1 vout.$1134.Metal3 0.0014452f
Cred_7122 vin.$516.Metal1 vout.$1152.Metal3 0.00407574f
Cred_7123 vin.$516.Metal1 vout.P44.nSD 0.00480046f
Cred_7124 vin.$516.Metal1 vout.P44.pSD 2.35498e-05f
Cred_7125 vin.$516.Metal1 vout.P46.nSD 0.00483978f
Cred_7126 vin.$516.Metal1 VSS.$14.Metal1 1.21203e-05f
Cred_7127 vin.$516.Metal1 VSS.$29.Metal1 2.03945e-05f
Cred_7128 vin.$516.Metal1 VSS.$406.Metal1 0.00016974f
Cred_7129 vin.$516.Metal1 VSS.$422.Metal1 0.0222073f
Cred_7130 vin.$516.Metal1 VSS.$434.Metal1 0.000284189f
Cred_7131 vin.$516.Metal1 VSS.$520.Metal1 0.00463068f
Cred_7132 vin.$516.Metal1 VSS.$832.Metal2 1.11757e-06f
Cred_7133 vin.$516.Metal1 VSS.$836.Metal2 0.00114209f
Cred_7134 vin.$516.Metal1 VSS.$843.Metal2 0.00197741f
Cred_7135 vin.$516.Metal1 VSS.P0.pSD 0.0338754f
Cred_7136 vin.$516.Metal1 VSS.P47.nSD 0.00575668f
Cred_7137 vin.$517.Metal1 vout.$1134.Metal3 0.00165311f
Cred_7138 vin.$517.Metal1 vout.$1152.Metal3 0.0049159f
Cred_7139 vin.$517.Metal1 vout.P44.nSD 9.93029e-06f
Cred_7140 vin.$517.Metal1 vout.P44.pSD 0.00525863f
Cred_7141 vin.$517.Metal1 vout.P46.pSD 0.0050933f
Cred_7142 vin.$52.GatPoly vout.$990.Metal3 0.00102218f
Cred_7143 vin.$52.GatPoly vout.P10.nSD 0.00168068f
Cred_7144 vin.$52.GatPoly VSS.$128.Metal1 3.43463e-06f
Cred_7145 vin.$52.GatPoly VSS.$136.Metal1 0.00257487f
Cred_7146 vin.$52.GatPoly VSS.$14.Metal1 1.17399e-05f
Cred_7147 vin.$52.GatPoly VSS.$29.Metal1 1.97544e-05f
Cred_7148 vin.$52.GatPoly VSS.$520.Metal1 6.96903e-07f
Cred_7149 vin.$52.GatPoly VSS.$617.Metal2 0.000127102f
Cred_7150 vin.$52.GatPoly VSS.$624.Metal2 6.58931e-05f
Cred_7151 vin.$52.GatPoly VSS.P0.pSD 0.000431911f
Cred_7152 vin.$52.GatPoly VSS.P13.nSD 0.000177367f
Cred_7153 vin.$522.Metal1 vout.$1152.Metal3 0.00724222f
Cred_7154 vin.$522.Metal1 vout.P46.nSD 0.0147516f
Cred_7155 vin.$522.Metal1 VSS.$1028.Metal3 2.46165e-08f
Cred_7156 vin.$522.Metal1 VSS.$1036.Metal3 2.46165e-08f
Cred_7157 vin.$522.Metal1 VSS.$14.Metal1 8.18637e-06f
Cred_7158 vin.$522.Metal1 VSS.$29.Metal1 1.37749e-05f
Cred_7159 vin.$522.Metal1 VSS.$422.Metal1 0.000709934f
Cred_7160 vin.$522.Metal1 VSS.$434.Metal1 0.000820126f
Cred_7161 vin.$522.Metal1 VSS.$440.Metal1 0.000839763f
Cred_7162 vin.$522.Metal1 VSS.$520.Metal1 0.00417334f
Cred_7163 vin.$522.Metal1 VSS.$843.Metal2 8.24173e-06f
Cred_7164 vin.$522.Metal1 VSS.$851.Metal2 8.30693e-05f
Cred_7165 vin.$522.Metal1 VSS.$858.Metal2 1.0562e-05f
Cred_7166 vin.$522.Metal1 VSS.P0.pSD 0.0259682f
Cred_7167 vin.$522.Metal1 VSS.P49.nSD 0.00101956f
Cred_7168 vin.$523.Metal1 vout.$1152.Metal3 0.00867664f
Cred_7169 vin.$523.Metal1 vout.P46.pSD 0.0156497f
Cred_7170 vin.$526.Metal1 vout.$1152.Metal3 0.00140206f
Cred_7171 vin.$526.Metal1 vout.$1170.Metal3 0.00135603f
Cred_7172 vin.$526.Metal1 vout.P46.nSD 5.24806e-06f
Cred_7173 vin.$526.Metal1 vout.P48.nSD 0.00453699f
Cred_7174 vin.$526.Metal1 vout.P48.pSD 2.20967e-05f
Cred_7175 vin.$526.Metal1 VSS.$1028.Metal3 8.20551e-09f
Cred_7176 vin.$526.Metal1 VSS.$1036.Metal3 8.20551e-09f
Cred_7177 vin.$526.Metal1 VSS.$14.Metal1 6.88883e-06f
Cred_7178 vin.$526.Metal1 VSS.$29.Metal1 1.15916e-05f
Cred_7179 vin.$526.Metal1 VSS.$434.Metal1 0.000178725f
Cred_7180 vin.$526.Metal1 VSS.$440.Metal1 0.0211977f
Cred_7181 vin.$526.Metal1 VSS.$456.Metal1 0.000225941f
Cred_7182 vin.$526.Metal1 VSS.$520.Metal1 0.00472139f
Cred_7183 vin.$526.Metal1 VSS.$843.Metal2 2.07978e-06f
Cred_7184 vin.$526.Metal1 VSS.$851.Metal2 0.00242392f
Cred_7185 vin.$526.Metal1 VSS.$858.Metal2 0.000339147f
Cred_7186 vin.$526.Metal1 VSS.$862.Metal2 1.06238e-06f
Cred_7187 vin.$526.Metal1 VSS.P0.pSD 0.0247787f
Cred_7188 vin.$526.Metal1 VSS.P49.nSD 0.00426491f
Cred_7189 vin.$527.Metal1 vout.$1152.Metal3 0.000342839f
Cred_7190 vin.$527.Metal1 vout.$1170.Metal3 0.000319069f
Cred_7191 vin.$527.Metal1 vout.P46.pSD 7.74098e-06f
Cred_7192 vin.$527.Metal1 vout.P48.nSD 1.91666e-06f
Cred_7193 vin.$527.Metal1 vout.P48.pSD 0.000666511f
Cred_7194 vin.$53.GatPoly vout.$990.Metal3 0.0050874f
Cred_7195 vin.$53.GatPoly vout.P10.pSD 0.00540855f
Cred_7196 vin.$531.Metal1 vout.$1152.Metal3 0.00510815f
Cred_7197 vin.$531.Metal1 vout.$1170.Metal3 0.00510815f
Cred_7198 vin.$531.Metal1 vout.P48.nSD 3.06849e-05f
Cred_7199 vin.$531.Metal1 vout.P48.pSD 0.0161219f
Cred_7200 vin.$534.Metal1 vout.$1152.Metal3 0.00377642f
Cred_7201 vin.$534.Metal1 vout.$1170.Metal3 0.00378169f
Cred_7202 vin.$534.Metal1 vout.P48.nSD 0.0142488f
Cred_7203 vin.$534.Metal1 vout.P48.pSD 6.15373e-05f
Cred_7204 vin.$534.Metal1 vout.P50.nSD 8.4284e-08f
Cred_7205 vin.$534.Metal1 VSS.$14.Metal1 6.15599e-06f
Cred_7206 vin.$534.Metal1 VSS.$29.Metal1 1.03585e-05f
Cred_7207 vin.$534.Metal1 VSS.$440.Metal1 0.00153128f
Cred_7208 vin.$534.Metal1 VSS.$456.Metal1 0.00270056f
Cred_7209 vin.$534.Metal1 VSS.$520.Metal1 0.00533239f
Cred_7210 vin.$534.Metal1 VSS.$851.Metal2 6.44862e-05f
Cred_7211 vin.$534.Metal1 VSS.$858.Metal2 1.28882e-05f
Cred_7212 vin.$534.Metal1 VSS.$862.Metal2 7.25013e-05f
Cred_7213 vin.$534.Metal1 VSS.$869.Metal2 0.000104313f
Cred_7214 vin.$534.Metal1 VSS.P0.pSD 0.0243989f
Cred_7215 vin.$534.Metal1 VSS.P49.nSD 0.000482409f
Cred_7216 vin.$534.Metal1 VSS.P51.nSD 0.000366895f
Cred_7217 vin.$538.Metal1 vout.$1152.Metal3 2.21257e-05f
Cred_7218 vin.$538.Metal1 vout.$1170.Metal3 0.002655f
Cred_7219 vin.$538.Metal1 vout.P48.nSD 6.85438e-07f
Cred_7220 vin.$538.Metal1 vout.P48.pSD 3.60541e-07f
Cred_7221 vin.$538.Metal1 vout.P50.nSD 0.00477896f
Cred_7222 vin.$538.Metal1 VSS.$14.Metal1 5.23903e-06f
Cred_7223 vin.$538.Metal1 VSS.$29.Metal1 8.81555e-06f
Cred_7224 vin.$538.Metal1 VSS.$456.Metal1 0.0206318f
Cred_7225 vin.$538.Metal1 VSS.$468.Metal1 0.000279266f
Cred_7226 vin.$538.Metal1 VSS.$520.Metal1 0.00608471f
Cred_7227 vin.$538.Metal1 VSS.$862.Metal2 0.00118019f
Cred_7228 vin.$538.Metal1 VSS.$869.Metal2 0.0018462f
Cred_7229 vin.$538.Metal1 VSS.P0.pSD 0.0233583f
Cred_7230 vin.$538.Metal1 VSS.P1.GatPoly 4.59859e-05f
Cred_7231 vin.$538.Metal1 VSS.P51.nSD 0.0055722f
Cred_7232 vin.$539.Metal1 vout.$1152.Metal3 0.00167216f
Cred_7233 vin.$539.Metal1 vout.$1170.Metal3 0.00497171f
Cred_7234 vin.$539.Metal1 vout.P48.nSD 1.00447e-05f
Cred_7235 vin.$539.Metal1 vout.P48.pSD 0.00528775f
Cred_7236 vin.$539.Metal1 vout.P50.pSD 0.00553096f
Cred_7237 vin.$544.Metal1 vout.$1170.Metal3 0.00739207f
Cred_7238 vin.$544.Metal1 vout.P50.nSD 0.015086f
Cred_7239 vin.$544.Metal1 VSS.$1042.Metal3 4.90491e-08f
Cred_7240 vin.$544.Metal1 VSS.$14.Metal1 4.84728e-06f
Cred_7241 vin.$544.Metal1 VSS.$29.Metal1 8.15636e-06f
Cred_7242 vin.$544.Metal1 VSS.$456.Metal1 0.000714862f
Cred_7243 vin.$544.Metal1 VSS.$468.Metal1 0.000787225f
Cred_7244 vin.$544.Metal1 VSS.$474.Metal1 0.00135289f
Cred_7245 vin.$544.Metal1 VSS.$520.Metal1 0.00712844f
Cred_7246 vin.$544.Metal1 VSS.$869.Metal2 8.26824e-06f
Cred_7247 vin.$544.Metal1 VSS.$877.Metal2 0.000128281f
Cred_7248 vin.$544.Metal1 VSS.$884.Metal2 1.31449e-05f
Cred_7249 vin.$544.Metal1 VSS.P0.pSD 0.0236855f
Cred_7250 vin.$544.Metal1 VSS.P1.GatPoly 0.000260634f
Cred_7251 vin.$544.Metal1 VSS.P53.nSD 0.00109806f
Cred_7252 vin.$545.Metal1 vout.$1170.Metal3 0.00984841f
Cred_7253 vin.$545.Metal1 vout.P50.pSD 0.0163093f
Cred_7254 vin.$548.Metal1 vout 0.011216f
Cred_7255 vin.$548.Metal1 vout.$1170.Metal3 0.000148244f
Cred_7256 vin.$548.Metal1 vout.P50.nSD 0.000168595f
Cred_7257 vin.$548.Metal1 vout.P52.nSD 0.0178066f
Cred_7258 vin.$548.Metal1 VSS.$1042.Metal3 1.90191e-08f
Cred_7259 vin.$548.Metal1 VSS.$1048.Metal3 8.64741e-07f
Cred_7260 vin.$548.Metal1 VSS.$14.Metal1 9.34134e-06f
Cred_7261 vin.$548.Metal1 VSS.$29.Metal1 1.57184e-05f
Cred_7262 vin.$548.Metal1 VSS.$468.Metal1 0.00019711f
Cred_7263 vin.$548.Metal1 VSS.$474.Metal1 0.0215177f
Cred_7264 vin.$548.Metal1 VSS.$486.Metal1 0.00266126f
Cred_7265 vin.$548.Metal1 VSS.$496.Metal1 0.000386098f
Cred_7266 vin.$548.Metal1 VSS.$500.Metal1 0.0198733f
Cred_7267 vin.$548.Metal1 VSS.$520.Metal1 0.0249921f
Cred_7268 vin.$548.Metal1 VSS.$869.Metal2 2.37211e-06f
Cred_7269 vin.$548.Metal1 VSS.$877.Metal2 0.00255466f
Cred_7270 vin.$548.Metal1 VSS.$884.Metal2 0.000385719f
Cred_7271 vin.$548.Metal1 VSS.$895.Metal2 0.000101937f
Cred_7272 vin.$548.Metal1 VSS.$904.Metal2 0.00169712f
Cred_7273 vin.$548.Metal1 VSS.P0.pSD 0.0552952f
Cred_7274 vin.$548.Metal1 VSS.P1.GatPoly 0.00362208f
Cred_7275 vin.$548.Metal1 VSS.P53.nSD 0.00476678f
Cred_7276 vin.$548.Metal1 VSS.P55.nSD 0.00180989f
Cred_7277 vin.$548.Metal1 VSS.P57.nSD 0.000206927f
Cred_7278 vin.$549.Metal1 vout 0.0147834f
Cred_7279 vin.$549.Metal1 vout.$1170.Metal3 0.000695108f
Cred_7280 vin.$549.Metal1 vout.P50.pSD 0.00066949f
Cred_7281 vin.$549.Metal1 vout.P52.pSD 0.0211262f
Cred_7282 vin.$549.Metal1 VSS.$500.Metal1 3.1467e-06f
Cred_7283 vin.$549.Metal1 VSS.$904.Metal2 6.28461e-05f
Cred_7284 vin.$549.Metal1 VSS.P55.nSD 2.33294e-08f
Cred_7285 vin.$549.Metal1 VSS.P57.nSD 2.33294e-08f
Cred_7286 vin.$564.Metal2 vout.$954.Metal3 0.0655071f
Cred_7287 vin.$564.Metal2 vout.P0.nSD 0.0124036f
Cred_7288 vin.$564.Metal2 vout.P0.pSD 0.000766906f
Cred_7289 vin.$564.Metal2 vout.P2.nSD 3.46252e-05f
Cred_7290 vin.$564.Metal2 VSS.$14.Metal1 0.00202134f
Cred_7291 vin.$564.Metal2 VSS.$29.Metal1 0.00665859f
Cred_7292 vin.$564.Metal2 VSS.$31.Metal1 3.22588e-05f
Cred_7293 vin.$564.Metal2 VSS.$42.Metal1 0.000233461f
Cred_7294 vin.$564.Metal2 VSS.$50.Metal1 0.00136372f
Cred_7295 vin.$564.Metal2 VSS.$520.Metal1 6.35417e-06f
Cred_7296 vin.$564.Metal2 VSS.$531.Metal2 0.0270128f
Cred_7297 vin.$564.Metal2 VSS.$540.Metal2 0.00314551f
Cred_7298 vin.$564.Metal2 VSS.$550.Metal2 0.00528853f
Cred_7299 vin.$564.Metal2 VSS.$557.Metal2 0.0108428f
Cred_7300 vin.$564.Metal2 VSS.$916.Metal3 2.66837e-05f
Cred_7301 vin.$564.Metal2 VSS.P0.GatPoly 0.000249047f
Cred_7302 vin.$564.Metal2 VSS.P0.nSD 2.98856e-05f
Cred_7303 vin.$564.Metal2 VSS.P0.pSD 0.0133842f
Cred_7304 vin.$564.Metal2 VSS.P1.nSD 0.000184186f
Cred_7305 vin.$564.Metal2 VSS.P3.nSD 0.000196771f
Cred_7306 vin.$566.Metal2 vout.$954.Metal3 0.0689218f
Cred_7307 vin.$566.Metal2 vout.P0.nSD 0.000277726f
Cred_7308 vin.$566.Metal2 vout.P0.pSD 0.0161356f
Cred_7309 vin.$566.Metal2 vout.P2.pSD 0.00114153f
Cred_7310 vin.$566.Metal2 VSS.$14.Metal1 1.11611e-05f
Cred_7311 vin.$566.Metal2 VSS.$29.Metal1 8.88196e-05f
Cred_7312 vin.$566.Metal2 VSS.$50.Metal1 7.48983e-05f
Cred_7313 vin.$566.Metal2 VSS.$520.Metal1 2.81823e-08f
Cred_7314 vin.$566.Metal2 VSS.$531.Metal2 0.00139883f
Cred_7315 vin.$566.Metal2 VSS.$550.Metal2 5.8177e-05f
Cred_7316 vin.$566.Metal2 VSS.$557.Metal2 0.000538137f
Cred_7317 vin.$566.Metal2 VSS.P0.nSD 5.19264e-07f
Cred_7318 vin.$566.Metal2 VSS.P0.pSD 6.44019e-05f
Cred_7319 vin.$566.Metal2 VSS.P1.nSD 5.19264e-07f
Cred_7320 vin.$566.Metal2 VSS.P3.nSD 8.67313e-06f
Cred_7321 vin.$569.Metal2 vout.$954.Metal3 0.028168f
Cred_7322 vin.$569.Metal2 vout.P0.nSD 0.000185829f
Cred_7323 vin.$569.Metal2 vout.P0.pSD 6.43386e-05f
Cred_7324 vin.$569.Metal2 vout.P2.nSD 0.00187198f
Cred_7325 vin.$569.Metal2 VSS.$14.Metal1 0.000574549f
Cred_7326 vin.$569.Metal2 VSS.$29.Metal1 0.00105291f
Cred_7327 vin.$569.Metal2 VSS.$31.Metal1 1.67626e-06f
Cred_7328 vin.$569.Metal2 VSS.$42.Metal1 1.1553e-05f
Cred_7329 vin.$569.Metal2 VSS.$50.Metal1 0.00214778f
Cred_7330 vin.$569.Metal2 VSS.$520.Metal1 3.23426e-06f
Cred_7331 vin.$569.Metal2 VSS.$531.Metal2 4.90382e-06f
Cred_7332 vin.$569.Metal2 VSS.$540.Metal2 1.54874e-07f
Cred_7333 vin.$569.Metal2 VSS.$550.Metal2 0.00295029f
Cred_7334 vin.$569.Metal2 VSS.$557.Metal2 0.0220464f
Cred_7335 vin.$569.Metal2 VSS.$565.Metal2 0.000965332f
Cred_7336 vin.$569.Metal2 VSS.$572.Metal2 4.74005e-05f
Cred_7337 vin.$569.Metal2 VSS.$60.Metal1 9.95626e-06f
Cred_7338 vin.$569.Metal2 VSS.$68.Metal1 7.99371e-06f
Cred_7339 vin.$569.Metal2 VSS.$916.Metal3 1.31381e-09f
Cred_7340 vin.$569.Metal2 VSS.$922.Metal3 7.146e-06f
Cred_7341 vin.$569.Metal2 VSS.P0.GatPoly 1.50766e-05f
Cred_7342 vin.$569.Metal2 VSS.P0.nSD 8.97231e-07f
Cred_7343 vin.$569.Metal2 VSS.P0.pSD 0.00554069f
Cred_7344 vin.$569.Metal2 VSS.P1.nSD 7.85473e-06f
Cred_7345 vin.$569.Metal2 VSS.P3.nSD 0.000261478f
Cred_7346 vin.$569.Metal2 VSS.P5.nSD 9.25454e-07f
Cred_7347 vin.$573.Metal2 vout.$954.Metal3 0.0681335f
Cred_7348 vin.$573.Metal2 vout.$972.Metal3 0.00056316f
Cred_7349 vin.$573.Metal2 vout.P0.nSD 2.59095e-05f
Cred_7350 vin.$573.Metal2 vout.P0.pSD 0.00069355f
Cred_7351 vin.$573.Metal2 vout.P2.nSD 3.47165e-05f
Cred_7352 vin.$573.Metal2 vout.P2.pSD 0.0114858f
Cred_7353 vin.$573.Metal2 vout.P4.nSD 3.38293e-06f
Cred_7354 vin.$573.Metal2 vout.P4.pSD 9.17678e-06f
Cred_7355 vin.$573.Metal2 VSS.$14.Metal1 0.000459424f
Cred_7356 vin.$573.Metal2 VSS.$29.Metal1 0.000773058f
Cred_7357 vin.$573.Metal2 VSS.$50.Metal1 6.22517e-05f
Cred_7358 vin.$573.Metal2 VSS.$520.Metal1 2.896e-06f
Cred_7359 vin.$573.Metal2 VSS.$550.Metal2 6.48683e-05f
Cred_7360 vin.$573.Metal2 VSS.$557.Metal2 0.000600032f
Cred_7361 vin.$573.Metal2 VSS.$565.Metal2 0.000243204f
Cred_7362 vin.$573.Metal2 VSS.$572.Metal2 0.000155651f
Cred_7363 vin.$573.Metal2 VSS.$68.Metal1 2.62492e-05f
Cred_7364 vin.$573.Metal2 VSS.P0.pSD 0.00476697f
Cred_7365 vin.$573.Metal2 VSS.P3.nSD 7.20854e-06f
Cred_7366 vin.$573.Metal2 VSS.P5.nSD 3.03894e-06f
Cred_7367 vin.$574.Metal2 vout.$954.Metal3 0.0511089f
Cred_7368 vin.$574.Metal2 vout.$972.Metal3 0.0012751f
Cred_7369 vin.$574.Metal2 vout.P0.nSD 2.59447e-06f
Cred_7370 vin.$574.Metal2 vout.P0.pSD 6.96807e-06f
Cred_7371 vin.$574.Metal2 vout.P2.nSD 0.0077443f
Cred_7372 vin.$574.Metal2 vout.P4.nSD 3.95018e-05f
Cred_7373 vin.$574.Metal2 vout.P4.pSD 2.0778e-05f
Cred_7374 vin.$574.Metal2 VSS.$14.Metal1 0.000716692f
Cred_7375 vin.$574.Metal2 VSS.$29.Metal1 0.00120595f
Cred_7376 vin.$574.Metal2 VSS.$50.Metal1 1.35066e-05f
Cred_7377 vin.$574.Metal2 VSS.$520.Metal1 4.51148e-06f
Cred_7378 vin.$574.Metal2 VSS.$550.Metal2 1.96825e-05f
Cred_7379 vin.$574.Metal2 VSS.$557.Metal2 0.000182063f
Cred_7380 vin.$574.Metal2 VSS.$565.Metal2 0.0122599f
Cred_7381 vin.$574.Metal2 VSS.$572.Metal2 0.00784631f
Cred_7382 vin.$574.Metal2 VSS.$60.Metal1 5.11298e-06f
Cred_7383 vin.$574.Metal2 VSS.$68.Metal1 0.00165911f
Cred_7384 vin.$574.Metal2 VSS.P0.pSD 0.00741324f
Cred_7385 vin.$574.Metal2 VSS.P3.nSD 1.56397e-06f
Cred_7386 vin.$574.Metal2 VSS.P5.nSD 0.000994624f
Cred_7387 vin.$577.Metal2 vout.$954.Metal3 0.0123014f
Cred_7388 vin.$577.Metal2 vout.$972.Metal3 0.0025096f
Cred_7389 vin.$577.Metal2 vout.P2.pSD 0.00241748f
Cred_7390 vin.$577.Metal2 vout.P4.nSD 1.50753e-05f
Cred_7391 vin.$577.Metal2 vout.P4.pSD 0.000238902f
Cred_7392 vin.$577.Metal2 VSS.$565.Metal2 0.000805197f
Cred_7393 vin.$577.Metal2 VSS.$572.Metal2 0.000515326f
Cred_7394 vin.$577.Metal2 VSS.$68.Metal1 0.000167126f
Cred_7395 vin.$577.Metal2 VSS.P5.nSD 1.93512e-05f
Cred_7396 vin.$578.Metal2 vout.$954.Metal3 0.0293169f
Cred_7397 vin.$578.Metal2 vout.$972.Metal3 0.0273238f
Cred_7398 vin.$578.Metal2 vout.P2.nSD 3.18422e-05f
Cred_7399 vin.$578.Metal2 vout.P4.nSD 0.0110802f
Cred_7400 vin.$578.Metal2 vout.P4.pSD 0.000445245f
Cred_7401 vin.$578.Metal2 VSS.$14.Metal1 0.000501597f
Cred_7402 vin.$578.Metal2 VSS.$29.Metal1 0.000844021f
Cred_7403 vin.$578.Metal2 VSS.$520.Metal1 5.1083e-06f
Cred_7404 vin.$578.Metal2 VSS.$565.Metal2 0.00948368f
Cred_7405 vin.$578.Metal2 VSS.$572.Metal2 0.00898871f
Cred_7406 vin.$578.Metal2 VSS.$576.Metal2 7.01759e-08f
Cred_7407 vin.$578.Metal2 VSS.$583.Metal2 4.31614e-07f
Cred_7408 vin.$578.Metal2 VSS.$68.Metal1 0.00162644f
Cred_7409 vin.$578.Metal2 VSS.$84.Metal1 7.87373e-06f
Cred_7410 vin.$578.Metal2 VSS.P0.pSD 0.00690866f
Cred_7411 vin.$578.Metal2 VSS.P5.nSD 0.000992272f
Cred_7412 vin.$578.Metal2 VSS.P7.nSD 3.22882e-06f
Cred_7413 vin.$579.Metal2 vout.$954.Metal3 0.0253293f
Cred_7414 vin.$579.Metal2 vout.$972.Metal3 0.0244179f
Cred_7415 vin.$579.Metal2 vout.P4.nSD 0.00014668f
Cred_7416 vin.$579.Metal2 vout.P4.pSD 0.0137831f
Cred_7417 vin.$58.GatPoly vout.$1008.Metal3 0.000470552f
Cred_7418 vin.$58.GatPoly vout.$990.Metal3 0.000545769f
Cred_7419 vin.$58.GatPoly vout.P10.nSD 0.00012321f
Cred_7420 vin.$58.GatPoly vout.P12.nSD 0.00156064f
Cred_7421 vin.$58.GatPoly vout.P12.pSD 7.66771e-06f
Cred_7422 vin.$58.GatPoly VSS.$136.Metal1 0.00356102f
Cred_7423 vin.$58.GatPoly VSS.$14.Metal1 1.21154e-05f
Cred_7424 vin.$58.GatPoly VSS.$29.Metal1 2.03862e-05f
Cred_7425 vin.$58.GatPoly VSS.$520.Metal1 7.35147e-07f
Cred_7426 vin.$58.GatPoly VSS.$617.Metal2 0.000176323f
Cred_7427 vin.$58.GatPoly VSS.$624.Metal2 9.14267e-05f
Cred_7428 vin.$58.GatPoly VSS.P0.pSD 0.000451157f
Cred_7429 vin.$58.GatPoly VSS.P13.nSD 0.000246097f
Cred_7430 vin.$581.Metal2 vout.$954.Metal3 0.0781209f
Cred_7431 vin.$581.Metal2 vout.$972.Metal3 0.0441409f
Cred_7432 vin.$581.Metal2 vout.P0.nSD 1.32754e-05f
Cred_7433 vin.$581.Metal2 vout.P0.pSD 3.56544e-05f
Cred_7434 vin.$581.Metal2 vout.P2.nSD 9.88659e-05f
Cred_7435 vin.$581.Metal2 vout.P4.nSD 0.000272426f
Cred_7436 vin.$581.Metal2 vout.P4.pSD 0.000733751f
Cred_7437 vin.$581.Metal2 VSS.$14.Metal1 0.0039584f
Cred_7438 vin.$581.Metal2 VSS.$29.Metal1 0.00666068f
Cred_7439 vin.$581.Metal2 VSS.$50.Metal1 6.91106e-05f
Cred_7440 vin.$581.Metal2 VSS.$520.Metal1 3.64053e-05f
Cred_7441 vin.$581.Metal2 VSS.$550.Metal2 0.000100712f
Cred_7442 vin.$581.Metal2 VSS.$557.Metal2 0.000931584f
Cred_7443 vin.$581.Metal2 VSS.$565.Metal2 0.00233057f
Cred_7444 vin.$581.Metal2 VSS.$572.Metal2 0.00149157f
Cred_7445 vin.$581.Metal2 VSS.$576.Metal2 0.000318497f
Cred_7446 vin.$581.Metal2 VSS.$583.Metal2 0.00229318f
Cred_7447 vin.$581.Metal2 VSS.$68.Metal1 0.000271064f
Cred_7448 vin.$581.Metal2 VSS.$84.Metal1 0.000183338f
Cred_7449 vin.$581.Metal2 VSS.P0.pSD 0.0510554f
Cred_7450 vin.$581.Metal2 VSS.P3.nSD 8.00255e-06f
Cred_7451 vin.$581.Metal2 VSS.P5.nSD 3.13824e-05f
Cred_7452 vin.$581.Metal2 VSS.P7.nSD 2.12289e-05f
Cred_7453 vin.$583.Metal2 vout.$954.Metal3 0.00623168f
Cred_7454 vin.$583.Metal2 vout.$972.Metal3 0.0194911f
Cred_7455 vin.$583.Metal2 vout.P4.nSD 0.000220518f
Cred_7456 vin.$583.Metal2 vout.P4.pSD 0.000101546f
Cred_7457 vin.$583.Metal2 vout.P6.nSD 0.00108986f
Cred_7458 vin.$583.Metal2 VSS.$14.Metal1 0.000264216f
Cred_7459 vin.$583.Metal2 VSS.$29.Metal1 0.000444587f
Cred_7460 vin.$583.Metal2 VSS.$520.Metal1 3.60849e-06f
Cred_7461 vin.$583.Metal2 VSS.$572.Metal2 9.58395e-09f
Cred_7462 vin.$583.Metal2 VSS.$576.Metal2 0.00364318f
Cred_7463 vin.$583.Metal2 VSS.$583.Metal2 0.0266242f
Cred_7464 vin.$583.Metal2 VSS.$591.Metal2 0.000393455f
Cred_7465 vin.$583.Metal2 VSS.$68.Metal1 2.03826e-06f
Cred_7466 vin.$583.Metal2 VSS.$84.Metal1 0.00310132f
Cred_7467 vin.$583.Metal2 VSS.$932.Metal3 3.15463e-06f
Cred_7468 vin.$583.Metal2 VSS.$94.Metal1 4.40001e-06f
Cred_7469 vin.$583.Metal2 VSS.P0.pSD 0.00429615f
Cred_7470 vin.$583.Metal2 VSS.P7.nSD 0.000373034f
Cred_7471 vin.$584.Metal2 vout.$954.Metal3 0.00680418f
Cred_7472 vin.$584.Metal2 vout.$972.Metal3 0.0158907f
Cred_7473 vin.$584.Metal2 vout.P4.nSD 4.00249e-05f
Cred_7474 vin.$584.Metal2 vout.P4.pSD 0.000709567f
Cred_7475 vin.$584.Metal2 vout.P6.pSD 0.00167165f
Cred_7476 vin.$584.Metal2 VSS.$576.Metal2 0.00012644f
Cred_7477 vin.$584.Metal2 VSS.$583.Metal2 0.000910365f
Cred_7478 vin.$584.Metal2 VSS.$84.Metal1 0.000130351f
Cred_7479 vin.$584.Metal2 VSS.P7.nSD 1.50943e-05f
Cred_7480 vin.$588.Metal2 vout.$972.Metal3 0.0931651f
Cred_7481 vin.$588.Metal2 vout.P6.nSD 0.000602542f
Cred_7482 vin.$588.Metal2 VSS.$102.Metal1 0.000165651f
Cred_7483 vin.$588.Metal2 VSS.$14.Metal1 0.00219918f
Cred_7484 vin.$588.Metal2 VSS.$29.Metal1 0.00370049f
Cred_7485 vin.$588.Metal2 VSS.$520.Metal1 3.93557e-05f
Cred_7486 vin.$588.Metal2 VSS.$576.Metal2 0.00055209f
Cred_7487 vin.$588.Metal2 VSS.$583.Metal2 0.00407612f
Cred_7488 vin.$588.Metal2 VSS.$591.Metal2 0.00186905f
Cred_7489 vin.$588.Metal2 VSS.$598.Metal2 0.00101999f
Cred_7490 vin.$588.Metal2 VSS.$84.Metal1 0.000330217f
Cred_7491 vin.$588.Metal2 VSS.$932.Metal3 8.10356e-07f
Cred_7492 vin.$588.Metal2 VSS.$94.Metal1 1.13027e-06f
Cred_7493 vin.$588.Metal2 VSS.P0.pSD 0.041898f
Cred_7494 vin.$588.Metal2 VSS.P10.nSD 1.91775e-05f
Cred_7495 vin.$588.Metal2 VSS.P7.nSD 3.87869e-05f
Cred_7496 vin.$589.Metal2 vout.$954.Metal3 0.000578474f
Cred_7497 vin.$589.Metal2 vout.$972.Metal3 0.0491016f
Cred_7498 vin.$589.Metal2 vout.$990.Metal3 0.000548242f
Cred_7499 vin.$589.Metal2 vout.P4.nSD 3.47493e-06f
Cred_7500 vin.$589.Metal2 vout.P4.pSD 9.42633e-06f
Cred_7501 vin.$589.Metal2 vout.P6.pSD 0.0108346f
Cred_7502 vin.$589.Metal2 vout.P8.nSD 3.29332e-06f
Cred_7503 vin.$589.Metal2 vout.P8.pSD 8.93368e-06f
Cred_7504 vin.$59.GatPoly vout.$1008.Metal3 0.00284953f
Cred_7505 vin.$59.GatPoly vout.$990.Metal3 0.00346416f
Cred_7506 vin.$59.GatPoly vout.P10.pSD 0.000605631f
Cred_7507 vin.$59.GatPoly vout.P12.nSD 1.71173e-05f
Cred_7508 vin.$59.GatPoly vout.P12.pSD 0.00595245f
Cred_7509 vin.$590.Metal2 vout.$972.Metal3 0.0506497f
Cred_7510 vin.$590.Metal2 vout.$990.Metal3 0.00128666f
Cred_7511 vin.$590.Metal2 vout.P6.nSD 0.00823064f
Cred_7512 vin.$590.Metal2 vout.P8.nSD 3.95714e-05f
Cred_7513 vin.$590.Metal2 vout.P8.pSD 2.09663e-05f
Cred_7514 vin.$590.Metal2 VSS.$102.Metal1 0.00166466f
Cred_7515 vin.$590.Metal2 VSS.$14.Metal1 0.000332087f
Cred_7516 vin.$590.Metal2 VSS.$29.Metal1 0.000558791f
Cred_7517 vin.$590.Metal2 VSS.$520.Metal1 5.89299e-06f
Cred_7518 vin.$590.Metal2 VSS.$576.Metal2 0.00059482f
Cred_7519 vin.$590.Metal2 VSS.$583.Metal2 0.00461823f
Cred_7520 vin.$590.Metal2 VSS.$591.Metal2 0.0139179f
Cred_7521 vin.$590.Metal2 VSS.$598.Metal2 0.00783594f
Cred_7522 vin.$590.Metal2 VSS.$84.Metal1 0.000359673f
Cred_7523 vin.$590.Metal2 VSS.$932.Metal3 2.69016e-06f
Cred_7524 vin.$590.Metal2 VSS.$94.Metal1 9.12322e-06f
Cred_7525 vin.$590.Metal2 VSS.P0.pSD 0.00627839f
Cred_7526 vin.$590.Metal2 VSS.P10.nSD 0.000938343f
Cred_7527 vin.$590.Metal2 VSS.P7.nSD 4.34743e-05f
Cred_7528 vin.$593.Metal2 vout.$972.Metal3 0.0129166f
Cred_7529 vin.$593.Metal2 vout.$990.Metal3 0.00253294f
Cred_7530 vin.$593.Metal2 vout.P6.pSD 0.00257966f
Cred_7531 vin.$593.Metal2 vout.P8.nSD 1.52155e-05f
Cred_7532 vin.$593.Metal2 vout.P8.pSD 0.000239283f
Cred_7533 vin.$593.Metal2 VSS.$102.Metal1 0.000167082f
Cred_7534 vin.$593.Metal2 VSS.$591.Metal2 0.000837436f
Cred_7535 vin.$593.Metal2 VSS.$598.Metal2 0.000483136f
Cred_7536 vin.$593.Metal2 VSS.P10.nSD 1.93462e-05f
Cred_7537 vin.$594.Metal2 vout.$972.Metal3 0.0302354f
Cred_7538 vin.$594.Metal2 vout.$990.Metal3 0.0273887f
Cred_7539 vin.$594.Metal2 vout.P6.nSD 3.18423e-05f
Cred_7540 vin.$594.Metal2 vout.P8.nSD 0.0111952f
Cred_7541 vin.$594.Metal2 vout.P8.pSD 0.000446303f
Cred_7542 vin.$594.Metal2 VSS.$102.Metal1 0.00164305f
Cred_7543 vin.$594.Metal2 VSS.$118.Metal1 8.95192e-06f
Cred_7544 vin.$594.Metal2 VSS.$14.Metal1 0.000318309f
Cred_7545 vin.$594.Metal2 VSS.$29.Metal1 0.000535608f
Cred_7546 vin.$594.Metal2 VSS.$520.Metal1 9.19915e-06f
Cred_7547 vin.$594.Metal2 VSS.$591.Metal2 0.00916098f
Cred_7548 vin.$594.Metal2 VSS.$598.Metal2 0.00840749f
Cred_7549 vin.$594.Metal2 VSS.$602.Metal2 9.77217e-08f
Cred_7550 vin.$594.Metal2 VSS.$609.Metal2 5.04184e-07f
Cred_7551 vin.$594.Metal2 VSS.P0.pSD 0.0079002f
Cred_7552 vin.$594.Metal2 VSS.P10.nSD 0.000937306f
Cred_7553 vin.$594.Metal2 VSS.P11.nSD 3.36646e-06f
Cred_7554 vin.$595.Metal2 vout.$972.Metal3 0.0260205f
Cred_7555 vin.$595.Metal2 vout.$990.Metal3 0.0259915f
Cred_7556 vin.$595.Metal2 vout.P8.nSD 0.000149906f
Cred_7557 vin.$595.Metal2 vout.P8.pSD 0.0140788f
Cred_7558 vin.$597.Metal2 vout.$972.Metal3 0.0447058f
Cred_7559 vin.$597.Metal2 vout.$990.Metal3 0.0446374f
Cred_7560 vin.$597.Metal2 vout.P8.nSD 0.000273772f
Cred_7561 vin.$597.Metal2 vout.P8.pSD 0.000738155f
Cred_7562 vin.$597.Metal2 VSS.$102.Metal1 0.000198151f
Cred_7563 vin.$597.Metal2 VSS.$118.Metal1 0.000217264f
Cred_7564 vin.$597.Metal2 VSS.$14.Metal1 0.00161324f
Cred_7565 vin.$597.Metal2 VSS.$29.Metal1 0.00271455f
Cred_7566 vin.$597.Metal2 VSS.$520.Metal1 4.85875e-05f
Cred_7567 vin.$597.Metal2 VSS.$591.Metal2 0.00170694f
Cred_7568 vin.$597.Metal2 VSS.$598.Metal2 0.000984775f
Cred_7569 vin.$597.Metal2 VSS.$602.Metal2 0.000419973f
Cred_7570 vin.$597.Metal2 VSS.$609.Metal2 0.00244985f
Cred_7571 vin.$597.Metal2 VSS.P0.pSD 0.0410199f
Cred_7572 vin.$597.Metal2 VSS.P10.nSD 2.29413e-05f
Cred_7573 vin.$597.Metal2 VSS.P11.nSD 2.51571e-05f
Cred_7574 vin.$599.Metal2 vout.$972.Metal3 0.00591452f
Cred_7575 vin.$599.Metal2 vout.$990.Metal3 0.0196145f
Cred_7576 vin.$599.Metal2 vout.P10.nSD 0.00131176f
Cred_7577 vin.$599.Metal2 vout.P8.nSD 0.000206346f
Cred_7578 vin.$599.Metal2 vout.P8.pSD 9.46634e-05f
Cred_7579 vin.$599.Metal2 VSS.$102.Metal1 1.90701e-06f
Cred_7580 vin.$599.Metal2 VSS.$118.Metal1 0.00316446f
Cred_7581 vin.$599.Metal2 VSS.$128.Metal1 4.32314e-06f
Cred_7582 vin.$599.Metal2 VSS.$14.Metal1 0.000144733f
Cred_7583 vin.$599.Metal2 VSS.$29.Metal1 0.000243537f
Cred_7584 vin.$599.Metal2 VSS.$520.Metal1 5.58328e-06f
Cred_7585 vin.$599.Metal2 VSS.$598.Metal2 9.32574e-09f
Cred_7586 vin.$599.Metal2 VSS.$602.Metal2 0.00444471f
Cred_7587 vin.$599.Metal2 VSS.$609.Metal2 0.0263203f
Cred_7588 vin.$599.Metal2 VSS.$617.Metal2 0.000393004f
Cred_7589 vin.$599.Metal2 VSS.$942.Metal3 3.15102e-06f
Cred_7590 vin.$599.Metal2 VSS.P0.pSD 0.00419328f
Cred_7591 vin.$599.Metal2 VSS.P11.nSD 0.000379527f
Cred_7592 vin.$600.Metal2 vout.$972.Metal3 0.00628433f
Cred_7593 vin.$600.Metal2 vout.$990.Metal3 0.0166886f
Cred_7594 vin.$600.Metal2 vout.P10.pSD 0.00204172f
Cred_7595 vin.$600.Metal2 vout.P8.nSD 3.69613e-05f
Cred_7596 vin.$600.Metal2 vout.P8.pSD 0.000654781f
Cred_7597 vin.$600.Metal2 VSS.$118.Metal1 0.000137024f
Cred_7598 vin.$600.Metal2 VSS.$602.Metal2 0.00015935f
Cred_7599 vin.$600.Metal2 VSS.$609.Metal2 0.00092954f
Cred_7600 vin.$600.Metal2 VSS.P11.nSD 1.58668e-05f
Cred_7601 vin.$604.Metal2 vout.$990.Metal3 0.0927648f
Cred_7602 vin.$604.Metal2 vout.P10.nSD 0.000555283f
Cred_7603 vin.$604.Metal2 VSS.$118.Metal1 0.000268919f
Cred_7604 vin.$604.Metal2 VSS.$128.Metal1 9.59171e-07f
Cred_7605 vin.$604.Metal2 VSS.$136.Metal1 0.00021928f
Cred_7606 vin.$604.Metal2 VSS.$14.Metal1 0.00130557f
Cred_7607 vin.$604.Metal2 VSS.$29.Metal1 0.00219684f
Cred_7608 vin.$604.Metal2 VSS.$520.Metal1 6.6241e-05f
Cred_7609 vin.$604.Metal2 VSS.$602.Metal2 0.000582954f
Cred_7610 vin.$604.Metal2 VSS.$609.Metal2 0.00348776f
Cred_7611 vin.$604.Metal2 VSS.$617.Metal2 0.00218924f
Cred_7612 vin.$604.Metal2 VSS.$624.Metal2 0.00108995f
Cred_7613 vin.$604.Metal2 VSS.$942.Metal3 6.99113e-07f
Cred_7614 vin.$604.Metal2 VSS.P0.pSD 0.0440425f
Cred_7615 vin.$604.Metal2 VSS.P11.nSD 3.15383e-05f
Cred_7616 vin.$604.Metal2 VSS.P13.nSD 2.53874e-05f
Cred_7617 vin.$605.Metal2 vout.$1008.Metal3 0.000574607f
Cred_7618 vin.$605.Metal2 vout.$972.Metal3 0.00055193f
Cred_7619 vin.$605.Metal2 vout.$990.Metal3 0.0490417f
Cred_7620 vin.$605.Metal2 vout.P10.pSD 0.0108194f
Cred_7621 vin.$605.Metal2 vout.P12.nSD 3.4517e-06f
Cred_7622 vin.$605.Metal2 vout.P12.pSD 9.36332e-06f
Cred_7623 vin.$605.Metal2 vout.P8.nSD 3.31547e-06f
Cred_7624 vin.$605.Metal2 vout.P8.pSD 8.99379e-06f
Cred_7625 vin.$606.Metal2 vout.$1008.Metal3 0.00142527f
Cred_7626 vin.$606.Metal2 vout.$990.Metal3 0.0506098f
Cred_7627 vin.$606.Metal2 vout.P10.nSD 0.00801904f
Cred_7628 vin.$606.Metal2 vout.P12.nSD 4.34943e-05f
Cred_7629 vin.$606.Metal2 vout.P12.pSD 2.32249e-05f
Cred_7630 vin.$606.Metal2 VSS.$118.Metal1 0.000311385f
Cred_7631 vin.$606.Metal2 VSS.$128.Metal1 9.35346e-06f
Cred_7632 vin.$606.Metal2 VSS.$136.Metal1 0.00163022f
Cred_7633 vin.$606.Metal2 VSS.$14.Metal1 0.000209521f
Cred_7634 vin.$606.Metal2 VSS.$29.Metal1 0.000352554f
Cred_7635 vin.$606.Metal2 VSS.$520.Metal1 1.04395e-05f
Cred_7636 vin.$606.Metal2 VSS.$602.Metal2 0.000666467f
Cred_7637 vin.$606.Metal2 VSS.$609.Metal2 0.00422544f
Cred_7638 vin.$606.Metal2 VSS.$617.Metal2 0.0143229f
Cred_7639 vin.$606.Metal2 VSS.$624.Metal2 0.00725156f
Cred_7640 vin.$606.Metal2 VSS.$942.Metal3 2.70768e-06f
Cred_7641 vin.$606.Metal2 VSS.P0.pSD 0.00697899f
Cred_7642 vin.$606.Metal2 VSS.P11.nSD 3.76065e-05f
Cred_7643 vin.$606.Metal2 VSS.P13.nSD 0.000877402f
Cred_7644 vin.$609.Metal2 vout.$1008.Metal3 0.00268296f
Cred_7645 vin.$609.Metal2 vout.$990.Metal3 0.0120253f
Cred_7646 vin.$609.Metal2 vout.P10.pSD 0.00223825f
Cred_7647 vin.$609.Metal2 vout.P12.nSD 1.61167e-05f
Cred_7648 vin.$609.Metal2 vout.P12.pSD 0.000248235f
Cred_7649 vin.$609.Metal2 VSS.$136.Metal1 0.000167029f
Cred_7650 vin.$609.Metal2 VSS.$617.Metal2 0.000869684f
Cred_7651 vin.$609.Metal2 VSS.$624.Metal2 0.000450947f
Cred_7652 vin.$609.Metal2 VSS.P13.nSD 1.93402e-05f
Cred_7653 vin.$610.Metal2 vout.$1008.Metal3 0.0276821f
Cred_7654 vin.$610.Metal2 vout.$990.Metal3 0.0296753f
Cred_7655 vin.$610.Metal2 vout.P10.nSD 3.18424e-05f
Cred_7656 vin.$610.Metal2 vout.P12.nSD 0.0113252f
Cred_7657 vin.$610.Metal2 vout.P12.pSD 0.000451083f
Cred_7658 vin.$610.Metal2 VSS.$136.Metal1 0.00160853f
Cred_7659 vin.$610.Metal2 VSS.$14.Metal1 0.000198965f
Cred_7660 vin.$610.Metal2 VSS.$152.Metal1 1.00109e-05f
Cred_7661 vin.$610.Metal2 VSS.$29.Metal1 0.000334791f
Cred_7662 vin.$610.Metal2 VSS.$520.Metal1 1.6173e-05f
Cred_7663 vin.$610.Metal2 VSS.$617.Metal2 0.00933374f
Cred_7664 vin.$610.Metal2 VSS.$624.Metal2 0.0071369f
Cred_7665 vin.$610.Metal2 VSS.$628.Metal2 0.00140063f
Cred_7666 vin.$610.Metal2 VSS.$635.Metal2 5.68179e-07f
Cred_7667 vin.$610.Metal2 VSS.P0.pSD 0.00861024f
Cred_7668 vin.$610.Metal2 VSS.P13.nSD 0.000876384f
Cred_7669 vin.$610.Metal2 VSS.P15.nSD 3.4689e-06f
Cred_7670 vin.$611.Metal2 vout.$1008.Metal3 0.0307401f
Cred_7671 vin.$611.Metal2 vout.$990.Metal3 0.0288206f
Cred_7672 vin.$611.Metal2 vout.P12.nSD 0.000167523f
Cred_7673 vin.$611.Metal2 vout.P12.pSD 0.0145884f
Cred_7674 vin.$611.Metal2 vout.P14.pSD 9.26831e-05f
Cred_7675 vin.$611.Metal2 VSS.$152.Metal1 6.72168e-05f
Cred_7676 vin.$611.Metal2 VSS.$628.Metal2 9.11198e-05f
Cred_7677 vin.$611.Metal2 VSS.$635.Metal2 0.000442582f
Cred_7678 vin.$611.Metal2 VSS.P15.nSD 7.78337e-06f
Cred_7679 vin.$613.Metal2 vout.$1008.Metal3 0.0439219f
Cred_7680 vin.$613.Metal2 vout.$990.Metal3 0.0438062f
Cred_7681 vin.$613.Metal2 vout.P12.nSD 0.000267709f
Cred_7682 vin.$613.Metal2 vout.P12.pSD 0.000735779f
Cred_7683 vin.$613.Metal2 vout.P14.pSD 5.58378e-06f
Cred_7684 vin.$613.Metal2 VSS.$136.Metal1 0.000189858f
Cred_7685 vin.$613.Metal2 VSS.$14.Metal1 0.00094063f
Cred_7686 vin.$613.Metal2 VSS.$152.Metal1 0.000207134f
Cred_7687 vin.$613.Metal2 VSS.$29.Metal1 0.00158277f
Cred_7688 vin.$613.Metal2 VSS.$520.Metal1 7.97474e-05f
Cred_7689 vin.$613.Metal2 VSS.$617.Metal2 0.00172543f
Cred_7690 vin.$613.Metal2 VSS.$624.Metal2 0.000894669f
Cred_7691 vin.$613.Metal2 VSS.$628.Metal2 0.000474473f
Cred_7692 vin.$613.Metal2 VSS.$635.Metal2 0.00230458f
Cred_7693 vin.$613.Metal2 VSS.P0.pSD 0.041685f
Cred_7694 vin.$613.Metal2 VSS.P13.nSD 2.19812e-05f
Cred_7695 vin.$613.Metal2 VSS.P15.nSD 2.39837e-05f
Cred_7696 vin.$615.Metal2 vout.$1008.Metal3 0.0195932f
Cred_7697 vin.$615.Metal2 vout.$990.Metal3 0.00536134f
Cred_7698 vin.$615.Metal2 vout.P12.nSD 0.000192024f
Cred_7699 vin.$615.Metal2 vout.P12.pSD 8.73638e-05f
Cred_7700 vin.$615.Metal2 vout.P14.nSD 0.00160379f
Cred_7701 vin.$615.Metal2 VSS.$136.Metal1 1.77348e-06f
Cred_7702 vin.$615.Metal2 VSS.$14.Metal1 8.44987e-05f
Cred_7703 vin.$615.Metal2 VSS.$152.Metal1 0.00321708f
Cred_7704 vin.$615.Metal2 VSS.$162.Metal1 4.18673e-06f
Cred_7705 vin.$615.Metal2 VSS.$29.Metal1 0.000142183f
Cred_7706 vin.$615.Metal2 VSS.$520.Metal1 9.35692e-06f
Cred_7707 vin.$615.Metal2 VSS.$624.Metal2 9.00652e-09f
Cred_7708 vin.$615.Metal2 VSS.$628.Metal2 0.0052466f
Cred_7709 vin.$615.Metal2 VSS.$635.Metal2 0.0258743f
Cred_7710 vin.$615.Metal2 VSS.$643.Metal2 0.000390895f
Cred_7711 vin.$615.Metal2 VSS.$952.Metal3 3.13411e-06f
Cred_7712 vin.$615.Metal2 VSS.P0.pSD 0.0042909f
Cred_7713 vin.$615.Metal2 VSS.P15.nSD 0.000384734f
Cred_7714 vin.$618.Metal2 vout.$1008.Metal3 0.0308636f
Cred_7715 vin.$618.Metal2 vout.$1026.Metal3 0.000204982f
Cred_7716 vin.$618.Metal2 vout.$990.Metal3 0.00301843f
Cred_7717 vin.$618.Metal2 vout.P12.nSD 1.78844e-05f
Cred_7718 vin.$618.Metal2 vout.P12.pSD 0.000280254f
Cred_7719 vin.$618.Metal2 vout.P14.pSD 0.00602147f
Cred_7720 vin.$618.Metal2 vout.P16.nSD 1.23134e-06f
Cred_7721 vin.$618.Metal2 vout.P16.pSD 3.34021e-06f
Cred_7722 vin.$618.Metal2 VSS.$152.Metal1 7.09206e-05f
Cred_7723 vin.$618.Metal2 VSS.$628.Metal2 9.61408e-05f
Cred_7724 vin.$618.Metal2 VSS.$635.Metal2 0.00046697f
Cred_7725 vin.$618.Metal2 VSS.P15.nSD 8.21226e-06f
Cred_7726 vin.$62.GatPoly vout.$1008.Metal3 0.000506962f
Cred_7727 vin.$62.GatPoly vout.$990.Metal3 0.000506962f
Cred_7728 vin.$62.GatPoly vout.P12.nSD 0.00168145f
Cred_7729 vin.$62.GatPoly vout.P12.pSD 8.26102e-06f
Cred_7730 vin.$62.GatPoly VSS.$136.Metal1 1.46686e-06f
Cred_7731 vin.$62.GatPoly VSS.$14.Metal1 3.41405e-05f
Cred_7732 vin.$62.GatPoly VSS.$152.Metal1 0.00258161f
Cred_7733 vin.$62.GatPoly VSS.$29.Metal1 5.74471e-05f
Cred_7734 vin.$62.GatPoly VSS.$520.Metal1 3.04465e-06f
Cred_7735 vin.$62.GatPoly VSS.$624.Metal2 7.44936e-09f
Cred_7736 vin.$62.GatPoly VSS.$628.Metal2 3.31601e-05f
Cred_7737 vin.$62.GatPoly VSS.$635.Metal2 0.000160972f
Cred_7738 vin.$62.GatPoly VSS.P0.pSD 0.00155773f
Cred_7739 vin.$62.GatPoly VSS.P15.nSD 0.000182623f
Cred_7740 vin.$620.Metal2 vout.$1008.Metal3 0.0979359f
Cred_7741 vin.$620.Metal2 vout.$1026.Metal3 8.29169e-05f
Cred_7742 vin.$620.Metal2 vout.$990.Metal3 8.29169e-05f
Cred_7743 vin.$620.Metal2 vout.P12.nSD 4.98086e-07f
Cred_7744 vin.$620.Metal2 vout.P12.pSD 1.35114e-06f
Cred_7745 vin.$620.Metal2 vout.P14.nSD 0.000734561f
Cred_7746 vin.$620.Metal2 vout.P14.pSD 0.000395137f
Cred_7747 vin.$620.Metal2 vout.P16.nSD 4.98086e-07f
Cred_7748 vin.$620.Metal2 vout.P16.pSD 1.35114e-06f
Cred_7749 vin.$620.Metal2 VSS.$14.Metal1 0.000769955f
Cred_7750 vin.$620.Metal2 VSS.$152.Metal1 0.000278533f
Cred_7751 vin.$620.Metal2 VSS.$162.Metal1 1.07548e-06f
Cred_7752 vin.$620.Metal2 VSS.$170.Metal1 0.000203997f
Cred_7753 vin.$620.Metal2 VSS.$29.Metal1 0.00129558f
Cred_7754 vin.$620.Metal2 VSS.$520.Metal1 0.000109048f
Cred_7755 vin.$620.Metal2 VSS.$628.Metal2 0.000709852f
Cred_7756 vin.$620.Metal2 VSS.$635.Metal2 0.00354827f
Cred_7757 vin.$620.Metal2 VSS.$643.Metal2 0.00218453f
Cred_7758 vin.$620.Metal2 VSS.$650.Metal2 0.000967626f
Cred_7759 vin.$620.Metal2 VSS.$952.Metal3 8.05084e-07f
Cred_7760 vin.$620.Metal2 VSS.P0.pSD 0.0446333f
Cred_7761 vin.$620.Metal2 VSS.P15.nSD 3.26195e-05f
Cred_7762 vin.$620.Metal2 VSS.P17.nSD 2.3618e-05f
Cred_7763 vin.$622.Metal2 vout.$1008.Metal3 0.0492485f
Cred_7764 vin.$622.Metal2 vout.$1026.Metal3 0.00156391f
Cred_7765 vin.$622.Metal2 vout.P14.nSD 0.00779556f
Cred_7766 vin.$622.Metal2 vout.P16.nSD 4.74174e-05f
Cred_7767 vin.$622.Metal2 vout.P16.pSD 2.54841e-05f
Cred_7768 vin.$622.Metal2 VSS.$14.Metal1 0.000119776f
Cred_7769 vin.$622.Metal2 VSS.$152.Metal1 0.000249958f
Cred_7770 vin.$622.Metal2 VSS.$162.Metal1 9.4915e-06f
Cred_7771 vin.$622.Metal2 VSS.$170.Metal1 0.00162782f
Cred_7772 vin.$622.Metal2 VSS.$29.Metal1 0.000201543f
Cred_7773 vin.$622.Metal2 VSS.$520.Metal1 1.67791e-05f
Cred_7774 vin.$622.Metal2 VSS.$628.Metal2 0.000690068f
Cred_7775 vin.$622.Metal2 VSS.$635.Metal2 0.0036851f
Cred_7776 vin.$622.Metal2 VSS.$643.Metal2 0.0148937f
Cred_7777 vin.$622.Metal2 VSS.$650.Metal2 0.00676016f
Cred_7778 vin.$622.Metal2 VSS.$952.Metal3 2.67266e-06f
Cred_7779 vin.$622.Metal2 VSS.P0.pSD 0.0068848f
Cred_7780 vin.$622.Metal2 VSS.P15.nSD 3.01671e-05f
Cred_7781 vin.$622.Metal2 VSS.P17.nSD 0.00082013f
Cred_7782 vin.$623.Metal2 vout.$1008.Metal3 0.0348262f
Cred_7783 vin.$623.Metal2 vout.$1026.Metal3 0.00167778f
Cred_7784 vin.$623.Metal2 vout.$990.Metal3 0.000275261f
Cred_7785 vin.$623.Metal2 vout.P12.nSD 1.65351e-06f
Cred_7786 vin.$623.Metal2 vout.P12.pSD 4.48543e-06f
Cred_7787 vin.$623.Metal2 vout.P14.pSD 0.00852763f
Cred_7788 vin.$623.Metal2 vout.P16.nSD 1.00785e-05f
Cred_7789 vin.$623.Metal2 vout.P16.pSD 0.000131808f
Cred_7790 vin.$623.Metal2 VSS.$170.Metal1 8.26582e-05f
Cred_7791 vin.$623.Metal2 VSS.$643.Metal2 0.000446511f
Cred_7792 vin.$623.Metal2 VSS.$650.Metal2 0.000207309f
Cred_7793 vin.$623.Metal2 VSS.P17.nSD 9.57097e-06f
Cred_7794 vin.$626.Metal2 vout.$1008.Metal3 0.029888f
Cred_7795 vin.$626.Metal2 vout.$1026.Metal3 0.0278948f
Cred_7796 vin.$626.Metal2 vout.P14.nSD 3.18426e-05f
Cred_7797 vin.$626.Metal2 vout.P16.nSD 0.0114543f
Cred_7798 vin.$626.Metal2 vout.P16.pSD 0.00045455f
Cred_7799 vin.$626.Metal2 VSS.$14.Metal1 0.00012482f
Cred_7800 vin.$626.Metal2 VSS.$170.Metal1 0.0016061f
Cred_7801 vin.$626.Metal2 VSS.$186.Metal1 1.10325e-05f
Cred_7802 vin.$626.Metal2 VSS.$29.Metal1 0.00021003f
Cred_7803 vin.$626.Metal2 VSS.$520.Metal1 2.83304e-05f
Cred_7804 vin.$626.Metal2 VSS.$643.Metal2 0.00966827f
Cred_7805 vin.$626.Metal2 VSS.$650.Metal2 0.00681403f
Cred_7806 vin.$626.Metal2 VSS.$654.Metal2 0.0015759f
Cred_7807 vin.$626.Metal2 VSS.$661.Metal2 6.21518e-07f
Cred_7808 vin.$626.Metal2 VSS.P0.pSD 0.00922091f
Cred_7809 vin.$626.Metal2 VSS.P17.nSD 0.000819136f
Cred_7810 vin.$626.Metal2 VSS.P19.nSD 3.53339e-06f
Cred_7811 vin.$627.Metal2 vout.$1008.Metal3 0.0322848f
Cred_7812 vin.$627.Metal2 vout.$1026.Metal3 0.0322076f
Cred_7813 vin.$627.Metal2 vout.P14.pSD 9.80249e-05f
Cred_7814 vin.$627.Metal2 vout.P16.nSD 0.000175995f
Cred_7815 vin.$627.Metal2 vout.P16.pSD 0.0149762f
Cred_7816 vin.$627.Metal2 vout.P18.pSD 9.41013e-05f
Cred_7817 vin.$627.Metal2 VSS.$170.Metal1 8.26582e-05f
Cred_7818 vin.$627.Metal2 VSS.$186.Metal1 7.13214e-05f
Cred_7819 vin.$627.Metal2 VSS.$643.Metal2 0.000446511f
Cred_7820 vin.$627.Metal2 VSS.$650.Metal2 0.000207309f
Cred_7821 vin.$627.Metal2 VSS.$654.Metal2 0.000110409f
Cred_7822 vin.$627.Metal2 VSS.$661.Metal2 0.000455439f
Cred_7823 vin.$627.Metal2 VSS.P17.nSD 9.57097e-06f
Cred_7824 vin.$627.Metal2 VSS.P19.nSD 8.25858e-06f
Cred_7825 vin.$629.Metal2 vout.$1008.Metal3 0.0436467f
Cred_7826 vin.$629.Metal2 vout.$1026.Metal3 0.0437263f
Cred_7827 vin.$629.Metal2 vout.P16.nSD 0.000265543f
Cred_7828 vin.$629.Metal2 vout.P16.pSD 0.000726296f
Cred_7829 vin.$629.Metal2 vout.P18.pSD 4.04944e-06f
Cred_7830 vin.$629.Metal2 VSS.$14.Metal1 0.00056595f
Cred_7831 vin.$629.Metal2 VSS.$170.Metal1 0.000203387f
Cred_7832 vin.$629.Metal2 VSS.$186.Metal1 0.000206386f
Cred_7833 vin.$629.Metal2 VSS.$29.Metal1 0.000952306f
Cred_7834 vin.$629.Metal2 VSS.$520.Metal1 0.000133764f
Cred_7835 vin.$629.Metal2 VSS.$643.Metal2 0.00186015f
Cred_7836 vin.$629.Metal2 VSS.$650.Metal2 0.000863642f
Cred_7837 vin.$629.Metal2 VSS.$654.Metal2 0.000539386f
Cred_7838 vin.$629.Metal2 VSS.$661.Metal2 0.00222497f
Cred_7839 vin.$629.Metal2 VSS.P0.pSD 0.0427519f
Cred_7840 vin.$629.Metal2 VSS.P17.nSD 2.35479e-05f
Cred_7841 vin.$629.Metal2 VSS.P19.nSD 2.38967e-05f
Cred_7842 vin.$63.GatPoly vout.$1008.Metal3 0.00249847f
Cred_7843 vin.$63.GatPoly vout.$990.Metal3 0.00249847f
Cred_7844 vin.$63.GatPoly vout.P12.nSD 1.50084e-05f
Cred_7845 vin.$63.GatPoly vout.P12.pSD 0.00539117f
Cred_7846 vin.$631.Metal2 vout.$1008.Metal3 0.00491795f
Cred_7847 vin.$631.Metal2 vout.$1026.Metal3 0.0207421f
Cred_7848 vin.$631.Metal2 vout.P16.nSD 0.000177716f
Cred_7849 vin.$631.Metal2 vout.P16.pSD 8.01388e-05f
Cred_7850 vin.$631.Metal2 vout.P18.nSD 0.00179132f
Cred_7851 vin.$631.Metal2 VSS.$14.Metal1 4.80858e-05f
Cred_7852 vin.$631.Metal2 VSS.$170.Metal1 1.63817e-06f
Cred_7853 vin.$631.Metal2 VSS.$186.Metal1 0.00320962f
Cred_7854 vin.$631.Metal2 VSS.$196.Metal1 3.95448e-06f
Cred_7855 vin.$631.Metal2 VSS.$29.Metal1 8.09123e-05f
Cred_7856 vin.$631.Metal2 VSS.$520.Metal1 1.51357e-05f
Cred_7857 vin.$631.Metal2 VSS.$650.Metal2 8.62767e-09f
Cred_7858 vin.$631.Metal2 VSS.$654.Metal2 0.00608887f
Cred_7859 vin.$631.Metal2 VSS.$661.Metal2 0.0254939f
Cred_7860 vin.$631.Metal2 VSS.$669.Metal2 0.000377457f
Cred_7861 vin.$631.Metal2 VSS.$962.Metal3 3.02636e-06f
Cred_7862 vin.$631.Metal2 VSS.P0.pSD 0.00419181f
Cred_7863 vin.$631.Metal2 VSS.P19.nSD 0.000382987f
Cred_7864 vin.$634.Metal2 vout.$1008.Metal3 0.0027644f
Cred_7865 vin.$634.Metal2 vout.$1026.Metal3 0.0329081f
Cred_7866 vin.$634.Metal2 vout.$1044.Metal3 0.000216308f
Cred_7867 vin.$634.Metal2 vout.P16.nSD 1.64076e-05f
Cred_7868 vin.$634.Metal2 vout.P16.pSD 0.000254672f
Cred_7869 vin.$634.Metal2 vout.P18.pSD 0.00651172f
Cred_7870 vin.$634.Metal2 vout.P20.nSD 1.29937e-06f
Cred_7871 vin.$634.Metal2 vout.P20.pSD 3.52477e-06f
Cred_7872 vin.$634.Metal2 VSS.$186.Metal1 7.42034e-05f
Cred_7873 vin.$634.Metal2 VSS.$654.Metal2 0.000114871f
Cred_7874 vin.$634.Metal2 VSS.$661.Metal2 0.000473842f
Cred_7875 vin.$634.Metal2 VSS.P19.nSD 8.5923e-06f
Cred_7876 vin.$636.Metal2 vout.$1008.Metal3 8.3775e-05f
Cred_7877 vin.$636.Metal2 vout.$1026.Metal3 0.0994923f
Cred_7878 vin.$636.Metal2 vout.$1044.Metal3 8.3775e-05f
Cred_7879 vin.$636.Metal2 vout.P16.nSD 5.03241e-07f
Cred_7880 vin.$636.Metal2 vout.P16.pSD 1.36513e-06f
Cred_7881 vin.$636.Metal2 vout.P18.nSD 0.000835147f
Cred_7882 vin.$636.Metal2 vout.P18.pSD 0.000410651f
Cred_7883 vin.$636.Metal2 vout.P20.nSD 5.03241e-07f
Cred_7884 vin.$636.Metal2 vout.P20.pSD 1.36513e-06f
Cred_7885 vin.$636.Metal2 VSS.$14.Metal1 0.000460565f
Cred_7886 vin.$636.Metal2 VSS.$186.Metal1 0.000248103f
Cred_7887 vin.$636.Metal2 VSS.$196.Metal1 1.07195e-06f
Cred_7888 vin.$636.Metal2 VSS.$204.Metal1 0.000204429f
Cred_7889 vin.$636.Metal2 VSS.$29.Metal1 0.000774978f
Cred_7890 vin.$636.Metal2 VSS.$520.Metal1 0.000181807f
Cred_7891 vin.$636.Metal2 VSS.$654.Metal2 0.000804521f
Cred_7892 vin.$636.Metal2 VSS.$661.Metal2 0.00342097f
Cred_7893 vin.$636.Metal2 VSS.$669.Metal2 0.00224991f
Cred_7894 vin.$636.Metal2 VSS.$676.Metal2 0.000888659f
Cred_7895 vin.$636.Metal2 VSS.$962.Metal3 8.20361e-07f
Cred_7896 vin.$636.Metal2 VSS.P0.pSD 0.0452212f
Cred_7897 vin.$636.Metal2 VSS.P19.nSD 2.90265e-05f
Cred_7898 vin.$636.Metal2 VSS.P21.nSD 2.36683e-05f
Cred_7899 vin.$638.Metal2 vout.$1026.Metal3 0.0462473f
Cred_7900 vin.$638.Metal2 vout.$1044.Metal3 0.00168359f
Cred_7901 vin.$638.Metal2 vout.P18.nSD 0.00750239f
Cred_7902 vin.$638.Metal2 vout.P20.nSD 5.12064e-05f
Cred_7903 vin.$638.Metal2 vout.P20.pSD 2.74343e-05f
Cred_7904 vin.$638.Metal2 VSS.$14.Metal1 7.04048e-05f
Cred_7905 vin.$638.Metal2 VSS.$186.Metal1 0.000140036f
Cred_7906 vin.$638.Metal2 VSS.$196.Metal1 9.57778e-06f
Cred_7907 vin.$638.Metal2 VSS.$204.Metal1 0.00162304f
Cred_7908 vin.$638.Metal2 VSS.$29.Metal1 0.000118468f
Cred_7909 vin.$638.Metal2 VSS.$520.Metal1 2.75396e-05f
Cred_7910 vin.$638.Metal2 VSS.$654.Metal2 0.000713615f
Cred_7911 vin.$638.Metal2 VSS.$661.Metal2 0.00326497f
Cred_7912 vin.$638.Metal2 VSS.$669.Metal2 0.0154556f
Cred_7913 vin.$638.Metal2 VSS.$676.Metal2 0.00626245f
Cred_7914 vin.$638.Metal2 VSS.$962.Metal3 2.57617e-06f
Cred_7915 vin.$638.Metal2 VSS.P0.pSD 0.00686195f
Cred_7916 vin.$638.Metal2 VSS.P19.nSD 1.71561e-05f
Cred_7917 vin.$638.Metal2 VSS.P21.nSD 0.000762555f
Cred_7918 vin.$639.Metal2 vout.$1008.Metal3 0.000263077f
Cred_7919 vin.$639.Metal2 vout.$1026.Metal3 0.0336899f
Cred_7920 vin.$639.Metal2 vout.$1044.Metal3 0.00195629f
Cred_7921 vin.$639.Metal2 vout.P16.nSD 1.58032e-06f
Cred_7922 vin.$639.Metal2 vout.P16.pSD 4.28688e-06f
Cred_7923 vin.$639.Metal2 vout.P18.pSD 0.00808985f
Cred_7924 vin.$639.Metal2 vout.P20.nSD 1.17515e-05f
Cred_7925 vin.$639.Metal2 vout.P20.pSD 0.00017406f
Cred_7926 vin.$639.Metal2 VSS.$204.Metal1 8.26236e-05f
Cred_7927 vin.$639.Metal2 VSS.$669.Metal2 0.000462486f
Cred_7928 vin.$639.Metal2 VSS.$676.Metal2 0.000191374f
Cred_7929 vin.$639.Metal2 VSS.P21.nSD 9.56702e-06f
Cred_7930 vin.$642.Metal2 vout.$1026.Metal3 0.0304824f
Cred_7931 vin.$642.Metal2 vout.$1044.Metal3 0.0284892f
Cred_7932 vin.$642.Metal2 vout.P18.nSD 3.18427e-05f
Cred_7933 vin.$642.Metal2 vout.P20.nSD 0.0115801f
Cred_7934 vin.$642.Metal2 vout.P20.pSD 0.000464235f
Cred_7935 vin.$642.Metal2 VSS.$14.Metal1 7.82698e-05f
Cred_7936 vin.$642.Metal2 VSS.$204.Metal1 0.00160113f
Cred_7937 vin.$642.Metal2 VSS.$220.Metal1 1.07685e-05f
Cred_7938 vin.$642.Metal2 VSS.$29.Metal1 0.000131702f
Cred_7939 vin.$642.Metal2 VSS.$520.Metal1 4.94197e-05f
Cred_7940 vin.$642.Metal2 VSS.$669.Metal2 0.00999093f
Cred_7941 vin.$642.Metal2 VSS.$676.Metal2 0.00646642f
Cred_7942 vin.$642.Metal2 VSS.$680.Metal2 0.00175125f
Cred_7943 vin.$642.Metal2 VSS.$687.Metal2 6.62415e-07f
Cred_7944 vin.$642.Metal2 VSS.P0.pSD 0.00973358f
Cred_7945 vin.$642.Metal2 VSS.P21.nSD 0.00076159f
Cred_7946 vin.$642.Metal2 VSS.P23.nSD 3.55717e-06f
Cred_7947 vin.$643.Metal2 vout.$1026.Metal3 0.0325173f
Cred_7948 vin.$643.Metal2 vout.$1044.Metal3 0.0324697f
Cred_7949 vin.$643.Metal2 vout.P18.pSD 9.80252e-05f
Cred_7950 vin.$643.Metal2 vout.P20.nSD 0.000177208f
Cred_7951 vin.$643.Metal2 vout.P20.pSD 0.0152033f
Cred_7952 vin.$643.Metal2 vout.P22.pSD 9.5603e-05f
Cred_7953 vin.$643.Metal2 VSS.$204.Metal1 8.26236e-05f
Cred_7954 vin.$643.Metal2 VSS.$220.Metal1 7.553e-05f
Cred_7955 vin.$643.Metal2 VSS.$669.Metal2 0.000462486f
Cred_7956 vin.$643.Metal2 VSS.$676.Metal2 0.000191374f
Cred_7957 vin.$643.Metal2 VSS.$680.Metal2 0.000131445f
Cred_7958 vin.$643.Metal2 VSS.$687.Metal2 0.00046736f
Cred_7959 vin.$643.Metal2 VSS.P21.nSD 9.56702e-06f
Cred_7960 vin.$643.Metal2 VSS.P23.nSD 8.74584e-06f
Cred_7961 vin.$645.Metal2 vout.$1026.Metal3 0.0432126f
Cred_7962 vin.$645.Metal2 vout.$1044.Metal3 0.0432611f
Cred_7963 vin.$645.Metal2 vout.P20.nSD 0.000261689f
Cred_7964 vin.$645.Metal2 vout.P20.pSD 0.000712919f
Cred_7965 vin.$645.Metal2 vout.P22.pSD 2.46844e-06f
Cred_7966 vin.$645.Metal2 VSS.$14.Metal1 0.000339297f
Cred_7967 vin.$645.Metal2 VSS.$204.Metal1 0.000204072f
Cred_7968 vin.$645.Metal2 VSS.$220.Metal1 0.000205481f
Cred_7969 vin.$645.Metal2 VSS.$29.Metal1 0.000570924f
Cred_7970 vin.$645.Metal2 VSS.$520.Metal1 0.000222942f
Cred_7971 vin.$645.Metal2 VSS.$669.Metal2 0.00192986f
Cred_7972 vin.$645.Metal2 VSS.$676.Metal2 0.000798562f
Cred_7973 vin.$645.Metal2 VSS.$680.Metal2 0.000603662f
Cred_7974 vin.$645.Metal2 VSS.$687.Metal2 0.00214635f
Cred_7975 vin.$645.Metal2 VSS.P0.pSD 0.0431131f
Cred_7976 vin.$645.Metal2 VSS.P21.nSD 2.36275e-05f
Cred_7977 vin.$645.Metal2 VSS.P23.nSD 2.37916e-05f
Cred_7978 vin.$647.Metal2 vout.$1026.Metal3 0.00443033f
Cred_7979 vin.$647.Metal2 vout.$1044.Metal3 0.0208487f
Cred_7980 vin.$647.Metal2 vout.P20.nSD 0.000161768f
Cred_7981 vin.$647.Metal2 vout.P20.pSD 7.21929e-05f
Cred_7982 vin.$647.Metal2 vout.P22.nSD 0.00196126f
Cred_7983 vin.$647.Metal2 VSS.$14.Metal1 2.73449e-05f
Cred_7984 vin.$647.Metal2 VSS.$204.Metal1 6.64607e-07f
Cred_7985 vin.$647.Metal2 VSS.$220.Metal1 0.00326083f
Cred_7986 vin.$647.Metal2 VSS.$230.Metal1 3.70538e-06f
Cred_7987 vin.$647.Metal2 VSS.$29.Metal1 4.60124e-05f
Cred_7988 vin.$647.Metal2 VSS.$520.Metal1 2.43644e-05f
Cred_7989 vin.$647.Metal2 VSS.$676.Metal2 3.62533e-09f
Cred_7990 vin.$647.Metal2 VSS.$680.Metal2 0.00694015f
Cred_7991 vin.$647.Metal2 VSS.$687.Metal2 0.0250397f
Cred_7992 vin.$647.Metal2 VSS.$695.Metal2 0.00036366f
Cred_7993 vin.$647.Metal2 VSS.$972.Metal3 2.91575e-06f
Cred_7994 vin.$647.Metal2 VSS.P0.pSD 0.00403595f
Cred_7995 vin.$647.Metal2 VSS.P23.nSD 0.000387579f
Cred_7996 vin.$650.Metal2 vout.$1026.Metal3 0.0024832f
Cred_7997 vin.$650.Metal2 vout.$1044.Metal3 0.0337009f
Cred_7998 vin.$650.Metal2 vout.P20.nSD 1.47959e-05f
Cred_7999 vin.$650.Metal2 vout.P20.pSD 0.000228481f
Cred_8000 vin.$650.Metal2 vout.P22.pSD 0.0069347f
Cred_8001 vin.$650.Metal2 VSS.$220.Metal1 7.74088e-05f
Cred_8002 vin.$650.Metal2 VSS.$680.Metal2 0.000134715f
Cred_8003 vin.$650.Metal2 VSS.$687.Metal2 0.000478985f
Cred_8004 vin.$650.Metal2 VSS.P23.nSD 8.96339e-06f
Cred_8005 vin.$652.Metal2 vout.$1026.Metal3 8.42884e-05f
Cred_8006 vin.$652.Metal2 vout.$1044.Metal3 0.099405f
Cred_8007 vin.$652.Metal2 vout.P20.nSD 5.06325e-07f
Cred_8008 vin.$652.Metal2 vout.P20.pSD 1.37349e-06f
Cred_8009 vin.$652.Metal2 vout.P22.nSD 0.000916962f
Cred_8010 vin.$652.Metal2 vout.P22.pSD 0.000419934f
Cred_8011 vin.$652.Metal2 VSS.$14.Metal1 0.000276629f
Cred_8012 vin.$652.Metal2 VSS.$220.Metal1 0.000232285f
Cred_8013 vin.$652.Metal2 VSS.$230.Metal1 1.05758e-06f
Cred_8014 vin.$652.Metal2 VSS.$238.Metal1 0.000184923f
Cred_8015 vin.$652.Metal2 VSS.$29.Metal1 0.000465475f
Cred_8016 vin.$652.Metal2 VSS.$520.Metal1 0.000302036f
Cred_8017 vin.$652.Metal2 VSS.$680.Metal2 0.00089091f
Cred_8018 vin.$652.Metal2 VSS.$687.Metal2 0.00327148f
Cred_8019 vin.$652.Metal2 VSS.$695.Metal2 0.00219896f
Cred_8020 vin.$652.Metal2 VSS.$702.Metal2 0.000768226f
Cred_8021 vin.$652.Metal2 VSS.$972.Metal3 8.32207e-07f
Cred_8022 vin.$652.Metal2 VSS.P0.pSD 0.0453146f
Cred_8023 vin.$652.Metal2 VSS.P23.nSD 2.68472e-05f
Cred_8024 vin.$652.Metal2 VSS.P25.nSD 2.141e-05f
Cred_8025 vin.$654.Metal2 vout.$1044.Metal3 0.0454881f
Cred_8026 vin.$654.Metal2 vout.$1062.Metal3 0.00191054f
Cred_8027 vin.$654.Metal2 vout.P22.nSD 0.00724584f
Cred_8028 vin.$654.Metal2 vout.P24.nSD 5.68973e-05f
Cred_8029 vin.$654.Metal2 vout.P24.pSD 3.11326e-05f
Cred_8030 vin.$654.Metal2 VSS.$14.Metal1 4.21875e-05f
Cred_8031 vin.$654.Metal2 VSS.$220.Metal1 8.49683e-05f
Cred_8032 vin.$654.Metal2 VSS.$230.Metal1 9.55778e-06f
Cred_8033 vin.$654.Metal2 VSS.$238.Metal1 0.00162223f
Cred_8034 vin.$654.Metal2 VSS.$29.Metal1 7.09875e-05f
Cred_8035 vin.$654.Metal2 VSS.$520.Metal1 4.62211e-05f
Cred_8036 vin.$654.Metal2 VSS.$680.Metal2 0.000707115f
Cred_8037 vin.$654.Metal2 VSS.$687.Metal2 0.00282342f
Cred_8038 vin.$654.Metal2 VSS.$695.Metal2 0.0160809f
Cred_8039 vin.$654.Metal2 VSS.$702.Metal2 0.00578294f
Cred_8040 vin.$654.Metal2 VSS.$972.Metal3 2.47935e-06f
Cred_8041 vin.$654.Metal2 VSS.P0.pSD 0.00689889f
Cred_8042 vin.$654.Metal2 VSS.P23.nSD 9.69669e-06f
Cred_8043 vin.$654.Metal2 VSS.P25.nSD 0.000705191f
Cred_8044 vin.$655.Metal2 vout.$1026.Metal3 0.000251116f
Cred_8045 vin.$655.Metal2 vout.$1044.Metal3 0.0322406f
Cred_8046 vin.$655.Metal2 vout.$1062.Metal3 0.00194952f
Cred_8047 vin.$655.Metal2 vout.P20.nSD 1.50846e-06f
Cred_8048 vin.$655.Metal2 vout.P20.pSD 4.09197e-06f
Cred_8049 vin.$655.Metal2 vout.P22.pSD 0.00765152f
Cred_8050 vin.$655.Metal2 vout.P24.nSD 1.15932e-05f
Cred_8051 vin.$655.Metal2 vout.P24.pSD 0.000190326f
Cred_8052 vin.$655.Metal2 VSS.$238.Metal1 8.25469e-05f
Cred_8053 vin.$655.Metal2 VSS.$695.Metal2 0.000478249f
Cred_8054 vin.$655.Metal2 VSS.$702.Metal2 0.000175358f
Cred_8055 vin.$655.Metal2 VSS.P25.nSD 9.5582e-06f
Cred_8056 vin.$659.Metal2 vout.$1044.Metal3 0.0431035f
Cred_8057 vin.$659.Metal2 vout.$1062.Metal3 0.0430033f
Cred_8058 vin.$659.Metal2 vout.P22.nSD 8.01848e-07f
Cred_8059 vin.$659.Metal2 vout.P22.pSD 2.46843e-06f
Cred_8060 vin.$659.Metal2 vout.P24.nSD 0.00026158f
Cred_8061 vin.$659.Metal2 vout.P24.pSD 0.000708777f
Cred_8062 vin.$659.Metal2 VSS.$14.Metal1 0.000209745f
Cred_8063 vin.$659.Metal2 VSS.$238.Metal1 0.000265588f
Cred_8064 vin.$659.Metal2 VSS.$254.Metal1 0.000167925f
Cred_8065 vin.$659.Metal2 VSS.$29.Metal1 0.000352931f
Cred_8066 vin.$659.Metal2 VSS.$520.Metal1 0.000377445f
Cred_8067 vin.$659.Metal2 VSS.$695.Metal2 0.00238014f
Cred_8068 vin.$659.Metal2 VSS.$702.Metal2 0.000872718f
Cred_8069 vin.$659.Metal2 VSS.$706.Metal2 0.00059684f
Cred_8070 vin.$659.Metal2 VSS.$713.Metal2 0.0018502f
Cred_8071 vin.$659.Metal2 VSS.P0.pSD 0.0439674f
Cred_8072 vin.$659.Metal2 VSS.P25.nSD 4.38268e-05f
Cred_8073 vin.$659.Metal2 VSS.P27.nSD 1.94425e-05f
Cred_8074 vin.$661.Metal2 vout.$1044.Metal3 0.0325736f
Cred_8075 vin.$661.Metal2 vout.$1062.Metal3 0.032623f
Cred_8076 vin.$661.Metal2 vout.P22.nSD 3.10557e-05f
Cred_8077 vin.$661.Metal2 vout.P24.nSD 0.0117004f
Cred_8078 vin.$661.Metal2 vout.P24.pSD 0.000499115f
Cred_8079 vin.$661.Metal2 vout.P26.nSD 3.1844e-05f
Cred_8080 vin.$661.Metal2 VSS.$14.Metal1 5.10957e-05f
Cred_8081 vin.$661.Metal2 VSS.$238.Metal1 0.00156208f
Cred_8082 vin.$661.Metal2 VSS.$254.Metal1 0.00168467f
Cred_8083 vin.$661.Metal2 VSS.$29.Metal1 8.59771e-05f
Cred_8084 vin.$661.Metal2 VSS.$520.Metal1 9.03226e-05f
Cred_8085 vin.$661.Metal2 VSS.$695.Metal2 0.0100594f
Cred_8086 vin.$661.Metal2 VSS.$702.Metal2 0.00586331f
Cred_8087 vin.$661.Metal2 VSS.$706.Metal2 0.00549099f
Cred_8088 vin.$661.Metal2 VSS.$713.Metal2 0.0110527f
Cred_8089 vin.$661.Metal2 VSS.P0.pSD 0.0106012f
Cred_8090 vin.$661.Metal2 VSS.P25.nSD 0.000687158f
Cred_8091 vin.$661.Metal2 VSS.P27.nSD 0.000201935f
Cred_8092 vin.$662.Metal2 vout.$1044.Metal3 0.0325673f
Cred_8093 vin.$662.Metal2 vout.$1062.Metal3 0.0325565f
Cred_8094 vin.$662.Metal2 vout.P22.pSD 9.56026e-05f
Cred_8095 vin.$662.Metal2 vout.P24.nSD 0.000177617f
Cred_8096 vin.$662.Metal2 vout.P24.pSD 0.0153118f
Cred_8097 vin.$662.Metal2 vout.P26.pSD 9.80294e-05f
Cred_8098 vin.$662.Metal2 VSS.$238.Metal1 8.05434e-05f
Cred_8099 vin.$662.Metal2 VSS.$254.Metal1 8.05785e-05f
Cred_8100 vin.$662.Metal2 VSS.$695.Metal2 0.000466641f
Cred_8101 vin.$662.Metal2 VSS.$702.Metal2 0.000171102f
Cred_8102 vin.$662.Metal2 VSS.$706.Metal2 0.000155709f
Cred_8103 vin.$662.Metal2 VSS.$713.Metal2 0.000482697f
Cred_8104 vin.$662.Metal2 VSS.P25.nSD 9.32621e-06f
Cred_8105 vin.$662.Metal2 VSS.P27.nSD 9.33034e-06f
Cred_8106 vin.$665.Metal2 vout.$1044.Metal3 0.00218079f
Cred_8107 vin.$665.Metal2 vout.$1062.Metal3 0.0337177f
Cred_8108 vin.$665.Metal2 vout.P24.nSD 7.4369e-05f
Cred_8109 vin.$665.Metal2 vout.P24.pSD 3.55364e-05f
Cred_8110 vin.$665.Metal2 vout.P26.nSD 0.00515631f
Cred_8111 vin.$665.Metal2 VSS 7.46449e-06f
Cred_8112 vin.$665.Metal2 VSS.$14.Metal1 2.30197e-05f
Cred_8113 vin.$665.Metal2 VSS.$238.Metal1 3.15102e-07f
Cred_8114 vin.$665.Metal2 VSS.$254.Metal1 0.0016822f
Cred_8115 vin.$665.Metal2 VSS.$29.Metal1 3.87345e-05f
Cred_8116 vin.$665.Metal2 VSS.$520.Metal1 6.36722e-05f
Cred_8117 vin.$665.Metal2 VSS.$702.Metal2 1.77814e-09f
Cred_8118 vin.$665.Metal2 VSS.$706.Metal2 0.00517165f
Cred_8119 vin.$665.Metal2 VSS.$713.Metal2 0.0167906f
Cred_8120 vin.$665.Metal2 VSS.$721.Metal2 0.000758489f
Cred_8121 vin.$665.Metal2 VSS.$982.Metal3 6.08139e-06f
Cred_8122 vin.$665.Metal2 VSS.P0.pSD 0.00593455f
Cred_8123 vin.$665.Metal2 VSS.P27.nSD 0.00019917f
Cred_8124 vin.$666.Metal2 vout.$1044.Metal3 0.00227248f
Cred_8125 vin.$666.Metal2 vout.$1062.Metal3 0.0353193f
Cred_8126 vin.$666.Metal2 vout.$1080.Metal3 0.000261554f
Cred_8127 vin.$666.Metal2 vout.P24.nSD 1.36509e-05f
Cred_8128 vin.$666.Metal2 vout.P24.pSD 0.000223575f
Cred_8129 vin.$666.Metal2 vout.P26.pSD 0.0074322f
Cred_8130 vin.$666.Metal2 vout.P28.nSD 1.57117e-06f
Cred_8131 vin.$666.Metal2 vout.P28.pSD 4.26206e-06f
Cred_8132 vin.$666.Metal2 VSS.$254.Metal1 8.05761e-05f
Cred_8133 vin.$666.Metal2 VSS.$706.Metal2 0.000155704f
Cred_8134 vin.$666.Metal2 VSS.$713.Metal2 0.000482683f
Cred_8135 vin.$666.Metal2 VSS.P27.nSD 9.33007e-06f
Cred_8136 vin.$668.Metal2 vout.$1044.Metal3 0.000170873f
Cred_8137 vin.$668.Metal2 vout.$1062.Metal3 0.0976637f
Cred_8138 vin.$668.Metal2 vout.$1080.Metal3 9.22943e-05f
Cred_8139 vin.$668.Metal2 vout.P24.nSD 1.02645e-06f
Cred_8140 vin.$668.Metal2 vout.P24.pSD 2.78441e-06f
Cred_8141 vin.$668.Metal2 vout.P26.nSD 0.000378381f
Cred_8142 vin.$668.Metal2 vout.P26.pSD 0.000423023f
Cred_8143 vin.$668.Metal2 vout.P28.nSD 5.54417e-07f
Cred_8144 vin.$668.Metal2 vout.P28.pSD 1.50395e-06f
Cred_8145 vin.$668.Metal2 VSS.$14.Metal1 0.000158507f
Cred_8146 vin.$668.Metal2 VSS.$254.Metal1 0.000211885f
Cred_8147 vin.$668.Metal2 VSS.$270.Metal1 0.000211885f
Cred_8148 vin.$668.Metal2 VSS.$29.Metal1 0.000266715f
Cred_8149 vin.$668.Metal2 VSS.$520.Metal1 0.000471927f
Cred_8150 vin.$668.Metal2 VSS.$706.Metal2 0.000746103f
Cred_8151 vin.$668.Metal2 VSS.$713.Metal2 0.00231292f
Cred_8152 vin.$668.Metal2 VSS.$721.Metal2 0.00231292f
Cred_8153 vin.$668.Metal2 VSS.$728.Metal2 0.000746103f
Cred_8154 vin.$668.Metal2 VSS.P0.pSD 0.0424873f
Cred_8155 vin.$668.Metal2 VSS.P27.nSD 2.45323e-05f
Cred_8156 vin.$668.Metal2 VSS.P29.nSD 2.45323e-05f
Cred_8157 vin.$670.Metal2 vout.$1044.Metal3 0.000215383f
Cred_8158 vin.$670.Metal2 vout.$1062.Metal3 0.0323615f
Cred_8159 vin.$670.Metal2 vout.$1080.Metal3 0.00194864f
Cred_8160 vin.$670.Metal2 vout.P24.nSD 1.29382e-06f
Cred_8161 vin.$670.Metal2 vout.P24.pSD 3.50971e-06f
Cred_8162 vin.$670.Metal2 vout.P26.nSD 0.00459341f
Cred_8163 vin.$670.Metal2 vout.P28.nSD 5.8947e-05f
Cred_8164 vin.$670.Metal2 vout.P28.pSD 3.17534e-05f
Cred_8165 vin.$670.Metal2 VSS 1.13469e-05f
Cred_8166 vin.$670.Metal2 VSS.$14.Metal1 2.17553e-05f
Cred_8167 vin.$670.Metal2 VSS.$270.Metal1 0.00168355f
Cred_8168 vin.$670.Metal2 VSS.$29.Metal1 3.6607e-05f
Cred_8169 vin.$670.Metal2 VSS.$520.Metal1 7.01497e-05f
Cred_8170 vin.$670.Metal2 VSS.$713.Metal2 0.000502734f
Cred_8171 vin.$670.Metal2 VSS.$721.Metal2 0.0164999f
Cred_8172 vin.$670.Metal2 VSS.$728.Metal2 0.00516036f
Cred_8173 vin.$670.Metal2 VSS.$982.Metal3 4.03081e-06f
Cred_8174 vin.$670.Metal2 VSS.P0.pSD 0.00605613f
Cred_8175 vin.$670.Metal2 VSS.P29.nSD 0.000197383f
Cred_8176 vin.$671.Metal2 vout.$1044.Metal3 0.000268857f
Cred_8177 vin.$671.Metal2 vout.$1062.Metal3 0.031133f
Cred_8178 vin.$671.Metal2 vout.$1080.Metal3 0.00224808f
Cred_8179 vin.$671.Metal2 vout.P24.nSD 1.61504e-06f
Cred_8180 vin.$671.Metal2 vout.P24.pSD 4.38107e-06f
Cred_8181 vin.$671.Metal2 vout.P26.pSD 0.00714975f
Cred_8182 vin.$671.Metal2 vout.P28.nSD 1.35043e-05f
Cred_8183 vin.$671.Metal2 vout.P28.pSD 0.000208196f
Cred_8184 vin.$671.Metal2 VSS.$270.Metal1 8.05754e-05f
Cred_8185 vin.$671.Metal2 VSS.$721.Metal2 0.000482679f
Cred_8186 vin.$671.Metal2 VSS.$728.Metal2 0.000155703f
Cred_8187 vin.$671.Metal2 VSS.P29.nSD 9.32999e-06f
Cred_8188 vin.$674.Metal2 vout.$1062.Metal3 0.0309635f
Cred_8189 vin.$674.Metal2 vout.$1080.Metal3 0.0289703f
Cred_8190 vin.$674.Metal2 vout.P26.nSD 3.18428e-05f
Cred_8191 vin.$674.Metal2 vout.P28.nSD 0.0116279f
Cred_8192 vin.$674.Metal2 vout.P28.pSD 0.000472075f
Cred_8193 vin.$674.Metal2 VSS.$14.Metal1 2.86383e-05f
Cred_8194 vin.$674.Metal2 VSS.$270.Metal1 0.0016648f
Cred_8195 vin.$674.Metal2 VSS.$286.Metal1 1.35923e-05f
Cred_8196 vin.$674.Metal2 VSS.$29.Metal1 4.81887e-05f
Cred_8197 vin.$674.Metal2 VSS.$520.Metal1 0.000143847f
Cred_8198 vin.$674.Metal2 VSS.$721.Metal2 0.0110166f
Cred_8199 vin.$674.Metal2 VSS.$728.Metal2 0.00547937f
Cred_8200 vin.$674.Metal2 VSS.$732.Metal2 0.00219506f
Cred_8201 vin.$674.Metal2 VSS.$739.Metal2 7.0118e-07f
Cred_8202 vin.$674.Metal2 VSS.P0.pSD 0.0100083f
Cred_8203 vin.$674.Metal2 VSS.P29.nSD 0.000196604f
Cred_8204 vin.$674.Metal2 VSS.P31.nSD 3.47155e-06f
Cred_8205 vin.$676.Metal2 vout.$1062.Metal3 0.0428073f
Cred_8206 vin.$676.Metal2 vout.$1080.Metal3 0.0428407f
Cred_8207 vin.$676.Metal2 vout.P28.nSD 0.000258585f
Cred_8208 vin.$676.Metal2 vout.P28.pSD 0.000702977f
Cred_8209 vin.$676.Metal2 vout.P30.pSD 1.65912e-06f
Cred_8210 vin.$676.Metal2 VSS.$14.Metal1 0.000126453f
Cred_8211 vin.$676.Metal2 VSS.$270.Metal1 0.000179614f
Cred_8212 vin.$676.Metal2 VSS.$286.Metal1 0.000219783f
Cred_8213 vin.$676.Metal2 VSS.$29.Metal1 0.000212779f
Cred_8214 vin.$676.Metal2 VSS.$520.Metal1 0.000626344f
Cred_8215 vin.$676.Metal2 VSS.$721.Metal2 0.00192022f
Cred_8216 vin.$676.Metal2 VSS.$728.Metal2 0.000619427f
Cred_8217 vin.$676.Metal2 VSS.$732.Metal2 0.000765785f
Cred_8218 vin.$676.Metal2 VSS.$739.Metal2 0.0020885f
Cred_8219 vin.$676.Metal2 VSS.P0.pSD 0.043953f
Cred_8220 vin.$676.Metal2 VSS.P29.nSD 2.0796e-05f
Cred_8221 vin.$676.Metal2 VSS.P31.nSD 2.54469e-05f
Cred_8222 vin.$678.Metal2 vout.$1062.Metal3 0.0326915f
Cred_8223 vin.$678.Metal2 vout.$1080.Metal3 0.0327038f
Cred_8224 vin.$678.Metal2 vout.P26.pSD 9.80257e-05f
Cred_8225 vin.$678.Metal2 vout.P28.nSD 0.000178292f
Cred_8226 vin.$678.Metal2 vout.P28.pSD 0.0152441f
Cred_8227 vin.$678.Metal2 vout.P30.pSD 9.63868e-05f
Cred_8228 vin.$678.Metal2 VSS.$270.Metal1 8.05754e-05f
Cred_8229 vin.$678.Metal2 VSS.$286.Metal1 8.1204e-05f
Cred_8230 vin.$678.Metal2 VSS.$721.Metal2 0.000482679f
Cred_8231 vin.$678.Metal2 VSS.$728.Metal2 0.000155703f
Cred_8232 vin.$678.Metal2 VSS.$732.Metal2 0.000172505f
Cred_8233 vin.$678.Metal2 VSS.$739.Metal2 0.000470469f
Cred_8234 vin.$678.Metal2 VSS.P29.nSD 9.32999e-06f
Cred_8235 vin.$678.Metal2 VSS.P31.nSD 9.40271e-06f
Cred_8236 vin.$679.Metal2 vout.$1062.Metal3 0.00378547f
Cred_8237 vin.$679.Metal2 vout.$1080.Metal3 0.0078117f
Cred_8238 vin.$679.Metal2 vout.P28.nSD 0.000139321f
Cred_8239 vin.$679.Metal2 vout.P28.pSD 6.16849e-05f
Cred_8240 vin.$679.Metal2 vout.P30.nSD 6.43212e-05f
Cred_8241 vin.$679.Metal2 VSS.$14.Metal1 4.0599e-06f
Cred_8242 vin.$679.Metal2 VSS.$270.Metal1 7.98617e-07f
Cred_8243 vin.$679.Metal2 VSS.$286.Metal1 0.00323998f
Cred_8244 vin.$679.Metal2 VSS.$29.Metal1 6.83145e-06f
Cred_8245 vin.$679.Metal2 VSS.$520.Metal1 2.29609e-05f
Cred_8246 vin.$679.Metal2 VSS.$728.Metal2 4.65698e-09f
Cred_8247 vin.$679.Metal2 VSS.$732.Metal2 0.00763952f
Cred_8248 vin.$679.Metal2 VSS.$739.Metal2 0.020835f
Cred_8249 vin.$679.Metal2 VSS.P0.pSD 0.00151272f
Cred_8250 vin.$679.Metal2 VSS.P31.nSD 0.0014251f
Cred_8251 vin.$68.GatPoly vout.$1008.Metal3 0.000988791f
Cred_8252 vin.$68.GatPoly vout.$990.Metal3 3.7194e-05f
Cred_8253 vin.$68.GatPoly vout.P12.nSD 0.000123433f
Cred_8254 vin.$68.GatPoly vout.P12.pSD 6.06082e-07f
Cred_8255 vin.$68.GatPoly vout.P14.nSD 0.00155781f
Cred_8256 vin.$68.GatPoly VSS.$14.Metal1 9.37644e-06f
Cred_8257 vin.$68.GatPoly VSS.$152.Metal1 0.00356089f
Cred_8258 vin.$68.GatPoly VSS.$29.Metal1 1.57774e-05f
Cred_8259 vin.$68.GatPoly VSS.$520.Metal1 9.51895e-07f
Cred_8260 vin.$68.GatPoly VSS.$628.Metal2 4.57371e-05f
Cred_8261 vin.$68.GatPoly VSS.$635.Metal2 0.000222152f
Cred_8262 vin.$68.GatPoly VSS.P0.pSD 0.000458288f
Cred_8263 vin.$68.GatPoly VSS.P15.nSD 0.000246082f
Cred_8264 vin.$681.Metal2 vout.$1080.Metal3 0.0415915f
Cred_8265 vin.$681.Metal2 vout.P30.nSD 0.00722432f
Cred_8266 vin.$681.Metal2 VSS.$14.Metal1 1.34097e-05f
Cred_8267 vin.$681.Metal2 VSS.$286.Metal1 2.26314e-05f
Cred_8268 vin.$681.Metal2 VSS.$29.Metal1 2.2564e-05f
Cred_8269 vin.$681.Metal2 VSS.$298.Metal1 9.55778e-06f
Cred_8270 vin.$681.Metal2 VSS.$304.Metal1 8.49683e-05f
Cred_8271 vin.$681.Metal2 VSS.$520.Metal1 0.000114458f
Cred_8272 vin.$681.Metal2 VSS.$732.Metal2 0.00200273f
Cred_8273 vin.$681.Metal2 VSS.$739.Metal2 0.00577126f
Cred_8274 vin.$681.Metal2 VSS.$747.Metal2 0.00282342f
Cred_8275 vin.$681.Metal2 VSS.$754.Metal2 0.000707115f
Cred_8276 vin.$681.Metal2 VSS.$992.Metal3 2.47935e-06f
Cred_8277 vin.$681.Metal2 VSS.P0.pSD 0.00612578f
Cred_8278 vin.$681.Metal2 VSS.P31.nSD 9.39204e-07f
Cred_8279 vin.$681.Metal2 VSS.P33.nSD 9.69669e-06f
Cred_8280 vin.$682.Metal2 vout.$1062.Metal3 0.00213131f
Cred_8281 vin.$682.Metal2 vout.$1080.Metal3 0.0364982f
Cred_8282 vin.$682.Metal2 vout.$1098.Metal3 0.000251116f
Cred_8283 vin.$682.Metal2 vout.P28.nSD 1.27233e-05f
Cred_8284 vin.$682.Metal2 vout.P28.pSD 0.000192674f
Cred_8285 vin.$682.Metal2 vout.P30.pSD 0.00786083f
Cred_8286 vin.$682.Metal2 vout.P32.nSD 1.50846e-06f
Cred_8287 vin.$682.Metal2 vout.P32.pSD 4.09197e-06f
Cred_8288 vin.$682.Metal2 VSS.$286.Metal1 8.25677e-05f
Cred_8289 vin.$682.Metal2 VSS.$732.Metal2 0.000175402f
Cred_8290 vin.$682.Metal2 VSS.$739.Metal2 0.00047837f
Cred_8291 vin.$682.Metal2 VSS.P31.nSD 9.56061e-06f
Cred_8292 vin.$684.Metal2 vout.$1062.Metal3 7.63101e-05f
Cred_8293 vin.$684.Metal2 vout.$1080.Metal3 0.0994961f
Cred_8294 vin.$684.Metal2 vout.$1098.Metal3 8.42884e-05f
Cred_8295 vin.$684.Metal2 vout.P28.nSD 4.58399e-07f
Cred_8296 vin.$684.Metal2 vout.P28.pSD 1.24349e-06f
Cred_8297 vin.$684.Metal2 vout.P30.nSD 0.000916962f
Cred_8298 vin.$684.Metal2 vout.P30.pSD 0.000419934f
Cred_8299 vin.$684.Metal2 vout.P32.nSD 5.06325e-07f
Cred_8300 vin.$684.Metal2 vout.P32.pSD 1.37349e-06f
Cred_8301 vin.$684.Metal2 VSS.$14.Metal1 0.000101325f
Cred_8302 vin.$684.Metal2 VSS.$286.Metal1 0.000189748f
Cred_8303 vin.$684.Metal2 VSS.$29.Metal1 0.000170495f
Cred_8304 vin.$684.Metal2 VSS.$298.Metal1 1.05758e-06f
Cred_8305 vin.$684.Metal2 VSS.$304.Metal1 0.000232285f
Cred_8306 vin.$684.Metal2 VSS.$520.Metal1 0.000827963f
Cred_8307 vin.$684.Metal2 VSS.$732.Metal2 0.000778476f
Cred_8308 vin.$684.Metal2 VSS.$739.Metal2 0.00222691f
Cred_8309 vin.$684.Metal2 VSS.$747.Metal2 0.00327148f
Cred_8310 vin.$684.Metal2 VSS.$754.Metal2 0.00089091f
Cred_8311 vin.$684.Metal2 VSS.$992.Metal3 8.32207e-07f
Cred_8312 vin.$684.Metal2 VSS.P0.pSD 0.0453546f
Cred_8313 vin.$684.Metal2 VSS.P31.nSD 2.19687e-05f
Cred_8314 vin.$684.Metal2 VSS.P33.nSD 2.68472e-05f
Cred_8315 vin.$687.Metal2 vout.$1062.Metal3 0.000206198f
Cred_8316 vin.$687.Metal2 vout.$1080.Metal3 0.0299201f
Cred_8317 vin.$687.Metal2 vout.$1098.Metal3 0.0024832f
Cred_8318 vin.$687.Metal2 vout.P28.nSD 1.23864e-06f
Cred_8319 vin.$687.Metal2 vout.P28.pSD 3.36003e-06f
Cred_8320 vin.$687.Metal2 vout.P30.pSD 0.00672416f
Cred_8321 vin.$687.Metal2 vout.P32.nSD 1.47959e-05f
Cred_8322 vin.$687.Metal2 vout.P32.pSD 0.000228481f
Cred_8323 vin.$687.Metal2 VSS.$304.Metal1 7.74088e-05f
Cred_8324 vin.$687.Metal2 VSS.$747.Metal2 0.000478985f
Cred_8325 vin.$687.Metal2 VSS.$754.Metal2 0.000134715f
Cred_8326 vin.$687.Metal2 VSS.P33.nSD 8.96339e-06f
Cred_8327 vin.$688.Metal2 vout.$1080.Metal3 0.0208487f
Cred_8328 vin.$688.Metal2 vout.$1098.Metal3 0.00443033f
Cred_8329 vin.$688.Metal2 vout.P30.nSD 0.00196126f
Cred_8330 vin.$688.Metal2 vout.P32.nSD 0.000161768f
Cred_8331 vin.$688.Metal2 vout.P32.pSD 7.21929e-05f
Cred_8332 vin.$688.Metal2 VSS.$14.Metal1 8.15958e-06f
Cred_8333 vin.$688.Metal2 VSS.$29.Metal1 1.37298e-05f
Cred_8334 vin.$688.Metal2 VSS.$298.Metal1 3.70538e-06f
Cred_8335 vin.$688.Metal2 VSS.$304.Metal1 0.00326083f
Cred_8336 vin.$688.Metal2 VSS.$320.Metal1 6.64607e-07f
Cred_8337 vin.$688.Metal2 VSS.$520.Metal1 8.17211e-05f
Cred_8338 vin.$688.Metal2 VSS.$739.Metal2 0.00036366f
Cred_8339 vin.$688.Metal2 VSS.$747.Metal2 0.0250397f
Cred_8340 vin.$688.Metal2 VSS.$754.Metal2 0.00694015f
Cred_8341 vin.$688.Metal2 VSS.$758.Metal2 3.62533e-09f
Cred_8342 vin.$688.Metal2 VSS.$992.Metal3 2.91575e-06f
Cred_8343 vin.$688.Metal2 VSS.P0.pSD 0.00403195f
Cred_8344 vin.$688.Metal2 VSS.P33.nSD 0.000387579f
Cred_8345 vin.$69.GatPoly vout.$1008.Metal3 0.00606653f
Cred_8346 vin.$69.GatPoly vout.$990.Metal3 0.000303925f
Cred_8347 vin.$69.GatPoly vout.P12.nSD 1.8257e-06f
Cred_8348 vin.$69.GatPoly vout.P12.pSD 0.000610584f
Cred_8349 vin.$69.GatPoly vout.P14.pSD 0.00590601f
Cred_8350 vin.$691.Metal2 vout.$1080.Metal3 0.0434603f
Cred_8351 vin.$691.Metal2 vout.$1098.Metal3 0.0434117f
Cred_8352 vin.$691.Metal2 vout.P30.pSD 2.46844e-06f
Cred_8353 vin.$691.Metal2 vout.P32.nSD 0.000262885f
Cred_8354 vin.$691.Metal2 vout.P32.pSD 0.000716164f
Cred_8355 vin.$691.Metal2 VSS.$14.Metal1 7.46196e-05f
Cred_8356 vin.$691.Metal2 VSS.$29.Metal1 0.00012556f
Cred_8357 vin.$691.Metal2 VSS.$304.Metal1 0.000205481f
Cred_8358 vin.$691.Metal2 VSS.$320.Metal1 0.000204072f
Cred_8359 vin.$691.Metal2 VSS.$520.Metal1 0.00101362f
Cred_8360 vin.$691.Metal2 VSS.$747.Metal2 0.00214635f
Cred_8361 vin.$691.Metal2 VSS.$754.Metal2 0.000603662f
Cred_8362 vin.$691.Metal2 VSS.$758.Metal2 0.000798562f
Cred_8363 vin.$691.Metal2 VSS.$765.Metal2 0.00192986f
Cred_8364 vin.$691.Metal2 VSS.P0.pSD 0.0430325f
Cred_8365 vin.$691.Metal2 VSS.P33.nSD 2.37916e-05f
Cred_8366 vin.$691.Metal2 VSS.P35.nSD 2.36275e-05f
Cred_8367 vin.$693.Metal2 vout.$1080.Metal3 0.0284892f
Cred_8368 vin.$693.Metal2 vout.$1098.Metal3 0.0304824f
Cred_8369 vin.$693.Metal2 vout.P32.nSD 0.0115801f
Cred_8370 vin.$693.Metal2 vout.P32.pSD 0.000464235f
Cred_8371 vin.$693.Metal2 vout.P34.nSD 3.18427e-05f
Cred_8372 vin.$693.Metal2 VSS.$14.Metal1 1.65409e-05f
Cred_8373 vin.$693.Metal2 VSS.$29.Metal1 2.78328e-05f
Cred_8374 vin.$693.Metal2 VSS.$304.Metal1 1.07685e-05f
Cred_8375 vin.$693.Metal2 VSS.$320.Metal1 0.00160113f
Cred_8376 vin.$693.Metal2 VSS.$520.Metal1 0.000233823f
Cred_8377 vin.$693.Metal2 VSS.$747.Metal2 6.62415e-07f
Cred_8378 vin.$693.Metal2 VSS.$754.Metal2 0.00175125f
Cred_8379 vin.$693.Metal2 VSS.$758.Metal2 0.00646642f
Cred_8380 vin.$693.Metal2 VSS.$765.Metal2 0.00999093f
Cred_8381 vin.$693.Metal2 VSS.P0.pSD 0.00971478f
Cred_8382 vin.$693.Metal2 VSS.P33.nSD 3.55717e-06f
Cred_8383 vin.$693.Metal2 VSS.P35.nSD 0.00076159f
Cred_8384 vin.$694.Metal2 vout.$1080.Metal3 0.0324896f
Cred_8385 vin.$694.Metal2 vout.$1098.Metal3 0.0325373f
Cred_8386 vin.$694.Metal2 vout.P30.pSD 9.5603e-05f
Cred_8387 vin.$694.Metal2 vout.P32.nSD 0.000177328f
Cred_8388 vin.$694.Metal2 vout.P32.pSD 0.0152688f
Cred_8389 vin.$694.Metal2 vout.P34.pSD 9.80284e-05f
Cred_8390 vin.$694.Metal2 VSS.$304.Metal1 7.553e-05f
Cred_8391 vin.$694.Metal2 VSS.$320.Metal1 8.26263e-05f
Cred_8392 vin.$694.Metal2 VSS.$747.Metal2 0.00046736f
Cred_8393 vin.$694.Metal2 VSS.$754.Metal2 0.000131445f
Cred_8394 vin.$694.Metal2 VSS.$758.Metal2 0.00019138f
Cred_8395 vin.$694.Metal2 VSS.$765.Metal2 0.000462501f
Cred_8396 vin.$694.Metal2 VSS.P33.nSD 8.74584e-06f
Cred_8397 vin.$694.Metal2 VSS.P35.nSD 9.56733e-06f
Cred_8398 vin.$697.Metal2 vout.$1080.Metal3 0.00168359f
Cred_8399 vin.$697.Metal2 vout.$1098.Metal3 0.0462538f
Cred_8400 vin.$697.Metal2 vout.P32.nSD 5.12064e-05f
Cred_8401 vin.$697.Metal2 vout.P32.pSD 2.74343e-05f
Cred_8402 vin.$697.Metal2 vout.P34.nSD 0.00751302f
Cred_8403 vin.$697.Metal2 VSS.$1002.Metal3 2.57617e-06f
Cred_8404 vin.$697.Metal2 VSS.$14.Metal1 9.21693e-06f
Cred_8405 vin.$697.Metal2 VSS.$29.Metal1 1.5509e-05f
Cred_8406 vin.$697.Metal2 VSS.$320.Metal1 0.00162304f
Cred_8407 vin.$697.Metal2 VSS.$332.Metal1 9.57778e-06f
Cred_8408 vin.$697.Metal2 VSS.$338.Metal1 0.000140036f
Cred_8409 vin.$697.Metal2 VSS.$520.Metal1 0.000210327f
Cred_8410 vin.$697.Metal2 VSS.$758.Metal2 0.00626245f
Cred_8411 vin.$697.Metal2 VSS.$765.Metal2 0.0154556f
Cred_8412 vin.$697.Metal2 VSS.$773.Metal2 0.00326497f
Cred_8413 vin.$697.Metal2 VSS.$780.Metal2 0.000713615f
Cred_8414 vin.$697.Metal2 VSS.P0.pSD 0.00684331f
Cred_8415 vin.$697.Metal2 VSS.P35.nSD 0.000762555f
Cred_8416 vin.$697.Metal2 VSS.P37.nSD 1.71561e-05f
Cred_8417 vin.$698.Metal2 vout.$1080.Metal3 0.00195999f
Cred_8418 vin.$698.Metal2 vout.$1098.Metal3 0.0377259f
Cred_8419 vin.$698.Metal2 vout.$1116.Metal3 0.000263077f
Cred_8420 vin.$698.Metal2 vout.P32.nSD 1.17737e-05f
Cred_8421 vin.$698.Metal2 vout.P32.pSD 0.000186213f
Cred_8422 vin.$698.Metal2 vout.P34.pSD 0.00829304f
Cred_8423 vin.$698.Metal2 vout.P36.nSD 1.58032e-06f
Cred_8424 vin.$698.Metal2 vout.P36.pSD 4.28688e-06f
Cred_8425 vin.$698.Metal2 VSS.$320.Metal1 8.26241e-05f
Cred_8426 vin.$698.Metal2 VSS.$758.Metal2 0.000191375f
Cred_8427 vin.$698.Metal2 VSS.$765.Metal2 0.000462489f
Cred_8428 vin.$698.Metal2 VSS.P35.nSD 9.56708e-06f
Cred_8429 vin.$700.Metal2 vout.$1080.Metal3 8.3775e-05f
Cred_8430 vin.$700.Metal2 vout.$1098.Metal3 0.0990896f
Cred_8431 vin.$700.Metal2 vout.$1116.Metal3 8.3775e-05f
Cred_8432 vin.$700.Metal2 vout.P32.nSD 5.03241e-07f
Cred_8433 vin.$700.Metal2 vout.P32.pSD 1.36513e-06f
Cred_8434 vin.$700.Metal2 vout.P34.nSD 0.000835147f
Cred_8435 vin.$700.Metal2 vout.P34.pSD 0.000410651f
Cred_8436 vin.$700.Metal2 vout.P36.nSD 5.03241e-07f
Cred_8437 vin.$700.Metal2 vout.P36.pSD 1.36513e-06f
Cred_8438 vin.$700.Metal2 VSS.$1002.Metal3 8.20361e-07f
Cred_8439 vin.$700.Metal2 VSS.$14.Metal1 6.0847e-05f
Cred_8440 vin.$700.Metal2 VSS.$29.Metal1 0.000102385f
Cred_8441 vin.$700.Metal2 VSS.$320.Metal1 0.000204429f
Cred_8442 vin.$700.Metal2 VSS.$332.Metal1 1.07195e-06f
Cred_8443 vin.$700.Metal2 VSS.$338.Metal1 0.000248103f
Cred_8444 vin.$700.Metal2 VSS.$520.Metal1 0.00137589f
Cred_8445 vin.$700.Metal2 VSS.$758.Metal2 0.000888659f
Cred_8446 vin.$700.Metal2 VSS.$765.Metal2 0.00224991f
Cred_8447 vin.$700.Metal2 VSS.$773.Metal2 0.00342097f
Cred_8448 vin.$700.Metal2 VSS.$780.Metal2 0.000804521f
Cred_8449 vin.$700.Metal2 VSS.P0.pSD 0.0450995f
Cred_8450 vin.$700.Metal2 VSS.P35.nSD 2.36683e-05f
Cred_8451 vin.$700.Metal2 VSS.P37.nSD 2.90265e-05f
Cred_8452 vin.$703.Metal2 vout.$1080.Metal3 0.000216308f
Cred_8453 vin.$703.Metal2 vout.$1098.Metal3 0.0288768f
Cred_8454 vin.$703.Metal2 vout.$1116.Metal3 0.0027644f
Cred_8455 vin.$703.Metal2 vout.P32.nSD 1.29937e-06f
Cred_8456 vin.$703.Metal2 vout.P32.pSD 3.52477e-06f
Cred_8457 vin.$703.Metal2 vout.P34.pSD 0.00629966f
Cred_8458 vin.$703.Metal2 vout.P36.nSD 1.64076e-05f
Cred_8459 vin.$703.Metal2 vout.P36.pSD 0.000254672f
Cred_8460 vin.$703.Metal2 VSS.$338.Metal1 7.42034e-05f
Cred_8461 vin.$703.Metal2 VSS.$773.Metal2 0.000473842f
Cred_8462 vin.$703.Metal2 VSS.$780.Metal2 0.000114871f
Cred_8463 vin.$703.Metal2 VSS.P37.nSD 8.5923e-06f
Cred_8464 vin.$704.Metal2 vout.$1098.Metal3 0.0207421f
Cred_8465 vin.$704.Metal2 vout.$1116.Metal3 0.00491795f
Cred_8466 vin.$704.Metal2 vout.P34.nSD 0.00179132f
Cred_8467 vin.$704.Metal2 vout.P36.nSD 0.000177716f
Cred_8468 vin.$704.Metal2 vout.P36.pSD 8.01388e-05f
Cred_8469 vin.$704.Metal2 VSS.$1002.Metal3 3.02636e-06f
Cred_8470 vin.$704.Metal2 VSS.$14.Metal1 5.06536e-06f
Cred_8471 vin.$704.Metal2 VSS.$29.Metal1 8.52331e-06f
Cred_8472 vin.$704.Metal2 VSS.$332.Metal1 3.95448e-06f
Cred_8473 vin.$704.Metal2 VSS.$338.Metal1 0.00320962f
Cred_8474 vin.$704.Metal2 VSS.$354.Metal1 1.63817e-06f
Cred_8475 vin.$704.Metal2 VSS.$520.Metal1 0.000143651f
Cred_8476 vin.$704.Metal2 VSS.$765.Metal2 0.000377457f
Cred_8477 vin.$704.Metal2 VSS.$773.Metal2 0.0254939f
Cred_8478 vin.$704.Metal2 VSS.$780.Metal2 0.00608887f
Cred_8479 vin.$704.Metal2 VSS.$784.Metal2 8.62767e-09f
Cred_8480 vin.$704.Metal2 VSS.P0.pSD 0.0041787f
Cred_8481 vin.$704.Metal2 VSS.P37.nSD 0.000382987f
Cred_8482 vin.$707.Metal2 vout.$1098.Metal3 0.0439254f
Cred_8483 vin.$707.Metal2 vout.$1116.Metal3 0.0438458f
Cred_8484 vin.$707.Metal2 vout.P34.pSD 4.04944e-06f
Cred_8485 vin.$707.Metal2 vout.P36.nSD 0.000266739f
Cred_8486 vin.$707.Metal2 vout.P36.pSD 0.000729541f
Cred_8487 vin.$707.Metal2 VSS.$14.Metal1 4.47626e-05f
Cred_8488 vin.$707.Metal2 VSS.$29.Metal1 7.53205e-05f
Cred_8489 vin.$707.Metal2 VSS.$338.Metal1 0.000206386f
Cred_8490 vin.$707.Metal2 VSS.$354.Metal1 0.000203387f
Cred_8491 vin.$707.Metal2 VSS.$520.Metal1 0.00169072f
Cred_8492 vin.$707.Metal2 VSS.$773.Metal2 0.00222497f
Cred_8493 vin.$707.Metal2 VSS.$780.Metal2 0.000539386f
Cred_8494 vin.$707.Metal2 VSS.$784.Metal2 0.000863642f
Cred_8495 vin.$707.Metal2 VSS.$791.Metal2 0.00186015f
Cred_8496 vin.$707.Metal2 VSS.P0.pSD 0.0425931f
Cred_8497 vin.$707.Metal2 VSS.P37.nSD 2.38967e-05f
Cred_8498 vin.$707.Metal2 VSS.P39.nSD 2.35479e-05f
Cred_8499 vin.$709.Metal2 vout.$1098.Metal3 0.0278948f
Cred_8500 vin.$709.Metal2 vout.$1116.Metal3 0.029888f
Cred_8501 vin.$709.Metal2 vout.P36.nSD 0.0114543f
Cred_8502 vin.$709.Metal2 vout.P36.pSD 0.00045455f
Cred_8503 vin.$709.Metal2 vout.P38.nSD 3.18426e-05f
Cred_8504 vin.$709.Metal2 VSS.$14.Metal1 9.48033e-06f
Cred_8505 vin.$709.Metal2 VSS.$29.Metal1 1.59522e-05f
Cred_8506 vin.$709.Metal2 VSS.$338.Metal1 1.10325e-05f
Cred_8507 vin.$709.Metal2 VSS.$354.Metal1 0.0016061f
Cred_8508 vin.$709.Metal2 VSS.$520.Metal1 0.000372886f
Cred_8509 vin.$709.Metal2 VSS.$773.Metal2 6.21518e-07f
Cred_8510 vin.$709.Metal2 VSS.$780.Metal2 0.0015759f
Cred_8511 vin.$709.Metal2 VSS.$784.Metal2 0.00681403f
Cred_8512 vin.$709.Metal2 VSS.$791.Metal2 0.00966827f
Cred_8513 vin.$709.Metal2 VSS.P0.pSD 0.00918577f
Cred_8514 vin.$709.Metal2 VSS.P37.nSD 3.53339e-06f
Cred_8515 vin.$709.Metal2 VSS.P39.nSD 0.000819136f
Cred_8516 vin.$710.Metal2 vout.$1098.Metal3 0.0322276f
Cred_8517 vin.$710.Metal2 vout.$1116.Metal3 0.0323048f
Cred_8518 vin.$710.Metal2 vout.P34.pSD 9.41013e-05f
Cred_8519 vin.$710.Metal2 vout.P36.nSD 0.000176115f
Cred_8520 vin.$710.Metal2 vout.P36.pSD 0.0150418f
Cred_8521 vin.$710.Metal2 vout.P38.pSD 9.80278e-05f
Cred_8522 vin.$710.Metal2 VSS.$338.Metal1 7.13214e-05f
Cred_8523 vin.$710.Metal2 VSS.$354.Metal1 8.26606e-05f
Cred_8524 vin.$710.Metal2 VSS.$773.Metal2 0.000455439f
Cred_8525 vin.$710.Metal2 VSS.$780.Metal2 0.000110409f
Cred_8526 vin.$710.Metal2 VSS.$784.Metal2 0.000207315f
Cred_8527 vin.$710.Metal2 VSS.$791.Metal2 0.000446524f
Cred_8528 vin.$710.Metal2 VSS.P37.nSD 8.25858e-06f
Cred_8529 vin.$710.Metal2 VSS.P39.nSD 9.57125e-06f
Cred_8530 vin.$713.Metal2 vout.$1098.Metal3 0.00156391f
Cred_8531 vin.$713.Metal2 vout.$1116.Metal3 0.0492552f
Cred_8532 vin.$713.Metal2 vout.P36.nSD 4.74174e-05f
Cred_8533 vin.$713.Metal2 vout.P36.pSD 2.54841e-05f
Cred_8534 vin.$713.Metal2 vout.P38.nSD 0.00780652f
Cred_8535 vin.$713.Metal2 VSS.$1012.Metal3 2.67266e-06f
Cred_8536 vin.$713.Metal2 VSS.$14.Metal1 5.69459e-06f
Cred_8537 vin.$713.Metal2 VSS.$29.Metal1 9.58209e-06f
Cred_8538 vin.$713.Metal2 VSS.$354.Metal1 0.00162782f
Cred_8539 vin.$713.Metal2 VSS.$366.Metal1 9.4915e-06f
Cred_8540 vin.$713.Metal2 VSS.$372.Metal1 0.000249958f
Cred_8541 vin.$713.Metal2 VSS.$520.Metal1 0.000348564f
Cred_8542 vin.$713.Metal2 VSS.$784.Metal2 0.00676016f
Cred_8543 vin.$713.Metal2 VSS.$791.Metal2 0.0148937f
Cred_8544 vin.$713.Metal2 VSS.$799.Metal2 0.0036851f
Cred_8545 vin.$713.Metal2 VSS.$806.Metal2 0.000690068f
Cred_8546 vin.$713.Metal2 VSS.P0.pSD 0.00683386f
Cred_8547 vin.$713.Metal2 VSS.P39.nSD 0.00082013f
Cred_8548 vin.$713.Metal2 VSS.P41.nSD 3.01671e-05f
Cred_8549 vin.$714.Metal2 vout.$1098.Metal3 0.00168098f
Cred_8550 vin.$714.Metal2 vout.$1116.Metal3 0.0375565f
Cred_8551 vin.$714.Metal2 vout.P36.nSD 1.00977e-05f
Cred_8552 vin.$714.Metal2 vout.P36.pSD 0.000142319f
Cred_8553 vin.$714.Metal2 vout.P38.pSD 0.00865985f
Cred_8554 vin.$714.Metal2 VSS.$354.Metal1 8.26586e-05f
Cred_8555 vin.$714.Metal2 VSS.$784.Metal2 0.000207309f
Cred_8556 vin.$714.Metal2 VSS.$791.Metal2 0.000446513f
Cred_8557 vin.$714.Metal2 VSS.P39.nSD 9.57102e-06f
Cred_8558 vin.$716.Metal2 vout.$1098.Metal3 8.29169e-05f
Cred_8559 vin.$716.Metal2 vout.$1116.Metal3 0.0974359f
Cred_8560 vin.$716.Metal2 vout.P36.nSD 4.98086e-07f
Cred_8561 vin.$716.Metal2 vout.P36.pSD 1.35114e-06f
Cred_8562 vin.$716.Metal2 vout.P38.nSD 0.000734561f
Cred_8563 vin.$716.Metal2 vout.P38.pSD 0.000395137f
Cred_8564 vin.$716.Metal2 VSS.$1012.Metal3 8.05084e-07f
Cred_8565 vin.$716.Metal2 VSS.$14.Metal1 3.62489e-05f
Cred_8566 vin.$716.Metal2 VSS.$29.Metal1 6.09948e-05f
Cred_8567 vin.$716.Metal2 VSS.$354.Metal1 0.000203997f
Cred_8568 vin.$716.Metal2 VSS.$366.Metal1 1.07548e-06f
Cred_8569 vin.$716.Metal2 VSS.$372.Metal1 0.000259278f
Cred_8570 vin.$716.Metal2 VSS.$520.Metal1 0.00227496f
Cred_8571 vin.$716.Metal2 VSS.$784.Metal2 0.000967626f
Cred_8572 vin.$716.Metal2 VSS.$791.Metal2 0.00218453f
Cred_8573 vin.$716.Metal2 VSS.$799.Metal2 0.00342148f
Cred_8574 vin.$716.Metal2 VSS.$806.Metal2 0.00068375f
Cred_8575 vin.$716.Metal2 VSS.P0.pSD 0.0440538f
Cred_8576 vin.$716.Metal2 VSS.P39.nSD 2.3618e-05f
Cred_8577 vin.$716.Metal2 VSS.P41.nSD 3.03899e-05f
Cred_8578 vin.$719.Metal2 vout.$1098.Metal3 0.000204982f
Cred_8579 vin.$719.Metal2 vout.$1116.Metal3 0.027641f
Cred_8580 vin.$719.Metal2 vout.$1134.Metal3 0.00292631f
Cred_8581 vin.$719.Metal2 vout.P36.nSD 1.23134e-06f
Cred_8582 vin.$719.Metal2 vout.P36.pSD 3.34021e-06f
Cred_8583 vin.$719.Metal2 vout.P38.pSD 0.00587691f
Cred_8584 vin.$719.Metal2 vout.P40.nSD 1.71721e-05f
Cred_8585 vin.$719.Metal2 vout.P40.pSD 0.000279784f
Cred_8586 vin.$719.Metal2 VSS.$372.Metal1 6.83515e-05f
Cred_8587 vin.$719.Metal2 VSS.$799.Metal2 0.000450054f
Cred_8588 vin.$719.Metal2 VSS.$806.Metal2 9.26581e-05f
Cred_8589 vin.$719.Metal2 VSS.P41.nSD 7.91477e-06f
Cred_8590 vin.$72.GatPoly vout.$1008.Metal3 0.00101813f
Cred_8591 vin.$72.GatPoly vout.P14.nSD 0.0016748f
Cred_8592 vin.$72.GatPoly VSS.$14.Metal1 2.64024e-05f
Cred_8593 vin.$72.GatPoly VSS.$162.Metal1 3.50063e-06f
Cred_8594 vin.$72.GatPoly VSS.$170.Metal1 0.0025748f
Cred_8595 vin.$72.GatPoly VSS.$29.Metal1 4.44265e-05f
Cred_8596 vin.$72.GatPoly VSS.$520.Metal1 3.93727e-06f
Cred_8597 vin.$72.GatPoly VSS.$643.Metal2 0.000131813f
Cred_8598 vin.$72.GatPoly VSS.$650.Metal2 6.11897e-05f
Cred_8599 vin.$72.GatPoly VSS.P0.pSD 0.0015761f
Cred_8600 vin.$72.GatPoly VSS.P17.nSD 0.000177366f
Cred_8601 vin.$720.Metal2 vout.$1116.Metal3 0.0197883f
Cred_8602 vin.$720.Metal2 vout.$1134.Metal3 0.00555641f
Cred_8603 vin.$720.Metal2 vout.P38.nSD 0.00160379f
Cred_8604 vin.$720.Metal2 vout.P40.nSD 0.000159922f
Cred_8605 vin.$720.Metal2 vout.P40.pSD 9.05426e-05f
Cred_8606 vin.$720.Metal2 VSS.$1012.Metal3 3.13411e-06f
Cred_8607 vin.$720.Metal2 VSS.$14.Metal1 3.32286e-06f
Cred_8608 vin.$720.Metal2 VSS.$29.Metal1 5.59126e-06f
Cred_8609 vin.$720.Metal2 VSS.$366.Metal1 4.18673e-06f
Cred_8610 vin.$720.Metal2 VSS.$372.Metal1 0.00320707f
Cred_8611 vin.$720.Metal2 VSS.$388.Metal1 8.07342e-07f
Cred_8612 vin.$720.Metal2 VSS.$520.Metal1 0.000263101f
Cred_8613 vin.$720.Metal2 VSS.$791.Metal2 0.000390895f
Cred_8614 vin.$720.Metal2 VSS.$799.Metal2 0.0258737f
Cred_8615 vin.$720.Metal2 VSS.$806.Metal2 0.00524647f
Cred_8616 vin.$720.Metal2 VSS.$810.Metal2 4.10004e-09f
Cred_8617 vin.$720.Metal2 VSS.P0.pSD 0.00449249f
Cred_8618 vin.$720.Metal2 VSS.P41.nSD 0.000381265f
Cred_8619 vin.$723.Metal2 vout.$1116.Metal3 0.0442122f
Cred_8620 vin.$723.Metal2 vout.$1134.Metal3 0.0440396f
Cred_8621 vin.$723.Metal2 vout.P38.pSD 8.5277e-06f
Cred_8622 vin.$723.Metal2 vout.P40.nSD 0.000271275f
Cred_8623 vin.$723.Metal2 vout.P40.pSD 0.000751037f
Cred_8624 vin.$723.Metal2 VSS.$14.Metal1 2.76255e-05f
Cred_8625 vin.$723.Metal2 VSS.$29.Metal1 4.64845e-05f
Cred_8626 vin.$723.Metal2 VSS.$372.Metal1 0.00022832f
Cred_8627 vin.$723.Metal2 VSS.$388.Metal1 0.00015744f
Cred_8628 vin.$723.Metal2 VSS.$520.Metal1 0.00289203f
Cred_8629 vin.$723.Metal2 VSS.$799.Metal2 0.00244408f
Cred_8630 vin.$723.Metal2 VSS.$806.Metal2 0.000503193f
Cred_8631 vin.$723.Metal2 VSS.$810.Metal2 0.000807145f
Cred_8632 vin.$723.Metal2 VSS.$817.Metal2 0.00155664f
Cred_8633 vin.$723.Metal2 VSS.P0.pSD 0.0427621f
Cred_8634 vin.$723.Metal2 VSS.P41.nSD 2.64369e-05f
Cred_8635 vin.$723.Metal2 VSS.P43.nSD 1.82275e-05f
Cred_8636 vin.$725.Metal2 vout.$1116.Metal3 0.0273287f
Cred_8637 vin.$725.Metal2 vout.$1134.Metal3 0.029322f
Cred_8638 vin.$725.Metal2 vout.P40.nSD 0.0114006f
Cred_8639 vin.$725.Metal2 vout.P40.pSD 0.000445325f
Cred_8640 vin.$725.Metal2 vout.P42.nSD 3.18433e-05f
Cred_8641 vin.$725.Metal2 VSS.$14.Metal1 5.09744e-06f
Cred_8642 vin.$725.Metal2 VSS.$29.Metal1 8.5773e-06f
Cred_8643 vin.$725.Metal2 VSS.$372.Metal1 2.21726e-06f
Cred_8644 vin.$725.Metal2 VSS.$388.Metal1 0.0016549f
Cred_8645 vin.$725.Metal2 VSS.$520.Metal1 0.0005181f
Cred_8646 vin.$725.Metal2 VSS.$806.Metal2 0.00136364f
Cred_8647 vin.$725.Metal2 VSS.$810.Metal2 0.00721586f
Cred_8648 vin.$725.Metal2 VSS.$817.Metal2 0.00948597f
Cred_8649 vin.$725.Metal2 VSS.P0.pSD 0.00776606f
Cred_8650 vin.$725.Metal2 VSS.P43.nSD 0.000883205f
Cred_8651 vin.$726.Metal2 vout.$1116.Metal3 0.0303579f
Cred_8652 vin.$726.Metal2 vout.$1134.Metal3 0.0285347f
Cred_8653 vin.$726.Metal2 vout.P38.pSD 9.00761e-05f
Cred_8654 vin.$726.Metal2 vout.P40.nSD 0.000165704f
Cred_8655 vin.$726.Metal2 vout.P40.pSD 0.0146564f
Cred_8656 vin.$726.Metal2 VSS.$372.Metal1 6.31731e-05f
Cred_8657 vin.$726.Metal2 VSS.$799.Metal2 0.000415957f
Cred_8658 vin.$726.Metal2 VSS.$806.Metal2 8.56382e-05f
Cred_8659 vin.$726.Metal2 VSS.P41.nSD 7.31513e-06f
Cred_8660 vin.$728.Metal2 vout.$1116.Metal3 0.00269096f
Cred_8661 vin.$728.Metal2 vout.$1134.Metal3 0.0133023f
Cred_8662 vin.$728.Metal2 vout.P40.nSD 1.61647e-05f
Cred_8663 vin.$728.Metal2 vout.P40.pSD 0.000266941f
Cred_8664 vin.$728.Metal2 vout.P42.pSD 0.00241836f
Cred_8665 vin.$728.Metal2 VSS.$388.Metal1 0.000167029f
Cred_8666 vin.$728.Metal2 VSS.$810.Metal2 0.000450947f
Cred_8667 vin.$728.Metal2 VSS.$817.Metal2 0.000869684f
Cred_8668 vin.$728.Metal2 VSS.P43.nSD 1.93402e-05f
Cred_8669 vin.$729.Metal2 vout.$1116.Metal3 0.00175829f
Cred_8670 vin.$729.Metal2 vout.$1134.Metal3 0.050501f
Cred_8671 vin.$729.Metal2 vout.P40.nSD 5.42351e-05f
Cred_8672 vin.$729.Metal2 vout.P40.pSD 2.86516e-05f
Cred_8673 vin.$729.Metal2 vout.P42.nSD 0.00794785f
Cred_8674 vin.$729.Metal2 VSS.$1022.Metal3 2.76878e-06f
Cred_8675 vin.$729.Metal2 VSS.$14.Metal1 3.54365e-06f
Cred_8676 vin.$729.Metal2 VSS.$29.Metal1 5.96277e-06f
Cred_8677 vin.$729.Metal2 VSS.$372.Metal1 3.01255e-07f
Cred_8678 vin.$729.Metal2 VSS.$388.Metal1 0.00166175f
Cred_8679 vin.$729.Metal2 VSS.$400.Metal1 9.40158e-06f
Cred_8680 vin.$729.Metal2 VSS.$406.Metal1 0.000307373f
Cred_8681 vin.$729.Metal2 VSS.$520.Metal1 0.000607203f
Cred_8682 vin.$729.Metal2 VSS.$806.Metal2 1.92678e-09f
Cred_8683 vin.$729.Metal2 VSS.$810.Metal2 0.00733006f
Cred_8684 vin.$729.Metal2 VSS.$817.Metal2 0.0144819f
Cred_8685 vin.$729.Metal2 VSS.$825.Metal2 0.00418296f
Cred_8686 vin.$729.Metal2 VSS.$832.Metal2 0.000657878f
Cred_8687 vin.$729.Metal2 VSS.P0.pSD 0.00685759f
Cred_8688 vin.$729.Metal2 VSS.P43.nSD 0.000881235f
Cred_8689 vin.$729.Metal2 VSS.P45.nSD 3.71219e-05f
Cred_8690 vin.$73.GatPoly vout.$1008.Metal3 0.00508539f
Cred_8691 vin.$73.GatPoly vout.P14.pSD 0.00540789f
Cred_8692 vin.$732.Metal2 vout.$1116.Metal3 9.35191e-05f
Cred_8693 vin.$732.Metal2 vout.$1134.Metal3 0.0952483f
Cred_8694 vin.$732.Metal2 vout.P40.nSD 5.61774e-07f
Cred_8695 vin.$732.Metal2 vout.P40.pSD 1.52391e-06f
Cred_8696 vin.$732.Metal2 vout.P42.nSD 0.000617024f
Cred_8697 vin.$732.Metal2 VSS.$1022.Metal3 7.86378e-07f
Cred_8698 vin.$732.Metal2 VSS.$14.Metal1 2.21175e-05f
Cred_8699 vin.$732.Metal2 VSS.$29.Metal1 3.72164e-05f
Cred_8700 vin.$732.Metal2 VSS.$388.Metal1 0.000201803f
Cred_8701 vin.$732.Metal2 VSS.$400.Metal1 1.06876e-06f
Cred_8702 vin.$732.Metal2 VSS.$406.Metal1 0.00030468f
Cred_8703 vin.$732.Metal2 VSS.$520.Metal1 0.00390173f
Cred_8704 vin.$732.Metal2 VSS.$810.Metal2 0.00104276f
Cred_8705 vin.$732.Metal2 VSS.$817.Metal2 0.00210912f
Cred_8706 vin.$732.Metal2 VSS.$825.Metal2 0.00378059f
Cred_8707 vin.$732.Metal2 VSS.$832.Metal2 0.000631287f
Cred_8708 vin.$732.Metal2 VSS.P0.pSD 0.0436017f
Cred_8709 vin.$732.Metal2 VSS.P43.nSD 2.33636e-05f
Cred_8710 vin.$732.Metal2 VSS.P45.nSD 3.57137e-05f
Cred_8711 vin.$733.Metal2 vout.$1116.Metal3 0.000632586f
Cred_8712 vin.$733.Metal2 vout.$1134.Metal3 0.0494783f
Cred_8713 vin.$733.Metal2 vout.$1152.Metal3 0.000615403f
Cred_8714 vin.$733.Metal2 vout.P40.nSD 3.79998e-06f
Cred_8715 vin.$733.Metal2 vout.P40.pSD 1.03081e-05f
Cred_8716 vin.$733.Metal2 vout.P42.pSD 0.0108197f
Cred_8717 vin.$733.Metal2 vout.P44.nSD 3.69676e-06f
Cred_8718 vin.$733.Metal2 vout.P44.pSD 1.00281e-05f
Cred_8719 vin.$736.Metal2 vout.$1116.Metal3 8.23316e-05f
Cred_8720 vin.$736.Metal2 vout.$1134.Metal3 0.0195299f
Cred_8721 vin.$736.Metal2 vout.$1152.Metal3 0.00563504f
Cred_8722 vin.$736.Metal2 vout.P40.nSD 4.9457e-07f
Cred_8723 vin.$736.Metal2 vout.P40.pSD 1.34161e-06f
Cred_8724 vin.$736.Metal2 vout.P42.nSD 0.0012907f
Cred_8725 vin.$736.Metal2 vout.P44.nSD 0.000164745f
Cred_8726 vin.$736.Metal2 vout.P44.pSD 9.18238e-05f
Cred_8727 vin.$736.Metal2 VSS.$1022.Metal3 3.23869e-06f
Cred_8728 vin.$736.Metal2 VSS.$14.Metal1 1.81685e-06f
Cred_8729 vin.$736.Metal2 VSS.$29.Metal1 3.05716e-06f
Cred_8730 vin.$736.Metal2 VSS.$400.Metal1 4.40165e-06f
Cred_8731 vin.$736.Metal2 VSS.$406.Metal1 0.00315125f
Cred_8732 vin.$736.Metal2 VSS.$422.Metal1 8.72086e-07f
Cred_8733 vin.$736.Metal2 VSS.$520.Metal1 0.000400862f
Cred_8734 vin.$736.Metal2 VSS.$817.Metal2 0.000403938f
Cred_8735 vin.$736.Metal2 VSS.$825.Metal2 0.0262953f
Cred_8736 vin.$736.Metal2 VSS.$832.Metal2 0.00443853f
Cred_8737 vin.$736.Metal2 VSS.$836.Metal2 4.26471e-09f
Cred_8738 vin.$736.Metal2 VSS.P0.pSD 0.00394528f
Cred_8739 vin.$736.Metal2 VSS.P45.nSD 0.000375281f
Cred_8740 vin.$737.Metal2 vout.$1134.Metal3 0.0148867f
Cred_8741 vin.$737.Metal2 vout.$1152.Metal3 0.00606923f
Cred_8742 vin.$737.Metal2 vout.P42.pSD 0.00182901f
Cred_8743 vin.$737.Metal2 vout.P44.nSD 3.59707e-05f
Cred_8744 vin.$737.Metal2 vout.P44.pSD 0.000607326f
Cred_8745 vin.$737.Metal2 VSS.$406.Metal1 0.00014056f
Cred_8746 vin.$737.Metal2 VSS.$825.Metal2 0.000953531f
Cred_8747 vin.$737.Metal2 VSS.$832.Metal2 0.000163462f
Cred_8748 vin.$737.Metal2 VSS.P45.nSD 1.62763e-05f
Cred_8749 vin.$739.Metal2 vout.$1134.Metal3 0.0442466f
Cred_8750 vin.$739.Metal2 vout.$1152.Metal3 0.0442487f
Cred_8751 vin.$739.Metal2 vout.P44.nSD 0.000269756f
Cred_8752 vin.$739.Metal2 vout.P44.pSD 0.000728555f
Cred_8753 vin.$739.Metal2 VSS.$14.Metal1 1.61724e-05f
Cred_8754 vin.$739.Metal2 VSS.$29.Metal1 2.72128e-05f
Cred_8755 vin.$739.Metal2 VSS.$406.Metal1 0.000188403f
Cred_8756 vin.$739.Metal2 VSS.$422.Metal1 0.000218971f
Cred_8757 vin.$739.Metal2 VSS.$520.Metal1 0.00481277f
Cred_8758 vin.$739.Metal2 VSS.$825.Metal2 0.00225405f
Cred_8759 vin.$739.Metal2 VSS.$832.Metal2 0.000386409f
Cred_8760 vin.$739.Metal2 VSS.$836.Metal2 0.00104498f
Cred_8761 vin.$739.Metal2 VSS.$843.Metal2 0.0018113f
Cred_8762 vin.$739.Metal2 VSS.P0.pSD 0.0404393f
Cred_8763 vin.$739.Metal2 VSS.P45.nSD 2.1815e-05f
Cred_8764 vin.$739.Metal2 VSS.P47.nSD 2.53521e-05f
Cred_8765 vin.$741.Metal2 vout.$1134.Metal3 0.027238f
Cred_8766 vin.$741.Metal2 vout.$1152.Metal3 0.0292312f
Cred_8767 vin.$741.Metal2 vout.P44.nSD 0.0112634f
Cred_8768 vin.$741.Metal2 vout.P44.pSD 0.000443848f
Cred_8769 vin.$741.Metal2 vout.P46.nSD 3.1843e-05f
Cred_8770 vin.$741.Metal2 VSS.$14.Metal1 3.2537e-06f
Cred_8771 vin.$741.Metal2 VSS.$29.Metal1 5.4749e-06f
Cred_8772 vin.$741.Metal2 VSS.$406.Metal1 2.38886e-06f
Cred_8773 vin.$741.Metal2 VSS.$422.Metal1 0.00162922f
Cred_8774 vin.$741.Metal2 VSS.$520.Metal1 0.00100716f
Cred_8775 vin.$741.Metal2 VSS.$832.Metal2 1.57283e-08f
Cred_8776 vin.$741.Metal2 VSS.$836.Metal2 0.00825734f
Cred_8777 vin.$741.Metal2 VSS.$843.Metal2 0.00900432f
Cred_8778 vin.$741.Metal2 VSS.P0.pSD 0.00826719f
Cred_8779 vin.$741.Metal2 VSS.P47.nSD 0.000936718f
Cred_8780 vin.$742.Metal2 vout.$1134.Metal3 0.0257857f
Cred_8781 vin.$742.Metal2 vout.$1152.Metal3 0.0258263f
Cred_8782 vin.$742.Metal2 vout.P44.nSD 0.000148966f
Cred_8783 vin.$742.Metal2 vout.P44.pSD 0.014143f
Cred_8784 vin.$744.Metal2 vout.$1134.Metal3 0.00253773f
Cred_8785 vin.$744.Metal2 vout.$1152.Metal3 0.0131298f
Cred_8786 vin.$744.Metal2 vout.P44.nSD 1.52443e-05f
Cred_8787 vin.$744.Metal2 vout.P44.pSD 0.000255239f
Cred_8788 vin.$744.Metal2 vout.P46.pSD 0.00244766f
Cred_8789 vin.$744.Metal2 VSS.$422.Metal1 0.000167082f
Cred_8790 vin.$744.Metal2 VSS.$836.Metal2 0.000483136f
Cred_8791 vin.$744.Metal2 VSS.$843.Metal2 0.000837436f
Cred_8792 vin.$744.Metal2 VSS.P47.nSD 1.93462e-05f
Cred_8793 vin.$745.Metal2 vout.$1134.Metal3 0.00128886f
Cred_8794 vin.$745.Metal2 vout.$1152.Metal3 0.0509797f
Cred_8795 vin.$745.Metal2 vout.P44.nSD 4.70898e-05f
Cred_8796 vin.$745.Metal2 vout.P44.pSD 2.10021e-05f
Cred_8797 vin.$745.Metal2 vout.P46.nSD 0.00821129f
Cred_8798 vin.$745.Metal2 VSS.$1028.Metal3 1.40963e-06f
Cred_8799 vin.$745.Metal2 VSS.$1036.Metal3 1.40963e-06f
Cred_8800 vin.$745.Metal2 VSS.$14.Metal1 2.05262e-06f
Cred_8801 vin.$745.Metal2 VSS.$29.Metal1 3.45387e-06f
Cred_8802 vin.$745.Metal2 VSS.$406.Metal1 2.68978e-07f
Cred_8803 vin.$745.Metal2 VSS.$422.Metal1 0.00163532f
Cred_8804 vin.$745.Metal2 VSS.$434.Metal1 9.31546e-06f
Cred_8805 vin.$745.Metal2 VSS.$440.Metal1 0.000365718f
Cred_8806 vin.$745.Metal2 VSS.$520.Metal1 0.00103904f
Cred_8807 vin.$745.Metal2 VSS.$832.Metal2 1.77096e-09f
Cred_8808 vin.$745.Metal2 VSS.$836.Metal2 0.00774512f
Cred_8809 vin.$745.Metal2 VSS.$843.Metal2 0.0137822f
Cred_8810 vin.$745.Metal2 VSS.$851.Metal2 0.00471197f
Cred_8811 vin.$745.Metal2 VSS.$858.Metal2 0.000604817f
Cred_8812 vin.$745.Metal2 VSS.P0.pSD 0.00646125f
Cred_8813 vin.$745.Metal2 VSS.P47.nSD 0.000935047f
Cred_8814 vin.$745.Metal2 VSS.P49.nSD 4.4205e-05f
Cred_8815 vin.$748.Metal2 vout.$1152.Metal3 0.0932226f
Cred_8816 vin.$748.Metal2 vout.P46.nSD 0.000534112f
Cred_8817 vin.$748.Metal2 VSS.$1028.Metal3 3.76093e-07f
Cred_8818 vin.$748.Metal2 VSS.$1036.Metal3 3.76093e-07f
Cred_8819 vin.$748.Metal2 VSS.$14.Metal1 1.28698e-05f
Cred_8820 vin.$748.Metal2 VSS.$29.Metal1 2.16555e-05f
Cred_8821 vin.$748.Metal2 VSS.$422.Metal1 0.000190436f
Cred_8822 vin.$748.Metal2 VSS.$434.Metal1 1.05238e-06f
Cred_8823 vin.$748.Metal2 VSS.$440.Metal1 0.000300222f
Cred_8824 vin.$748.Metal2 VSS.$520.Metal1 0.00642406f
Cred_8825 vin.$748.Metal2 VSS.$836.Metal2 0.00109165f
Cred_8826 vin.$748.Metal2 VSS.$843.Metal2 0.00198753f
Cred_8827 vin.$748.Metal2 VSS.$851.Metal2 0.00380787f
Cred_8828 vin.$748.Metal2 VSS.$858.Metal2 0.000515631f
Cred_8829 vin.$748.Metal2 VSS.P0.pSD 0.04039f
Cred_8830 vin.$748.Metal2 VSS.P47.nSD 2.20473e-05f
Cred_8831 vin.$748.Metal2 VSS.P49.nSD 3.52589e-05f
Cred_8832 vin.$749.Metal2 vout.$1134.Metal3 0.000509855f
Cred_8833 vin.$749.Metal2 vout.$1152.Metal3 0.0493572f
Cred_8834 vin.$749.Metal2 vout.$1170.Metal3 0.00056316f
Cred_8835 vin.$749.Metal2 vout.P44.nSD 3.06272e-06f
Cred_8836 vin.$749.Metal2 vout.P44.pSD 8.30816e-06f
Cred_8837 vin.$749.Metal2 vout.P46.pSD 0.0108685f
Cred_8838 vin.$749.Metal2 vout.P48.nSD 3.38293e-06f
Cred_8839 vin.$749.Metal2 vout.P48.pSD 9.17678e-06f
Cred_8840 vin.$752.Metal2 vout.$1152.Metal3 0.0194879f
Cred_8841 vin.$752.Metal2 vout.$1170.Metal3 0.00624141f
Cred_8842 vin.$752.Metal2 vout.P46.nSD 0.00111549f
Cred_8843 vin.$752.Metal2 vout.P48.nSD 0.000220576f
Cred_8844 vin.$752.Metal2 vout.P48.pSD 0.000101705f
Cred_8845 vin.$752.Metal2 VSS.$1028.Metal3 1.64354e-06f
Cred_8846 vin.$752.Metal2 VSS.$1036.Metal3 1.64354e-06f
Cred_8847 vin.$752.Metal2 VSS.$14.Metal1 1.1627e-06f
Cred_8848 vin.$752.Metal2 VSS.$29.Metal1 1.95644e-06f
Cred_8849 vin.$752.Metal2 VSS.$434.Metal1 4.59894e-06f
Cred_8850 vin.$752.Metal2 VSS.$440.Metal1 0.00310595f
Cred_8851 vin.$752.Metal2 VSS.$456.Metal1 2.03826e-06f
Cred_8852 vin.$752.Metal2 VSS.$520.Metal1 0.00077007f
Cred_8853 vin.$752.Metal2 VSS.$843.Metal2 0.000416574f
Cred_8854 vin.$752.Metal2 VSS.$851.Metal2 0.0267025f
Cred_8855 vin.$752.Metal2 VSS.$858.Metal2 0.00365084f
Cred_8856 vin.$752.Metal2 VSS.$862.Metal2 9.58395e-09f
Cred_8857 vin.$752.Metal2 VSS.P0.pSD 0.00409478f
Cred_8858 vin.$752.Metal2 VSS.P49.nSD 0.000373594f
Cred_8859 vin.$753.Metal2 vout.$1152.Metal3 0.0154525f
Cred_8860 vin.$753.Metal2 vout.$1170.Metal3 0.00679882f
Cred_8861 vin.$753.Metal2 vout.P46.pSD 0.0017485f
Cred_8862 vin.$753.Metal2 vout.P48.nSD 3.99927e-05f
Cred_8863 vin.$753.Metal2 vout.P48.pSD 0.000665743f
Cred_8864 vin.$753.Metal2 VSS.$440.Metal1 0.000130351f
Cred_8865 vin.$753.Metal2 VSS.$851.Metal2 0.000910365f
Cred_8866 vin.$753.Metal2 VSS.$858.Metal2 0.00012644f
Cred_8867 vin.$753.Metal2 VSS.P49.nSD 1.50943e-05f
Cred_8868 vin.$755.Metal2 vout.$1152.Metal3 0.0440365f
Cred_8869 vin.$755.Metal2 vout.$1170.Metal3 0.0440365f
Cred_8870 vin.$755.Metal2 vout.P48.nSD 0.00027128f
Cred_8871 vin.$755.Metal2 vout.P48.pSD 0.000730643f
Cred_8872 vin.$755.Metal2 VSS.$14.Metal1 9.44853e-06f
Cred_8873 vin.$755.Metal2 VSS.$29.Metal1 1.58987e-05f
Cred_8874 vin.$755.Metal2 VSS.$440.Metal1 0.000202563f
Cred_8875 vin.$755.Metal2 VSS.$456.Metal1 0.000196311f
Cred_8876 vin.$755.Metal2 VSS.$520.Metal1 0.00797762f
Cred_8877 vin.$755.Metal2 VSS.$851.Metal2 0.00242745f
Cred_8878 vin.$755.Metal2 VSS.$858.Metal2 0.000337145f
Cred_8879 vin.$755.Metal2 VSS.$862.Metal2 0.0010483f
Cred_8880 vin.$755.Metal2 VSS.$869.Metal2 0.00163798f
Cred_8881 vin.$755.Metal2 VSS.P0.pSD 0.0369917f
Cred_8882 vin.$755.Metal2 VSS.P49.nSD 2.34552e-05f
Cred_8883 vin.$755.Metal2 VSS.P51.nSD 2.27281e-05f
Cred_8884 vin.$757.Metal2 vout.$1152.Metal3 0.0273803f
Cred_8885 vin.$757.Metal2 vout.$1170.Metal3 0.0293735f
Cred_8886 vin.$757.Metal2 vout.P48.nSD 0.0110803f
Cred_8887 vin.$757.Metal2 vout.P48.pSD 0.000446167f
Cred_8888 vin.$757.Metal2 vout.P50.nSD 3.18422e-05f
Cred_8889 vin.$757.Metal2 VSS.$14.Metal1 1.70515e-06f
Cred_8890 vin.$757.Metal2 VSS.$29.Metal1 2.86919e-06f
Cred_8891 vin.$757.Metal2 VSS.$440.Metal1 7.87373e-06f
Cred_8892 vin.$757.Metal2 VSS.$456.Metal1 0.00162644f
Cred_8893 vin.$757.Metal2 VSS.$520.Metal1 0.00150359f
Cred_8894 vin.$757.Metal2 VSS.$851.Metal2 4.31614e-07f
Cred_8895 vin.$757.Metal2 VSS.$858.Metal2 7.01759e-08f
Cred_8896 vin.$757.Metal2 VSS.$862.Metal2 0.00898871f
Cred_8897 vin.$757.Metal2 VSS.$869.Metal2 0.00948368f
Cred_8898 vin.$757.Metal2 VSS.P0.pSD 0.00678299f
Cred_8899 vin.$757.Metal2 VSS.P49.nSD 3.22882e-06f
Cred_8900 vin.$757.Metal2 VSS.P51.nSD 0.000992272f
Cred_8901 vin.$758.Metal2 vout.$1152.Metal3 0.0253909f
Cred_8902 vin.$758.Metal2 vout.$1170.Metal3 0.0253909f
Cred_8903 vin.$758.Metal2 vout.P48.nSD 0.00014705f
Cred_8904 vin.$758.Metal2 vout.P48.pSD 0.0138169f
Cred_8905 vin.$760.Metal2 vout.$1152.Metal3 0.00251362f
Cred_8906 vin.$760.Metal2 vout.$1170.Metal3 0.0130682f
Cred_8907 vin.$760.Metal2 vout.P48.nSD 1.50995e-05f
Cred_8908 vin.$760.Metal2 vout.P48.pSD 0.000252035f
Cred_8909 vin.$760.Metal2 vout.P50.pSD 0.00247287f
Cred_8910 vin.$760.Metal2 VSS.$456.Metal1 0.000167126f
Cred_8911 vin.$760.Metal2 VSS.$862.Metal2 0.000515326f
Cred_8912 vin.$760.Metal2 VSS.$869.Metal2 0.000805197f
Cred_8913 vin.$760.Metal2 VSS.P51.nSD 1.93512e-05f
Cred_8914 vin.$761.Metal2 vout.$1152.Metal3 0.0012751f
Cred_8915 vin.$761.Metal2 vout.$1170.Metal3 0.0519306f
Cred_8916 vin.$761.Metal2 vout.P48.nSD 3.95018e-05f
Cred_8917 vin.$761.Metal2 vout.P48.pSD 2.0778e-05f
Cred_8918 vin.$761.Metal2 vout.P50.nSD 0.00847774f
Cred_8919 vin.$761.Metal2 VSS.$1042.Metal3 2.93579e-06f
Cred_8920 vin.$761.Metal2 VSS.$14.Metal1 1.22924e-06f
Cred_8921 vin.$761.Metal2 VSS.$29.Metal1 2.0684e-06f
Cred_8922 vin.$761.Metal2 VSS.$456.Metal1 0.0016445f
Cred_8923 vin.$761.Metal2 VSS.$468.Metal1 9.20331e-06f
Cred_8924 vin.$761.Metal2 VSS.$474.Metal1 0.000425074f
Cred_8925 vin.$761.Metal2 VSS.$520.Metal1 0.00179829f
Cred_8926 vin.$761.Metal2 VSS.$862.Metal2 0.00775968f
Cred_8927 vin.$761.Metal2 VSS.$869.Metal2 0.0124907f
Cred_8928 vin.$761.Metal2 VSS.$877.Metal2 0.00527055f
Cred_8929 vin.$761.Metal2 VSS.$884.Metal2 0.000530205f
Cred_8930 vin.$761.Metal2 VSS.P0.pSD 0.00596477f
Cred_8931 vin.$761.Metal2 VSS.P51.nSD 0.000992933f
Cred_8932 vin.$761.Metal2 VSS.P53.nSD 5.14216e-05f
Cred_8933 vin.$764.Metal2 vout.$1170.Metal3 0.0936336f
Cred_8934 vin.$764.Metal2 vout.P50.nSD 0.000449842f
Cred_8935 vin.$764.Metal2 VSS.$1042.Metal3 7.32744e-07f
Cred_8936 vin.$764.Metal2 VSS.$14.Metal1 7.34471e-06f
Cred_8937 vin.$764.Metal2 VSS.$29.Metal1 1.23587e-05f
Cred_8938 vin.$764.Metal2 VSS.$456.Metal1 0.000198069f
Cred_8939 vin.$764.Metal2 VSS.$468.Metal1 1.02091e-06f
Cred_8940 vin.$764.Metal2 VSS.$474.Metal1 0.000308423f
Cred_8941 vin.$764.Metal2 VSS.$520.Metal1 0.0105562f
Cred_8942 vin.$764.Metal2 VSS.$862.Metal2 0.0011745f
Cred_8943 vin.$764.Metal2 VSS.$869.Metal2 0.00192654f
Cred_8944 vin.$764.Metal2 VSS.$877.Metal2 0.00392188f
Cred_8945 vin.$764.Metal2 VSS.$884.Metal2 0.000414107f
Cred_8946 vin.$764.Metal2 VSS.P0.pSD 0.0355084f
Cred_8947 vin.$764.Metal2 VSS.P51.nSD 2.2931e-05f
Cred_8948 vin.$764.Metal2 VSS.P53.nSD 3.62628e-05f
Cred_8949 vin.$765.Metal2 vout 0.00110101f
Cred_8950 vin.$765.Metal2 vout.$1152.Metal3 0.00056316f
Cred_8951 vin.$765.Metal2 vout.$1170.Metal3 0.0490687f
Cred_8952 vin.$765.Metal2 vout.P48.nSD 3.38293e-06f
Cred_8953 vin.$765.Metal2 vout.P48.pSD 9.17678e-06f
Cred_8954 vin.$765.Metal2 vout.P50.pSD 0.010935f
Cred_8955 vin.$768.Metal2 vout 0.0524834f
Cred_8956 vin.$768.Metal2 vout.$1170.Metal3 0.012673f
Cred_8957 vin.$768.Metal2 vout.P50.nSD 0.000938514f
Cred_8958 vin.$768.Metal2 vout.P52.nSD 0.00878323f
Cred_8959 vin.$768.Metal2 VSS.$1042.Metal3 3.40939e-06f
Cred_8960 vin.$768.Metal2 VSS.$1048.Metal3 1.8834e-05f
Cred_8961 vin.$768.Metal2 VSS.$14.Metal1 1.94283e-06f
Cred_8962 vin.$768.Metal2 VSS.$29.Metal1 3.26913e-06f
Cred_8963 vin.$768.Metal2 VSS.$468.Metal1 4.75018e-06f
Cred_8964 vin.$768.Metal2 VSS.$474.Metal1 0.00297015f
Cred_8965 vin.$768.Metal2 VSS.$486.Metal1 0.000180587f
Cred_8966 vin.$768.Metal2 VSS.$496.Metal1 2.50622e-05f
Cred_8967 vin.$768.Metal2 VSS.$500.Metal1 0.00241684f
Cred_8968 vin.$768.Metal2 VSS.$520.Metal1 0.00511085f
Cred_8969 vin.$768.Metal2 VSS.$869.Metal2 0.000425229f
Cred_8970 vin.$768.Metal2 VSS.$877.Metal2 0.026258f
Cred_8971 vin.$768.Metal2 VSS.$884.Metal2 0.00660606f
Cred_8972 vin.$768.Metal2 VSS.$895.Metal2 0.00222018f
Cred_8973 vin.$768.Metal2 VSS.$904.Metal2 0.0190712f
Cred_8974 vin.$768.Metal2 VSS.P0.pSD 0.0114919f
Cred_8975 vin.$768.Metal2 VSS.P1.GatPoly 0.000196411f
Cred_8976 vin.$768.Metal2 VSS.P53.nSD 0.00038407f
Cred_8977 vin.$768.Metal2 VSS.P55.nSD 0.000140747f
Cred_8978 vin.$768.Metal2 VSS.P57.nSD 2.23206e-05f
Cred_8979 vin.$769.Metal2 vout 0.05041f
Cred_8980 vin.$769.Metal2 vout.$1170.Metal3 0.00928802f
Cred_8981 vin.$769.Metal2 vout.P50.pSD 0.00166406f
Cred_8982 vin.$769.Metal2 vout.P52.pSD 0.012723f
Cred_8983 vin.$769.Metal2 VSS.$474.Metal1 0.000114629f
Cred_8984 vin.$769.Metal2 VSS.$500.Metal1 5.00286e-05f
Cred_8985 vin.$769.Metal2 VSS.$877.Metal2 0.000823599f
Cred_8986 vin.$769.Metal2 VSS.$884.Metal2 8.90378e-05f
Cred_8987 vin.$769.Metal2 VSS.$904.Metal2 0.000999174f
Cred_8988 vin.$769.Metal2 VSS.P53.nSD 1.32739e-05f
Cred_8989 vin.$769.Metal2 VSS.P55.nSD 3.70907e-07f
Cred_8990 vin.$769.Metal2 VSS.P57.nSD 3.70907e-07f
Cred_8991 vin.$771.Metal2 vout 0.0837978f
Cred_8992 vin.$771.Metal2 vout.$1170.Metal3 0.00470444f
Cred_8993 vin.$771.Metal2 vout.P52.nSD 0.00325543f
Cred_8994 vin.$771.Metal2 vout.P52.pSD 0.00394861f
Cred_8995 vin.$771.Metal2 VSS.$1048.Metal3 7.2755e-06f
Cred_8996 vin.$771.Metal2 VSS.$14.Metal1 4.32938e-06f
Cred_8997 vin.$771.Metal2 VSS.$29.Metal1 7.28491e-06f
Cred_8998 vin.$771.Metal2 VSS.$474.Metal1 0.000215717f
Cred_8999 vin.$771.Metal2 VSS.$486.Metal1 5.99139e-05f
Cred_9000 vin.$771.Metal2 VSS.$496.Metal1 8.25276e-06f
Cred_9001 vin.$771.Metal2 VSS.$500.Metal1 0.000878832f
Cred_9002 vin.$771.Metal2 VSS.$520.Metal1 0.0114925f
Cred_9003 vin.$771.Metal2 VSS.$877.Metal2 0.00250556f
Cred_9004 vin.$771.Metal2 VSS.$884.Metal2 0.0011783f
Cred_9005 vin.$771.Metal2 VSS.$895.Metal2 0.000857645f
Cred_9006 vin.$771.Metal2 VSS.$904.Metal2 0.00773476f
Cred_9007 vin.$771.Metal2 VSS.P0.pSD 0.0258791f
Cred_9008 vin.$771.Metal2 VSS.P1.GatPoly 6.30215e-05f
Cred_9009 vin.$771.Metal2 VSS.P53.nSD 3.31695e-05f
Cred_9010 vin.$771.Metal2 VSS.P55.nSD 4.78143e-05f
Cred_9011 vin.$771.Metal2 VSS.P57.nSD 7.99579e-06f
Cred_9012 vin.$78.GatPoly vout.$1008.Metal3 0.000545769f
Cred_9013 vin.$78.GatPoly vout.$1026.Metal3 0.000470552f
Cred_9014 vin.$78.GatPoly vout.P14.nSD 0.00012321f
Cred_9015 vin.$78.GatPoly vout.P16.nSD 0.00156064f
Cred_9016 vin.$78.GatPoly vout.P16.pSD 7.66771e-06f
Cred_9017 vin.$78.GatPoly VSS.$14.Metal1 7.25936e-06f
Cred_9018 vin.$78.GatPoly VSS.$170.Metal1 0.00356101f
Cred_9019 vin.$78.GatPoly VSS.$29.Metal1 1.22151e-05f
Cred_9020 vin.$78.GatPoly VSS.$520.Metal1 1.23177e-06f
Cred_9021 vin.$78.GatPoly VSS.$643.Metal2 0.000182863f
Cred_9022 vin.$78.GatPoly VSS.$650.Metal2 8.49006e-05f
Cred_9023 vin.$78.GatPoly VSS.P0.pSD 0.000463688f
Cred_9024 vin.$78.GatPoly VSS.P17.nSD 0.000246095f
Cred_9025 vin.$79.GatPoly vout.$1008.Metal3 0.00346416f
Cred_9026 vin.$79.GatPoly vout.$1026.Metal3 0.00284953f
Cred_9027 vin.$79.GatPoly vout.P14.pSD 0.000605631f
Cred_9028 vin.$79.GatPoly vout.P16.nSD 1.71173e-05f
Cred_9029 vin.$79.GatPoly vout.P16.pSD 0.00595245f
Cred_9030 vin.$82.GatPoly vout.$1008.Metal3 0.00050726f
Cred_9031 vin.$82.GatPoly vout.$1026.Metal3 0.00050726f
Cred_9032 vin.$82.GatPoly vout.P16.nSD 0.00168251f
Cred_9033 vin.$82.GatPoly vout.P16.pSD 8.26589e-06f
Cred_9034 vin.$82.GatPoly VSS.$14.Metal1 2.04694e-05f
Cred_9035 vin.$82.GatPoly VSS.$170.Metal1 1.47399e-06f
Cred_9036 vin.$82.GatPoly VSS.$186.Metal1 0.00258202f
Cred_9037 vin.$82.GatPoly VSS.$29.Metal1 3.44431e-05f
Cred_9038 vin.$82.GatPoly VSS.$520.Metal1 5.09707e-06f
Cred_9039 vin.$82.GatPoly VSS.$650.Metal2 7.76299e-09f
Cred_9040 vin.$82.GatPoly VSS.$654.Metal2 3.79014e-05f
Cred_9041 vin.$82.GatPoly VSS.$661.Metal2 0.000156264f
Cred_9042 vin.$82.GatPoly VSS.P0.pSD 0.00159225f
Cred_9043 vin.$82.GatPoly VSS.P19.nSD 0.000182354f
Cred_9044 vin.$83.GatPoly vout.$1008.Metal3 0.00249847f
Cred_9045 vin.$83.GatPoly vout.$1026.Metal3 0.00249847f
Cred_9046 vin.$83.GatPoly vout.P16.nSD 1.50084e-05f
Cred_9047 vin.$83.GatPoly vout.P16.pSD 0.00539117f
Cred_9048 vin.$88.GatPoly vout.$1008.Metal3 3.7194e-05f
Cred_9049 vin.$88.GatPoly vout.$1026.Metal3 0.000988791f
Cred_9050 vin.$88.GatPoly vout.P16.nSD 0.000123433f
Cred_9051 vin.$88.GatPoly vout.P16.pSD 6.06082e-07f
Cred_9052 vin.$88.GatPoly vout.P18.nSD 0.00155781f
Cred_9053 vin.$88.GatPoly VSS.$14.Metal1 5.62374e-06f
Cred_9054 vin.$88.GatPoly VSS.$186.Metal1 0.00356092f
Cred_9055 vin.$88.GatPoly VSS.$29.Metal1 9.46289e-06f
Cred_9056 vin.$88.GatPoly VSS.$520.Metal1 1.59335e-06f
Cred_9057 vin.$88.GatPoly VSS.$654.Metal2 5.2266e-05f
Cred_9058 vin.$88.GatPoly VSS.$661.Metal2 0.000215597f
Cred_9059 vin.$88.GatPoly VSS.P0.pSD 0.000467714f
Cred_9060 vin.$88.GatPoly VSS.P19.nSD 0.000246085f
Cred_9061 vin.$89.GatPoly vout.$1008.Metal3 0.000303925f
Cred_9062 vin.$89.GatPoly vout.$1026.Metal3 0.00606653f
Cred_9063 vin.$89.GatPoly vout.P16.nSD 1.8257e-06f
Cred_9064 vin.$89.GatPoly vout.P16.pSD 0.000610584f
Cred_9065 vin.$89.GatPoly vout.P18.pSD 0.00590601f
Cred_9066 vin.$92.GatPoly vout.$1026.Metal3 0.00101822f
Cred_9067 vin.$92.GatPoly vout.P18.nSD 0.00167559f
Cred_9068 vin.$92.GatPoly VSS.$14.Metal1 1.5875e-05f
Cred_9069 vin.$92.GatPoly VSS.$196.Metal1 3.56767e-06f
Cred_9070 vin.$92.GatPoly VSS.$204.Metal1 0.00257473f
Cred_9071 vin.$92.GatPoly VSS.$29.Metal1 2.67123e-05f
Cred_9072 vin.$92.GatPoly VSS.$520.Metal1 6.59598e-06f
Cred_9073 vin.$92.GatPoly VSS.$669.Metal2 0.000136527f
Cred_9074 vin.$92.GatPoly VSS.$676.Metal2 5.64861e-05f
Cred_9075 vin.$92.GatPoly VSS.P0.pSD 0.00160388f
Cred_9076 vin.$92.GatPoly VSS.P21.nSD 0.000177365f
Cred_9077 vin.$93.GatPoly vout.$1026.Metal3 0.00508005f
Cred_9078 vin.$93.GatPoly vout.P18.pSD 0.00540872f
Cred_9079 vin.$98.GatPoly vout.$1026.Metal3 0.000545769f
Cred_9080 vin.$98.GatPoly vout.$1044.Metal3 0.000470552f
Cred_9081 vin.$98.GatPoly vout.P18.nSD 0.00012321f
Cred_9082 vin.$98.GatPoly vout.P20.nSD 0.00156064f
Cred_9083 vin.$98.GatPoly vout.P20.pSD 7.66771e-06f
Cred_9084 vin.$98.GatPoly VSS.$14.Metal1 4.36111e-06f
Cred_9085 vin.$98.GatPoly VSS.$204.Metal1 0.00356099f
Cred_9086 vin.$98.GatPoly VSS.$29.Metal1 7.3383e-06f
Cred_9087 vin.$98.GatPoly VSS.$520.Metal1 2.0606e-06f
Cred_9088 vin.$98.GatPoly VSS.$669.Metal2 0.000189405f
Cred_9089 vin.$98.GatPoly VSS.$676.Metal2 7.83745e-05f
Cred_9090 vin.$98.GatPoly VSS.P0.pSD 0.000470634f
Cred_9091 vin.$98.GatPoly VSS.P21.nSD 0.000246094f
Cred_9092 vin.$99.GatPoly vout.$1026.Metal3 0.00346416f
Cred_9093 vin.$99.GatPoly vout.$1044.Metal3 0.00284953f
Cred_9094 vin.$99.GatPoly vout.P18.pSD 0.000605631f
Cred_9095 vin.$99.GatPoly vout.P20.nSD 1.71173e-05f
Cred_9096 vin.$99.GatPoly vout.P20.pSD 0.00595245f
Cred_9097 vin.P0.GatPoly vout.$954.Metal3 0.00471126f
Cred_9098 vin.P0.GatPoly vout.P0.nSD 0.00791808f
Cred_9099 vin.P0.GatPoly vout.P0.pSD 5.70428e-05f
Cred_9100 vin.P0.GatPoly vout.P2.nSD 3.7803e-10f
Cred_9101 vin.P0.GatPoly VSS.$14.Metal1 1.7846e-05f
Cred_9102 vin.P0.GatPoly VSS.$29.Metal1 0.0230655f
Cred_9103 vin.P0.GatPoly VSS.$31.Metal1 0.000262095f
Cred_9104 vin.P0.GatPoly VSS.$42.Metal1 0.00163928f
Cred_9105 vin.P0.GatPoly VSS.$50.Metal1 1.89044e-06f
Cred_9106 vin.P0.GatPoly VSS.$520.Metal1 5.33558e-08f
Cred_9107 vin.P0.GatPoly VSS.$531.Metal2 0.00136496f
Cred_9108 vin.P0.GatPoly VSS.$540.Metal2 0.000739992f
Cred_9109 vin.P0.GatPoly VSS.$550.Metal2 0.000782978f
Cred_9110 vin.P0.GatPoly VSS.$557.Metal2 2.75246e-07f
Cred_9111 vin.P0.GatPoly VSS.$916.Metal3 6.27743e-06f
Cred_9112 vin.P0.GatPoly VSS.P0.GatPoly 0.0533053f
Cred_9113 vin.P0.GatPoly VSS.P0.nSD 0.000105597f
Cred_9114 vin.P0.GatPoly VSS.P0.pSD 0.00011379f
Cred_9115 vin.P0.GatPoly VSS.P1.nSD 0.00011f
Cred_9116 vin.P0.GatPoly VSS.P3.nSD 1.36202e-06f
Cred_9117 vin.P1.GatPoly vout.$954.Metal3 0.00400172f
Cred_9118 vin.P1.GatPoly vout.P0.nSD 0.00672479f
Cred_9119 vin.P1.GatPoly vout.P0.pSD 4.84521e-05f
Cred_9120 vin.P1.GatPoly VSS.$29.Metal1 0.00126417f
Cred_9121 vin.P1.GatPoly VSS.$42.Metal1 0.00038523f
Cred_9122 vin.P1.GatPoly VSS.$50.Metal1 0.0108258f
Cred_9123 vin.P1.GatPoly VSS.$550.Metal2 0.000349235f
Cred_9124 vin.P1.GatPoly VSS.$557.Metal2 0.00320294f
Cred_9125 vin.P1.GatPoly VSS.P0.GatPoly 0.00821234f
Cred_9126 vin.P1.GatPoly VSS.P0.pSD 1.72971e-06f
Cred_9127 vin.P1.GatPoly VSS.P3.nSD 0.000981618f
Cred_9128 vin.P10.GatPoly vout.$990.Metal3 0.00432914f
Cred_9129 vin.P10.GatPoly vout.P10.nSD 0.00707015f
Cred_9130 vin.P10.GatPoly VSS.$118.Metal1 0.0125122f
Cred_9131 vin.P10.GatPoly VSS.$128.Metal1 0.000722397f
Cred_9132 vin.P10.GatPoly VSS.$602.Metal2 0.000579204f
Cred_9133 vin.P10.GatPoly VSS.$609.Metal2 0.00338f
Cred_9134 vin.P10.GatPoly VSS.P0.pSD 1.04274e-06f
Cred_9135 vin.P10.GatPoly VSS.P11.nSD 0.00116895f
Cred_9136 vin.P100.GatPoly vout.$1134.Metal3 5.55162e-06f
Cred_9137 vin.P100.GatPoly vout.$1152.Metal3 0.0158726f
Cred_9138 vin.P100.GatPoly vout.P44.nSD 3.33489e-08f
Cred_9139 vin.P100.GatPoly vout.P44.pSD 1.11532e-05f
Cred_9140 vin.P100.GatPoly vout.P46.pSD 0.0205504f
Cred_9141 vin.P101.GatPoly vout.$1152.Metal3 0.0157689f
Cred_9142 vin.P101.GatPoly vout.P46.pSD 0.0204536f
Cred_9143 vin.P102.GatPoly vout.$1152.Metal3 0.00792429f
Cred_9144 vin.P102.GatPoly vout.$1170.Metal3 0.00792429f
Cred_9145 vin.P102.GatPoly vout.P48.nSD 4.76016e-05f
Cred_9146 vin.P102.GatPoly vout.P48.pSD 0.0208456f
Cred_9147 vin.P103.GatPoly vout.$1152.Metal3 0.00784604f
Cred_9148 vin.P103.GatPoly vout.$1170.Metal3 0.00785727f
Cred_9149 vin.P103.GatPoly vout.P48.nSD 4.71316e-05f
Cred_9150 vin.P103.GatPoly vout.P48.pSD 0.0206782f
Cred_9151 vin.P103.GatPoly vout.P50.pSD 1.10627e-05f
Cred_9152 vin.P104.GatPoly vout.$1152.Metal3 5.55162e-06f
Cred_9153 vin.P104.GatPoly vout.$1170.Metal3 0.0158726f
Cred_9154 vin.P104.GatPoly vout.P48.nSD 3.33489e-08f
Cred_9155 vin.P104.GatPoly vout.P48.pSD 1.11532e-05f
Cred_9156 vin.P104.GatPoly vout.P50.pSD 0.0205504f
Cred_9157 vin.P105.GatPoly vout.$1170.Metal3 0.0160253f
Cred_9158 vin.P105.GatPoly vout.P50.pSD 0.0207164f
Cred_9159 vin.P106.GatPoly vout 0.0155414f
Cred_9160 vin.P106.GatPoly vout.P52.pSD 0.0206811f
Cred_9161 vin.P107.GatPoly vout 0.0144143f
Cred_9162 vin.P107.GatPoly vout.$1170.Metal3 3.14846e-08f
Cred_9163 vin.P107.GatPoly vout.P52.pSD 0.020784f
Cred_9164 vin.P107.GatPoly VSS.$500.Metal1 4.2167e-09f
Cred_9165 vin.P107.GatPoly VSS.$904.Metal2 8.42162e-08f
Cred_9166 vin.P107.GatPoly VSS.P55.nSD 3.12622e-11f
Cred_9167 vin.P107.GatPoly VSS.P57.nSD 3.12622e-11f
Cred_9168 vin.P11.GatPoly vout.$990.Metal3 0.00412147f
Cred_9169 vin.P11.GatPoly vout.P10.nSD 0.00673078f
Cred_9170 vin.P11.GatPoly VSS.$128.Metal1 0.000547833f
Cred_9171 vin.P11.GatPoly VSS.$136.Metal1 0.012333f
Cred_9172 vin.P11.GatPoly VSS.$14.Metal1 4.72973e-07f
Cred_9173 vin.P11.GatPoly VSS.$29.Metal1 7.95856e-07f
Cred_9174 vin.P11.GatPoly VSS.$520.Metal1 2.86994e-08f
Cred_9175 vin.P11.GatPoly VSS.$617.Metal2 0.00258242f
Cred_9176 vin.P11.GatPoly VSS.$624.Metal2 0.00133721f
Cred_9177 vin.P11.GatPoly VSS.P0.pSD 1.88128e-05f
Cred_9178 vin.P11.GatPoly VSS.P13.nSD 0.00113316f
Cred_9179 vin.P12.GatPoly vout.$1008.Metal3 0.0021407f
Cred_9180 vin.P12.GatPoly vout.$990.Metal3 0.0021407f
Cred_9181 vin.P12.GatPoly vout.P12.nSD 0.00708301f
Cred_9182 vin.P12.GatPoly vout.P12.pSD 3.4883e-05f
Cred_9183 vin.P12.GatPoly VSS.$136.Metal1 0.0126756f
Cred_9184 vin.P12.GatPoly VSS.$152.Metal1 0.000336493f
Cred_9185 vin.P12.GatPoly VSS.$617.Metal2 0.00240255f
Cred_9186 vin.P12.GatPoly VSS.$624.Metal2 0.00125053f
Cred_9187 vin.P12.GatPoly VSS.$628.Metal2 2.15216e-06f
Cred_9188 vin.P12.GatPoly VSS.P0.pSD 2.52427e-06f
Cred_9189 vin.P12.GatPoly VSS.P13.nSD 0.00114537f
Cred_9190 vin.P13.GatPoly vout.$1008.Metal3 0.00203801f
Cred_9191 vin.P13.GatPoly vout.$990.Metal3 0.00203801f
Cred_9192 vin.P13.GatPoly vout.P12.nSD 0.00674302f
Cred_9193 vin.P13.GatPoly vout.P12.pSD 3.32097e-05f
Cred_9194 vin.P13.GatPoly VSS.$136.Metal1 0.000292981f
Cred_9195 vin.P13.GatPoly VSS.$14.Metal1 3.66047e-07f
Cred_9196 vin.P13.GatPoly VSS.$152.Metal1 0.0128009f
Cred_9197 vin.P13.GatPoly VSS.$29.Metal1 6.15935e-07f
Cred_9198 vin.P13.GatPoly VSS.$520.Metal1 3.7161e-08f
Cred_9199 vin.P13.GatPoly VSS.$624.Metal2 1.48788e-06f
Cred_9200 vin.P13.GatPoly VSS.$628.Metal2 0.000632111f
Cred_9201 vin.P13.GatPoly VSS.$635.Metal2 0.00305198f
Cred_9202 vin.P13.GatPoly VSS.P0.pSD 2.01783e-05f
Cred_9203 vin.P13.GatPoly VSS.P15.nSD 0.00115312f
Cred_9204 vin.P14.GatPoly vout.$1008.Metal3 0.00432914f
Cred_9205 vin.P14.GatPoly vout.P14.nSD 0.00707015f
Cred_9206 vin.P14.GatPoly VSS.$152.Metal1 0.0120349f
Cred_9207 vin.P14.GatPoly VSS.$162.Metal1 0.00070728f
Cred_9208 vin.P14.GatPoly VSS.$628.Metal2 0.000667168f
Cred_9209 vin.P14.GatPoly VSS.$635.Metal2 0.00324208f
Cred_9210 vin.P14.GatPoly VSS.P0.pSD 1.05612e-06f
Cred_9211 vin.P14.GatPoly VSS.P15.nSD 0.00112334f
Cred_9212 vin.P15.GatPoly vout.$1008.Metal3 0.00412147f
Cred_9213 vin.P15.GatPoly vout.P14.nSD 0.00673078f
Cred_9214 vin.P15.GatPoly VSS.$14.Metal1 2.83398e-07f
Cred_9215 vin.P15.GatPoly VSS.$162.Metal1 0.000558135f
Cred_9216 vin.P15.GatPoly VSS.$170.Metal1 0.0123229f
Cred_9217 vin.P15.GatPoly VSS.$29.Metal1 4.76865e-07f
Cred_9218 vin.P15.GatPoly VSS.$520.Metal1 4.80873e-08f
Cred_9219 vin.P15.GatPoly VSS.$643.Metal2 0.0026778f
Cred_9220 vin.P15.GatPoly VSS.$650.Metal2 0.00124176f
Cred_9221 vin.P15.GatPoly VSS.P0.pSD 1.92689e-05f
Cred_9222 vin.P15.GatPoly VSS.P17.nSD 0.00113314f
Cred_9223 vin.P16.GatPoly vout.$1008.Metal3 0.0021407f
Cred_9224 vin.P16.GatPoly vout.$1026.Metal3 0.0021407f
Cred_9225 vin.P16.GatPoly vout.P16.nSD 0.00708301f
Cred_9226 vin.P16.GatPoly vout.P16.pSD 3.4883e-05f
Cred_9227 vin.P16.GatPoly VSS.$170.Metal1 0.0126831f
Cred_9228 vin.P16.GatPoly VSS.$186.Metal1 0.000336486f
Cred_9229 vin.P16.GatPoly VSS.$643.Metal2 0.00248609f
Cred_9230 vin.P16.GatPoly VSS.$650.Metal2 0.00115896f
Cred_9231 vin.P16.GatPoly VSS.$654.Metal2 2.08879e-06f
Cred_9232 vin.P16.GatPoly VSS.P0.pSD 2.52442e-06f
Cred_9233 vin.P16.GatPoly VSS.P17.nSD 0.00114604f
Cred_9234 vin.P17.GatPoly vout.$1008.Metal3 0.00203801f
Cred_9235 vin.P17.GatPoly vout.$1026.Metal3 0.00203801f
Cred_9236 vin.P17.GatPoly vout.P16.nSD 0.00674302f
Cred_9237 vin.P17.GatPoly vout.P16.pSD 3.32097e-05f
Cred_9238 vin.P17.GatPoly VSS.$14.Metal1 2.19546e-07f
Cred_9239 vin.P17.GatPoly VSS.$170.Metal1 0.000292974f
Cred_9240 vin.P17.GatPoly VSS.$186.Metal1 0.0128122f
Cred_9241 vin.P17.GatPoly VSS.$29.Metal1 3.69422e-07f
Cred_9242 vin.P17.GatPoly VSS.$520.Metal1 6.22028e-08f
Cred_9243 vin.P17.GatPoly VSS.$650.Metal2 1.54299e-06f
Cred_9244 vin.P17.GatPoly VSS.$654.Metal2 0.000719497f
Cred_9245 vin.P17.GatPoly VSS.$661.Metal2 0.00295218f
Cred_9246 vin.P17.GatPoly VSS.P0.pSD 2.05461e-05f
Cred_9247 vin.P17.GatPoly VSS.P19.nSD 0.00115418f
Cred_9248 vin.P18.GatPoly vout.$1026.Metal3 0.00432914f
Cred_9249 vin.P18.GatPoly vout.P18.nSD 0.00707015f
Cred_9250 vin.P18.GatPoly VSS.$186.Metal1 0.0120495f
Cred_9251 vin.P18.GatPoly VSS.$196.Metal1 0.00069277f
Cred_9252 vin.P18.GatPoly VSS.$654.Metal2 0.000762405f
Cred_9253 vin.P18.GatPoly VSS.$661.Metal2 0.00314671f
Cred_9254 vin.P18.GatPoly VSS.P0.pSD 1.06893e-06f
Cred_9255 vin.P18.GatPoly VSS.P19.nSD 0.00112338f
Cred_9256 vin.P19.GatPoly vout.$1026.Metal3 0.00412147f
Cred_9257 vin.P19.GatPoly vout.P18.nSD 0.00673078f
Cred_9258 vin.P19.GatPoly VSS.$14.Metal1 1.70254e-07f
Cred_9259 vin.P19.GatPoly VSS.$196.Metal1 0.000568816f
Cred_9260 vin.P19.GatPoly VSS.$204.Metal1 0.0123123f
Cred_9261 vin.P19.GatPoly VSS.$29.Metal1 2.8648e-07f
Cred_9262 vin.P19.GatPoly VSS.$520.Metal1 8.04439e-08f
Cred_9263 vin.P19.GatPoly VSS.$669.Metal2 0.00277322f
Cred_9264 vin.P19.GatPoly VSS.$676.Metal2 0.00114631f
Cred_9265 vin.P19.GatPoly VSS.P0.pSD 1.95057e-05f
Cred_9266 vin.P19.GatPoly VSS.P21.nSD 0.00113311f
Cred_9267 vin.P2.GatPoly vout.$954.Metal3 0.00442733f
Cred_9268 vin.P2.GatPoly vout.P2.nSD 0.00723089f
Cred_9269 vin.P2.GatPoly VSS.$14.Metal1 4.05924e-06f
Cred_9270 vin.P2.GatPoly VSS.$29.Metal1 0.000797636f
Cred_9271 vin.P2.GatPoly VSS.$50.Metal1 0.0123177f
Cred_9272 vin.P2.GatPoly VSS.$520.Metal1 1.80155e-08f
Cred_9273 vin.P2.GatPoly VSS.$550.Metal2 0.000383794f
Cred_9274 vin.P2.GatPoly VSS.$557.Metal2 0.00355095f
Cred_9275 vin.P2.GatPoly VSS.$60.Metal1 0.000754615f
Cred_9276 vin.P2.GatPoly VSS.P0.GatPoly 0.00364759f
Cred_9277 vin.P2.GatPoly VSS.P0.pSD 3.50787e-05f
Cred_9278 vin.P2.GatPoly VSS.P3.nSD 0.00114605f
Cred_9279 vin.P20.GatPoly vout.$1026.Metal3 0.0021407f
Cred_9280 vin.P20.GatPoly vout.$1044.Metal3 0.0021407f
Cred_9281 vin.P20.GatPoly vout.P20.nSD 0.00708301f
Cred_9282 vin.P20.GatPoly vout.P20.pSD 3.4883e-05f
Cred_9283 vin.P20.GatPoly VSS.$204.Metal1 0.0126865f
Cred_9284 vin.P20.GatPoly VSS.$220.Metal1 0.000336481f
Cred_9285 vin.P20.GatPoly VSS.$669.Metal2 0.00257229f
Cred_9286 vin.P20.GatPoly VSS.$676.Metal2 0.00106904f
Cred_9287 vin.P20.GatPoly VSS.$680.Metal2 2.02544e-06f
Cred_9288 vin.P20.GatPoly VSS.P0.pSD 2.52456e-06f
Cred_9289 vin.P20.GatPoly VSS.P21.nSD 0.00114635f
Cred_9290 vin.P21.GatPoly vout.$1026.Metal3 0.00203801f
Cred_9291 vin.P21.GatPoly vout.$1044.Metal3 0.00203801f
Cred_9292 vin.P21.GatPoly vout.P20.nSD 0.00674302f
Cred_9293 vin.P21.GatPoly vout.P20.pSD 3.32097e-05f
Cred_9294 vin.P21.GatPoly VSS.$14.Metal1 1.32254e-07f
Cred_9295 vin.P21.GatPoly VSS.$204.Metal1 0.000295011f
Cred_9296 vin.P21.GatPoly VSS.$220.Metal1 0.0128321f
Cred_9297 vin.P21.GatPoly VSS.$29.Metal1 2.22539e-07f
Cred_9298 vin.P21.GatPoly VSS.$520.Metal1 1.0402e-07f
Cred_9299 vin.P21.GatPoly VSS.$676.Metal2 1.60924e-06f
Cred_9300 vin.P21.GatPoly VSS.$680.Metal2 0.000806885f
Cred_9301 vin.P21.GatPoly VSS.$687.Metal2 0.00285505f
Cred_9302 vin.P21.GatPoly VSS.P0.pSD 2.07543e-05f
Cred_9303 vin.P21.GatPoly VSS.P23.nSD 0.00115502f
Cred_9304 vin.P22.GatPoly vout.$1044.Metal3 0.00432914f
Cred_9305 vin.P22.GatPoly vout.P22.nSD 0.00707015f
Cred_9306 vin.P22.GatPoly VSS.$220.Metal1 0.0120634f
Cred_9307 vin.P22.GatPoly VSS.$230.Metal1 0.00067883f
Cred_9308 vin.P22.GatPoly VSS.$680.Metal2 0.000857629f
Cred_9309 vin.P22.GatPoly VSS.$687.Metal2 0.00305139f
Cred_9310 vin.P22.GatPoly VSS.P0.pSD 1.08121e-06f
Cred_9311 vin.P22.GatPoly VSS.P23.nSD 0.00112342f
Cred_9312 vin.P23.GatPoly vout.$1044.Metal3 0.00412147f
Cred_9313 vin.P23.GatPoly vout.P22.nSD 0.00673078f
Cred_9314 vin.P23.GatPoly VSS.$14.Metal1 1.03025e-07f
Cred_9315 vin.P23.GatPoly VSS.$230.Metal1 0.000579897f
Cred_9316 vin.P23.GatPoly VSS.$238.Metal1 0.0123013f
Cred_9317 vin.P23.GatPoly VSS.$29.Metal1 1.73356e-07f
Cred_9318 vin.P23.GatPoly VSS.$520.Metal1 1.34495e-07f
Cred_9319 vin.P23.GatPoly VSS.$695.Metal2 0.00286866f
Cred_9320 vin.P23.GatPoly VSS.$702.Metal2 0.00105085f
Cred_9321 vin.P23.GatPoly VSS.P0.pSD 1.95963e-05f
Cred_9322 vin.P23.GatPoly VSS.P25.nSD 0.00113309f
Cred_9323 vin.P24.GatPoly vout.$1044.Metal3 0.0021407f
Cred_9324 vin.P24.GatPoly vout.$1062.Metal3 0.0021407f
Cred_9325 vin.P24.GatPoly vout.P24.nSD 0.00708301f
Cred_9326 vin.P24.GatPoly vout.P24.pSD 3.4883e-05f
Cred_9327 vin.P24.GatPoly VSS.$238.Metal1 0.0126865f
Cred_9328 vin.P24.GatPoly VSS.$254.Metal1 0.000336478f
Cred_9329 vin.P24.GatPoly VSS.$695.Metal2 0.00266116f
Cred_9330 vin.P24.GatPoly VSS.$702.Metal2 0.000980336f
Cred_9331 vin.P24.GatPoly VSS.$706.Metal2 1.96211e-06f
Cred_9332 vin.P24.GatPoly VSS.P0.pSD 2.52471e-06f
Cred_9333 vin.P24.GatPoly VSS.P25.nSD 0.00114633f
Cred_9334 vin.P25.GatPoly vout.$1044.Metal3 0.00203656f
Cred_9335 vin.P25.GatPoly vout.$1062.Metal3 0.00203656f
Cred_9336 vin.P25.GatPoly vout.P24.nSD 0.0067382f
Cred_9337 vin.P25.GatPoly vout.P24.pSD 3.3186e-05f
Cred_9338 vin.P25.GatPoly VSS.$238.Metal1 0.000295008f
Cred_9339 vin.P25.GatPoly VSS.$254.Metal1 0.012765f
Cred_9340 vin.P25.GatPoly VSS.$702.Metal2 1.66475e-06f
Cred_9341 vin.P25.GatPoly VSS.$706.Metal2 0.000894216f
Cred_9342 vin.P25.GatPoly VSS.$713.Metal2 0.0027598f
Cred_9343 vin.P25.GatPoly VSS.P0.pSD 2.30271e-06f
Cred_9344 vin.P25.GatPoly VSS.P27.nSD 0.00115465f
Cred_9345 vin.P26.GatPoly vout.$1062.Metal3 0.00440677f
Cred_9346 vin.P26.GatPoly vout.P26.nSD 0.00719722f
Cred_9347 vin.P26.GatPoly VSS 0.000665426f
Cred_9348 vin.P26.GatPoly VSS.$14.Metal1 4.6843e-07f
Cred_9349 vin.P26.GatPoly VSS.$254.Metal1 0.012214f
Cred_9350 vin.P26.GatPoly VSS.$29.Metal1 7.88212e-07f
Cred_9351 vin.P26.GatPoly VSS.$520.Metal1 1.19248e-06f
Cred_9352 vin.P26.GatPoly VSS.$706.Metal2 0.000957637f
Cred_9353 vin.P26.GatPoly VSS.$713.Metal2 0.00297097f
Cred_9354 vin.P26.GatPoly VSS.P0.pSD 0.000117682f
Cred_9355 vin.P26.GatPoly VSS.P27.nSD 0.00114151f
Cred_9356 vin.P27.GatPoly vout.$1062.Metal3 0.00412147f
Cred_9357 vin.P27.GatPoly vout.P26.nSD 0.00673078f
Cred_9358 vin.P27.GatPoly VSS 0.000665426f
Cred_9359 vin.P27.GatPoly VSS.$14.Metal1 5.82064e-08f
Cred_9360 vin.P27.GatPoly VSS.$270.Metal1 0.0122159f
Cred_9361 vin.P27.GatPoly VSS.$29.Metal1 9.79419e-08f
Cred_9362 vin.P27.GatPoly VSS.$520.Metal1 2.40875e-07f
Cred_9363 vin.P27.GatPoly VSS.$721.Metal2 0.00296401f
Cred_9364 vin.P27.GatPoly VSS.$728.Metal2 0.000955393f
Cred_9365 vin.P27.GatPoly VSS.P0.pSD 1.96062e-05f
Cred_9366 vin.P27.GatPoly VSS.P29.nSD 0.00113306f
Cred_9367 vin.P28.GatPoly vout.$1062.Metal3 0.0021407f
Cred_9368 vin.P28.GatPoly vout.$1080.Metal3 0.0021407f
Cred_9369 vin.P28.GatPoly vout.P28.nSD 0.00708301f
Cred_9370 vin.P28.GatPoly vout.P28.pSD 3.4883e-05f
Cred_9371 vin.P28.GatPoly VSS.$270.Metal1 0.0126993f
Cred_9372 vin.P28.GatPoly VSS.$286.Metal1 0.000295008f
Cred_9373 vin.P28.GatPoly VSS.$721.Metal2 0.00275269f
Cred_9374 vin.P28.GatPoly VSS.$728.Metal2 0.000891922f
Cred_9375 vin.P28.GatPoly VSS.$732.Metal2 1.66475e-06f
Cred_9376 vin.P28.GatPoly VSS.P0.pSD 2.30271e-06f
Cred_9377 vin.P28.GatPoly VSS.P29.nSD 0.001146f
Cred_9378 vin.P29.GatPoly vout.$1062.Metal3 0.00203819f
Cred_9379 vin.P29.GatPoly vout.$1080.Metal3 0.0020415f
Cred_9380 vin.P29.GatPoly vout.P28.nSD 0.00674363f
Cred_9381 vin.P29.GatPoly vout.P28.pSD 3.32126e-05f
Cred_9382 vin.P29.GatPoly vout.P30.nSD 5.41305e-06f
Cred_9383 vin.P29.GatPoly VSS.$14.Metal1 5.06627e-08f
Cred_9384 vin.P29.GatPoly VSS.$270.Metal1 0.000336478f
Cred_9385 vin.P29.GatPoly VSS.$286.Metal1 0.0128429f
Cred_9386 vin.P29.GatPoly VSS.$29.Metal1 8.52485e-08f
Cred_9387 vin.P29.GatPoly VSS.$520.Metal1 3.46366e-07f
Cred_9388 vin.P29.GatPoly VSS.$728.Metal2 1.96211e-06f
Cred_9389 vin.P29.GatPoly VSS.$732.Metal2 0.000983493f
Cred_9390 vin.P29.GatPoly VSS.$739.Metal2 0.00266977f
Cred_9391 vin.P29.GatPoly VSS.P0.pSD 2.33236e-05f
Cred_9392 vin.P29.GatPoly VSS.P31.nSD 0.00115714f
Cred_9393 vin.P3.GatPoly vout.$954.Metal3 0.00412147f
Cred_9394 vin.P3.GatPoly vout.P2.nSD 0.00673078f
Cred_9395 vin.P3.GatPoly VSS.$14.Metal1 1.32032e-06f
Cred_9396 vin.P3.GatPoly VSS.$29.Metal1 2.22166e-06f
Cred_9397 vin.P3.GatPoly VSS.$520.Metal1 1.00024e-08f
Cred_9398 vin.P3.GatPoly VSS.$565.Metal2 0.00234884f
Cred_9399 vin.P3.GatPoly VSS.$572.Metal2 0.00149914f
Cred_9400 vin.P3.GatPoly VSS.$60.Metal1 0.000833847f
Cred_9401 vin.P3.GatPoly VSS.$68.Metal1 0.0124035f
Cred_9402 vin.P3.GatPoly VSS.P0.GatPoly 0.00235593f
Cred_9403 vin.P3.GatPoly VSS.P0.pSD 1.7351e-05f
Cred_9404 vin.P3.GatPoly VSS.P5.nSD 0.00106506f
Cred_9405 vin.P30.GatPoly vout.$1062.Metal3 1.63406e-06f
Cred_9406 vin.P30.GatPoly vout.$1080.Metal3 0.00436044f
Cred_9407 vin.P30.GatPoly vout.P28.nSD 5.42286e-06f
Cred_9408 vin.P30.GatPoly vout.P28.pSD 2.66273e-08f
Cred_9409 vin.P30.GatPoly vout.P30.nSD 0.00711873f
Cred_9410 vin.P30.GatPoly VSS.$14.Metal1 5.06627e-08f
Cred_9411 vin.P30.GatPoly VSS.$286.Metal1 0.0123187f
Cred_9412 vin.P30.GatPoly VSS.$29.Metal1 8.52485e-08f
Cred_9413 vin.P30.GatPoly VSS.$298.Metal1 0.000579897f
Cred_9414 vin.P30.GatPoly VSS.$520.Metal1 3.46366e-07f
Cred_9415 vin.P30.GatPoly VSS.$732.Metal2 0.00105121f
Cred_9416 vin.P30.GatPoly VSS.$739.Metal2 0.00286962f
Cred_9417 vin.P30.GatPoly VSS.P0.pSD 2.18958e-05f
Cred_9418 vin.P30.GatPoly VSS.P31.nSD 0.00113429f
Cred_9419 vin.P31.GatPoly vout.$1080.Metal3 0.00409218f
Cred_9420 vin.P31.GatPoly vout.P30.nSD 0.00668279f
Cred_9421 vin.P31.GatPoly VSS.$298.Metal1 0.00067883f
Cred_9422 vin.P31.GatPoly VSS.$304.Metal1 0.0120634f
Cred_9423 vin.P31.GatPoly VSS.$747.Metal2 0.00305139f
Cred_9424 vin.P31.GatPoly VSS.$754.Metal2 0.000857629f
Cred_9425 vin.P31.GatPoly VSS.P0.pSD 1.08121e-06f
Cred_9426 vin.P31.GatPoly VSS.P33.nSD 0.00112342f
Cred_9427 vin.P32.GatPoly vout.$1080.Metal3 0.00215519f
Cred_9428 vin.P32.GatPoly vout.$1098.Metal3 0.00215519f
Cred_9429 vin.P32.GatPoly vout.P32.nSD 0.00713108f
Cred_9430 vin.P32.GatPoly vout.P32.pSD 3.51191e-05f
Cred_9431 vin.P32.GatPoly VSS.$14.Metal1 3.48166e-08f
Cred_9432 vin.P32.GatPoly VSS.$29.Metal1 5.85847e-08f
Cred_9433 vin.P32.GatPoly VSS.$304.Metal1 0.0128321f
Cred_9434 vin.P32.GatPoly VSS.$320.Metal1 0.000295011f
Cred_9435 vin.P32.GatPoly VSS.$520.Metal1 3.95095e-07f
Cred_9436 vin.P32.GatPoly VSS.$747.Metal2 0.00285505f
Cred_9437 vin.P32.GatPoly VSS.$754.Metal2 0.000806885f
Cred_9438 vin.P32.GatPoly VSS.$758.Metal2 1.60924e-06f
Cred_9439 vin.P32.GatPoly VSS.P0.pSD 2.07246e-05f
Cred_9440 vin.P32.GatPoly VSS.P33.nSD 0.00115502f
Cred_9441 vin.P33.GatPoly vout.$1080.Metal3 0.00202352f
Cred_9442 vin.P33.GatPoly vout.$1098.Metal3 0.00202352f
Cred_9443 vin.P33.GatPoly vout.P32.nSD 0.00669495f
Cred_9444 vin.P33.GatPoly vout.P32.pSD 3.29736e-05f
Cred_9445 vin.P33.GatPoly VSS.$304.Metal1 0.000336481f
Cred_9446 vin.P33.GatPoly VSS.$320.Metal1 0.0126865f
Cred_9447 vin.P33.GatPoly VSS.$754.Metal2 2.02544e-06f
Cred_9448 vin.P33.GatPoly VSS.$758.Metal2 0.00106904f
Cred_9449 vin.P33.GatPoly VSS.$765.Metal2 0.00257229f
Cred_9450 vin.P33.GatPoly VSS.P0.pSD 2.52456e-06f
Cred_9451 vin.P33.GatPoly VSS.P35.nSD 0.00114635f
Cred_9452 vin.P34.GatPoly vout.$1098.Metal3 0.00435844f
Cred_9453 vin.P34.GatPoly vout.P34.nSD 0.00711813f
Cred_9454 vin.P34.GatPoly VSS.$14.Metal1 2.69237e-08f
Cred_9455 vin.P34.GatPoly VSS.$29.Metal1 4.53036e-08f
Cred_9456 vin.P34.GatPoly VSS.$320.Metal1 0.0123123f
Cred_9457 vin.P34.GatPoly VSS.$332.Metal1 0.000568816f
Cred_9458 vin.P34.GatPoly VSS.$520.Metal1 5.08616e-07f
Cred_9459 vin.P34.GatPoly VSS.$758.Metal2 0.00114631f
Cred_9460 vin.P34.GatPoly VSS.$765.Metal2 0.00277322f
Cred_9461 vin.P34.GatPoly VSS.P0.pSD 1.94621e-05f
Cred_9462 vin.P34.GatPoly VSS.P35.nSD 0.00113311f
Cred_9463 vin.P35.GatPoly vout.$1098.Metal3 0.00409218f
Cred_9464 vin.P35.GatPoly vout.P34.nSD 0.00668279f
Cred_9465 vin.P35.GatPoly VSS.$332.Metal1 0.00069277f
Cred_9466 vin.P35.GatPoly VSS.$338.Metal1 0.0120495f
Cred_9467 vin.P35.GatPoly VSS.$773.Metal2 0.00314671f
Cred_9468 vin.P35.GatPoly VSS.$780.Metal2 0.000762405f
Cred_9469 vin.P35.GatPoly VSS.P0.pSD 1.06893e-06f
Cred_9470 vin.P35.GatPoly VSS.P37.nSD 0.00112338f
Cred_9471 vin.P36.GatPoly vout.$1098.Metal3 0.00215519f
Cred_9472 vin.P36.GatPoly vout.$1116.Metal3 0.00215519f
Cred_9473 vin.P36.GatPoly vout.P36.nSD 0.00713108f
Cred_9474 vin.P36.GatPoly vout.P36.pSD 3.51191e-05f
Cred_9475 vin.P36.GatPoly VSS.$14.Metal1 2.08165e-08f
Cred_9476 vin.P36.GatPoly VSS.$29.Metal1 3.50272e-08f
Cred_9477 vin.P36.GatPoly VSS.$338.Metal1 0.0128122f
Cred_9478 vin.P36.GatPoly VSS.$354.Metal1 0.000292974f
Cred_9479 vin.P36.GatPoly VSS.$520.Metal1 6.55869e-07f
Cred_9480 vin.P36.GatPoly VSS.$773.Metal2 0.00295218f
Cred_9481 vin.P36.GatPoly VSS.$780.Metal2 0.000719497f
Cred_9482 vin.P36.GatPoly VSS.$784.Metal2 1.54299e-06f
Cred_9483 vin.P36.GatPoly VSS.P0.pSD 2.04856e-05f
Cred_9484 vin.P36.GatPoly VSS.P37.nSD 0.00115418f
Cred_9485 vin.P37.GatPoly vout.$1098.Metal3 0.00202352f
Cred_9486 vin.P37.GatPoly vout.$1116.Metal3 0.00202352f
Cred_9487 vin.P37.GatPoly vout.P36.nSD 0.00669495f
Cred_9488 vin.P37.GatPoly vout.P36.pSD 3.29736e-05f
Cred_9489 vin.P37.GatPoly VSS.$338.Metal1 0.000336486f
Cred_9490 vin.P37.GatPoly VSS.$354.Metal1 0.0126831f
Cred_9491 vin.P37.GatPoly VSS.$780.Metal2 2.08879e-06f
Cred_9492 vin.P37.GatPoly VSS.$784.Metal2 0.00115896f
Cred_9493 vin.P37.GatPoly VSS.$791.Metal2 0.00248609f
Cred_9494 vin.P37.GatPoly VSS.P0.pSD 2.52442e-06f
Cred_9495 vin.P37.GatPoly VSS.P39.nSD 0.00114604f
Cred_9496 vin.P38.GatPoly vout.$1116.Metal3 0.00435844f
Cred_9497 vin.P38.GatPoly vout.P38.nSD 0.00711813f
Cred_9498 vin.P38.GatPoly VSS.$14.Metal1 1.60899e-08f
Cred_9499 vin.P38.GatPoly VSS.$29.Metal1 2.7074e-08f
Cred_9500 vin.P38.GatPoly VSS.$354.Metal1 0.0123229f
Cred_9501 vin.P38.GatPoly VSS.$366.Metal1 0.000558135f
Cred_9502 vin.P38.GatPoly VSS.$520.Metal1 8.46622e-07f
Cred_9503 vin.P38.GatPoly VSS.$784.Metal2 0.00124176f
Cred_9504 vin.P38.GatPoly VSS.$791.Metal2 0.0026778f
Cred_9505 vin.P38.GatPoly VSS.P0.pSD 1.91875e-05f
Cred_9506 vin.P38.GatPoly VSS.P39.nSD 0.00113314f
Cred_9507 vin.P39.GatPoly vout.$1116.Metal3 0.00419037f
Cred_9508 vin.P39.GatPoly vout.P38.nSD 0.00684354f
Cred_9509 vin.P39.GatPoly VSS.$14.Metal1 2.9562e-08f
Cred_9510 vin.P39.GatPoly VSS.$29.Metal1 4.97429e-08f
Cred_9511 vin.P39.GatPoly VSS.$366.Metal1 0.00070728f
Cred_9512 vin.P39.GatPoly VSS.$372.Metal1 0.0123655f
Cred_9513 vin.P39.GatPoly VSS.$520.Metal1 2.60061e-06f
Cred_9514 vin.P39.GatPoly VSS.$799.Metal2 0.00326271f
Cred_9515 vin.P39.GatPoly VSS.$806.Metal2 0.000671415f
Cred_9516 vin.P39.GatPoly VSS.P0.pSD 4.33484e-05f
Cred_9517 vin.P39.GatPoly VSS.P41.nSD 0.00114619f
Cred_9518 vin.P4.GatPoly vout.$954.Metal3 0.0021407f
Cred_9519 vin.P4.GatPoly vout.$972.Metal3 0.0021407f
Cred_9520 vin.P4.GatPoly vout.P4.nSD 0.00708301f
Cred_9521 vin.P4.GatPoly vout.P4.pSD 3.4883e-05f
Cred_9522 vin.P4.GatPoly VSS.$565.Metal2 0.00224343f
Cred_9523 vin.P4.GatPoly VSS.$572.Metal2 0.00144059f
Cred_9524 vin.P4.GatPoly VSS.$576.Metal2 2.2323e-06f
Cred_9525 vin.P4.GatPoly VSS.$68.Metal1 0.0126147f
Cred_9526 vin.P4.GatPoly VSS.$84.Metal1 0.000329625f
Cred_9527 vin.P4.GatPoly VSS.P0.GatPoly 0.00181603f
Cred_9528 vin.P4.GatPoly VSS.P0.pSD 2.47229e-06f
Cred_9529 vin.P4.GatPoly VSS.P5.nSD 0.00114276f
Cred_9530 vin.P40.GatPoly vout.$1116.Metal3 0.0021407f
Cred_9531 vin.P40.GatPoly vout.$1134.Metal3 0.0021407f
Cred_9532 vin.P40.GatPoly vout.P40.nSD 0.00708301f
Cred_9533 vin.P40.GatPoly vout.P40.pSD 3.4883e-05f
Cred_9534 vin.P40.GatPoly VSS.$372.Metal1 0.0126619f
Cred_9535 vin.P40.GatPoly VSS.$388.Metal1 0.000292981f
Cred_9536 vin.P40.GatPoly VSS.$799.Metal2 0.00304331f
Cred_9537 vin.P40.GatPoly VSS.$806.Metal2 0.000630325f
Cred_9538 vin.P40.GatPoly VSS.$810.Metal2 1.48788e-06f
Cred_9539 vin.P40.GatPoly VSS.P0.pSD 2.28712e-06f
Cred_9540 vin.P40.GatPoly VSS.P41.nSD 0.00114351f
Cred_9541 vin.P41.GatPoly vout.$1116.Metal3 0.00203819f
Cred_9542 vin.P41.GatPoly vout.$1134.Metal3 0.0020415f
Cred_9543 vin.P41.GatPoly vout.P40.nSD 0.00674363f
Cred_9544 vin.P41.GatPoly vout.P40.pSD 3.32126e-05f
Cred_9545 vin.P41.GatPoly vout.P42.nSD 5.41305e-06f
Cred_9546 vin.P41.GatPoly VSS.$14.Metal1 1.07984e-08f
Cred_9547 vin.P41.GatPoly VSS.$29.Metal1 1.81702e-08f
Cred_9548 vin.P41.GatPoly VSS.$372.Metal1 0.000336493f
Cred_9549 vin.P41.GatPoly VSS.$388.Metal1 0.0128321f
Cred_9550 vin.P41.GatPoly VSS.$520.Metal1 1.5901e-06f
Cred_9551 vin.P41.GatPoly VSS.$806.Metal2 2.15216e-06f
Cred_9552 vin.P41.GatPoly VSS.$810.Metal2 0.00125455f
Cred_9553 vin.P41.GatPoly VSS.$817.Metal2 0.00241029f
Cred_9554 vin.P41.GatPoly VSS.P0.pSD 2.21863e-05f
Cred_9555 vin.P41.GatPoly VSS.P43.nSD 0.00115618f
Cred_9556 vin.P42.GatPoly vout.$1116.Metal3 1.63406e-06f
Cred_9557 vin.P42.GatPoly vout.$1134.Metal3 0.00436044f
Cred_9558 vin.P42.GatPoly vout.P40.nSD 5.42286e-06f
Cred_9559 vin.P42.GatPoly vout.P40.pSD 2.66273e-08f
Cred_9560 vin.P42.GatPoly vout.P42.nSD 0.00711873f
Cred_9561 vin.P42.GatPoly VSS.$14.Metal1 1.07984e-08f
Cred_9562 vin.P42.GatPoly VSS.$29.Metal1 1.81702e-08f
Cred_9563 vin.P42.GatPoly VSS.$388.Metal1 0.0123505f
Cred_9564 vin.P42.GatPoly VSS.$400.Metal1 0.000547833f
Cred_9565 vin.P42.GatPoly VSS.$520.Metal1 1.5901e-06f
Cred_9566 vin.P42.GatPoly VSS.$810.Metal2 0.00133766f
Cred_9567 vin.P42.GatPoly VSS.$817.Metal2 0.00258329f
Cred_9568 vin.P42.GatPoly VSS.P0.pSD 2.08621e-05f
Cred_9569 vin.P42.GatPoly VSS.P43.nSD 0.00113436f
Cred_9570 vin.P43.GatPoly vout.$1134.Metal3 0.00419037f
Cred_9571 vin.P43.GatPoly vout.P42.nSD 0.00684354f
Cred_9572 vin.P43.GatPoly VSS.$14.Metal1 1.7591e-08f
Cred_9573 vin.P43.GatPoly VSS.$29.Metal1 2.95997e-08f
Cred_9574 vin.P43.GatPoly VSS.$400.Metal1 0.000722397f
Cred_9575 vin.P43.GatPoly VSS.$406.Metal1 0.0123502f
Cred_9576 vin.P43.GatPoly VSS.$520.Metal1 4.3428e-06f
Cred_9577 vin.P43.GatPoly VSS.$825.Metal2 0.00335874f
Cred_9578 vin.P43.GatPoly VSS.$832.Metal2 0.000575558f
Cred_9579 vin.P43.GatPoly VSS.P0.pSD 4.16249e-05f
Cred_9580 vin.P43.GatPoly VSS.P45.nSD 0.00114615f
Cred_9581 vin.P44.GatPoly vout.$1134.Metal3 0.0021407f
Cred_9582 vin.P44.GatPoly vout.$1152.Metal3 0.0021407f
Cred_9583 vin.P44.GatPoly vout.P44.nSD 0.00708301f
Cred_9584 vin.P44.GatPoly vout.P44.pSD 3.4883e-05f
Cred_9585 vin.P44.GatPoly VSS.$406.Metal1 0.0126484f
Cred_9586 vin.P44.GatPoly VSS.$422.Metal1 0.000292989f
Cred_9587 vin.P44.GatPoly VSS.$825.Metal2 0.00314553f
Cred_9588 vin.P44.GatPoly VSS.$832.Metal2 0.000542941f
Cred_9589 vin.P44.GatPoly VSS.$836.Metal2 1.43279e-06f
Cred_9590 vin.P44.GatPoly VSS.P0.pSD 2.28723e-06f
Cred_9591 vin.P44.GatPoly VSS.P45.nSD 0.00114224f
Cred_9592 vin.P45.GatPoly vout.$1134.Metal3 0.00203819f
Cred_9593 vin.P45.GatPoly vout.$1152.Metal3 0.0020415f
Cred_9594 vin.P45.GatPoly vout.P44.nSD 0.00674363f
Cred_9595 vin.P45.GatPoly vout.P44.pSD 3.32126e-05f
Cred_9596 vin.P45.GatPoly vout.P46.nSD 5.41305e-06f
Cred_9597 vin.P45.GatPoly VSS.$14.Metal1 6.40197e-09f
Cred_9598 vin.P45.GatPoly VSS.$29.Metal1 1.07724e-08f
Cred_9599 vin.P45.GatPoly VSS.$406.Metal1 0.000329613f
Cred_9600 vin.P45.GatPoly VSS.$422.Metal1 0.0127879f
Cred_9601 vin.P45.GatPoly VSS.$520.Metal1 2.65628e-06f
Cred_9602 vin.P45.GatPoly VSS.$832.Metal2 2.17019e-06f
Cred_9603 vin.P45.GatPoly VSS.$836.Metal2 0.00134846f
Cred_9604 vin.P45.GatPoly VSS.$843.Metal2 0.00232913f
Cred_9605 vin.P45.GatPoly VSS.P0.pSD 2.10801e-05f
Cred_9606 vin.P45.GatPoly VSS.P47.nSD 0.0011551f
Cred_9607 vin.P46.GatPoly vout.$1134.Metal3 1.63406e-06f
Cred_9608 vin.P46.GatPoly vout.$1152.Metal3 0.00436044f
Cred_9609 vin.P46.GatPoly vout.P44.nSD 5.42286e-06f
Cred_9610 vin.P46.GatPoly vout.P44.pSD 2.66273e-08f
Cred_9611 vin.P46.GatPoly vout.P46.nSD 0.00711873f
Cred_9612 vin.P46.GatPoly VSS.$14.Metal1 6.40197e-09f
Cred_9613 vin.P46.GatPoly VSS.$29.Metal1 1.07724e-08f
Cred_9614 vin.P46.GatPoly VSS.$422.Metal1 0.0123603f
Cred_9615 vin.P46.GatPoly VSS.$434.Metal1 0.000537889f
Cred_9616 vin.P46.GatPoly VSS.$520.Metal1 2.65628e-06f
Cred_9617 vin.P46.GatPoly VSS.$836.Metal2 0.00143314f
Cred_9618 vin.P46.GatPoly VSS.$843.Metal2 0.00248791f
Cred_9619 vin.P46.GatPoly VSS.P0.pSD 1.98395e-05f
Cred_9620 vin.P46.GatPoly VSS.P1.GatPoly 0.00110577f
Cred_9621 vin.P46.GatPoly VSS.P47.nSD 0.00113438f
Cred_9622 vin.P47.GatPoly vout.$1152.Metal3 0.00409218f
Cred_9623 vin.P47.GatPoly vout.P46.nSD 0.00668279f
Cred_9624 vin.P47.GatPoly VSS.$434.Metal1 0.000738161f
Cred_9625 vin.P47.GatPoly VSS.$440.Metal1 0.0120037f
Cred_9626 vin.P47.GatPoly VSS.$851.Metal2 0.00343297f
Cred_9627 vin.P47.GatPoly VSS.$858.Metal2 0.000476652f
Cred_9628 vin.P47.GatPoly VSS.P0.pSD 1.02875e-06f
Cred_9629 vin.P47.GatPoly VSS.P1.GatPoly 0.00127154f
Cred_9630 vin.P47.GatPoly VSS.P49.nSD 0.00112326f
Cred_9631 vin.P48.GatPoly vout.$1152.Metal3 0.00215519f
Cred_9632 vin.P48.GatPoly vout.$1170.Metal3 0.00215519f
Cred_9633 vin.P48.GatPoly vout.P48.nSD 0.00713108f
Cred_9634 vin.P48.GatPoly vout.P48.pSD 3.51191e-05f
Cred_9635 vin.P48.GatPoly VSS.$14.Metal1 4.35799e-09f
Cred_9636 vin.P48.GatPoly VSS.$29.Metal1 7.33304e-09f
Cred_9637 vin.P48.GatPoly VSS.$440.Metal1 0.0127718f
Cred_9638 vin.P48.GatPoly VSS.$456.Metal1 0.000293f
Cred_9639 vin.P48.GatPoly VSS.$520.Metal1 3.05115e-06f
Cred_9640 vin.P48.GatPoly VSS.$851.Metal2 0.00325962f
Cred_9641 vin.P48.GatPoly VSS.$858.Metal2 0.000456376f
Cred_9642 vin.P48.GatPoly VSS.$862.Metal2 1.3777e-06f
Cred_9643 vin.P48.GatPoly VSS.P0.pSD 1.81348e-05f
Cred_9644 vin.P48.GatPoly VSS.P1.GatPoly 0.00149577f
Cred_9645 vin.P48.GatPoly VSS.P49.nSD 0.00115039f
Cred_9646 vin.P49.GatPoly vout.$1152.Metal3 0.00202352f
Cred_9647 vin.P49.GatPoly vout.$1170.Metal3 0.00202352f
Cred_9648 vin.P49.GatPoly vout.P48.nSD 0.00669495f
Cred_9649 vin.P49.GatPoly vout.P48.pSD 3.29736e-05f
Cred_9650 vin.P49.GatPoly VSS.$440.Metal1 0.000329625f
Cred_9651 vin.P49.GatPoly VSS.$456.Metal1 0.0126147f
Cred_9652 vin.P49.GatPoly VSS.$858.Metal2 2.2323e-06f
Cred_9653 vin.P49.GatPoly VSS.$862.Metal2 0.00144059f
Cred_9654 vin.P49.GatPoly VSS.$869.Metal2 0.00224343f
Cred_9655 vin.P49.GatPoly VSS.P0.pSD 2.47229e-06f
Cred_9656 vin.P49.GatPoly VSS.P1.GatPoly 0.00181603f
Cred_9657 vin.P49.GatPoly VSS.P51.nSD 0.00114276f
Cred_9658 vin.P5.GatPoly vout.$954.Metal3 0.00203801f
Cred_9659 vin.P5.GatPoly vout.$972.Metal3 0.00203801f
Cred_9660 vin.P5.GatPoly vout.P4.nSD 0.00674302f
Cred_9661 vin.P5.GatPoly vout.P4.pSD 3.32097e-05f
Cred_9662 vin.P5.GatPoly VSS.$14.Metal1 1.02134e-06f
Cred_9663 vin.P5.GatPoly VSS.$29.Metal1 1.71858e-06f
Cred_9664 vin.P5.GatPoly VSS.$520.Metal1 1.30928e-08f
Cred_9665 vin.P5.GatPoly VSS.$572.Metal2 1.3777e-06f
Cred_9666 vin.P5.GatPoly VSS.$576.Metal2 0.000450305f
Cred_9667 vin.P5.GatPoly VSS.$583.Metal2 0.00321591f
Cred_9668 vin.P5.GatPoly VSS.$68.Metal1 0.000293f
Cred_9669 vin.P5.GatPoly VSS.$84.Metal1 0.0122793f
Cred_9670 vin.P5.GatPoly VSS.P0.GatPoly 0.00149577f
Cred_9671 vin.P5.GatPoly VSS.P0.pSD 1.84446e-05f
Cred_9672 vin.P5.GatPoly VSS.P7.nSD 0.00110474f
Cred_9673 vin.P50.GatPoly vout.$1170.Metal3 0.00435844f
Cred_9674 vin.P50.GatPoly vout.P50.nSD 0.00711813f
Cred_9675 vin.P50.GatPoly VSS.$14.Metal1 3.31626e-09f
Cred_9676 vin.P50.GatPoly VSS.$29.Metal1 5.58016e-09f
Cred_9677 vin.P50.GatPoly VSS.$456.Metal1 0.0124035f
Cred_9678 vin.P50.GatPoly VSS.$468.Metal1 0.000833847f
Cred_9679 vin.P50.GatPoly VSS.$520.Metal1 3.94431e-06f
Cred_9680 vin.P50.GatPoly VSS.$862.Metal2 0.00149914f
Cred_9681 vin.P50.GatPoly VSS.$869.Metal2 0.00234884f
Cred_9682 vin.P50.GatPoly VSS.P0.pSD 1.69497e-05f
Cred_9683 vin.P50.GatPoly VSS.P1.GatPoly 0.00235593f
Cred_9684 vin.P50.GatPoly VSS.P51.nSD 0.00106506f
Cred_9685 vin.P51.GatPoly vout.$1170.Metal3 0.00419037f
Cred_9686 vin.P51.GatPoly vout.P50.nSD 0.00684354f
Cred_9687 vin.P51.GatPoly VSS.$14.Metal1 5.93235e-09f
Cred_9688 vin.P51.GatPoly VSS.$29.Metal1 9.98216e-09f
Cred_9689 vin.P51.GatPoly VSS.$468.Metal1 0.000754615f
Cred_9690 vin.P51.GatPoly VSS.$474.Metal1 0.0118251f
Cred_9691 vin.P51.GatPoly VSS.$500.Metal1 0.000790806f
Cred_9692 vin.P51.GatPoly VSS.$520.Metal1 1.21265e-05f
Cred_9693 vin.P51.GatPoly VSS.$877.Metal2 0.00350601f
Cred_9694 vin.P51.GatPoly VSS.$884.Metal2 0.000378936f
Cred_9695 vin.P51.GatPoly VSS.P0.pSD 3.38438e-05f
Cred_9696 vin.P51.GatPoly VSS.P1.GatPoly 0.00364759f
Cred_9697 vin.P51.GatPoly VSS.P53.nSD 0.00110041f
Cred_9698 vin.P52.GatPoly vout 0.00418601f
Cred_9699 vin.P52.GatPoly vout.P52.nSD 0.00690112f
Cred_9700 vin.P52.GatPoly VSS.$474.Metal1 0.0103332f
Cred_9701 vin.P52.GatPoly VSS.$486.Metal1 0.00038523f
Cred_9702 vin.P52.GatPoly VSS.$500.Metal1 0.00126417f
Cred_9703 vin.P52.GatPoly VSS.$877.Metal2 0.00315801f
Cred_9704 vin.P52.GatPoly VSS.$884.Metal2 0.000344377f
Cred_9705 vin.P52.GatPoly VSS.P0.pSD 1.72971e-06f
Cred_9706 vin.P52.GatPoly VSS.P1.GatPoly 0.00821234f
Cred_9707 vin.P52.GatPoly VSS.P53.nSD 0.000935971f
Cred_9708 vin.P53.GatPoly vout 0.00467184f
Cred_9709 vin.P53.GatPoly vout.P52.nSD 0.00770305f
Cred_9710 vin.P53.GatPoly VSS.$1048.Metal3 6.27886e-06f
Cred_9711 vin.P53.GatPoly VSS.$14.Metal1 1.75306e-08f
Cred_9712 vin.P53.GatPoly VSS.$29.Metal1 2.94981e-08f
Cred_9713 vin.P53.GatPoly VSS.$474.Metal1 1.87872e-06f
Cred_9714 vin.P53.GatPoly VSS.$486.Metal1 0.00163929f
Cred_9715 vin.P53.GatPoly VSS.$496.Metal1 0.000262096f
Cred_9716 vin.P53.GatPoly VSS.$500.Metal1 0.0230357f
Cred_9717 vin.P53.GatPoly VSS.$520.Metal1 5.3614e-05f
Cred_9718 vin.P53.GatPoly VSS.$877.Metal2 1.57133e-07f
Cred_9719 vin.P53.GatPoly VSS.$884.Metal2 0.000783135f
Cred_9720 vin.P53.GatPoly VSS.$895.Metal2 0.00074016f
Cred_9721 vin.P53.GatPoly VSS.$904.Metal2 0.00136641f
Cred_9722 vin.P53.GatPoly VSS.P0.pSD 0.000108988f
Cred_9723 vin.P53.GatPoly VSS.P1.GatPoly 0.0468557f
Cred_9724 vin.P53.GatPoly VSS.P53.nSD 1.36217e-06f
Cred_9725 vin.P53.GatPoly VSS.P55.nSD 0.000110009f
Cred_9726 vin.P53.GatPoly VSS.P57.nSD 0.000105599f
Cred_9727 vin.P54.GatPoly vout.$954.Metal3 0.0141675f
Cred_9728 vin.P54.GatPoly vout.P0.nSD 6.38696e-05f
Cred_9729 vin.P54.GatPoly vout.P0.pSD 0.02094f
Cred_9730 vin.P54.GatPoly VSS.$29.Metal1 1.07476e-09f
Cred_9731 vin.P54.GatPoly VSS.$531.Metal2 2.14652e-08f
Cred_9732 vin.P54.GatPoly VSS.P0.nSD 7.9682e-12f
Cred_9733 vin.P54.GatPoly VSS.P1.nSD 7.9682e-12f
Cred_9734 vin.P55.GatPoly vout.$954.Metal3 0.0152874f
Cred_9735 vin.P55.GatPoly vout.P0.nSD 6.89185e-05f
Cred_9736 vin.P55.GatPoly vout.P0.pSD 0.0208662f
Cred_9737 vin.P56.GatPoly vout.$954.Metal3 0.0160253f
Cred_9738 vin.P56.GatPoly vout.P2.pSD 0.0207164f
Cred_9739 vin.P57.GatPoly vout.$954.Metal3 0.0158658f
Cred_9740 vin.P57.GatPoly vout.P2.pSD 0.0205491f
Cred_9741 vin.P58.GatPoly vout.$954.Metal3 0.00779749f
Cred_9742 vin.P58.GatPoly vout.$972.Metal3 0.00779749f
Cred_9743 vin.P58.GatPoly vout.P4.nSD 4.684e-05f
Cred_9744 vin.P58.GatPoly vout.P4.pSD 0.0205807f
Cred_9745 vin.P59.GatPoly vout.$954.Metal3 0.0078454f
Cred_9746 vin.P59.GatPoly vout.$972.Metal3 0.0078454f
Cred_9747 vin.P59.GatPoly vout.P4.nSD 4.71278e-05f
Cred_9748 vin.P59.GatPoly vout.P4.pSD 0.0206769f
Cred_9749 vin.P6.GatPoly vout.$972.Metal3 0.00432914f
Cred_9750 vin.P6.GatPoly vout.P6.nSD 0.00707015f
Cred_9751 vin.P6.GatPoly VSS.$576.Metal2 0.00047058f
Cred_9752 vin.P6.GatPoly VSS.$583.Metal2 0.00338925f
Cred_9753 vin.P6.GatPoly VSS.$84.Metal1 0.0115112f
Cred_9754 vin.P6.GatPoly VSS.$94.Metal1 0.000738161f
Cred_9755 vin.P6.GatPoly VSS.P0.GatPoly 0.00127154f
Cred_9756 vin.P6.GatPoly VSS.P0.pSD 1.02875e-06f
Cred_9757 vin.P6.GatPoly VSS.P7.nSD 0.00107761f
Cred_9758 vin.P60.GatPoly vout.$972.Metal3 0.0157689f
Cred_9759 vin.P60.GatPoly vout.P6.pSD 0.0204536f
Cred_9760 vin.P61.GatPoly vout.$972.Metal3 0.0158658f
Cred_9761 vin.P61.GatPoly vout.P6.pSD 0.0205491f
Cred_9762 vin.P62.GatPoly vout.$972.Metal3 0.00779749f
Cred_9763 vin.P62.GatPoly vout.$990.Metal3 0.00779749f
Cred_9764 vin.P62.GatPoly vout.P8.nSD 4.684e-05f
Cred_9765 vin.P62.GatPoly vout.P8.pSD 0.0205807f
Cred_9766 vin.P63.GatPoly vout.$972.Metal3 0.0078454f
Cred_9767 vin.P63.GatPoly vout.$990.Metal3 0.0078454f
Cred_9768 vin.P63.GatPoly vout.P8.nSD 4.71278e-05f
Cred_9769 vin.P63.GatPoly vout.P8.pSD 0.0206769f
Cred_9770 vin.P64.GatPoly vout.$990.Metal3 0.0157689f
Cred_9771 vin.P64.GatPoly vout.P10.pSD 0.0204536f
Cred_9772 vin.P65.GatPoly vout.$990.Metal3 0.0158658f
Cred_9773 vin.P65.GatPoly vout.P10.pSD 0.0205491f
Cred_9774 vin.P66.GatPoly vout.$1008.Metal3 0.00779749f
Cred_9775 vin.P66.GatPoly vout.$990.Metal3 0.00779749f
Cred_9776 vin.P66.GatPoly vout.P12.nSD 4.684e-05f
Cred_9777 vin.P66.GatPoly vout.P12.pSD 0.0205807f
Cred_9778 vin.P67.GatPoly vout.$1008.Metal3 0.0078454f
Cred_9779 vin.P67.GatPoly vout.$990.Metal3 0.0078454f
Cred_9780 vin.P67.GatPoly vout.P12.nSD 4.71278e-05f
Cred_9781 vin.P67.GatPoly vout.P12.pSD 0.0206769f
Cred_9782 vin.P68.GatPoly vout.$1008.Metal3 0.0157689f
Cred_9783 vin.P68.GatPoly vout.P14.pSD 0.0204536f
Cred_9784 vin.P69.GatPoly vout.$1008.Metal3 0.0158658f
Cred_9785 vin.P69.GatPoly vout.P14.pSD 0.0205491f
Cred_9786 vin.P7.GatPoly vout.$972.Metal3 0.00412147f
Cred_9787 vin.P7.GatPoly vout.P6.nSD 0.00673078f
Cred_9788 vin.P7.GatPoly VSS.$102.Metal1 0.013328f
Cred_9789 vin.P7.GatPoly VSS.$14.Metal1 7.90104e-07f
Cred_9790 vin.P7.GatPoly VSS.$29.Metal1 1.32948e-06f
Cred_9791 vin.P7.GatPoly VSS.$520.Metal1 1.70516e-08f
Cred_9792 vin.P7.GatPoly VSS.$591.Metal2 0.00255017f
Cred_9793 vin.P7.GatPoly VSS.$598.Metal2 0.00146907f
Cred_9794 vin.P7.GatPoly VSS.$94.Metal1 0.000537889f
Cred_9795 vin.P7.GatPoly VSS.P0.GatPoly 0.00110577f
Cred_9796 vin.P7.GatPoly VSS.P0.pSD 1.80055e-05f
Cred_9797 vin.P7.GatPoly VSS.P10.nSD 0.00122448f
Cred_9798 vin.P70.GatPoly vout.$1008.Metal3 0.00779749f
Cred_9799 vin.P70.GatPoly vout.$1026.Metal3 0.00779749f
Cred_9800 vin.P70.GatPoly vout.P16.nSD 4.684e-05f
Cred_9801 vin.P70.GatPoly vout.P16.pSD 0.0205807f
Cred_9802 vin.P71.GatPoly vout.$1008.Metal3 0.0078454f
Cred_9803 vin.P71.GatPoly vout.$1026.Metal3 0.0078454f
Cred_9804 vin.P71.GatPoly vout.P16.nSD 4.71278e-05f
Cred_9805 vin.P71.GatPoly vout.P16.pSD 0.0206769f
Cred_9806 vin.P72.GatPoly vout.$1026.Metal3 0.0157689f
Cred_9807 vin.P72.GatPoly vout.P18.pSD 0.0204536f
Cred_9808 vin.P73.GatPoly vout.$1026.Metal3 0.0158658f
Cred_9809 vin.P73.GatPoly vout.P18.pSD 0.0205491f
Cred_9810 vin.P74.GatPoly vout.$1026.Metal3 0.00779749f
Cred_9811 vin.P74.GatPoly vout.$1044.Metal3 0.00779749f
Cred_9812 vin.P74.GatPoly vout.P20.nSD 4.684e-05f
Cred_9813 vin.P74.GatPoly vout.P20.pSD 0.0205807f
Cred_9814 vin.P75.GatPoly vout.$1026.Metal3 0.0078454f
Cred_9815 vin.P75.GatPoly vout.$1044.Metal3 0.0078454f
Cred_9816 vin.P75.GatPoly vout.P20.nSD 4.71278e-05f
Cred_9817 vin.P75.GatPoly vout.P20.pSD 0.0206769f
Cred_9818 vin.P76.GatPoly vout.$1044.Metal3 0.0157689f
Cred_9819 vin.P76.GatPoly vout.P22.pSD 0.0204536f
Cred_9820 vin.P77.GatPoly vout.$1044.Metal3 0.0158658f
Cred_9821 vin.P77.GatPoly vout.P22.pSD 0.0205491f
Cred_9822 vin.P78.GatPoly vout.$1044.Metal3 0.00779749f
Cred_9823 vin.P78.GatPoly vout.$1062.Metal3 0.00779749f
Cred_9824 vin.P78.GatPoly vout.P24.nSD 4.684e-05f
Cred_9825 vin.P78.GatPoly vout.P24.pSD 0.0205807f
Cred_9826 vin.P79.GatPoly vout.$1044.Metal3 0.0078454f
Cred_9827 vin.P79.GatPoly vout.$1062.Metal3 0.0078454f
Cred_9828 vin.P79.GatPoly vout.P24.nSD 4.71278e-05f
Cred_9829 vin.P79.GatPoly vout.P24.pSD 0.0206769f
Cred_9830 vin.P8.GatPoly vout.$972.Metal3 0.0021407f
Cred_9831 vin.P8.GatPoly vout.$990.Metal3 0.0021407f
Cred_9832 vin.P8.GatPoly vout.P8.nSD 0.00708301f
Cred_9833 vin.P8.GatPoly vout.P8.pSD 3.4883e-05f
Cred_9834 vin.P8.GatPoly VSS.$102.Metal1 0.0126314f
Cred_9835 vin.P8.GatPoly VSS.$118.Metal1 0.000329613f
Cred_9836 vin.P8.GatPoly VSS.$591.Metal2 0.00232167f
Cred_9837 vin.P8.GatPoly VSS.$598.Metal2 0.00134416f
Cred_9838 vin.P8.GatPoly VSS.$602.Metal2 2.17019e-06f
Cred_9839 vin.P8.GatPoly VSS.P0.pSD 2.47243e-06f
Cred_9840 vin.P8.GatPoly VSS.P10.nSD 0.00114429f
Cred_9841 vin.P80.GatPoly vout.$1062.Metal3 0.0157689f
Cred_9842 vin.P80.GatPoly vout.P26.pSD 0.0204536f
Cred_9843 vin.P81.GatPoly vout.$1062.Metal3 0.0158658f
Cred_9844 vin.P81.GatPoly vout.P26.pSD 0.0205491f
Cred_9845 vin.P82.GatPoly vout.$1062.Metal3 0.00779749f
Cred_9846 vin.P82.GatPoly vout.$1080.Metal3 0.00779749f
Cred_9847 vin.P82.GatPoly vout.P28.nSD 4.684e-05f
Cred_9848 vin.P82.GatPoly vout.P28.pSD 0.0205807f
Cred_9849 vin.P83.GatPoly vout.$1062.Metal3 0.0078454f
Cred_9850 vin.P83.GatPoly vout.$1080.Metal3 0.0078454f
Cred_9851 vin.P83.GatPoly vout.P28.nSD 4.71278e-05f
Cred_9852 vin.P83.GatPoly vout.P28.pSD 0.0206769f
Cred_9853 vin.P84.GatPoly vout.$1080.Metal3 0.0157689f
Cred_9854 vin.P84.GatPoly vout.P30.pSD 0.0204536f
Cred_9855 vin.P85.GatPoly vout.$1080.Metal3 0.0158658f
Cred_9856 vin.P85.GatPoly vout.P30.pSD 0.0205491f
Cred_9857 vin.P86.GatPoly vout.$1080.Metal3 0.00779749f
Cred_9858 vin.P86.GatPoly vout.$1098.Metal3 0.00779749f
Cred_9859 vin.P86.GatPoly vout.P32.nSD 4.684e-05f
Cred_9860 vin.P86.GatPoly vout.P32.pSD 0.0205807f
Cred_9861 vin.P87.GatPoly vout.$1080.Metal3 0.0078454f
Cred_9862 vin.P87.GatPoly vout.$1098.Metal3 0.0078454f
Cred_9863 vin.P87.GatPoly vout.P32.nSD 4.71278e-05f
Cred_9864 vin.P87.GatPoly vout.P32.pSD 0.0206769f
Cred_9865 vin.P88.GatPoly vout.$1098.Metal3 0.0157689f
Cred_9866 vin.P88.GatPoly vout.P34.pSD 0.0204536f
Cred_9867 vin.P89.GatPoly vout.$1098.Metal3 0.0158658f
Cred_9868 vin.P89.GatPoly vout.P34.pSD 0.0205491f
Cred_9869 vin.P9.GatPoly vout.$972.Metal3 0.00203801f
Cred_9870 vin.P9.GatPoly vout.$990.Metal3 0.00203801f
Cred_9871 vin.P9.GatPoly vout.P8.nSD 0.00674302f
Cred_9872 vin.P9.GatPoly vout.P8.pSD 3.32097e-05f
Cred_9873 vin.P9.GatPoly VSS.$102.Metal1 0.000292989f
Cred_9874 vin.P9.GatPoly VSS.$118.Metal1 0.0122948f
Cred_9875 vin.P9.GatPoly VSS.$14.Metal1 6.11268e-07f
Cred_9876 vin.P9.GatPoly VSS.$29.Metal1 1.02856e-06f
Cred_9877 vin.P9.GatPoly VSS.$520.Metal1 2.21413e-08f
Cred_9878 vin.P9.GatPoly VSS.$598.Metal2 1.43279e-06f
Cred_9879 vin.P9.GatPoly VSS.$602.Metal2 0.000537186f
Cred_9880 vin.P9.GatPoly VSS.$609.Metal2 0.00311196f
Cred_9881 vin.P9.GatPoly VSS.P0.pSD 1.95355e-05f
Cred_9882 vin.P9.GatPoly VSS.P11.nSD 0.0011062f
Cred_9883 vin.P90.GatPoly vout.$1098.Metal3 0.00779749f
Cred_9884 vin.P90.GatPoly vout.$1116.Metal3 0.00779749f
Cred_9885 vin.P90.GatPoly vout.P36.nSD 4.684e-05f
Cred_9886 vin.P90.GatPoly vout.P36.pSD 0.0205807f
Cred_9887 vin.P91.GatPoly vout.$1098.Metal3 0.0078454f
Cred_9888 vin.P91.GatPoly vout.$1116.Metal3 0.0078454f
Cred_9889 vin.P91.GatPoly vout.P36.nSD 4.71278e-05f
Cred_9890 vin.P91.GatPoly vout.P36.pSD 0.0206769f
Cred_9891 vin.P92.GatPoly vout.$1116.Metal3 0.0157689f
Cred_9892 vin.P92.GatPoly vout.P38.pSD 0.0204536f
Cred_9893 vin.P93.GatPoly vout.$1116.Metal3 0.0158658f
Cred_9894 vin.P93.GatPoly vout.P38.pSD 0.0205491f
Cred_9895 vin.P94.GatPoly vout.$1116.Metal3 0.00779749f
Cred_9896 vin.P94.GatPoly vout.$1134.Metal3 0.00779749f
Cred_9897 vin.P94.GatPoly vout.P40.nSD 4.684e-05f
Cred_9898 vin.P94.GatPoly vout.P40.pSD 0.0205807f
Cred_9899 vin.P95.GatPoly vout.$1116.Metal3 0.00784604f
Cred_9900 vin.P95.GatPoly vout.$1134.Metal3 0.00785727f
Cred_9901 vin.P95.GatPoly vout.P40.nSD 4.71316e-05f
Cred_9902 vin.P95.GatPoly vout.P40.pSD 0.0206782f
Cred_9903 vin.P95.GatPoly vout.P42.pSD 1.10627e-05f
Cred_9904 vin.P96.GatPoly vout.$1116.Metal3 5.55162e-06f
Cred_9905 vin.P96.GatPoly vout.$1134.Metal3 0.0158726f
Cred_9906 vin.P96.GatPoly vout.P40.nSD 3.33489e-08f
Cred_9907 vin.P96.GatPoly vout.P40.pSD 1.11532e-05f
Cred_9908 vin.P96.GatPoly vout.P42.pSD 0.0205504f
Cred_9909 vin.P97.GatPoly vout.$1134.Metal3 0.0157689f
Cred_9910 vin.P97.GatPoly vout.P42.pSD 0.0204536f
Cred_9911 vin.P98.GatPoly vout.$1134.Metal3 0.00792429f
Cred_9912 vin.P98.GatPoly vout.$1152.Metal3 0.00792429f
Cred_9913 vin.P98.GatPoly vout.P44.nSD 4.76016e-05f
Cred_9914 vin.P98.GatPoly vout.P44.pSD 0.0208456f
Cred_9915 vin.P99.GatPoly vout.$1134.Metal3 0.00784604f
Cred_9916 vin.P99.GatPoly vout.$1152.Metal3 0.00785727f
Cred_9917 vin.P99.GatPoly vout.P44.nSD 4.71316e-05f
Cred_9918 vin.P99.GatPoly vout.P44.pSD 0.0206782f
Cred_9919 vin.P99.GatPoly vout.P46.pSD 1.10627e-05f
Cred_9920 vout VSS.$1042.Metal3 0.00491575f
Cred_9921 vout VSS.$1048.Metal3 0.0147788f
Cred_9922 vout VSS.$14.Metal1 1.14802e-06f
Cred_9923 vout VSS.$29.Metal1 1.93174e-06f
Cred_9924 vout VSS.$474.Metal1 0.0365746f
Cred_9925 vout VSS.$486.Metal1 0.0021723f
Cred_9926 vout VSS.$500.Metal1 0.036199f
Cred_9927 vout VSS.$520.Metal1 0.00453198f
Cred_9928 vout VSS.$877.Metal2 0.0699389f
Cred_9929 vout VSS.$884.Metal2 0.0120752f
Cred_9930 vout VSS.$895.Metal2 0.000402164f
Cred_9931 vout VSS.$904.Metal2 0.111657f
Cred_9932 vout VSS.P0.pSD 0.00774081f
Cred_9933 vout VSS.P53.nSD 0.00403752f
Cred_9934 vout VSS.P55.nSD 0.000297287f
Cred_9935 vout VSS.P57.nSD 0.000297287f
Cred_9936 vout.$1008.Metal3 VSS.$136.Metal1 0.0191566f
Cred_9937 vout.$1008.Metal3 VSS.$14.Metal1 0.000137116f
Cred_9938 vout.$1008.Metal3 VSS.$152.Metal1 0.0550087f
Cred_9939 vout.$1008.Metal3 VSS.$162.Metal1 0.00317694f
Cred_9940 vout.$1008.Metal3 VSS.$170.Metal1 0.0552608f
Cred_9941 vout.$1008.Metal3 VSS.$186.Metal1 0.0187643f
Cred_9942 vout.$1008.Metal3 VSS.$29.Metal1 0.000230721f
Cred_9943 vout.$1008.Metal3 VSS.$520.Metal1 1.86721e-05f
Cred_9944 vout.$1008.Metal3 VSS.$617.Metal2 0.0271401f
Cred_9945 vout.$1008.Metal3 VSS.$624.Metal2 0.0150609f
Cred_9946 vout.$1008.Metal3 VSS.$628.Metal2 0.0225392f
Cred_9947 vout.$1008.Metal3 VSS.$635.Metal2 0.10347f
Cred_9948 vout.$1008.Metal3 VSS.$643.Metal2 0.0839898f
Cred_9949 vout.$1008.Metal3 VSS.$650.Metal2 0.0390747f
Cred_9950 vout.$1008.Metal3 VSS.$654.Metal2 0.00917163f
Cred_9951 vout.$1008.Metal3 VSS.$661.Metal2 0.0312852f
Cred_9952 vout.$1008.Metal3 VSS.$942.Metal3 0.0019961f
Cred_9953 vout.$1008.Metal3 VSS.$948.Metal3 0.0139175f
Cred_9954 vout.$1008.Metal3 VSS.$952.Metal3 0.0261952f
Cred_9955 vout.$1008.Metal3 VSS.$958.Metal3 0.0131861f
Cred_9956 vout.$1008.Metal3 VSS.$962.Metal3 0.000424439f
Cred_9957 vout.$1008.Metal3 VSS.P0.pSD 0.00763866f
Cred_9958 vout.$1008.Metal3 VSS.P13.nSD 0.00209397f
Cred_9959 vout.$1008.Metal3 VSS.P15.nSD 0.00618384f
Cred_9960 vout.$1008.Metal3 VSS.P17.nSD 0.00618711f
Cred_9961 vout.$1008.Metal3 VSS.P19.nSD 0.00204484f
Cred_9962 vout.$1026.Metal3 VSS.$14.Metal1 8.23074e-05f
Cred_9963 vout.$1026.Metal3 VSS.$170.Metal1 0.018762f
Cred_9964 vout.$1026.Metal3 VSS.$186.Metal1 0.0550192f
Cred_9965 vout.$1026.Metal3 VSS.$196.Metal1 0.00323676f
Cred_9966 vout.$1026.Metal3 VSS.$204.Metal1 0.055195f
Cred_9967 vout.$1026.Metal3 VSS.$220.Metal1 0.0187674f
Cred_9968 vout.$1026.Metal3 VSS.$29.Metal1 0.000138496f
Cred_9969 vout.$1026.Metal3 VSS.$520.Metal1 3.12429e-05f
Cred_9970 vout.$1026.Metal3 VSS.$643.Metal2 0.0281142f
Cred_9971 vout.$1026.Metal3 VSS.$650.Metal2 0.0141465f
Cred_9972 vout.$1026.Metal3 VSS.$654.Metal2 0.0254111f
Cred_9973 vout.$1026.Metal3 VSS.$661.Metal2 0.100482f
Cred_9974 vout.$1026.Metal3 VSS.$669.Metal2 0.0869131f
Cred_9975 vout.$1026.Metal3 VSS.$676.Metal2 0.0362608f
Cred_9976 vout.$1026.Metal3 VSS.$680.Metal2 0.0100149f
Cred_9977 vout.$1026.Metal3 VSS.$687.Metal2 0.0303343f
Cred_9978 vout.$1026.Metal3 VSS.$952.Metal3 0.00236828f
Cred_9979 vout.$1026.Metal3 VSS.$958.Metal3 0.0140179f
Cred_9980 vout.$1026.Metal3 VSS.$962.Metal3 0.0263559f
Cred_9981 vout.$1026.Metal3 VSS.$968.Metal3 0.013027f
Cred_9982 vout.$1026.Metal3 VSS.$972.Metal3 0.000390483f
Cred_9983 vout.$1026.Metal3 VSS.P0.pSD 0.00777293f
Cred_9984 vout.$1026.Metal3 VSS.P17.nSD 0.00204884f
Cred_9985 vout.$1026.Metal3 VSS.P19.nSD 0.00618505f
Cred_9986 vout.$1026.Metal3 VSS.P21.nSD 0.00618638f
Cred_9987 vout.$1026.Metal3 VSS.P23.nSD 0.00204519f
Cred_9988 vout.$1044.Metal3 VSS.$14.Metal1 4.9696e-05f
Cred_9989 vout.$1044.Metal3 VSS.$204.Metal1 0.0187598f
Cred_9990 vout.$1044.Metal3 VSS.$220.Metal1 0.055029f
Cred_9991 vout.$1044.Metal3 VSS.$230.Metal1 0.00329887f
Cred_9992 vout.$1044.Metal3 VSS.$238.Metal1 0.0551261f
Cred_9993 vout.$1044.Metal3 VSS.$254.Metal1 0.0187702f
Cred_9994 vout.$1044.Metal3 VSS.$29.Metal1 8.36218e-05f
Cred_9995 vout.$1044.Metal3 VSS.$520.Metal1 5.22395e-05f
Cred_9996 vout.$1044.Metal3 VSS.$669.Metal2 0.0291199f
Cred_9997 vout.$1044.Metal3 VSS.$676.Metal2 0.0132485f
Cred_9998 vout.$1044.Metal3 VSS.$680.Metal2 0.0282826f
Cred_9999 vout.$1044.Metal3 VSS.$687.Metal2 0.0975f
Cred_10000 vout.$1044.Metal3 VSS.$695.Metal2 0.0898374f
Cred_10001 vout.$1044.Metal3 VSS.$702.Metal2 0.0334467f
Cred_10002 vout.$1044.Metal3 VSS.$706.Metal2 0.010858f
Cred_10003 vout.$1044.Metal3 VSS.$713.Metal2 0.0293838f
Cred_10004 vout.$1044.Metal3 VSS.$962.Metal3 0.00244697f
Cred_10005 vout.$1044.Metal3 VSS.$968.Metal3 0.0145708f
Cred_10006 vout.$1044.Metal3 VSS.$972.Metal3 0.025904f
Cred_10007 vout.$1044.Metal3 VSS.$978.Metal3 0.0128496f
Cred_10008 vout.$1044.Metal3 VSS.$982.Metal3 0.000356529f
Cred_10009 vout.$1044.Metal3 VSS.P0.pSD 0.00783921f
Cred_10010 vout.$1044.Metal3 VSS.P21.nSD 0.00204859f
Cred_10011 vout.$1044.Metal3 VSS.P23.nSD 0.00618616f
Cred_10012 vout.$1044.Metal3 VSS.P25.nSD 0.00618556f
Cred_10013 vout.$1044.Metal3 VSS.P27.nSD 0.00204552f
Cred_10014 vout.$1062.Metal3 VSS 0.00339919f
Cred_10015 vout.$1062.Metal3 VSS.$14.Metal1 3.27339e-05f
Cred_10016 vout.$1062.Metal3 VSS.$238.Metal1 0.0187574f
Cred_10017 vout.$1062.Metal3 VSS.$254.Metal1 0.0550379f
Cred_10018 vout.$1062.Metal3 VSS.$270.Metal1 0.0550106f
Cred_10019 vout.$1062.Metal3 VSS.$286.Metal1 0.0187398f
Cred_10020 vout.$1062.Metal3 VSS.$29.Metal1 5.50803e-05f
Cred_10021 vout.$1062.Metal3 VSS.$520.Metal1 9.77913e-05f
Cred_10022 vout.$1062.Metal3 VSS.$695.Metal2 0.030126f
Cred_10023 vout.$1062.Metal3 VSS.$702.Metal2 0.0123503f
Cred_10024 vout.$1062.Metal3 VSS.$706.Metal2 0.0311539f
Cred_10025 vout.$1062.Metal3 VSS.$713.Metal2 0.0945127f
Cred_10026 vout.$1062.Metal3 VSS.$721.Metal2 0.0927051f
Cred_10027 vout.$1062.Metal3 VSS.$728.Metal2 0.0306135f
Cred_10028 vout.$1062.Metal3 VSS.$732.Metal2 0.0117009f
Cred_10029 vout.$1062.Metal3 VSS.$739.Metal2 0.0284337f
Cred_10030 vout.$1062.Metal3 VSS.$972.Metal3 0.00251652f
Cred_10031 vout.$1062.Metal3 VSS.$978.Metal3 0.0142719f
Cred_10032 vout.$1062.Metal3 VSS.$982.Metal3 0.0254686f
Cred_10033 vout.$1062.Metal3 VSS.$988.Metal3 0.0127478f
Cred_10034 vout.$1062.Metal3 VSS.$992.Metal3 0.000322573f
Cred_10035 vout.$1062.Metal3 VSS.P0.pSD 0.00865364f
Cred_10036 vout.$1062.Metal3 VSS.P25.nSD 0.00204831f
Cred_10037 vout.$1062.Metal3 VSS.P27.nSD 0.00618719f
Cred_10038 vout.$1062.Metal3 VSS.P29.nSD 0.00618354f
Cred_10039 vout.$1062.Metal3 VSS.P31.nSD 0.00204581f
Cred_10040 vout.$1080.Metal3 VSS.$1002.Metal3 0.000288619f
Cred_10041 vout.$1080.Metal3 VSS.$14.Metal1 1.74855e-05f
Cred_10042 vout.$1080.Metal3 VSS.$270.Metal1 0.0187781f
Cred_10043 vout.$1080.Metal3 VSS.$286.Metal1 0.055144f
Cred_10044 vout.$1080.Metal3 VSS.$29.Metal1 2.94223e-05f
Cred_10045 vout.$1080.Metal3 VSS.$298.Metal1 0.00329887f
Cred_10046 vout.$1080.Metal3 VSS.$304.Metal1 0.0550114f
Cred_10047 vout.$1080.Metal3 VSS.$320.Metal1 0.0187421f
Cred_10048 vout.$1080.Metal3 VSS.$520.Metal1 0.000148463f
Cred_10049 vout.$1080.Metal3 VSS.$721.Metal2 0.0310747f
Cred_10050 vout.$1080.Metal3 VSS.$728.Metal2 0.0114331f
Cred_10051 vout.$1080.Metal3 VSS.$732.Metal2 0.0340247f
Cred_10052 vout.$1080.Metal3 VSS.$739.Metal2 0.0915333f
Cred_10053 vout.$1080.Metal3 VSS.$747.Metal2 0.0956891f
Cred_10054 vout.$1080.Metal3 VSS.$754.Metal2 0.0278175f
Cred_10055 vout.$1080.Metal3 VSS.$758.Metal2 0.0125439f
Cred_10056 vout.$1080.Metal3 VSS.$765.Metal2 0.0274838f
Cred_10057 vout.$1080.Metal3 VSS.$982.Metal3 0.00254595f
Cred_10058 vout.$1080.Metal3 VSS.$988.Metal3 0.0148604f
Cred_10059 vout.$1080.Metal3 VSS.$992.Metal3 0.0258314f
Cred_10060 vout.$1080.Metal3 VSS.$998.Metal3 0.0126095f
Cred_10061 vout.$1080.Metal3 VSS.P0.pSD 0.0078294f
Cred_10062 vout.$1080.Metal3 VSS.P29.nSD 0.00204689f
Cred_10063 vout.$1080.Metal3 VSS.P31.nSD 0.00618812f
Cred_10064 vout.$1080.Metal3 VSS.P33.nSD 0.00618365f
Cred_10065 vout.$1080.Metal3 VSS.P35.nSD 0.00204608f
Cred_10066 vout.$1098.Metal3 VSS.$1002.Metal3 0.0261097f
Cred_10067 vout.$1098.Metal3 VSS.$1008.Metal3 0.0121672f
Cred_10068 vout.$1098.Metal3 VSS.$1012.Metal3 0.000254663f
Cred_10069 vout.$1098.Metal3 VSS.$14.Metal1 1.04563e-05f
Cred_10070 vout.$1098.Metal3 VSS.$29.Metal1 1.75944e-05f
Cred_10071 vout.$1098.Metal3 VSS.$304.Metal1 0.0187846f
Cred_10072 vout.$1098.Metal3 VSS.$320.Metal1 0.055213f
Cred_10073 vout.$1098.Metal3 VSS.$332.Metal1 0.00323676f
Cred_10074 vout.$1098.Metal3 VSS.$338.Metal1 0.0550018f
Cred_10075 vout.$1098.Metal3 VSS.$354.Metal1 0.0187441f
Cred_10076 vout.$1098.Metal3 VSS.$520.Metal1 0.000245885f
Cred_10077 vout.$1098.Metal3 VSS.$747.Metal2 0.0321389f
Cred_10078 vout.$1098.Metal3 VSS.$754.Metal2 0.0105533f
Cred_10079 vout.$1098.Metal3 VSS.$758.Metal2 0.0368955f
Cred_10080 vout.$1098.Metal3 VSS.$765.Metal2 0.0885517f
Cred_10081 vout.$1098.Metal3 VSS.$773.Metal2 0.0986125f
Cred_10082 vout.$1098.Metal3 VSS.$780.Metal2 0.0250006f
Cred_10083 vout.$1098.Metal3 VSS.$784.Metal2 0.0133869f
Cred_10084 vout.$1098.Metal3 VSS.$791.Metal2 0.0265344f
Cred_10085 vout.$1098.Metal3 VSS.$992.Metal3 0.00262465f
Cred_10086 vout.$1098.Metal3 VSS.$998.Metal3 0.0150064f
Cred_10087 vout.$1098.Metal3 VSS.P0.pSD 0.00775104f
Cred_10088 vout.$1098.Metal3 VSS.P33.nSD 0.00204765f
Cred_10089 vout.$1098.Metal3 VSS.P35.nSD 0.00618895f
Cred_10090 vout.$1098.Metal3 VSS.P37.nSD 0.00618255f
Cred_10091 vout.$1098.Metal3 VSS.P39.nSD 0.00204632f
Cred_10092 vout.$1116.Metal3 VSS.$1002.Metal3 0.00270333f
Cred_10093 vout.$1116.Metal3 VSS.$1008.Metal3 0.0151317f
Cred_10094 vout.$1116.Metal3 VSS.$1012.Metal3 0.0259821f
Cred_10095 vout.$1116.Metal3 VSS.$1018.Metal3 0.011873f
Cred_10096 vout.$1116.Metal3 VSS.$14.Metal1 6.24699e-06f
Cred_10097 vout.$1116.Metal3 VSS.$29.Metal1 1.05116e-05f
Cred_10098 vout.$1116.Metal3 VSS.$338.Metal1 0.0187814f
Cred_10099 vout.$1116.Metal3 VSS.$354.Metal1 0.055279f
Cred_10100 vout.$1116.Metal3 VSS.$366.Metal1 0.00317694f
Cred_10101 vout.$1116.Metal3 VSS.$372.Metal1 0.0549915f
Cred_10102 vout.$1116.Metal3 VSS.$388.Metal1 0.0187459f
Cred_10103 vout.$1116.Metal3 VSS.$520.Metal1 0.00040962f
Cred_10104 vout.$1116.Metal3 VSS.$773.Metal2 0.0331462f
Cred_10105 vout.$1116.Metal3 VSS.$780.Metal2 0.00965502f
Cred_10106 vout.$1116.Metal3 VSS.$784.Metal2 0.0397662f
Cred_10107 vout.$1116.Metal3 VSS.$791.Metal2 0.0855711f
Cred_10108 vout.$1116.Metal3 VSS.$799.Metal2 0.101543f
Cred_10109 vout.$1116.Metal3 VSS.$806.Metal2 0.0221864f
Cred_10110 vout.$1116.Metal3 VSS.$810.Metal2 0.0142299f
Cred_10111 vout.$1116.Metal3 VSS.$817.Metal2 0.0255834f
Cred_10112 vout.$1116.Metal3 VSS.P0.pSD 0.00759879f
Cred_10113 vout.$1116.Metal3 VSS.P37.nSD 0.00204728f
Cred_10114 vout.$1116.Metal3 VSS.P39.nSD 0.0061897f
Cred_10115 vout.$1116.Metal3 VSS.P41.nSD 0.00618137f
Cred_10116 vout.$1116.Metal3 VSS.P43.nSD 0.00204652f
Cred_10117 vout.$1134.Metal3 VSS.$1012.Metal3 0.00278202f
Cred_10118 vout.$1134.Metal3 VSS.$1018.Metal3 0.0154549f
Cred_10119 vout.$1134.Metal3 VSS.$1022.Metal3 0.0260799f
Cred_10120 vout.$1134.Metal3 VSS.$1028.Metal3 0.011868f
Cred_10121 vout.$1134.Metal3 VSS.$14.Metal1 3.72248e-06f
Cred_10122 vout.$1134.Metal3 VSS.$29.Metal1 6.26369e-06f
Cred_10123 vout.$1134.Metal3 VSS.$372.Metal1 0.0187778f
Cred_10124 vout.$1134.Metal3 VSS.$388.Metal1 0.0553419f
Cred_10125 vout.$1134.Metal3 VSS.$400.Metal1 0.00311929f
Cred_10126 vout.$1134.Metal3 VSS.$406.Metal1 0.0549708f
Cred_10127 vout.$1134.Metal3 VSS.$422.Metal1 0.0187474f
Cred_10128 vout.$1134.Metal3 VSS.$520.Metal1 0.000683826f
Cred_10129 vout.$1134.Metal3 VSS.$799.Metal2 0.0341539f
Cred_10130 vout.$1134.Metal3 VSS.$806.Metal2 0.00875657f
Cred_10131 vout.$1134.Metal3 VSS.$810.Metal2 0.0426369f
Cred_10132 vout.$1134.Metal3 VSS.$817.Metal2 0.0825932f
Cred_10133 vout.$1134.Metal3 VSS.$825.Metal2 0.104411f
Cred_10134 vout.$1134.Metal3 VSS.$832.Metal2 0.0193607f
Cred_10135 vout.$1134.Metal3 VSS.$836.Metal2 0.0150728f
Cred_10136 vout.$1134.Metal3 VSS.$843.Metal2 0.0246348f
Cred_10137 vout.$1134.Metal3 VSS.P0.pSD 0.00733154f
Cred_10138 vout.$1134.Metal3 VSS.P41.nSD 0.00204687f
Cred_10139 vout.$1134.Metal3 VSS.P43.nSD 0.00619035f
Cred_10140 vout.$1134.Metal3 VSS.P45.nSD 0.00617899f
Cred_10141 vout.$1134.Metal3 VSS.P47.nSD 0.0020467f
Cred_10142 vout.$1152.Metal3 VSS.$1022.Metal3 0.0028607f
Cred_10143 vout.$1152.Metal3 VSS.$1028.Metal3 0.0268457f
Cred_10144 vout.$1152.Metal3 VSS.$1036.Metal3 0.0242348f
Cred_10145 vout.$1152.Metal3 VSS.$1042.Metal3 0.00192903f
Cred_10146 vout.$1152.Metal3 VSS.$14.Metal1 2.20189e-06f
Cred_10147 vout.$1152.Metal3 VSS.$29.Metal1 3.70504e-06f
Cred_10148 vout.$1152.Metal3 VSS.$406.Metal1 0.0187645f
Cred_10149 vout.$1152.Metal3 VSS.$422.Metal1 0.0554019f
Cred_10150 vout.$1152.Metal3 VSS.$434.Metal1 0.00306442f
Cred_10151 vout.$1152.Metal3 VSS.$440.Metal1 0.0549754f
Cred_10152 vout.$1152.Metal3 VSS.$456.Metal1 0.0187487f
Cred_10153 vout.$1152.Metal3 VSS.$520.Metal1 0.00114245f
Cred_10154 vout.$1152.Metal3 VSS.$825.Metal2 0.0350973f
Cred_10155 vout.$1152.Metal3 VSS.$832.Metal2 0.00784689f
Cred_10156 vout.$1152.Metal3 VSS.$836.Metal2 0.0455076f
Cred_10157 vout.$1152.Metal3 VSS.$843.Metal2 0.079795f
Cred_10158 vout.$1152.Metal3 VSS.$851.Metal2 0.107615f
Cred_10159 vout.$1152.Metal3 VSS.$858.Metal2 0.0165153f
Cred_10160 vout.$1152.Metal3 VSS.$862.Metal2 0.0159469f
Cred_10161 vout.$1152.Metal3 VSS.$869.Metal2 0.0237019f
Cred_10162 vout.$1152.Metal3 VSS.P0.pSD 0.00687718f
Cred_10163 vout.$1152.Metal3 VSS.P45.nSD 0.00204532f
Cred_10164 vout.$1152.Metal3 VSS.P47.nSD 0.0061909f
Cred_10165 vout.$1152.Metal3 VSS.P49.nSD 0.00617954f
Cred_10166 vout.$1152.Metal3 VSS.P51.nSD 0.00204685f
Cred_10167 vout.$1170.Metal3 VSS.$1028.Metal3 0.000258998f
Cred_10168 vout.$1170.Metal3 VSS.$1036.Metal3 0.0140222f
Cred_10169 vout.$1170.Metal3 VSS.$1042.Metal3 0.0270493f
Cred_10170 vout.$1170.Metal3 VSS.$1048.Metal3 0.00216985f
Cred_10171 vout.$1170.Metal3 VSS.$14.Metal1 1.05844e-06f
Cred_10172 vout.$1170.Metal3 VSS.$29.Metal1 1.781e-06f
Cred_10173 vout.$1170.Metal3 VSS.$434.Metal1 1.65834e-08f
Cred_10174 vout.$1170.Metal3 VSS.$440.Metal1 0.018777f
Cred_10175 vout.$1170.Metal3 VSS.$456.Metal1 0.0554913f
Cred_10176 vout.$1170.Metal3 VSS.$468.Metal1 0.00301004f
Cred_10177 vout.$1170.Metal3 VSS.$474.Metal1 0.0360337f
Cred_10178 vout.$1170.Metal3 VSS.$520.Metal1 0.00133862f
Cred_10179 vout.$1170.Metal3 VSS.$843.Metal2 4.14492e-06f
Cred_10180 vout.$1170.Metal3 VSS.$851.Metal2 0.0362047f
Cred_10181 vout.$1170.Metal3 VSS.$858.Metal2 0.0069272f
Cred_10182 vout.$1170.Metal3 VSS.$862.Metal2 0.0485289f
Cred_10183 vout.$1170.Metal3 VSS.$869.Metal2 0.0768077f
Cred_10184 vout.$1170.Metal3 VSS.$877.Metal2 0.074123f
Cred_10185 vout.$1170.Metal3 VSS.$884.Metal2 0.0077906f
Cred_10186 vout.$1170.Metal3 VSS.P0.pSD 0.00481022f
Cred_10187 vout.$1170.Metal3 VSS.P49.nSD 0.00204678f
Cred_10188 vout.$1170.Metal3 VSS.P51.nSD 0.00619508f
Cred_10189 vout.$1170.Metal3 VSS.P53.nSD 0.00411404f
Cred_10190 vout.$954.Metal3 VSS.$14.Metal1 0.00186381f
Cred_10191 vout.$954.Metal3 VSS.$29.Metal1 0.0408688f
Cred_10192 vout.$954.Metal3 VSS.$42.Metal1 0.00213679f
Cred_10193 vout.$954.Metal3 VSS.$50.Metal1 0.0725864f
Cred_10194 vout.$954.Metal3 VSS.$520.Metal1 6.20515e-06f
Cred_10195 vout.$954.Metal3 VSS.$531.Metal2 0.112189f
Cred_10196 vout.$954.Metal3 VSS.$540.Metal2 0.000395591f
Cred_10197 vout.$954.Metal3 VSS.$550.Metal2 0.0201011f
Cred_10198 vout.$954.Metal3 VSS.$557.Metal2 0.146967f
Cred_10199 vout.$954.Metal3 VSS.$565.Metal2 0.0752472f
Cred_10200 vout.$954.Metal3 VSS.$572.Metal2 0.0474873f
Cred_10201 vout.$954.Metal3 VSS.$576.Metal2 0.00667994f
Cred_10202 vout.$954.Metal3 VSS.$583.Metal2 0.0341599f
Cred_10203 vout.$954.Metal3 VSS.$60.Metal1 0.00301004f
Cred_10204 vout.$954.Metal3 VSS.$68.Metal1 0.0554478f
Cred_10205 vout.$954.Metal3 VSS.$84.Metal1 0.0187535f
Cred_10206 vout.$954.Metal3 VSS.$916.Metal3 0.0159217f
Cred_10207 vout.$954.Metal3 VSS.$922.Metal3 0.028596f
Cred_10208 vout.$954.Metal3 VSS.$926.Metal3 0.0160784f
Cred_10209 vout.$954.Metal3 VSS.$932.Metal3 0.00293939f
Cred_10210 vout.$954.Metal3 VSS.P0.nSD 0.000310095f
Cred_10211 vout.$954.Metal3 VSS.P0.pSD 0.0122042f
Cred_10212 vout.$954.Metal3 VSS.P1.nSD 0.000310095f
Cred_10213 vout.$954.Metal3 VSS.P3.nSD 0.00815203f
Cred_10214 vout.$954.Metal3 VSS.P5.nSD 0.00618958f
Cred_10215 vout.$954.Metal3 VSS.P7.nSD 0.00204359f
Cred_10216 vout.$972.Metal3 VSS.$102.Metal1 0.0571071f
Cred_10217 vout.$972.Metal3 VSS.$118.Metal1 0.0180269f
Cred_10218 vout.$972.Metal3 VSS.$14.Metal1 0.000382426f
Cred_10219 vout.$972.Metal3 VSS.$29.Metal1 0.000643495f
Cred_10220 vout.$972.Metal3 VSS.$520.Metal1 6.60552e-06f
Cred_10221 vout.$972.Metal3 VSS.$565.Metal2 0.0251158f
Cred_10222 vout.$972.Metal3 VSS.$572.Metal2 0.0168307f
Cred_10223 vout.$972.Metal3 VSS.$576.Metal2 0.0168155f
Cred_10224 vout.$972.Metal3 VSS.$583.Metal2 0.109273f
Cred_10225 vout.$972.Metal3 VSS.$591.Metal2 0.0782973f
Cred_10226 vout.$972.Metal3 VSS.$598.Metal2 0.0447888f
Cred_10227 vout.$972.Metal3 VSS.$602.Metal2 0.00747146f
Cred_10228 vout.$972.Metal3 VSS.$609.Metal2 0.0331108f
Cred_10229 vout.$972.Metal3 VSS.$68.Metal1 0.0187739f
Cred_10230 vout.$972.Metal3 VSS.$84.Metal1 0.0532617f
Cred_10231 vout.$972.Metal3 VSS.$926.Metal3 0.0118542f
Cred_10232 vout.$972.Metal3 VSS.$932.Metal3 0.0294701f
Cred_10233 vout.$972.Metal3 VSS.$938.Metal3 0.0143265f
Cred_10234 vout.$972.Metal3 VSS.$94.Metal1 0.00306369f
Cred_10235 vout.$972.Metal3 VSS.$942.Metal3 0.000492349f
Cred_10236 vout.$972.Metal3 VSS.P0.pSD 0.00699301f
Cred_10237 vout.$972.Metal3 VSS.P10.nSD 0.0063846f
Cred_10238 vout.$972.Metal3 VSS.P11.nSD 0.00196101f
Cred_10239 vout.$972.Metal3 VSS.P5.nSD 0.00205023f
Cred_10240 vout.$972.Metal3 VSS.P7.nSD 0.00598486f
Cred_10241 vout.$990.Metal3 VSS.$102.Metal1 0.0187655f
Cred_10242 vout.$990.Metal3 VSS.$118.Metal1 0.0557248f
Cred_10243 vout.$990.Metal3 VSS.$128.Metal1 0.00311929f
Cred_10244 vout.$990.Metal3 VSS.$136.Metal1 0.0549221f
Cred_10245 vout.$990.Metal3 VSS.$14.Metal1 0.000228904f
Cred_10246 vout.$990.Metal3 VSS.$152.Metal1 0.018761f
Cred_10247 vout.$990.Metal3 VSS.$29.Metal1 0.00038517f
Cred_10248 vout.$990.Metal3 VSS.$520.Metal1 1.1137e-05f
Cred_10249 vout.$990.Metal3 VSS.$591.Metal2 0.0261016f
Cred_10250 vout.$990.Metal3 VSS.$598.Metal2 0.0159416f
Cred_10251 vout.$990.Metal3 VSS.$602.Metal2 0.0196579f
Cred_10252 vout.$990.Metal3 VSS.$609.Metal2 0.106407f
Cred_10253 vout.$990.Metal3 VSS.$617.Metal2 0.0810353f
Cred_10254 vout.$990.Metal3 VSS.$624.Metal2 0.0418719f
Cred_10255 vout.$990.Metal3 VSS.$628.Metal2 0.00832826f
Cred_10256 vout.$990.Metal3 VSS.$635.Metal2 0.0322366f
Cred_10257 vout.$990.Metal3 VSS.$932.Metal3 0.00196256f
Cred_10258 vout.$990.Metal3 VSS.$938.Metal3 0.0139649f
Cred_10259 vout.$990.Metal3 VSS.$942.Metal3 0.0263135f
Cred_10260 vout.$990.Metal3 VSS.$948.Metal3 0.0134946f
Cred_10261 vout.$990.Metal3 VSS.$952.Metal3 0.000458393f
Cred_10262 vout.$990.Metal3 VSS.P0.pSD 0.00740015f
Cred_10263 vout.$990.Metal3 VSS.P10.nSD 0.00204925f
Cred_10264 vout.$990.Metal3 VSS.P11.nSD 0.00626518f
Cred_10265 vout.$990.Metal3 VSS.P13.nSD 0.00614185f
Cred_10266 vout.$990.Metal3 VSS.P15.nSD 0.00204445f
Cred_10267 vout.P0.nSD VSS.$14.Metal1 6.83433e-06f
Cred_10268 vout.P0.nSD VSS.$29.Metal1 0.0560792f
Cred_10269 vout.P0.nSD VSS.$42.Metal1 0.00408805f
Cred_10270 vout.P0.nSD VSS.$50.Metal1 0.0489547f
Cred_10271 vout.P0.nSD VSS.$520.Metal1 1.59232e-08f
Cred_10272 vout.P0.nSD VSS.$531.Metal2 0.0352124f
Cred_10273 vout.P0.nSD VSS.$540.Metal2 0.000192857f
Cred_10274 vout.P0.nSD VSS.$550.Metal2 0.00562791f
Cred_10275 vout.P0.nSD VSS.$557.Metal2 0.0321911f
Cred_10276 vout.P0.nSD VSS.$916.Metal3 0.000399754f
Cred_10277 vout.P0.nSD VSS.$922.Metal3 0.000116178f
Cred_10278 vout.P0.nSD VSS.P0.nSD 0.000467446f
Cred_10279 vout.P0.nSD VSS.P0.pSD 4.43981e-05f
Cred_10280 vout.P0.nSD VSS.P1.nSD 0.000467446f
Cred_10281 vout.P0.nSD VSS.P3.nSD 0.00533263f
Cred_10282 vout.P0.pSD VSS.$14.Metal1 1.83552e-05f
Cred_10283 vout.P0.pSD VSS.$29.Metal1 0.000487745f
Cred_10284 vout.P0.pSD VSS.$42.Metal1 2.58719e-05f
Cred_10285 vout.P0.pSD VSS.$50.Metal1 0.000431031f
Cred_10286 vout.P0.pSD VSS.$520.Metal1 4.27656e-08f
Cred_10287 vout.P0.pSD VSS.$531.Metal2 0.00135837f
Cred_10288 vout.P0.pSD VSS.$540.Metal2 4.78974e-06f
Cred_10289 vout.P0.pSD VSS.$550.Metal2 0.000146018f
Cred_10290 vout.P0.pSD VSS.$557.Metal2 0.000852762f
Cred_10291 vout.P0.pSD VSS.$916.Metal3 0.00018617f
Cred_10292 vout.P0.pSD VSS.$922.Metal3 7.89377e-05f
Cred_10293 vout.P0.pSD VSS.P0.nSD 3.75457e-06f
Cred_10294 vout.P0.pSD VSS.P0.pSD 9.91107e-05f
Cred_10295 vout.P0.pSD VSS.P1.nSD 3.75457e-06f
Cred_10296 vout.P0.pSD VSS.P3.nSD 4.76617e-05f
Cred_10297 vout.P10.nSD VSS.$118.Metal1 0.0497476f
Cred_10298 vout.P10.nSD VSS.$128.Metal1 0.00546921f
Cred_10299 vout.P10.nSD VSS.$136.Metal1 0.0474587f
Cred_10300 vout.P10.nSD VSS.$602.Metal2 0.00521023f
Cred_10301 vout.P10.nSD VSS.$609.Metal2 0.031932f
Cred_10302 vout.P10.nSD VSS.$617.Metal2 0.0245154f
Cred_10303 vout.P10.nSD VSS.$624.Metal2 0.0119129f
Cred_10304 vout.P10.nSD VSS.$942.Metal3 0.000344638f
Cred_10305 vout.P10.nSD VSS.$948.Metal3 1.77805e-05f
Cred_10306 vout.P10.nSD VSS.P0.pSD 1.79171e-06f
Cred_10307 vout.P10.nSD VSS.P11.nSD 0.00566909f
Cred_10308 vout.P10.nSD VSS.P13.nSD 0.00534641f
Cred_10309 vout.P12.nSD VSS.$136.Metal1 0.0515107f
Cred_10310 vout.P12.nSD VSS.$14.Metal1 2.60251e-07f
Cred_10311 vout.P12.nSD VSS.$152.Metal1 0.0511682f
Cred_10312 vout.P12.nSD VSS.$29.Metal1 4.37915e-07f
Cred_10313 vout.P12.nSD VSS.$520.Metal1 2.11951e-08f
Cred_10314 vout.P12.nSD VSS.$617.Metal2 0.0235095f
Cred_10315 vout.P12.nSD VSS.$624.Metal2 0.0131164f
Cred_10316 vout.P12.nSD VSS.$628.Metal2 0.00764774f
Cred_10317 vout.P12.nSD VSS.$635.Metal2 0.0292797f
Cred_10318 vout.P12.nSD VSS.$942.Metal3 5.69648e-05f
Cred_10319 vout.P12.nSD VSS.$948.Metal3 0.00037085f
Cred_10320 vout.P12.nSD VSS.$952.Metal3 2.75359e-06f
Cred_10321 vout.P12.nSD VSS.P0.pSD 2.31755e-05f
Cred_10322 vout.P12.nSD VSS.P13.nSD 0.0055568f
Cred_10323 vout.P12.nSD VSS.P15.nSD 0.00550449f
Cred_10324 vout.P12.pSD VSS.$136.Metal1 0.00031216f
Cred_10325 vout.P12.pSD VSS.$14.Metal1 7.05974e-07f
Cred_10326 vout.P12.pSD VSS.$152.Metal1 0.000305713f
Cred_10327 vout.P12.pSD VSS.$29.Metal1 1.18792e-06f
Cred_10328 vout.P12.pSD VSS.$520.Metal1 5.74953e-08f
Cred_10329 vout.P12.pSD VSS.$617.Metal2 0.000442253f
Cred_10330 vout.P12.pSD VSS.$624.Metal2 0.00024542f
Cred_10331 vout.P12.pSD VSS.$628.Metal2 0.00013571f
Cred_10332 vout.P12.pSD VSS.$635.Metal2 0.0005253f
Cred_10333 vout.P12.pSD VSS.$942.Metal3 3.25267e-05f
Cred_10334 vout.P12.pSD VSS.$948.Metal3 0.000180123f
Cred_10335 vout.P12.pSD VSS.$952.Metal3 7.46958e-06f
Cred_10336 vout.P12.pSD VSS.P0.pSD 3.05859e-05f
Cred_10337 vout.P12.pSD VSS.P13.nSD 3.41215e-05f
Cred_10338 vout.P12.pSD VSS.P15.nSD 3.33147e-05f
Cred_10339 vout.P14.nSD VSS.$152.Metal1 0.0473329f
Cred_10340 vout.P14.nSD VSS.$162.Metal1 0.00556714f
Cred_10341 vout.P14.nSD VSS.$170.Metal1 0.0486478f
Cred_10342 vout.P14.nSD VSS.$628.Metal2 0.00602703f
Cred_10343 vout.P14.nSD VSS.$635.Metal2 0.030815f
Cred_10344 vout.P14.nSD VSS.$643.Metal2 0.0254842f
Cred_10345 vout.P14.nSD VSS.$650.Metal2 0.011116f
Cred_10346 vout.P14.nSD VSS.$952.Metal3 0.000346796f
Cred_10347 vout.P14.nSD VSS.$958.Metal3 1.56887e-05f
Cred_10348 vout.P14.nSD VSS.P0.pSD 1.45916e-06f
Cred_10349 vout.P14.nSD VSS.P15.nSD 0.00539465f
Cred_10350 vout.P14.nSD VSS.P17.nSD 0.00549389f
Cred_10351 vout.P16.nSD VSS.$14.Metal1 1.56016e-07f
Cred_10352 vout.P16.nSD VSS.$170.Metal1 0.0502149f
Cred_10353 vout.P16.nSD VSS.$186.Metal1 0.0511712f
Cred_10354 vout.P16.nSD VSS.$29.Metal1 2.62523e-07f
Cred_10355 vout.P16.nSD VSS.$520.Metal1 3.54909e-08f
Cred_10356 vout.P16.nSD VSS.$643.Metal2 0.0242661f
Cred_10357 vout.P16.nSD VSS.$650.Metal2 0.0122918f
Cred_10358 vout.P16.nSD VSS.$654.Metal2 0.00840919f
Cred_10359 vout.P16.nSD VSS.$661.Metal2 0.0284158f
Cred_10360 vout.P16.nSD VSS.$952.Metal3 6.12924e-05f
Cred_10361 vout.P16.nSD VSS.$958.Metal3 0.00036931f
Cred_10362 vout.P16.nSD VSS.$962.Metal3 2.54963e-06f
Cred_10363 vout.P16.nSD VSS.P0.pSD 2.3441e-05f
Cred_10364 vout.P16.nSD VSS.P17.nSD 0.00540865f
Cred_10365 vout.P16.nSD VSS.P19.nSD 0.00550484f
Cred_10366 vout.P16.pSD VSS.$14.Metal1 4.2322e-07f
Cred_10367 vout.P16.pSD VSS.$170.Metal1 0.000305729f
Cred_10368 vout.P16.pSD VSS.$186.Metal1 0.000305768f
Cred_10369 vout.P16.pSD VSS.$29.Metal1 7.12139e-07f
Cred_10370 vout.P16.pSD VSS.$520.Metal1 9.6275e-08f
Cred_10371 vout.P16.pSD VSS.$643.Metal2 0.000458125f
Cred_10372 vout.P16.pSD VSS.$650.Metal2 0.00023052f
Cred_10373 vout.P16.pSD VSS.$654.Metal2 0.000149453f
Cred_10374 vout.P16.pSD VSS.$661.Metal2 0.000509798f
Cred_10375 vout.P16.pSD VSS.$952.Metal3 3.85915e-05f
Cred_10376 vout.P16.pSD VSS.$958.Metal3 0.000181757f
Cred_10377 vout.P16.pSD VSS.$962.Metal3 6.9163e-06f
Cred_10378 vout.P16.pSD VSS.P0.pSD 3.13056e-05f
Cred_10379 vout.P16.pSD VSS.P17.nSD 3.33862e-05f
Cred_10380 vout.P16.pSD VSS.P19.nSD 3.33209e-05f
Cred_10381 vout.P18.nSD VSS.$186.Metal1 0.047336f
Cred_10382 vout.P18.nSD VSS.$196.Metal1 0.00566979f
Cred_10383 vout.P18.nSD VSS.$204.Metal1 0.0485413f
Cred_10384 vout.P18.nSD VSS.$654.Metal2 0.00688737f
Cred_10385 vout.P18.nSD VSS.$661.Metal2 0.0299526f
Cred_10386 vout.P18.nSD VSS.$669.Metal2 0.0263417f
Cred_10387 vout.P18.nSD VSS.$676.Metal2 0.0102616f
Cred_10388 vout.P18.nSD VSS.$962.Metal3 0.000348948f
Cred_10389 vout.P18.nSD VSS.$968.Metal3 1.35969e-05f
Cred_10390 vout.P18.nSD VSS.P0.pSD 1.11464e-06f
Cred_10391 vout.P18.nSD VSS.P19.nSD 0.005395f
Cred_10392 vout.P18.nSD VSS.P21.nSD 0.00549368f
Cred_10393 vout.P2.nSD VSS.$50.Metal1 0.0487424f
Cred_10394 vout.P2.nSD VSS.$550.Metal2 0.00346148f
Cred_10395 vout.P2.nSD VSS.$557.Metal2 0.0335374f
Cred_10396 vout.P2.nSD VSS.$565.Metal2 0.0228952f
Cred_10397 vout.P2.nSD VSS.$572.Metal2 0.0136793f
Cred_10398 vout.P2.nSD VSS.$60.Metal1 0.00531263f
Cred_10399 vout.P2.nSD VSS.$68.Metal1 0.0489489f
Cred_10400 vout.P2.nSD VSS.$922.Metal3 0.000338604f
Cred_10401 vout.P2.nSD VSS.$926.Metal3 3.87682e-05f
Cred_10402 vout.P2.nSD VSS.P0.pSD 2.4362e-06f
Cred_10403 vout.P2.nSD VSS.P3.nSD 0.00554205f
Cred_10404 vout.P2.nSD VSS.P5.nSD 0.00549437f
Cred_10405 vout.P20.nSD VSS.$14.Metal1 9.38579e-08f
Cred_10406 vout.P20.nSD VSS.$204.Metal1 0.0502131f
Cred_10407 vout.P20.nSD VSS.$220.Metal1 0.0511739f
Cred_10408 vout.P20.nSD VSS.$29.Metal1 1.57932e-07f
Cred_10409 vout.P20.nSD VSS.$520.Metal1 5.93582e-08f
Cred_10410 vout.P20.nSD VSS.$669.Metal2 0.0251343f
Cred_10411 vout.P20.nSD VSS.$676.Metal2 0.0115249f
Cred_10412 vout.P20.nSD VSS.$680.Metal2 0.00917052f
Cred_10413 vout.P20.nSD VSS.$687.Metal2 0.0275522f
Cred_10414 vout.P20.nSD VSS.$962.Metal3 6.3857e-05f
Cred_10415 vout.P20.nSD VSS.$968.Metal3 0.000366894f
Cred_10416 vout.P20.nSD VSS.$972.Metal3 2.34565e-06f
Cred_10417 vout.P20.nSD VSS.P0.pSD 2.35841e-05f
Cred_10418 vout.P20.nSD VSS.P21.nSD 0.00540844f
Cred_10419 vout.P20.nSD VSS.P23.nSD 0.00550516f
Cred_10420 vout.P20.pSD VSS.$14.Metal1 2.54606e-07f
Cred_10421 vout.P20.pSD VSS.$204.Metal1 0.000305694f
Cred_10422 vout.P20.pSD VSS.$220.Metal1 0.000305818f
Cred_10423 vout.P20.pSD VSS.$29.Metal1 4.28416e-07f
Cred_10424 vout.P20.pSD VSS.$520.Metal1 1.61019e-07f
Cred_10425 vout.P20.pSD VSS.$669.Metal2 0.000474514f
Cred_10426 vout.P20.pSD VSS.$676.Metal2 0.000215886f
Cred_10427 vout.P20.pSD VSS.$680.Metal2 0.000163194f
Cred_10428 vout.P20.pSD VSS.$687.Metal2 0.000494303f
Cred_10429 vout.P20.pSD VSS.$962.Metal3 3.98738e-05f
Cred_10430 vout.P20.pSD VSS.$968.Metal3 0.000181011f
Cred_10431 vout.P20.pSD VSS.$972.Metal3 6.36298e-06f
Cred_10432 vout.P20.pSD VSS.P0.pSD 3.16932e-05f
Cred_10433 vout.P20.pSD VSS.P21.nSD 3.33821e-05f
Cred_10434 vout.P20.pSD VSS.P23.nSD 3.33267e-05f
Cred_10435 vout.P22.nSD VSS.$220.Metal1 0.0473388f
Cred_10436 vout.P22.nSD VSS.$230.Metal1 0.00577741f
Cred_10437 vout.P22.nSD VSS.$238.Metal1 0.0484306f
Cred_10438 vout.P22.nSD VSS.$680.Metal2 0.0077476f
Cred_10439 vout.P22.nSD VSS.$687.Metal2 0.0290901f
Cred_10440 vout.P22.nSD VSS.$695.Metal2 0.027199f
Cred_10441 vout.P22.nSD VSS.$702.Metal2 0.00940706f
Cred_10442 vout.P22.nSD VSS.$968.Metal3 1.10554e-05f
Cred_10443 vout.P22.nSD VSS.$972.Metal3 0.000339953f
Cred_10444 vout.P22.nSD VSS.$978.Metal3 1.1505e-05f
Cred_10445 vout.P22.nSD VSS.P0.pSD 7.57266e-07f
Cred_10446 vout.P22.nSD VSS.P23.nSD 0.00539533f
Cred_10447 vout.P22.nSD VSS.P25.nSD 0.00549344f
Cred_10448 vout.P24.nSD VSS.$14.Metal1 5.70124e-08f
Cred_10449 vout.P24.nSD VSS.$238.Metal1 0.0502111f
Cred_10450 vout.P24.nSD VSS.$254.Metal1 0.0511764f
Cred_10451 vout.P24.nSD VSS.$29.Metal1 9.59328e-08f
Cred_10452 vout.P24.nSD VSS.$520.Metal1 9.92339e-08f
Cred_10453 vout.P24.nSD VSS.$695.Metal2 0.0260027f
Cred_10454 vout.P24.nSD VSS.$702.Metal2 0.0107579f
Cred_10455 vout.P24.nSD VSS.$706.Metal2 0.00993177f
Cred_10456 vout.P24.nSD VSS.$713.Metal2 0.026689f
Cred_10457 vout.P24.nSD VSS.$972.Metal3 6.63665e-05f
Cred_10458 vout.P24.nSD VSS.$978.Metal3 0.000364365f
Cred_10459 vout.P24.nSD VSS.$982.Metal3 2.14169e-06f
Cred_10460 vout.P24.nSD VSS.P0.pSD 2.36432e-05f
Cred_10461 vout.P24.nSD VSS.P25.nSD 0.00540819f
Cred_10462 vout.P24.nSD VSS.P27.nSD 0.00550546f
Cred_10463 vout.P24.pSD VSS.$14.Metal1 1.54656e-07f
Cred_10464 vout.P24.pSD VSS.$238.Metal1 0.000305654f
Cred_10465 vout.P24.pSD VSS.$254.Metal1 0.000305864f
Cred_10466 vout.P24.pSD VSS.$29.Metal1 2.60234e-07f
Cred_10467 vout.P24.pSD VSS.$520.Metal1 2.69189e-07f
Cred_10468 vout.P24.pSD VSS.$695.Metal2 0.000490907f
Cred_10469 vout.P24.pSD VSS.$702.Metal2 0.00020125f
Cred_10470 vout.P24.pSD VSS.$706.Metal2 0.000176933f
Cred_10471 vout.P24.pSD VSS.$713.Metal2 0.000478814f
Cred_10472 vout.P24.pSD VSS.$972.Metal3 4.10071e-05f
Cred_10473 vout.P24.pSD VSS.$978.Metal3 0.000179966f
Cred_10474 vout.P24.pSD VSS.$982.Metal3 5.8097e-06f
Cred_10475 vout.P24.pSD VSS.P0.pSD 3.18532e-05f
Cred_10476 vout.P24.pSD VSS.P25.nSD 3.33775e-05f
Cred_10477 vout.P24.pSD VSS.P27.nSD 3.3332e-05f
Cred_10478 vout.P26.nSD VSS 0.00600763f
Cred_10479 vout.P26.nSD VSS.$254.Metal1 0.0473414f
Cred_10480 vout.P26.nSD VSS.$270.Metal1 0.0481982f
Cred_10481 vout.P26.nSD VSS.$706.Metal2 0.00860774f
Cred_10482 vout.P26.nSD VSS.$713.Metal2 0.0282274f
Cred_10483 vout.P26.nSD VSS.$721.Metal2 0.0280559f
Cred_10484 vout.P26.nSD VSS.$728.Metal2 0.0085525f
Cred_10485 vout.P26.nSD VSS.$978.Metal3 1.42141e-05f
Cred_10486 vout.P26.nSD VSS.$982.Metal3 0.000339492f
Cred_10487 vout.P26.nSD VSS.$988.Metal3 9.41323e-06f
Cred_10488 vout.P26.nSD VSS.P27.nSD 0.00539562f
Cred_10489 vout.P26.nSD VSS.P29.nSD 0.00549317f
Cred_10490 vout.P28.nSD VSS.$14.Metal1 3.32162e-08f
Cred_10491 vout.P28.nSD VSS.$270.Metal1 0.0503194f
Cred_10492 vout.P28.nSD VSS.$286.Metal1 0.0510678f
Cred_10493 vout.P28.nSD VSS.$29.Metal1 5.58919e-08f
Cred_10494 vout.P28.nSD VSS.$520.Metal1 1.7032e-07f
Cred_10495 vout.P28.nSD VSS.$721.Metal2 0.0268693f
Cred_10496 vout.P28.nSD VSS.$728.Metal2 0.00999098f
Cred_10497 vout.P28.nSD VSS.$732.Metal2 0.0106923f
Cred_10498 vout.P28.nSD VSS.$739.Metal2 0.0258262f
Cred_10499 vout.P28.nSD VSS.$982.Metal3 7.96418e-05f
Cred_10500 vout.P28.nSD VSS.$988.Metal3 0.00035102f
Cred_10501 vout.P28.nSD VSS.$992.Metal3 1.93771e-06f
Cred_10502 vout.P28.nSD VSS.P0.pSD 2.3636e-05f
Cred_10503 vout.P28.nSD VSS.P29.nSD 0.00540788f
Cred_10504 vout.P28.nSD VSS.P31.nSD 0.00550573f
Cred_10505 vout.P28.pSD VSS.$14.Metal1 9.01047e-08f
Cred_10506 vout.P28.pSD VSS.$270.Metal1 0.000305991f
Cred_10507 vout.P28.pSD VSS.$286.Metal1 0.000305368f
Cred_10508 vout.P28.pSD VSS.$29.Metal1 1.51616e-07f
Cred_10509 vout.P28.pSD VSS.$520.Metal1 4.62023e-07f
Cred_10510 vout.P28.pSD VSS.$721.Metal2 0.000506368f
Cred_10511 vout.P28.pSD VSS.$728.Metal2 0.000186304f
Cred_10512 vout.P28.pSD VSS.$732.Metal2 0.000190668f
Cred_10513 vout.P28.pSD VSS.$739.Metal2 0.000463331f
Cred_10514 vout.P28.pSD VSS.$982.Metal3 4.14867e-05f
Cred_10515 vout.P28.pSD VSS.$988.Metal3 0.000180154f
Cred_10516 vout.P28.pSD VSS.$992.Metal3 5.25637e-06f
Cred_10517 vout.P28.pSD VSS.P0.pSD 3.18335e-05f
Cred_10518 vout.P28.pSD VSS.P29.nSD 3.33544e-05f
Cred_10519 vout.P28.pSD VSS.P31.nSD 3.33368e-05f
Cred_10520 vout.P30.nSD VSS.$286.Metal1 0.0475739f
Cred_10521 vout.P30.nSD VSS.$298.Metal1 0.00577741f
Cred_10522 vout.P30.nSD VSS.$304.Metal1 0.0481956f
Cred_10523 vout.P30.nSD VSS.$732.Metal2 0.00946781f
Cred_10524 vout.P30.nSD VSS.$739.Metal2 0.0273649f
Cred_10525 vout.P30.nSD VSS.$747.Metal2 0.0289131f
Cred_10526 vout.P30.nSD VSS.$754.Metal2 0.00769787f
Cred_10527 vout.P30.nSD VSS.$988.Metal3 1.73727e-05f
Cred_10528 vout.P30.nSD VSS.$992.Metal3 0.00033787f
Cred_10529 vout.P30.nSD VSS.$998.Metal3 7.32139e-06f
Cred_10530 vout.P30.nSD VSS.P0.pSD 7.57266e-07f
Cred_10531 vout.P30.nSD VSS.P31.nSD 0.00539589f
Cred_10532 vout.P30.nSD VSS.P33.nSD 0.00549288f
Cred_10533 vout.P32.nSD VSS.$1002.Metal3 1.73375e-06f
Cred_10534 vout.P32.nSD VSS.$14.Metal1 1.98673e-08f
Cred_10535 vout.P32.nSD VSS.$29.Metal1 3.34301e-08f
Cred_10536 vout.P32.nSD VSS.$304.Metal1 0.0503172f
Cred_10537 vout.P32.nSD VSS.$320.Metal1 0.0510698f
Cred_10538 vout.P32.nSD VSS.$520.Metal1 2.80392e-07f
Cred_10539 vout.P32.nSD VSS.$747.Metal2 0.0277406f
Cred_10540 vout.P32.nSD VSS.$754.Metal2 0.00922462f
Cred_10541 vout.P32.nSD VSS.$758.Metal2 0.0114535f
Cred_10542 vout.P32.nSD VSS.$765.Metal2 0.0249636f
Cred_10543 vout.P32.nSD VSS.$992.Metal3 8.22066e-05f
Cred_10544 vout.P32.nSD VSS.$998.Metal3 0.000348728f
Cred_10545 vout.P32.nSD VSS.P0.pSD 2.35616e-05f
Cred_10546 vout.P32.nSD VSS.P33.nSD 0.00540763f
Cred_10547 vout.P32.nSD VSS.P35.nSD 0.00550597f
Cred_10548 vout.P32.pSD VSS.$1002.Metal3 4.70309e-06f
Cred_10549 vout.P32.pSD VSS.$14.Metal1 5.38935e-08f
Cred_10550 vout.P32.pSD VSS.$29.Metal1 9.06848e-08f
Cred_10551 vout.P32.pSD VSS.$304.Metal1 0.000306099f
Cred_10552 vout.P32.pSD VSS.$320.Metal1 0.000305406f
Cred_10553 vout.P32.pSD VSS.$520.Metal1 7.6061e-07f
Cred_10554 vout.P32.pSD VSS.$747.Metal2 0.000523708f
Cred_10555 vout.P32.pSD VSS.$754.Metal2 0.000171968f
Cred_10556 vout.P32.pSD VSS.$758.Metal2 0.000204405f
Cred_10557 vout.P32.pSD VSS.$765.Metal2 0.000447853f
Cred_10558 vout.P32.pSD VSS.$992.Metal3 4.2769e-05f
Cred_10559 vout.P32.pSD VSS.$998.Metal3 0.000179746f
Cred_10560 vout.P32.pSD VSS.P0.pSD 3.16321e-05f
Cred_10561 vout.P32.pSD VSS.P33.nSD 3.33668e-05f
Cred_10562 vout.P32.pSD VSS.P35.nSD 3.33412e-05f
Cred_10563 vout.P34.nSD VSS.$1002.Metal3 0.000342176f
Cred_10564 vout.P34.nSD VSS.$320.Metal1 0.0476846f
Cred_10565 vout.P34.nSD VSS.$332.Metal1 0.00566979f
Cred_10566 vout.P34.nSD VSS.$338.Metal1 0.0481928f
Cred_10567 vout.P34.nSD VSS.$758.Metal2 0.0103278f
Cred_10568 vout.P34.nSD VSS.$765.Metal2 0.026502f
Cred_10569 vout.P34.nSD VSS.$773.Metal2 0.02977f
Cred_10570 vout.P34.nSD VSS.$780.Metal2 0.00684311f
Cred_10571 vout.P34.nSD VSS.$998.Metal3 2.05314e-05f
Cred_10572 vout.P34.nSD VSS.P0.pSD 1.11464e-06f
Cred_10573 vout.P34.nSD VSS.P35.nSD 0.00539613f
Cred_10574 vout.P34.nSD VSS.P37.nSD 0.00549256f
Cred_10575 vout.P36.nSD VSS.$1002.Metal3 8.47707e-05f
Cred_10576 vout.P36.nSD VSS.$1008.Metal3 0.00034631f
Cred_10577 vout.P36.nSD VSS.$1012.Metal3 1.52977e-06f
Cred_10578 vout.P36.nSD VSS.$14.Metal1 1.18765e-08f
Cred_10579 vout.P36.nSD VSS.$29.Metal1 1.99841e-08f
Cred_10580 vout.P36.nSD VSS.$338.Metal1 0.0503145f
Cred_10581 vout.P36.nSD VSS.$354.Metal1 0.0510715f
Cred_10582 vout.P36.nSD VSS.$520.Metal1 4.66082e-07f
Cred_10583 vout.P36.nSD VSS.$773.Metal2 0.0286101f
Cred_10584 vout.P36.nSD VSS.$780.Metal2 0.00845746f
Cred_10585 vout.P36.nSD VSS.$784.Metal2 0.0122146f
Cred_10586 vout.P36.nSD VSS.$791.Metal2 0.0241014f
Cred_10587 vout.P36.nSD VSS.P0.pSD 2.33971e-05f
Cred_10588 vout.P36.nSD VSS.P37.nSD 0.0054073f
Cred_10589 vout.P36.nSD VSS.P39.nSD 0.00550619f
Cred_10590 vout.P36.pSD VSS.$1002.Metal3 4.40511e-05f
Cred_10591 vout.P36.pSD VSS.$1008.Metal3 0.000178999f
Cred_10592 vout.P36.pSD VSS.$1012.Metal3 4.14977e-06f
Cred_10593 vout.P36.pSD VSS.$14.Metal1 3.22169e-08f
Cred_10594 vout.P36.pSD VSS.$29.Metal1 5.42103e-08f
Cred_10595 vout.P36.pSD VSS.$338.Metal1 0.000306045f
Cred_10596 vout.P36.pSD VSS.$354.Metal1 0.000305439f
Cred_10597 vout.P36.pSD VSS.$520.Metal1 1.26433e-06f
Cred_10598 vout.P36.pSD VSS.$773.Metal2 0.000540122f
Cred_10599 vout.P36.pSD VSS.$780.Metal2 0.00015733f
Cred_10600 vout.P36.pSD VSS.$784.Metal2 0.000218142f
Cred_10601 vout.P36.pSD VSS.$791.Metal2 0.000432381f
Cred_10602 vout.P36.pSD VSS.P0.pSD 3.11865e-05f
Cred_10603 vout.P36.pSD VSS.P37.nSD 3.33607e-05f
Cred_10604 vout.P36.pSD VSS.P39.nSD 3.3345e-05f
Cred_10605 vout.P38.nSD VSS.$1008.Metal3 2.36902e-05f
Cred_10606 vout.P38.nSD VSS.$1012.Metal3 0.000338983f
Cred_10607 vout.P38.nSD VSS.$354.Metal1 0.0477911f
Cred_10608 vout.P38.nSD VSS.$366.Metal1 0.00556714f
Cred_10609 vout.P38.nSD VSS.$372.Metal1 0.0481898f
Cred_10610 vout.P38.nSD VSS.$784.Metal2 0.0111878f
Cred_10611 vout.P38.nSD VSS.$791.Metal2 0.025639f
Cred_10612 vout.P38.nSD VSS.$799.Metal2 0.0306269f
Cred_10613 vout.P38.nSD VSS.$806.Metal2 0.0059883f
Cred_10614 vout.P38.nSD VSS.P0.pSD 1.45916e-06f
Cred_10615 vout.P38.nSD VSS.P39.nSD 0.00539635f
Cred_10616 vout.P38.nSD VSS.P41.nSD 0.00549221f
Cred_10617 vout.P4.nSD VSS.$14.Metal1 7.26321e-07f
Cred_10618 vout.P4.nSD VSS.$29.Metal1 1.22216e-06f
Cred_10619 vout.P4.nSD VSS.$520.Metal1 7.43803e-09f
Cred_10620 vout.P4.nSD VSS.$565.Metal2 0.0216641f
Cred_10621 vout.P4.nSD VSS.$572.Metal2 0.0145926f
Cred_10622 vout.P4.nSD VSS.$576.Metal2 0.00612589f
Cred_10623 vout.P4.nSD VSS.$583.Metal2 0.0310094f
Cred_10624 vout.P4.nSD VSS.$68.Metal1 0.0502191f
Cred_10625 vout.P4.nSD VSS.$84.Metal1 0.0511616f
Cred_10626 vout.P4.nSD VSS.$926.Metal3 0.00033814f
Cred_10627 vout.P4.nSD VSS.$932.Metal3 9.24644e-05f
Cred_10628 vout.P4.nSD VSS.P0.pSD 2.19383e-05f
Cred_10629 vout.P4.nSD VSS.P5.nSD 0.00540917f
Cred_10630 vout.P4.nSD VSS.P7.nSD 0.00550371f
Cred_10631 vout.P4.pSD VSS.$14.Metal1 1.97027e-06f
Cred_10632 vout.P4.pSD VSS.$29.Metal1 3.31531e-06f
Cred_10633 vout.P4.pSD VSS.$520.Metal1 2.01769e-08f
Cred_10634 vout.P4.pSD VSS.$565.Metal2 0.000409266f
Cred_10635 vout.P4.pSD VSS.$572.Metal2 0.000274258f
Cred_10636 vout.P4.pSD VSS.$576.Metal2 0.000108851f
Cred_10637 vout.P4.pSD VSS.$583.Metal2 0.00055664f
Cred_10638 vout.P4.pSD VSS.$68.Metal1 0.000305923f
Cred_10639 vout.P4.pSD VSS.$84.Metal1 0.000305592f
Cred_10640 vout.P4.pSD VSS.$926.Metal3 0.00017427f
Cred_10641 vout.P4.pSD VSS.$932.Metal3 4.78979e-05f
Cred_10642 vout.P4.pSD VSS.P0.pSD 2.72315e-05f
Cred_10643 vout.P4.pSD VSS.P5.nSD 3.34088e-05f
Cred_10644 vout.P4.pSD VSS.P7.nSD 3.33007e-05f
Cred_10645 vout.P40.nSD VSS.$1012.Metal3 8.73355e-05f
Cred_10646 vout.P40.nSD VSS.$1018.Metal3 0.000342401f
Cred_10647 vout.P40.nSD VSS.$14.Metal1 7.08856e-09f
Cred_10648 vout.P40.nSD VSS.$29.Metal1 1.19277e-08f
Cred_10649 vout.P40.nSD VSS.$372.Metal1 0.0503115f
Cred_10650 vout.P40.nSD VSS.$388.Metal1 0.0510731f
Cred_10651 vout.P40.nSD VSS.$520.Metal1 7.7747e-07f
Cred_10652 vout.P40.nSD VSS.$799.Metal2 0.0294799f
Cred_10653 vout.P40.nSD VSS.$806.Metal2 0.00769019f
Cred_10654 vout.P40.nSD VSS.$810.Metal2 0.0129757f
Cred_10655 vout.P40.nSD VSS.$817.Metal2 0.0232394f
Cred_10656 vout.P40.nSD VSS.P0.pSD 2.30983e-05f
Cred_10657 vout.P40.nSD VSS.P41.nSD 0.00540695f
Cred_10658 vout.P40.nSD VSS.P43.nSD 0.00550637f
Cred_10659 vout.P40.pSD VSS.$1012.Metal3 4.53334e-05f
Cred_10660 vout.P40.pSD VSS.$1018.Metal3 0.000174205f
Cred_10661 vout.P40.pSD VSS.$14.Metal1 1.92289e-08f
Cred_10662 vout.P40.pSD VSS.$29.Metal1 3.23559e-08f
Cred_10663 vout.P40.pSD VSS.$372.Metal1 0.000305988f
Cred_10664 vout.P40.pSD VSS.$388.Metal1 0.000305468f
Cred_10665 vout.P40.pSD VSS.$520.Metal1 2.10902e-06f
Cred_10666 vout.P40.pSD VSS.$799.Metal2 0.000556542f
Cred_10667 vout.P40.pSD VSS.$806.Metal2 0.00014269f
Cred_10668 vout.P40.pSD VSS.$810.Metal2 0.000231878f
Cred_10669 vout.P40.pSD VSS.$817.Metal2 0.000416885f
Cred_10670 vout.P40.pSD VSS.P0.pSD 3.03767e-05f
Cred_10671 vout.P40.pSD VSS.P41.nSD 3.3354e-05f
Cred_10672 vout.P40.pSD VSS.P43.nSD 3.33484e-05f
Cred_10673 vout.P42.nSD VSS.$1018.Metal3 2.68488e-05f
Cred_10674 vout.P42.nSD VSS.$1022.Metal3 0.000335783f
Cred_10675 vout.P42.nSD VSS.$388.Metal1 0.0478938f
Cred_10676 vout.P42.nSD VSS.$400.Metal1 0.00546921f
Cred_10677 vout.P42.nSD VSS.$406.Metal1 0.0481865f
Cred_10678 vout.P42.nSD VSS.$810.Metal2 0.0120478f
Cred_10679 vout.P42.nSD VSS.$817.Metal2 0.0247756f
Cred_10680 vout.P42.nSD VSS.$825.Metal2 0.0314836f
Cred_10681 vout.P42.nSD VSS.$832.Metal2 0.00513336f
Cred_10682 vout.P42.nSD VSS.P0.pSD 1.79171e-06f
Cred_10683 vout.P42.nSD VSS.P43.nSD 0.00539654f
Cred_10684 vout.P42.nSD VSS.P45.nSD 0.00549184f
Cred_10685 vout.P44.nSD VSS.$1022.Metal3 8.98996e-05f
Cred_10686 vout.P44.nSD VSS.$1028.Metal3 0.000340228f
Cred_10687 vout.P44.nSD VSS.$14.Metal1 4.21238e-09f
Cred_10688 vout.P44.nSD VSS.$29.Metal1 7.08803e-09f
Cred_10689 vout.P44.nSD VSS.$406.Metal1 0.0503079f
Cred_10690 vout.P44.nSD VSS.$422.Metal1 0.0510744f
Cred_10691 vout.P44.nSD VSS.$520.Metal1 1.29853e-06f
Cred_10692 vout.P44.nSD VSS.$825.Metal2 0.0303476f
Cred_10693 vout.P44.nSD VSS.$832.Metal2 0.00692236f
Cred_10694 vout.P44.nSD VSS.$836.Metal2 0.0137368f
Cred_10695 vout.P44.nSD VSS.$843.Metal2 0.0223777f
Cred_10696 vout.P44.nSD VSS.P0.pSD 2.25847e-05f
Cred_10697 vout.P44.nSD VSS.P45.nSD 0.00540653f
Cred_10698 vout.P44.nSD VSS.P47.nSD 0.00550654f
Cred_10699 vout.P44.pSD VSS.$1022.Metal3 4.66155e-05f
Cred_10700 vout.P44.pSD VSS.$1028.Metal3 0.000174125f
Cred_10701 vout.P44.pSD VSS.$14.Metal1 1.14268e-08f
Cred_10702 vout.P44.pSD VSS.$29.Metal1 1.92275e-08f
Cred_10703 vout.P44.pSD VSS.$406.Metal1 0.00030577f
Cred_10704 vout.P44.pSD VSS.$422.Metal1 0.000305493f
Cred_10705 vout.P44.pSD VSS.$520.Metal1 3.5225e-06f
Cred_10706 vout.P44.pSD VSS.$825.Metal2 0.000571916f
Cred_10707 vout.P44.pSD VSS.$832.Metal2 0.000127866f
Cred_10708 vout.P44.pSD VSS.$836.Metal2 0.000245614f
Cred_10709 vout.P44.pSD VSS.$843.Metal2 0.000401427f
Cred_10710 vout.P44.pSD VSS.P0.pSD 2.89841e-05f
Cred_10711 vout.P44.pSD VSS.P45.nSD 3.33289e-05f
Cred_10712 vout.P44.pSD VSS.P47.nSD 3.33513e-05f
Cred_10713 vout.P46.nSD VSS.$1028.Metal3 0.000194288f
Cred_10714 vout.P46.nSD VSS.$1036.Metal3 0.00016428f
Cred_10715 vout.P46.nSD VSS.$422.Metal1 0.0479928f
Cred_10716 vout.P46.nSD VSS.$434.Metal1 0.00537576f
Cred_10717 vout.P46.nSD VSS.$440.Metal1 0.048183f
Cred_10718 vout.P46.nSD VSS.$836.Metal2 0.0129078f
Cred_10719 vout.P46.nSD VSS.$843.Metal2 0.0239147f
Cred_10720 vout.P46.nSD VSS.$851.Metal2 0.0323428f
Cred_10721 vout.P46.nSD VSS.$858.Metal2 0.00427828f
Cred_10722 vout.P46.nSD VSS.P0.pSD 2.11311e-06f
Cred_10723 vout.P46.nSD VSS.P47.nSD 0.0053967f
Cred_10724 vout.P46.nSD VSS.P49.nSD 0.00549144f
Cred_10725 vout.P48.nSD VSS.$1028.Metal3 1.55582e-06f
Cred_10726 vout.P48.nSD VSS.$1036.Metal3 0.000377511f
Cred_10727 vout.P48.nSD VSS.$1042.Metal3 5.23783e-05f
Cred_10728 vout.P48.nSD VSS.$14.Metal1 2.47224e-09f
Cred_10729 vout.P48.nSD VSS.$29.Metal1 4.15996e-09f
Cred_10730 vout.P48.nSD VSS.$434.Metal1 9.96175e-11f
Cred_10731 vout.P48.nSD VSS.$440.Metal1 0.0503051f
Cred_10732 vout.P48.nSD VSS.$456.Metal1 0.0510754f
Cred_10733 vout.P48.nSD VSS.$520.Metal1 2.1698e-06f
Cred_10734 vout.P48.nSD VSS.$843.Metal2 2.48988e-08f
Cred_10735 vout.P48.nSD VSS.$851.Metal2 0.0312219f
Cred_10736 vout.P48.nSD VSS.$858.Metal2 0.00615406f
Cred_10737 vout.P48.nSD VSS.$862.Metal2 0.0144988f
Cred_10738 vout.P48.nSD VSS.$869.Metal2 0.0215166f
Cred_10739 vout.P48.nSD VSS.P0.pSD 2.17177e-05f
Cred_10740 vout.P48.nSD VSS.P49.nSD 0.0054062f
Cred_10741 vout.P48.nSD VSS.P51.nSD 0.00550667f
Cred_10742 vout.P48.pSD VSS.$1028.Metal3 4.22041e-06f
Cred_10743 vout.P48.pSD VSS.$1036.Metal3 0.000186569f
Cred_10744 vout.P48.pSD VSS.$1042.Metal3 3.14338e-05f
Cred_10745 vout.P48.pSD VSS.$14.Metal1 6.70638e-09f
Cred_10746 vout.P48.pSD VSS.$29.Metal1 1.12846e-08f
Cred_10747 vout.P48.pSD VSS.$434.Metal1 2.70229e-10f
Cred_10748 vout.P48.pSD VSS.$440.Metal1 0.000305974f
Cred_10749 vout.P48.pSD VSS.$456.Metal1 0.000305513f
Cred_10750 vout.P48.pSD VSS.$520.Metal1 5.88596e-06f
Cred_10751 vout.P48.pSD VSS.$843.Metal2 6.75421e-08f
Cred_10752 vout.P48.pSD VSS.$851.Metal2 0.000589961f
Cred_10753 vout.P48.pSD VSS.$858.Metal2 0.00011288f
Cred_10754 vout.P48.pSD VSS.$862.Metal2 0.000259857f
Cred_10755 vout.P48.pSD VSS.$869.Metal2 0.000386226f
Cred_10756 vout.P48.pSD VSS.P0.pSD 2.66333e-05f
Cred_10757 vout.P48.pSD VSS.P49.nSD 3.33525e-05f
Cred_10758 vout.P48.pSD VSS.P51.nSD 3.33537e-05f
Cred_10759 vout.P50.nSD VSS.$1036.Metal3 2.56741e-05f
Cred_10760 vout.P50.nSD VSS.$1042.Metal3 0.00035139f
Cred_10761 vout.P50.nSD VSS.$456.Metal1 0.0480927f
Cred_10762 vout.P50.nSD VSS.$468.Metal1 0.00531263f
Cred_10763 vout.P50.nSD VSS.$474.Metal1 0.0477492f
Cred_10764 vout.P50.nSD VSS.$862.Metal2 0.0137696f
Cred_10765 vout.P50.nSD VSS.$869.Metal2 0.023036f
Cred_10766 vout.P50.nSD VSS.$877.Metal2 0.0332745f
Cred_10767 vout.P50.nSD VSS.$884.Metal2 0.00343306f
Cred_10768 vout.P50.nSD VSS.P0.pSD 2.4362e-06f
Cred_10769 vout.P50.nSD VSS.P51.nSD 0.00539689f
Cred_10770 vout.P50.nSD VSS.P53.nSD 0.00544203f
Cred_10771 vout.P52.nSD VSS.$1042.Metal3 8.67863e-05f
Cred_10772 vout.P52.nSD VSS.$1048.Metal3 0.000330436f
Cred_10773 vout.P52.nSD VSS.$474.Metal1 0.0498f
Cred_10774 vout.P52.nSD VSS.$486.Metal1 0.00407842f
Cred_10775 vout.P52.nSD VSS.$500.Metal1 0.0524739f
Cred_10776 vout.P52.nSD VSS.$877.Metal2 0.0322209f
Cred_10777 vout.P52.nSD VSS.$884.Metal2 0.00561109f
Cred_10778 vout.P52.nSD VSS.$895.Metal2 0.000191074f
Cred_10779 vout.P52.nSD VSS.$904.Metal2 0.0336631f
Cred_10780 vout.P52.nSD VSS.P0.pSD 7.49556e-06f
Cred_10781 vout.P52.nSD VSS.P53.nSD 0.00541627f
Cred_10782 vout.P52.nSD VSS.P55.nSD 0.000437449f
Cred_10783 vout.P52.nSD VSS.P57.nSD 0.000437449f
Cred_10784 vout.P6.nSD VSS.$102.Metal1 0.0516646f
Cred_10785 vout.P6.nSD VSS.$576.Metal2 0.0042625f
Cred_10786 vout.P6.nSD VSS.$583.Metal2 0.0322266f
Cred_10787 vout.P6.nSD VSS.$591.Metal2 0.0239941f
Cred_10788 vout.P6.nSD VSS.$598.Metal2 0.0129552f
Cred_10789 vout.P6.nSD VSS.$84.Metal1 0.0445114f
Cred_10790 vout.P6.nSD VSS.$932.Metal3 0.000343726f
Cred_10791 vout.P6.nSD VSS.$938.Metal3 1.98723e-05f
Cred_10792 vout.P6.nSD VSS.$94.Metal1 0.00537575f
Cred_10793 vout.P6.nSD VSS.P0.pSD 2.11311e-06f
Cred_10794 vout.P6.nSD VSS.P10.nSD 0.00581484f
Cred_10795 vout.P6.nSD VSS.P7.nSD 0.00507331f
Cred_10796 vout.P8.nSD VSS.$102.Metal1 0.0502177f
Cred_10797 vout.P8.nSD VSS.$118.Metal1 0.0487424f
Cred_10798 vout.P8.nSD VSS.$14.Metal1 4.34672e-07f
Cred_10799 vout.P8.nSD VSS.$29.Metal1 7.31408e-07f
Cred_10800 vout.P8.nSD VSS.$520.Metal1 1.26154e-08f
Cred_10801 vout.P8.nSD VSS.$591.Metal2 0.0225306f
Cred_10802 vout.P8.nSD VSS.$598.Metal2 0.0138257f
Cred_10803 vout.P8.nSD VSS.$602.Metal2 0.00684207f
Cred_10804 vout.P8.nSD VSS.$609.Metal2 0.0298867f
Cred_10805 vout.P8.nSD VSS.$932.Metal3 5.46716e-05f
Cred_10806 vout.P8.nSD VSS.$938.Metal3 0.000373401f
Cred_10807 vout.P8.nSD VSS.$942.Metal3 2.95757e-06f
Cred_10808 vout.P8.nSD VSS.P0.pSD 2.27158e-05f
Cred_10809 vout.P8.nSD VSS.P10.nSD 0.00540901f
Cred_10810 vout.P8.nSD VSS.P11.nSD 0.00522877f
Cred_10811 vout.P8.pSD VSS.$102.Metal1 0.000305786f
Cred_10812 vout.P8.pSD VSS.$118.Metal1 0.000293751f
Cred_10813 vout.P8.pSD VSS.$14.Metal1 1.17912e-06f
Cred_10814 vout.P8.pSD VSS.$29.Metal1 1.98407e-06f
Cred_10815 vout.P8.pSD VSS.$520.Metal1 3.42215e-08f
Cred_10816 vout.P8.pSD VSS.$591.Metal2 0.00042533f
Cred_10817 vout.P8.pSD VSS.$598.Metal2 0.000259771f
Cred_10818 vout.P8.pSD VSS.$602.Metal2 0.000121749f
Cred_10819 vout.P8.pSD VSS.$609.Metal2 0.000539545f
Cred_10820 vout.P8.pSD VSS.$932.Metal3 3.19802e-05f
Cred_10821 vout.P8.pSD VSS.$938.Metal3 0.000181235f
Cred_10822 vout.P8.pSD VSS.$942.Metal3 8.0229e-06f
Cred_10823 vout.P8.pSD VSS.P0.pSD 2.93398e-05f
Cred_10824 vout.P8.pSD VSS.P10.nSD 3.33928e-05f
Cred_10825 vout.P8.pSD VSS.P11.nSD 3.1955e-05f
Rred_1 VDD VDD.$1051.Metal2 6.5054901145
Rred_2 VDD VDD.$1059.Metal2 6.5054901145
Rred_3 VDD VDD.$1376.Metal3 2299.30001576
Rred_4 VDD VDD.$1384.Metal3 2299.30001576
Rred_5 VDD VDD.$384.Metal1 0.0432441175152
Rred_6 VDD VDD.$409.Metal1 0.0432441175152
Rred_7 VDD VDD.P0.nSD 24.1135601645
Rred_8 VDD.$1002.Metal2 VDD.$1006.Metal2 0.0360795100174
Rred_9 VDD.$1002.Metal2 VDD.$1360.Metal3 13.6446092814
Rred_10 VDD.$1002.Metal2 VDD.$1366.Metal3 6.79506398421
Rred_11 VDD.$1002.Metal2 VDD.$307.Metal1 4.39775030228
Rred_12 VDD.$1002.Metal2 VDD.$332.Metal1 15.9921256466
Rred_13 VDD.$1002.Metal2 VDD.$991.Metal2 0.03616911139
Rred_14 VDD.$1002.Metal2 VDD.P0.nSD 2877.78000062
Rred_15 VDD.$1002.Metal2 VDD.P21.pSD 35.6017082724
Rred_16 VDD.$1006.Metal2 VDD.$1017.Metal2 0.0361543835534
Rred_17 VDD.$1006.Metal2 VDD.$1366.Metal3 4.5
Rred_18 VDD.$1006.Metal2 VDD.$307.Metal1 14.4920184664
Rred_19 VDD.$1006.Metal2 VDD.$332.Metal1 4.91271403682
Rred_20 VDD.$1006.Metal2 VDD.P0.nSD 2765.02078485
Rred_21 VDD.$1006.Metal2 VDD.P23.pSD 47.4486068341
Rred_22 VDD.$1017.Metal2 VDD.$1025.Metal2 0.0727385628444
Rred_23 VDD.$1017.Metal2 VDD.$1366.Metal3 9.03608
Rred_24 VDD.$1017.Metal2 VDD.$1370.Metal3 4.52704202798
Rred_25 VDD.$1017.Metal2 VDD.$332.Metal1 2.72653961924
Rred_26 VDD.$1017.Metal2 VDD.$351.Metal1 6.66004996855
Rred_27 VDD.$1017.Metal2 VDD.P0.nSD 15726.8115927
Rred_28 VDD.$1017.Metal2 VDD.P23.pSD 13.3449206721
Rred_29 VDD.$1025.Metal2 VDD.$1036.Metal2 0.0361644626155
Rred_30 VDD.$1025.Metal2 VDD.$1370.Metal3 3.88510981734
Rred_31 VDD.$1025.Metal2 VDD.$1376.Metal3 13.6446092814
Rred_32 VDD.$1025.Metal2 VDD.$351.Metal1 6.36419690526
Rred_33 VDD.$1025.Metal2 VDD.$359.Metal1 2.87272058958
Rred_34 VDD.$1025.Metal2 VDD.P0.nSD 11271.6859306
Rred_35 VDD.$1025.Metal2 VDD.P25.pSD 14.2388529314
Rred_36 VDD.$1036.Metal2 VDD.$1040.Metal2 0.0360795089622
Rred_37 VDD.$1036.Metal2 VDD.$1370.Metal3 13.6446092814
Rred_38 VDD.$1036.Metal2 VDD.$1376.Metal3 6.79506398421
Rred_39 VDD.$1036.Metal2 VDD.$359.Metal1 4.55698940605
Rred_40 VDD.$1036.Metal2 VDD.$384.Metal1 15.4588823963
Rred_41 VDD.$1036.Metal2 VDD.P0.nSD 2835.7147738
Rred_42 VDD.$1036.Metal2 VDD.P25.pSD 38.8332352673
Rred_43 VDD.$1040.Metal2 VDD.$1051.Metal2 0.0361600656304
Rred_44 VDD.$1040.Metal2 VDD.$1376.Metal3 4.5
Rred_45 VDD.$1040.Metal2 VDD.$359.Metal1 14.9598053869
Rred_46 VDD.$1040.Metal2 VDD.$384.Metal1 4.72815362384
Rred_47 VDD.$1040.Metal2 VDD.P0.nSD 2810.11808649
Rred_48 VDD.$1040.Metal2 VDD.P27.pSD 42.7104575353
Rred_49 VDD.$1051.Metal2 VDD.$1059.Metal2 0.0727293596086
Rred_50 VDD.$1051.Metal2 VDD.$1376.Metal3 4.55847300828
Rred_51 VDD.$1051.Metal2 VDD.$1384.Metal3 9.19927248124
Rred_52 VDD.$1051.Metal2 VDD.$384.Metal1 2.79825659651
Rred_53 VDD.$1051.Metal2 VDD.P0.nSD 14001.5420309
Rred_54 VDD.$1051.Metal2 VDD.P27.pSD 13.7775669469
Rred_55 VDD.$1059.Metal2 VDD.$1070.Metal2 0.0361600656304
Rred_56 VDD.$1059.Metal2 VDD.$1376.Metal3 9.19927248124
Rred_57 VDD.$1059.Metal2 VDD.$1384.Metal3 4.55847300828
Rred_58 VDD.$1059.Metal2 VDD.$409.Metal1 2.79825659651
Rred_59 VDD.$1059.Metal2 VDD.P0.nSD 14001.5420309
Rred_60 VDD.$1059.Metal2 VDD.P29.pSD 13.7775669469
Rred_61 VDD.$1070.Metal2 VDD.$1074.Metal2 0.0360795089622
Rred_62 VDD.$1070.Metal2 VDD.$1384.Metal3 4.5
Rred_63 VDD.$1070.Metal2 VDD.$409.Metal1 4.72815362384
Rred_64 VDD.$1070.Metal2 VDD.$434.Metal1 14.9598053869
Rred_65 VDD.$1070.Metal2 VDD.P0.nSD 2810.11808649
Rred_66 VDD.$1070.Metal2 VDD.P29.pSD 42.7104575353
Rred_67 VDD.$1074.Metal2 VDD.$1085.Metal2 0.0361644626155
Rred_68 VDD.$1074.Metal2 VDD.$1384.Metal3 6.79506398421
Rred_69 VDD.$1074.Metal2 VDD.$1390.Metal3 13.6446092814
Rred_70 VDD.$1074.Metal2 VDD.$409.Metal1 15.4588823963
Rred_71 VDD.$1074.Metal2 VDD.$434.Metal1 4.55698940605
Rred_72 VDD.$1074.Metal2 VDD.P0.nSD 2835.7147738
Rred_73 VDD.$1074.Metal2 VDD.P31.pSD 38.8332352673
Rred_74 VDD.$1085.Metal2 VDD.$1093.Metal2 0.0727385628444
Rred_75 VDD.$1085.Metal2 VDD.$1384.Metal3 13.6446092814
Rred_76 VDD.$1085.Metal2 VDD.$1390.Metal3 3.88510981734
Rred_77 VDD.$1085.Metal2 VDD.$434.Metal1 2.87272058958
Rred_78 VDD.$1085.Metal2 VDD.$455.Metal1 6.36419690526
Rred_79 VDD.$1085.Metal2 VDD.P0.nSD 11271.6859306
Rred_80 VDD.$1085.Metal2 VDD.P31.pSD 14.2388529314
Rred_81 VDD.$1093.Metal2 VDD.$1104.Metal2 0.0361543835534
Rred_82 VDD.$1093.Metal2 VDD.$1390.Metal3 4.52704202798
Rred_83 VDD.$1093.Metal2 VDD.$1394.Metal3 9.03608
Rred_84 VDD.$1093.Metal2 VDD.$455.Metal1 6.66004996855
Rred_85 VDD.$1093.Metal2 VDD.$461.Metal1 2.72653961924
Rred_86 VDD.$1093.Metal2 VDD.P0.nSD 15726.8115927
Rred_87 VDD.$1093.Metal2 VDD.P33.pSD 13.3449206721
Rred_88 VDD.$1104.Metal2 VDD.$1108.Metal2 0.0360795100174
Rred_89 VDD.$1104.Metal2 VDD.$1394.Metal3 4.5
Rred_90 VDD.$1104.Metal2 VDD.$461.Metal1 4.91271403682
Rred_91 VDD.$1104.Metal2 VDD.$486.Metal1 14.4920184664
Rred_92 VDD.$1104.Metal2 VDD.P0.nSD 2765.02078485
Rred_93 VDD.$1104.Metal2 VDD.P33.pSD 47.4486068341
Rred_94 VDD.$1108.Metal2 VDD.$1119.Metal2 0.03616911139
Rred_95 VDD.$1108.Metal2 VDD.$1394.Metal3 6.79506398421
Rred_96 VDD.$1108.Metal2 VDD.$1400.Metal3 13.6446092814
Rred_97 VDD.$1108.Metal2 VDD.$461.Metal1 15.9921256466
Rred_98 VDD.$1108.Metal2 VDD.$486.Metal1 4.39775030228
Rred_99 VDD.$1108.Metal2 VDD.P0.nSD 2877.78000062
Rred_100 VDD.$1108.Metal2 VDD.P35.pSD 35.6017082724
Rred_101 VDD.$1119.Metal2 VDD.$1127.Metal2 0.0727385628444
Rred_102 VDD.$1119.Metal2 VDD.$1394.Metal3 13.6446092814
Rred_103 VDD.$1119.Metal2 VDD.$1400.Metal3 3.88510981734
Rred_104 VDD.$1119.Metal2 VDD.$486.Metal1 2.95003185319
Rred_105 VDD.$1119.Metal2 VDD.$507.Metal1 6.23366856258
Rred_106 VDD.$1119.Metal2 VDD.P0.nSD 10005.7880435
Rred_107 VDD.$1119.Metal2 VDD.P35.pSD 14.7317413541
Rred_108 VDD.$1127.Metal2 VDD.$1138.Metal2 0.036148184924
Rred_109 VDD.$1127.Metal2 VDD.$1400.Metal3 4.52704202798
Rred_110 VDD.$1127.Metal2 VDD.$1404.Metal3 9.03608
Rred_111 VDD.$1127.Metal2 VDD.$507.Metal1 6.82862411992
Rred_112 VDD.$1127.Metal2 VDD.$513.Metal1 2.6573341369
Rred_113 VDD.$1127.Metal2 VDD.P0.nSD 17895.7038428
Rred_114 VDD.$1127.Metal2 VDD.P37.pSD 12.938310497
Rred_115 VDD.$1138.Metal2 VDD.$1142.Metal2 0.036079512126
Rred_116 VDD.$1138.Metal2 VDD.$1404.Metal3 4.5
Rred_117 VDD.$1138.Metal2 VDD.$513.Metal1 5.11227038279
Rred_118 VDD.$1138.Metal2 VDD.$538.Metal1 14.0524898581
Rred_119 VDD.$1138.Metal2 VDD.P0.nSD 2721.33522066
Rred_120 VDD.$1138.Metal2 VDD.P37.pSD 53.3705308002
Rred_121 VDD.$1142.Metal2 VDD.$1153.Metal2 0.036173243634
Rred_122 VDD.$1142.Metal2 VDD.$1404.Metal3 6.79506398421
Rred_123 VDD.$1142.Metal2 VDD.$1410.Metal3 13.6446092814
Rred_124 VDD.$1142.Metal2 VDD.$513.Metal1 16.5633578113
Rred_125 VDD.$1142.Metal2 VDD.$538.Metal1 4.24924988908
Rred_126 VDD.$1142.Metal2 VDD.P0.nSD 2921.09636554
Rred_127 VDD.$1142.Metal2 VDD.P39.pSD 32.8668699492
Rred_128 VDD.$1153.Metal2 VDD.$1161.Metal2 0.0727385628444
Rred_129 VDD.$1153.Metal2 VDD.$1404.Metal3 13.6446092814
Rred_130 VDD.$1153.Metal2 VDD.$1410.Metal3 3.88510981734
Rred_131 VDD.$1153.Metal2 VDD.$538.Metal1 3.03045058224
Rred_132 VDD.$1153.Metal2 VDD.$559.Metal1 6.11297515126
Rred_133 VDD.$1153.Metal2 VDD.P0.nSD 8963.37454531
Rred_134 VDD.$1153.Metal2 VDD.P39.pSD 15.2596181907
Rred_135 VDD.$1161.Metal2 VDD.$1172.Metal2 0.0361414697421
Rred_136 VDD.$1161.Metal2 VDD.$1410.Metal3 4.52704202798
Rred_137 VDD.$1161.Metal2 VDD.$1414.Metal3 9.03608
Rred_138 VDD.$1161.Metal2 VDD.$559.Metal1 7.01359480942
Rred_139 VDD.$1161.Metal2 VDD.$565.Metal1 2.59047149199
Rred_140 VDD.$1161.Metal2 VDD.P0.nSD 20699.7491345
Rred_141 VDD.$1161.Metal2 VDD.P41.pSD 12.5554391188
Rred_142 VDD.$1172.Metal2 VDD.$1176.Metal2 0.0360795152881
Rred_143 VDD.$1172.Metal2 VDD.$1414.Metal3 4.5
Rred_144 VDD.$1172.Metal2 VDD.$565.Metal1 5.32873613468
Rred_145 VDD.$1172.Metal2 VDD.$590.Metal1 13.6387252473
Rred_146 VDD.$1172.Metal2 VDD.P0.nSD 2678.9960806
Rred_147 VDD.$1172.Metal2 VDD.P41.pSD 60.983561434
Rred_148 VDD.$1176.Metal2 VDD.$1187.Metal2 0.0361768593475
Rred_149 VDD.$1176.Metal2 VDD.$1414.Metal3 6.79506398421
Rred_150 VDD.$1176.Metal2 VDD.$1420.Metal3 13.6446092814
Rred_151 VDD.$1176.Metal2 VDD.$565.Metal1 17.1768024012
Rred_152 VDD.$1176.Metal2 VDD.$590.Metal1 4.11043232908
Rred_153 VDD.$1176.Metal2 VDD.P0.nSD 2965.7204549
Rred_154 VDD.$1176.Metal2 VDD.P43.pSD 30.5222870107
Rred_155 VDD.$1187.Metal2 VDD.$1195.Metal2 0.0727385628444
Rred_156 VDD.$1187.Metal2 VDD.$1414.Metal3 13.6446092814
Rred_157 VDD.$1187.Metal2 VDD.$1420.Metal3 3.88510981734
Rred_158 VDD.$1187.Metal2 VDD.$590.Metal1 3.11421058532
Rred_159 VDD.$1187.Metal2 VDD.$611.Metal1 6.00104546937
Rred_160 VDD.$1187.Metal2 VDD.P0.nSD 8092.91553003
Rred_161 VDD.$1187.Metal2 VDD.P43.pSD 15.8263710426
Rred_162 VDD.$1195.Metal2 VDD.$1206.Metal2 0.0361342380077
Rred_163 VDD.$1195.Metal2 VDD.$1420.Metal3 4.52704202798
Rred_164 VDD.$1195.Metal2 VDD.$1424.Metal3 9.03608
Rred_165 VDD.$1195.Metal2 VDD.$611.Metal1 7.21747657563
Rred_166 VDD.$1195.Metal2 VDD.$617.Metal1 2.52579519121
Rred_167 VDD.$1195.Metal2 VDD.P0.nSD 24458.3910316
Rred_168 VDD.$1195.Metal2 VDD.P45.pSD 12.1942717833
Rred_169 VDD.$1206.Metal2 VDD.$1210.Metal2 0.0360795195038
Rred_170 VDD.$1206.Metal2 VDD.$1424.Metal3 4.5
Rred_171 VDD.$1206.Metal2 VDD.$617.Metal1 5.56436477162
Rred_172 VDD.$1206.Metal2 VDD.$642.Metal1 13.2485154879
Rred_173 VDD.$1206.Metal2 VDD.P0.nSD 2637.94201861
Rred_174 VDD.$1206.Metal2 VDD.P45.pSD 71.1332520693
Rred_175 VDD.$1210.Metal2 VDD.$1221.Metal2 0.0361799585304
Rred_176 VDD.$1210.Metal2 VDD.$1424.Metal3 6.79506398421
Rred_177 VDD.$1210.Metal2 VDD.$1430.Metal3 13.6446092814
Rred_178 VDD.$1210.Metal2 VDD.$617.Metal1 17.8373331011
Rred_179 VDD.$1210.Metal2 VDD.$642.Metal1 3.98037580709
Rred_180 VDD.$1210.Metal2 VDD.P0.nSD 3011.71231884
Rred_181 VDD.$1210.Metal2 VDD.P47.pSD 28.4899083802
Rred_182 VDD.$1221.Metal2 VDD.$1229.Metal2 0.0727385628444
Rred_183 VDD.$1221.Metal2 VDD.$1424.Metal3 13.6446092814
Rred_184 VDD.$1221.Metal2 VDD.$1430.Metal3 3.88510981734
Rred_185 VDD.$1221.Metal2 VDD.$642.Metal1 3.20156710577
Rred_186 VDD.$1221.Metal2 VDD.$663.Metal1 5.89695842818
Rred_187 VDD.$1221.Metal2 VDD.P0.nSD 7357.21367385
Rred_188 VDD.$1221.Metal2 VDD.P47.pSD 16.436485604
Rred_189 VDD.$1229.Metal2 VDD.$1240.Metal2 0.0361264897209
Rred_190 VDD.$1229.Metal2 VDD.$1430.Metal3 4.52704202798
Rred_191 VDD.$1229.Metal2 VDD.$1434.Metal3 9.03608
Rred_192 VDD.$1229.Metal2 VDD.$663.Metal1 7.44332582136
Rred_193 VDD.$1229.Metal2 VDD.$669.Metal1 2.46315964352
Rred_194 VDD.$1229.Metal2 VDD.P0.nSD 29746.948013
Rred_195 VDD.$1229.Metal2 VDD.P49.pSD 11.8529998204
Rred_196 VDD.$124.Metal1 VDD.$143.Metal1 0.0389769346281
Rred_197 VDD.$124.Metal1 VDD.$866.Metal2 18.5506038882
Rred_198 VDD.$124.Metal1 VDD.$870.Metal2 5.8218288097
Rred_199 VDD.$124.Metal1 VDD.$881.Metal2 2.46315964352
Rred_200 VDD.$124.Metal1 VDD.$99.Metal1 0.0872255693867
Rred_201 VDD.$124.Metal1 VDD.P0.nSD 7.98366931108
Rred_202 VDD.$124.Metal1 VDD.P7.pSD 3.73652486978
Rred_203 VDD.$1240.Metal2 VDD.$1244.Metal2 0.0360795247734
Rred_204 VDD.$1240.Metal2 VDD.$1434.Metal3 4.5
Rred_205 VDD.$1240.Metal2 VDD.$669.Metal1 5.8218288097
Rred_206 VDD.$1240.Metal2 VDD.$694.Metal1 12.8798969812
Rred_207 VDD.$1240.Metal2 VDD.P0.nSD 2598.11535914
Rred_208 VDD.$1240.Metal2 VDD.P49.pSD 85.3415987069
Rred_209 VDD.$1244.Metal2 VDD.$1255.Metal2 0.0361825411829
Rred_210 VDD.$1244.Metal2 VDD.$1434.Metal3 6.79506398421
Rred_211 VDD.$1244.Metal2 VDD.$1440.Metal3 13.6446092814
Rred_212 VDD.$1244.Metal2 VDD.$669.Metal1 18.5506038882
Rred_213 VDD.$1244.Metal2 VDD.$694.Metal1 3.85827191909
Rred_214 VDD.$1244.Metal2 VDD.P0.nSD 3059.13574035
Rred_215 VDD.$1244.Metal2 VDD.P51.pSD 26.7111957498
Rred_216 VDD.$1255.Metal2 VDD.$1263.Metal2 0.0727385628444
Rred_217 VDD.$1255.Metal2 VDD.$1434.Metal3 13.6446092814
Rred_218 VDD.$1255.Metal2 VDD.$1440.Metal3 3.88510981734
Rred_219 VDD.$1255.Metal2 VDD.$694.Metal1 3.29279951375
Rred_220 VDD.$1255.Metal2 VDD.$715.Metal1 5.79991764697
Rred_221 VDD.$1255.Metal2 VDD.P0.nSD 6728.80975083
Rred_222 VDD.$1255.Metal2 VDD.P51.pSD 17.0951652799
Rred_223 VDD.$1263.Metal2 VDD.$1274.Metal2 0.0361212216421
Rred_224 VDD.$1263.Metal2 VDD.$1440.Metal3 3.88510981734
Rred_225 VDD.$1263.Metal2 VDD.$1446.Metal3 13.6446092814
Rred_226 VDD.$1263.Metal2 VDD.$715.Metal1 9.07216
Rred_227 VDD.$1263.Metal2 VDD.$719.Metal1 4.5
Rred_228 VDD.$1263.Metal2 VDD.$735.Metal1 3.61171769061
Rred_229 VDD.$1263.Metal2 VDD.P53.pSD 18.7434927053
Rred_230 VDD.$1274.Metal2 VDD.$1289.Metal2 0.0748661170905
Rred_231 VDD.$1274.Metal2 VDD.$1440.Metal3 13.6446092814
Rred_232 VDD.$1274.Metal2 VDD.$1446.Metal3 3.83912533356
Rred_233 VDD.$1274.Metal2 VDD.$719.Metal1 9.11039461524
Rred_234 VDD.$1274.Metal2 VDD.$735.Metal1 32.5125960372
Rred_235 VDD.$1274.Metal2 VDD.$742.Metal1 4.4677403711
Rred_236 VDD.$1274.Metal2 VDD.P0.nSD 3788.62853426
Rred_237 VDD.$1274.Metal2 VDD.P53.pSD 173.377307524
Rred_238 VDD.$1287.Metal2 VDD.$1300.Metal2 0.112032957945
Rred_239 VDD.$1287.Metal2 VDD.$752.Metal1 5.52921186987
Rred_240 VDD.$1287.Metal2 VDD.$759.Metal1 1.0199432646
Rred_241 VDD.$1287.Metal2 VDD.$765.Metal1 19.7539250048
Rred_242 VDD.$1287.Metal2 VDD.P55.pSD 47.8288742398
Rred_243 VDD.$1287.Metal2 VDD.P57.pSD 47.8288742398
Rred_244 VDD.$1289.Metal2 VDD.$1300.Metal2 0.0993672001198
Rred_245 VDD.$1289.Metal2 VDD.$1446.Metal3 2.53404256545
Rred_246 VDD.$1289.Metal2 VDD.$742.Metal1 9.33751460386
Rred_247 VDD.$1289.Metal2 VDD.$746.Metal1 19.2212234495
Rred_248 VDD.$1289.Metal2 VDD.$761.Metal1 4.10974337583
Rred_249 VDD.$1300.Metal2 VDD.$1446.Metal3 2.83350568258
Rred_250 VDD.$1300.Metal2 VDD.$746.Metal1 3.4037149656
Rred_251 VDD.$1300.Metal2 VDD.$752.Metal1 24.8021965517
Rred_252 VDD.$1300.Metal2 VDD.$761.Metal1 15.4962345707
Rred_253 VDD.$1300.Metal2 VDD.$765.Metal1 14.49412488
Rred_254 VDD.$1300.Metal2 VDD.P0.nSD 9957.4758603
Rred_255 VDD.$1314.Metal3 VDD.$1320.Metal3 0.109399445083
Rred_256 VDD.$1314.Metal3 VDD.$3.Metal1 1025.03120601
Rred_257 VDD.$1314.Metal3 VDD.$44.Metal1 6484.85703727
Rred_258 VDD.$1314.Metal3 VDD.$64.Metal1 1100.71886473
Rred_259 VDD.$1314.Metal3 VDD.$807.Metal2 2.83591210143
Rred_260 VDD.$1314.Metal3 VDD.$822.Metal2 2.53200976035
Rred_261 VDD.$1314.Metal3 VDD.$836.Metal2 3.83912533356
Rred_262 VDD.$1314.Metal3 VDD.$847.Metal2 13.6446092814
Rred_263 VDD.$1320.Metal3 VDD.$1326.Metal3 0.109399445083
Rred_264 VDD.$1320.Metal3 VDD.$836.Metal2 13.6446092814
Rred_265 VDD.$1320.Metal3 VDD.$847.Metal2 3.88510981734
Rred_266 VDD.$1320.Metal3 VDD.$855.Metal2 3.88510981734
Rred_267 VDD.$1320.Metal3 VDD.$866.Metal2 13.6446092814
Rred_268 VDD.$1320.Metal3 VDD.$91.Metal1 1131.50554324
Rred_269 VDD.$1326.Metal3 VDD.$1330.Metal3 0.0724492814222
Rred_270 VDD.$1326.Metal3 VDD.$855.Metal2 13.6446092814
Rred_271 VDD.$1326.Metal3 VDD.$866.Metal2 6.79506398421
Rred_272 VDD.$1326.Metal3 VDD.$870.Metal2 4.5
Rred_273 VDD.$1326.Metal3 VDD.$881.Metal2 9.03608
Rred_274 VDD.$1330.Metal3 VDD.$1336.Metal3 0.109399445083
Rred_275 VDD.$1330.Metal3 VDD.$143.Metal1 1131.50554324
Rred_276 VDD.$1330.Metal3 VDD.$881.Metal2 4.52704202798
Rred_277 VDD.$1330.Metal3 VDD.$889.Metal2 3.88510981734
Rred_278 VDD.$1330.Metal3 VDD.$900.Metal2 13.6446092814
Rred_279 VDD.$1336.Metal3 VDD.$1340.Metal3 0.0724492814222
Rred_280 VDD.$1336.Metal3 VDD.$889.Metal2 13.6446092814
Rred_281 VDD.$1336.Metal3 VDD.$900.Metal2 6.79506398421
Rred_282 VDD.$1336.Metal3 VDD.$904.Metal2 4.5
Rred_283 VDD.$1336.Metal3 VDD.$915.Metal2 9.03608
Rred_284 VDD.$1340.Metal3 VDD.$1346.Metal3 0.109399445083
Rred_285 VDD.$1340.Metal3 VDD.$195.Metal1 1131.50554324
Rred_286 VDD.$1340.Metal3 VDD.$915.Metal2 4.52704202798
Rred_287 VDD.$1340.Metal3 VDD.$923.Metal2 3.88510981734
Rred_288 VDD.$1340.Metal3 VDD.$934.Metal2 13.6446092814
Rred_289 VDD.$1346.Metal3 VDD.$1350.Metal3 0.0724492814222
Rred_290 VDD.$1346.Metal3 VDD.$923.Metal2 13.6446092814
Rred_291 VDD.$1346.Metal3 VDD.$934.Metal2 6.79506398421
Rred_292 VDD.$1346.Metal3 VDD.$938.Metal2 4.5
Rred_293 VDD.$1346.Metal3 VDD.$949.Metal2 9.03608
Rred_294 VDD.$1350.Metal3 VDD.$1356.Metal3 0.109399445083
Rred_295 VDD.$1350.Metal3 VDD.$247.Metal1 1131.50554324
Rred_296 VDD.$1350.Metal3 VDD.$949.Metal2 4.52704202798
Rred_297 VDD.$1350.Metal3 VDD.$957.Metal2 3.88510981734
Rred_298 VDD.$1350.Metal3 VDD.$968.Metal2 13.6446092814
Rred_299 VDD.$1356.Metal3 VDD.$1360.Metal3 0.0724492814222
Rred_300 VDD.$1356.Metal3 VDD.$957.Metal2 13.6446092814
Rred_301 VDD.$1356.Metal3 VDD.$968.Metal2 6.79506398421
Rred_302 VDD.$1356.Metal3 VDD.$972.Metal2 4.5
Rred_303 VDD.$1356.Metal3 VDD.$983.Metal2 9.03608
Rred_304 VDD.$1360.Metal3 VDD.$1366.Metal3 0.109399445083
Rred_305 VDD.$1360.Metal3 VDD.$299.Metal1 1131.50554324
Rred_306 VDD.$1360.Metal3 VDD.$983.Metal2 4.52704202798
Rred_307 VDD.$1360.Metal3 VDD.$991.Metal2 3.88510981734
Rred_308 VDD.$1366.Metal3 VDD.$1370.Metal3 0.0724492814222
Rred_309 VDD.$1366.Metal3 VDD.$991.Metal2 13.6446092814
Rred_310 VDD.$1370.Metal3 VDD.$1376.Metal3 0.109399445083
Rred_311 VDD.$1370.Metal3 VDD.$351.Metal1 1131.50554324
Rred_312 VDD.$1376.Metal3 VDD.$1384.Metal3 0.147222110321
Rred_313 VDD.$1384.Metal3 VDD.$1390.Metal3 0.109399445083
Rred_314 VDD.$1390.Metal3 VDD.$1394.Metal3 0.0724492814222
Rred_315 VDD.$1390.Metal3 VDD.$455.Metal1 1131.50554324
Rred_316 VDD.$1394.Metal3 VDD.$1400.Metal3 0.109399445083
Rred_317 VDD.$1400.Metal3 VDD.$1404.Metal3 0.0724492814222
Rred_318 VDD.$1400.Metal3 VDD.$507.Metal1 1131.50554324
Rred_319 VDD.$1404.Metal3 VDD.$1410.Metal3 0.109399445083
Rred_320 VDD.$1410.Metal3 VDD.$1414.Metal3 0.0724492814222
Rred_321 VDD.$1410.Metal3 VDD.$559.Metal1 1131.50554324
Rred_322 VDD.$1414.Metal3 VDD.$1420.Metal3 0.109399445083
Rred_323 VDD.$1420.Metal3 VDD.$1424.Metal3 0.0724492814222
Rred_324 VDD.$1420.Metal3 VDD.$611.Metal1 1131.50554324
Rred_325 VDD.$1424.Metal3 VDD.$1430.Metal3 0.109399445083
Rred_326 VDD.$143.Metal1 VDD.$151.Metal1 0.0475220913035
Rred_327 VDD.$143.Metal1 VDD.$881.Metal2 7.44332582136
Rred_328 VDD.$143.Metal1 VDD.$889.Metal2 5.89695842818
Rred_329 VDD.$143.Metal1 VDD.P0.nSD 10.838511324
Rred_330 VDD.$1430.Metal3 VDD.$1434.Metal3 0.0724492814222
Rred_331 VDD.$1430.Metal3 VDD.$663.Metal1 1131.50554324
Rred_332 VDD.$1434.Metal3 VDD.$1440.Metal3 0.109399445083
Rred_333 VDD.$1440.Metal3 VDD.$1446.Metal3 0.109399445083
Rred_334 VDD.$1440.Metal3 VDD.$715.Metal1 1131.50554324
Rred_335 VDD.$1446.Metal3 VDD.$742.Metal1 1100.71886473
Rred_336 VDD.$1446.Metal3 VDD.$746.Metal1 1012.50762939
Rred_337 VDD.$1446.Metal3 VDD.$761.Metal1 6623.118996
Rred_338 VDD.$151.Metal1 VDD.$176.Metal1 0.0872287793389
Rred_339 VDD.$151.Metal1 VDD.$889.Metal2 3.20156710577
Rred_340 VDD.$151.Metal1 VDD.$900.Metal2 3.98037580709
Rred_341 VDD.$151.Metal1 VDD.$904.Metal2 13.2485154879
Rred_342 VDD.$151.Metal1 VDD.P0.nSD 7.45252628727
Rred_343 VDD.$151.Metal1 VDD.P10.pSD 3.73509451027
Rred_344 VDD.$176.Metal1 VDD.$195.Metal1 0.0398303720292
Rred_345 VDD.$176.Metal1 VDD.$900.Metal2 17.8373331011
Rred_346 VDD.$176.Metal1 VDD.$904.Metal2 5.56436477162
Rred_347 VDD.$176.Metal1 VDD.$915.Metal2 2.52579519121
Rred_348 VDD.$176.Metal1 VDD.P0.nSD 7.95325273154
Rred_349 VDD.$176.Metal1 VDD.P11.pSD 3.73632020267
Rred_350 VDD.$195.Metal1 VDD.$203.Metal1 0.0466666322121
Rred_351 VDD.$195.Metal1 VDD.$915.Metal2 7.21747657563
Rred_352 VDD.$195.Metal1 VDD.$923.Metal2 6.00104546937
Rred_353 VDD.$195.Metal1 VDD.P0.nSD 10.7480140374
Rred_354 VDD.$203.Metal1 VDD.$228.Metal1 0.0872313477116
Rred_355 VDD.$203.Metal1 VDD.$923.Metal2 3.11421058532
Rred_356 VDD.$203.Metal1 VDD.$934.Metal2 4.11043232908
Rred_357 VDD.$203.Metal1 VDD.$938.Metal2 13.6387252473
Rred_358 VDD.$203.Metal1 VDD.P0.nSD 7.52240411843
Rred_359 VDD.$203.Metal1 VDD.P13.pSD 3.7351761001
Rred_360 VDD.$228.Metal1 VDD.$247.Metal1 0.0406838090659
Rred_361 VDD.$228.Metal1 VDD.$934.Metal2 17.1768024012
Rred_362 VDD.$228.Metal1 VDD.$938.Metal2 5.32873613468
Rred_363 VDD.$228.Metal1 VDD.$949.Metal2 2.59047149199
Rred_364 VDD.$228.Metal1 VDD.P0.nSD 7.92433989575
Rred_365 VDD.$228.Metal1 VDD.P15.pSD 3.73612927942
Rred_366 VDD.$247.Metal1 VDD.$255.Metal1 0.0458111725817
Rred_367 VDD.$247.Metal1 VDD.$949.Metal2 7.01359480942
Rred_368 VDD.$247.Metal1 VDD.$957.Metal2 6.11297515126
Rred_369 VDD.$247.Metal1 VDD.P0.nSD 10.6514438992
Rred_370 VDD.$255.Metal1 VDD.$280.Metal1 0.0872332745045
Rred_371 VDD.$255.Metal1 VDD.$957.Metal2 3.03045058224
Rred_372 VDD.$255.Metal1 VDD.$968.Metal2 4.24924988908
Rred_373 VDD.$255.Metal1 VDD.$972.Metal2 14.0524898581
Rred_374 VDD.$255.Metal1 VDD.P0.nSD 7.59630185661
Rred_375 VDD.$255.Metal1 VDD.P17.pSD 3.73527131041
Rred_376 VDD.$280.Metal1 VDD.$299.Metal1 0.0415372456909
Rred_377 VDD.$280.Metal1 VDD.$968.Metal2 16.5633578113
Rred_378 VDD.$280.Metal1 VDD.$972.Metal2 5.11227038279
Rred_379 VDD.$280.Metal1 VDD.$983.Metal2 2.6573341369
Rred_380 VDD.$280.Metal1 VDD.P0.nSD 7.89682260524
Rred_381 VDD.$280.Metal1 VDD.P19.pSD 3.73595207941
Rred_382 VDD.$299.Metal1 VDD.$307.Metal1 0.0449557125074
Rred_383 VDD.$299.Metal1 VDD.$983.Metal2 6.82862411992
Rred_384 VDD.$299.Metal1 VDD.$991.Metal2 6.23366856258
Rred_385 VDD.$299.Metal1 VDD.P0.nSD 10.5490093969
Rred_386 VDD.$3.Metal1 VDD.$42.Metal1 0.0838067653463
Rred_387 VDD.$3.Metal1 VDD.$44.Metal1 0.0795791280122
Rred_388 VDD.$3.Metal1 VDD.$807.Metal2 3.41764408919
Rred_389 VDD.$3.Metal1 VDD.$822.Metal2 19.3036966072
Rred_390 VDD.$3.Metal1 VDD.P0.nSD 7.57204486078
Rred_391 VDD.$307.Metal1 VDD.$332.Metal1 0.0872345597175
Rred_392 VDD.$307.Metal1 VDD.$991.Metal2 2.95003185319
Rred_393 VDD.$307.Metal1 VDD.P0.nSD 7.6745759053
Rred_394 VDD.$307.Metal1 VDD.P21.pSD 3.73538015145
Rred_395 VDD.$31.Metal1 VDD.$38.Metal1 0.00440445844384
Rred_396 VDD.$31.Metal1 VDD.$42.Metal1 0.0538078283208
Rred_397 VDD.$31.Metal1 VDD.$752.Metal1 25376.1851002
Rred_398 VDD.$31.Metal1 VDD.$759.Metal1 57164.862693
Rred_399 VDD.$31.Metal1 VDD.$807.Metal2 24.8021965517
Rred_400 VDD.$31.Metal1 VDD.$819.Metal2 5.52921186987
Rred_401 VDD.$31.Metal1 VDD.P0.nSD 2.20404876779
Rred_402 VDD.$31.Metal1 VDD.P0.pSD 28.7472895851
Rred_403 VDD.$31.Metal1 VDD.P1.pSD 28.7472895851
Rred_404 VDD.$332.Metal1 VDD.$351.Metal1 0.0423906818564
Rred_405 VDD.$332.Metal1 VDD.P0.nSD 7.87060279587
Rred_406 VDD.$332.Metal1 VDD.P23.pSD 3.73578858351
Rred_407 VDD.$351.Metal1 VDD.$359.Metal1 0.0441002520844
Rred_408 VDD.$351.Metal1 VDD.P0.nSD 10.4409088958
Rred_409 VDD.$359.Metal1 VDD.$384.Metal1 0.0872352033503
Rred_410 VDD.$359.Metal1 VDD.P0.nSD 7.75762608647
Rred_411 VDD.$359.Metal1 VDD.P25.pSD 3.73550263494
Rred_412 VDD.$38.Metal1 VDD.$752.Metal1 57164.862693
Rred_413 VDD.$38.Metal1 VDD.$759.Metal1 128775.129666
Rred_414 VDD.$38.Metal1 VDD.$819.Metal2 1.0199432646
Rred_415 VDD.$38.Metal1 VDD.P0.nSD 5.52959953002
Rred_416 VDD.$38.Metal1 VDD.P0.pSD 2.66051576044
Rred_417 VDD.$38.Metal1 VDD.P1.pSD 2.66051576044
Rred_418 VDD.$384.Metal1 VDD.P0.nSD 7.84559137844
Rred_419 VDD.$384.Metal1 VDD.P27.pSD 3.73563877407
Rred_420 VDD.$409.Metal1 VDD.$434.Metal1 0.0872352033503
Rred_421 VDD.$409.Metal1 VDD.P0.nSD 7.84559137844
Rred_422 VDD.$409.Metal1 VDD.P29.pSD 3.73563877407
Rred_423 VDD.$42.Metal1 VDD.$807.Metal2 14.49412488
Rred_424 VDD.$42.Metal1 VDD.$819.Metal2 19.7539250048
Rred_425 VDD.$42.Metal1 VDD.P0.GatPoly 105.461538462
Rred_426 VDD.$42.Metal1 VDD.P0.nSD 3.44994879017
Rred_427 VDD.$42.Metal1 VDD.P0.pSD 41.8568198511
Rred_428 VDD.$42.Metal1 VDD.P1.pSD 41.8568198511
Rred_429 VDD.$434.Metal1 VDD.$455.Metal1 0.0441002520844
Rred_430 VDD.$434.Metal1 VDD.P0.nSD 7.75762608647
Rred_431 VDD.$434.Metal1 VDD.P31.pSD 3.73550263494
Rred_432 VDD.$44.Metal1 VDD.$64.Metal1 0.0367151920338
Rred_433 VDD.$44.Metal1 VDD.$807.Metal2 15.2864475995
Rred_434 VDD.$44.Metal1 VDD.$822.Metal2 4.10052293257
Rred_435 VDD.$44.Metal1 VDD.P0.nSD 122.940264235
Rred_436 VDD.$455.Metal1 VDD.$461.Metal1 0.0423906818564
Rred_437 VDD.$455.Metal1 VDD.P0.nSD 10.4409088958
Rred_438 VDD.$461.Metal1 VDD.$486.Metal1 0.0872345597175
Rred_439 VDD.$461.Metal1 VDD.P0.nSD 7.87060279587
Rred_440 VDD.$461.Metal1 VDD.P33.pSD 3.73578858351
Rred_441 VDD.$486.Metal1 VDD.$507.Metal1 0.0449557125074
Rred_442 VDD.$486.Metal1 VDD.P0.nSD 7.6745759053
Rred_443 VDD.$486.Metal1 VDD.P35.pSD 3.73538015145
Rred_444 VDD.$507.Metal1 VDD.$513.Metal1 0.0415372456909
Rred_445 VDD.$507.Metal1 VDD.P0.nSD 10.5490093969
Rred_446 VDD.$513.Metal1 VDD.$538.Metal1 0.0872332745045
Rred_447 VDD.$513.Metal1 VDD.P0.nSD 7.89682260524
Rred_448 VDD.$513.Metal1 VDD.P37.pSD 3.73595207941
Rred_449 VDD.$538.Metal1 VDD.$559.Metal1 0.0458111725817
Rred_450 VDD.$538.Metal1 VDD.P0.nSD 7.59630185661
Rred_451 VDD.$538.Metal1 VDD.P39.pSD 3.73527131041
Rred_452 VDD.$559.Metal1 VDD.$565.Metal1 0.0406838090659
Rred_453 VDD.$559.Metal1 VDD.P0.nSD 10.6514438992
Rred_454 VDD.$565.Metal1 VDD.$590.Metal1 0.0872313477116
Rred_455 VDD.$565.Metal1 VDD.P0.nSD 7.92433989575
Rred_456 VDD.$565.Metal1 VDD.P41.pSD 3.73612927942
Rred_457 VDD.$590.Metal1 VDD.$611.Metal1 0.0466666322121
Rred_458 VDD.$590.Metal1 VDD.P0.nSD 7.52240411843
Rred_459 VDD.$590.Metal1 VDD.P43.pSD 3.7351761001
Rred_460 VDD.$611.Metal1 VDD.$617.Metal1 0.0398303720292
Rred_461 VDD.$611.Metal1 VDD.P0.nSD 10.7480140374
Rred_462 VDD.$617.Metal1 VDD.$642.Metal1 0.0872287793389
Rred_463 VDD.$617.Metal1 VDD.P0.nSD 7.95325273154
Rred_464 VDD.$617.Metal1 VDD.P45.pSD 3.73632020267
Rred_465 VDD.$64.Metal1 VDD.$822.Metal2 9.33751460386
Rred_466 VDD.$64.Metal1 VDD.$836.Metal2 4.4677403711
Rred_467 VDD.$64.Metal1 VDD.$86.Metal1 9.35216696505
Rred_468 VDD.$64.Metal1 VDD.$87.Metal1 0.0702667285389
Rred_469 VDD.$64.Metal1 VDD.P0.nSD 9.65815051258
Rred_470 VDD.$642.Metal1 VDD.$663.Metal1 0.0475220913035
Rred_471 VDD.$642.Metal1 VDD.P0.nSD 7.45252628727
Rred_472 VDD.$642.Metal1 VDD.P47.pSD 3.73509451027
Rred_473 VDD.$663.Metal1 VDD.$669.Metal1 0.0389769346281
Rred_474 VDD.$663.Metal1 VDD.P0.nSD 10.838511324
Rred_475 VDD.$669.Metal1 VDD.$694.Metal1 0.0872255693867
Rred_476 VDD.$669.Metal1 VDD.P0.nSD 7.98366931108
Rred_477 VDD.$669.Metal1 VDD.P49.pSD 3.73652486978
Rred_478 VDD.$694.Metal1 VDD.$715.Metal1 0.048377549761
Rred_479 VDD.$694.Metal1 VDD.P0.nSD 7.38634964019
Rred_480 VDD.$694.Metal1 VDD.P51.pSD 3.73502653214
Rred_481 VDD.$715.Metal1 VDD.$719.Metal1 0.0347082276367
Rred_482 VDD.$715.Metal1 VDD.P0.nSD 11.3488349089
Rred_483 VDD.$719.Metal1 VDD.$735.Metal1 0.477123384564
Rred_484 VDD.$719.Metal1 VDD.$742.Metal1 0.0702667285389
Rred_485 VDD.$719.Metal1 VDD.P0.nSD 9.74470028873
Rred_486 VDD.$735.Metal1 VDD.$742.Metal1 9.35216696505
Rred_487 VDD.$735.Metal1 VDD.P0.nSD 2082.86090981
Rred_488 VDD.$735.Metal1 VDD.P53.pSD 2.88722332362
Rred_489 VDD.$742.Metal1 VDD.$761.Metal1 0.0367151920338
Rred_490 VDD.$742.Metal1 VDD.P0.nSD 9.65815051258
Rred_491 VDD.$746.Metal1 VDD.$761.Metal1 0.0787239786651
Rred_492 VDD.$746.Metal1 VDD.$765.Metal1 0.0838067653463
Rred_493 VDD.$746.Metal1 VDD.P0.nSD 7.57204486078
Rred_494 VDD.$752.Metal1 VDD.$759.Metal1 0.00440445844384
Rred_495 VDD.$752.Metal1 VDD.$765.Metal1 0.0538078283208
Rred_496 VDD.$752.Metal1 VDD.P0.nSD 2.20404876779
Rred_497 VDD.$752.Metal1 VDD.P55.pSD 28.7472895851
Rred_498 VDD.$752.Metal1 VDD.P57.pSD 28.7472895851
Rred_499 VDD.$759.Metal1 VDD.P0.nSD 5.52959953002
Rred_500 VDD.$759.Metal1 VDD.P55.pSD 2.66051576044
Rred_501 VDD.$759.Metal1 VDD.P57.pSD 2.66051576044
Rred_502 VDD.$761.Metal1 VDD.P0.nSD 122.940264235
Rred_503 VDD.$765.Metal1 VDD.P0.nSD 3.44994879017
Rred_504 VDD.$765.Metal1 VDD.P1.GatPoly 105.461538462
Rred_505 VDD.$765.Metal1 VDD.P55.pSD 41.8568198511
Rred_506 VDD.$765.Metal1 VDD.P57.pSD 41.8568198511
Rred_507 VDD.$807.Metal2 VDD.$819.Metal2 0.112032957945
Rred_508 VDD.$807.Metal2 VDD.$822.Metal2 0.100259393703
Rred_509 VDD.$807.Metal2 VDD.P0.nSD 9957.4758603
Rred_510 VDD.$819.Metal2 VDD.P0.pSD 47.8288742398
Rred_511 VDD.$819.Metal2 VDD.P1.pSD 47.8288742398
Rred_512 VDD.$822.Metal2 VDD.$836.Metal2 0.0748661170905
Rred_513 VDD.$836.Metal2 VDD.$847.Metal2 0.0361212216421
Rred_514 VDD.$836.Metal2 VDD.$86.Metal1 32.5125960372
Rred_515 VDD.$836.Metal2 VDD.$87.Metal1 9.11039461524
Rred_516 VDD.$836.Metal2 VDD.P0.nSD 3788.62853426
Rred_517 VDD.$836.Metal2 VDD.P3.pSD 173.377307524
Rred_518 VDD.$847.Metal2 VDD.$855.Metal2 0.0727385628444
Rred_519 VDD.$847.Metal2 VDD.$86.Metal1 3.61171769061
Rred_520 VDD.$847.Metal2 VDD.$87.Metal1 4.5
Rred_521 VDD.$847.Metal2 VDD.$91.Metal1 9.07216
Rred_522 VDD.$847.Metal2 VDD.P3.pSD 18.7434927053
Rred_523 VDD.$855.Metal2 VDD.$866.Metal2 0.0361825411829
Rred_524 VDD.$855.Metal2 VDD.$91.Metal1 5.79991764697
Rred_525 VDD.$855.Metal2 VDD.$99.Metal1 3.29279951375
Rred_526 VDD.$855.Metal2 VDD.P0.nSD 6728.80975083
Rred_527 VDD.$855.Metal2 VDD.P5.pSD 17.0951652799
Rred_528 VDD.$86.Metal1 VDD.$87.Metal1 0.477123384564
Rred_529 VDD.$86.Metal1 VDD.P0.nSD 2082.86090981
Rred_530 VDD.$86.Metal1 VDD.P3.pSD 2.88722332362
Rred_531 VDD.$866.Metal2 VDD.$870.Metal2 0.0360795247734
Rred_532 VDD.$866.Metal2 VDD.$99.Metal1 3.85827191909
Rred_533 VDD.$866.Metal2 VDD.P0.nSD 3059.13574035
Rred_534 VDD.$866.Metal2 VDD.P5.pSD 26.7111957498
Rred_535 VDD.$87.Metal1 VDD.$91.Metal1 0.0347082276367
Rred_536 VDD.$87.Metal1 VDD.P0.nSD 9.74470028873
Rred_537 VDD.$870.Metal2 VDD.$881.Metal2 0.0361264897209
Rred_538 VDD.$870.Metal2 VDD.$99.Metal1 12.8798969812
Rred_539 VDD.$870.Metal2 VDD.P0.nSD 2598.11535914
Rred_540 VDD.$870.Metal2 VDD.P7.pSD 85.3415987069
Rred_541 VDD.$881.Metal2 VDD.$889.Metal2 0.0727385628444
Rred_542 VDD.$881.Metal2 VDD.P0.nSD 29746.948013
Rred_543 VDD.$881.Metal2 VDD.P7.pSD 11.8529998204
Rred_544 VDD.$889.Metal2 VDD.$900.Metal2 0.0361799585304
Rred_545 VDD.$889.Metal2 VDD.P0.nSD 7357.21367385
Rred_546 VDD.$889.Metal2 VDD.P10.pSD 16.436485604
Rred_547 VDD.$900.Metal2 VDD.$904.Metal2 0.0360795195038
Rred_548 VDD.$900.Metal2 VDD.P0.nSD 3011.71231884
Rred_549 VDD.$900.Metal2 VDD.P10.pSD 28.4899083802
Rred_550 VDD.$904.Metal2 VDD.$915.Metal2 0.0361342380077
Rred_551 VDD.$904.Metal2 VDD.P0.nSD 2637.94201861
Rred_552 VDD.$904.Metal2 VDD.P11.pSD 71.1332520693
Rred_553 VDD.$91.Metal1 VDD.$99.Metal1 0.048377549761
Rred_554 VDD.$91.Metal1 VDD.P0.nSD 11.3488349089
Rred_555 VDD.$915.Metal2 VDD.$923.Metal2 0.0727385628444
Rred_556 VDD.$915.Metal2 VDD.P0.nSD 24458.3910316
Rred_557 VDD.$915.Metal2 VDD.P11.pSD 12.1942717833
Rred_558 VDD.$923.Metal2 VDD.$934.Metal2 0.0361768593475
Rred_559 VDD.$923.Metal2 VDD.P0.nSD 8092.91553003
Rred_560 VDD.$923.Metal2 VDD.P13.pSD 15.8263710426
Rred_561 VDD.$934.Metal2 VDD.$938.Metal2 0.0360795152881
Rred_562 VDD.$934.Metal2 VDD.P0.nSD 2965.7204549
Rred_563 VDD.$934.Metal2 VDD.P13.pSD 30.5222870107
Rred_564 VDD.$938.Metal2 VDD.$949.Metal2 0.0361414697421
Rred_565 VDD.$938.Metal2 VDD.P0.nSD 2678.9960806
Rred_566 VDD.$938.Metal2 VDD.P15.pSD 60.983561434
Rred_567 VDD.$949.Metal2 VDD.$957.Metal2 0.0727385628444
Rred_568 VDD.$949.Metal2 VDD.P0.nSD 20699.7491345
Rred_569 VDD.$949.Metal2 VDD.P15.pSD 12.5554391188
Rred_570 VDD.$957.Metal2 VDD.$968.Metal2 0.036173243634
Rred_571 VDD.$957.Metal2 VDD.P0.nSD 8963.37454531
Rred_572 VDD.$957.Metal2 VDD.P17.pSD 15.2596181907
Rred_573 VDD.$968.Metal2 VDD.$972.Metal2 0.036079512126
Rred_574 VDD.$968.Metal2 VDD.P0.nSD 2921.09636554
Rred_575 VDD.$968.Metal2 VDD.P17.pSD 32.8668699492
Rred_576 VDD.$972.Metal2 VDD.$983.Metal2 0.036148184924
Rred_577 VDD.$972.Metal2 VDD.P0.nSD 2721.33522066
Rred_578 VDD.$972.Metal2 VDD.P19.pSD 53.3705308002
Rred_579 VDD.$983.Metal2 VDD.$991.Metal2 0.0727385628444
Rred_580 VDD.$983.Metal2 VDD.P0.nSD 17895.7038428
Rred_581 VDD.$983.Metal2 VDD.P19.pSD 12.938310497
Rred_582 VDD.$99.Metal1 VDD.P0.nSD 7.38634964019
Rred_583 VDD.$99.Metal1 VDD.P5.pSD 3.73502653214
Rred_584 VDD.$991.Metal2 VDD.P0.nSD 10005.7880435
Rred_585 VDD.$991.Metal2 VDD.P21.pSD 14.7317413541
Rred_586 VDD.P0.nSD VDD.P0.pSD 17471.8793511
Rred_587 VDD.P0.nSD VDD.P1.pSD 17471.8793511
Rred_588 VDD.P0.nSD VDD.P55.pSD 17471.8793511
Rred_589 VDD.P0.nSD VDD.P57.pSD 17471.8793511
Rred_590 VDD.P0.pSD VDD.P1.pSD 132.632154588
Rred_591 VDD.P55.pSD VDD.P57.pSD 132.632154588
Rred_592 vin vin.$564.Metal2 0.39910723995
Rred_593 vin vin.$566.Metal2 0.415507035372
Rred_594 vin vin.$569.Metal2 2.23269222465
Rred_595 vin vin.$573.Metal2 0.679924864825
Rred_596 vin vin.$574.Metal2 1.2216617833
Rred_597 vin vin.$581.Metal2 0.238753944337
Rred_598 vin.$102.GatPoly vin.$108.GatPoly 17.8026479167
Rred_599 vin.$102.GatPoly vin.$376.Metal1 22.2573661566
Rred_600 vin.$102.GatPoly vin.$384.Metal1 18.1264226977
Rred_601 vin.$102.GatPoly vin.$642.Metal2 3372.27982918
Rred_602 vin.$102.GatPoly vin.$647.Metal2 4543.078818
Rred_603 vin.$102.GatPoly vin.$98.GatPoly 10.9656296296
Rred_604 vin.$102.GatPoly vin.P21.GatPoly 45.7113030919
Rred_605 vin.$103.GatPoly vin.$109.GatPoly 17.3428707176
Rred_606 vin.$103.GatPoly vin.$377.Metal1 82.9333333334
Rred_607 vin.$103.GatPoly vin.$381.Metal1 15
Rred_608 vin.$103.GatPoly vin.$385.Metal1 43.7215228174
Rred_609 vin.$103.GatPoly vin.$99.GatPoly 10.9656296296
Rred_610 vin.$103.GatPoly vin.P75.GatPoly 110.017140972
Rred_611 vin.$108.GatPoly vin.$112.GatPoly 10.9656296296
Rred_612 vin.$108.GatPoly vin.$384.Metal1 32.3463963964
Rred_613 vin.$108.GatPoly vin.$388.Metal1 20.7333333333
Rred_614 vin.$108.GatPoly vin.P21.GatPoly 328.664269231
Rred_615 vin.$108.GatPoly vin.P22.GatPoly 36.6153846154
Rred_616 vin.$109.GatPoly vin.$113.GatPoly 10.9656296296
Rred_617 vin.$109.GatPoly vin.$385.Metal1 32.2606653979
Rred_618 vin.$109.GatPoly vin.$389.Metal1 20.7333333333
Rred_619 vin.$109.GatPoly vin.P75.GatPoly 791.023243591
Rred_620 vin.$109.GatPoly vin.P76.GatPoly 90.4615384615
Rred_621 vin.$112.GatPoly vin.$118.GatPoly 17.8026479167
Rred_622 vin.$112.GatPoly vin.$388.Metal1 22.2630620995
Rred_623 vin.$112.GatPoly vin.$394.Metal1 18.1499184064
Rred_624 vin.$112.GatPoly vin.$654.Metal2 1662.19395849
Rred_625 vin.$112.GatPoly vin.P23.GatPoly 45.7113030919
Rred_626 vin.$113.GatPoly vin.$119.GatPoly 17.3428707176
Rred_627 vin.$113.GatPoly vin.$389.Metal1 22.2630620995
Rred_628 vin.$113.GatPoly vin.$395.Metal1 17.9573941128
Rred_629 vin.$113.GatPoly vin.$655.Metal2 1662.19395849
Rred_630 vin.$113.GatPoly vin.P77.GatPoly 110.017140972
Rred_631 vin.$118.GatPoly vin.$122.GatPoly 10.9656296296
Rred_632 vin.$118.GatPoly vin.$394.Metal1 32.3463963964
Rred_633 vin.$118.GatPoly vin.$398.Metal1 20.7333333333
Rred_634 vin.$118.GatPoly vin.P23.GatPoly 328.664269231
Rred_635 vin.$118.GatPoly vin.P24.GatPoly 36.6153846154
Rred_636 vin.$119.GatPoly vin.$123.GatPoly 10.9656296296
Rred_637 vin.$119.GatPoly vin.$395.Metal1 32.2606653979
Rred_638 vin.$119.GatPoly vin.$399.Metal1 20.7333333333
Rred_639 vin.$119.GatPoly vin.P77.GatPoly 791.023243591
Rred_640 vin.$119.GatPoly vin.P78.GatPoly 90.4615384615
Rred_641 vin.$12.GatPoly vin.$18.GatPoly 17.8026479167
Rred_642 vin.$12.GatPoly vin.$274.Metal1 104.339988889
Rred_643 vin.$12.GatPoly vin.$278.Metal1 16.2624834653
Rred_644 vin.$12.GatPoly vin.$284.Metal1 18.1353577754
Rred_645 vin.$12.GatPoly vin.$4.GatPoly 41.3881955926
Rred_646 vin.$12.GatPoly vin.$574.Metal2 1662.19395849
Rred_647 vin.$12.GatPoly vin.P2.GatPoly 106.2711773
Rred_648 vin.$12.GatPoly vin.P3.GatPoly 45.7113030919
Rred_649 vin.$122.GatPoly vin.$126.GatPoly 8.255625
Rred_650 vin.$122.GatPoly vin.$398.Metal1 22.2591458859
Rred_651 vin.$122.GatPoly vin.$406.Metal1 30.402178794
Rred_652 vin.$122.GatPoly vin.$661.Metal2 2408.82989466
Rred_653 vin.$122.GatPoly vin.$665.Metal2 10049.5231154
Rred_654 vin.$122.GatPoly vin.P25.GatPoly 50.8038461538
Rred_655 vin.$123.GatPoly vin.$129.GatPoly 17.3428707176
Rred_656 vin.$123.GatPoly vin.$399.Metal1 22.2591458859
Rred_657 vin.$123.GatPoly vin.$407.Metal1 17.9325846517
Rred_658 vin.$123.GatPoly vin.$662.Metal2 2408.82989466
Rred_659 vin.$123.GatPoly vin.$666.Metal2 10049.5231154
Rred_660 vin.$123.GatPoly vin.P79.GatPoly 110.017140972
Rred_661 vin.$126.GatPoly vin.$132.GatPoly 21.8444333333
Rred_662 vin.$126.GatPoly vin.$406.Metal1 15
Rred_663 vin.$126.GatPoly vin.$410.Metal1 41.3025
Rred_664 vin.$126.GatPoly vin.P25.GatPoly 152.411538462
Rred_665 vin.$126.GatPoly vin.P26.GatPoly 72.94084838
Rred_666 vin.$129.GatPoly vin.$133.GatPoly 10.9656296296
Rred_667 vin.$129.GatPoly vin.$407.Metal1 32.2606653979
Rred_668 vin.$129.GatPoly vin.$411.Metal1 20.7333333333
Rred_669 vin.$129.GatPoly vin.P79.GatPoly 791.023243591
Rred_670 vin.$129.GatPoly vin.P80.GatPoly 90.4615384615
Rred_671 vin.$13.GatPoly vin.$19.GatPoly 17.3428707176
Rred_672 vin.$13.GatPoly vin.$275.Metal1 97.9314417107
Rred_673 vin.$13.GatPoly vin.$279.Metal1 15.9794571737
Rred_674 vin.$13.GatPoly vin.$285.Metal1 17.9426804457
Rred_675 vin.$13.GatPoly vin.$5.GatPoly 38.8461385453
Rred_676 vin.$13.GatPoly vin.$573.Metal2 2261.71190487
Rred_677 vin.$13.GatPoly vin.$577.Metal2 6395.18538618
Rred_678 vin.$13.GatPoly vin.P56.GatPoly 246.426394462
Rred_679 vin.$13.GatPoly vin.P57.GatPoly 110.017140972
Rred_680 vin.$132.GatPoly vin.$138.GatPoly 17.8026479167
Rred_681 vin.$132.GatPoly vin.$410.Metal1 17.2199796994
Rred_682 vin.$132.GatPoly vin.$416.Metal1 18.1494021678
Rred_683 vin.$132.GatPoly vin.$670.Metal2 1716.610141
Rred_684 vin.$132.GatPoly vin.P26.GatPoly 134.427282051
Rred_685 vin.$132.GatPoly vin.P27.GatPoly 45.7113030919
Rred_686 vin.$133.GatPoly vin.$139.GatPoly 17.3428707176
Rred_687 vin.$133.GatPoly vin.$411.Metal1 22.2544914996
Rred_688 vin.$133.GatPoly vin.$417.Metal1 17.9568887679
Rred_689 vin.$133.GatPoly vin.$671.Metal2 1716.610141
Rred_690 vin.$133.GatPoly vin.P81.GatPoly 110.017140972
Rred_691 vin.$138.GatPoly vin.$142.GatPoly 10.9656296296
Rred_692 vin.$138.GatPoly vin.$416.Metal1 32.3463963964
Rred_693 vin.$138.GatPoly vin.$420.Metal1 20.7333333333
Rred_694 vin.$138.GatPoly vin.P27.GatPoly 328.664269231
Rred_695 vin.$138.GatPoly vin.P28.GatPoly 36.6153846154
Rred_696 vin.$139.GatPoly vin.$143.GatPoly 10.9656296296
Rred_697 vin.$139.GatPoly vin.$417.Metal1 32.2606653979
Rred_698 vin.$139.GatPoly vin.$421.Metal1 20.7333333333
Rred_699 vin.$139.GatPoly vin.P81.GatPoly 791.023243591
Rred_700 vin.$139.GatPoly vin.P82.GatPoly 90.4615384615
Rred_701 vin.$142.GatPoly vin.$150.GatPoly 21.9492989844
Rred_702 vin.$142.GatPoly vin.$420.Metal1 22.2612207117
Rred_703 vin.$142.GatPoly vin.$428.Metal1 17.2504509015
Rred_704 vin.$142.GatPoly vin.$674.Metal2 2987.58348254
Rred_705 vin.$142.GatPoly vin.$679.Metal2 5498.19357361
Rred_706 vin.$142.GatPoly vin.P29.GatPoly 45.1439599386
Rred_707 vin.$142.GatPoly vin.P30.GatPoly 405.217827404
Rred_708 vin.$143.GatPoly vin.$149.GatPoly 17.3428707176
Rred_709 vin.$143.GatPoly vin.$421.Metal1 82.9333333334
Rred_710 vin.$143.GatPoly vin.$425.Metal1 15
Rred_711 vin.$143.GatPoly vin.$429.Metal1 43.7215228174
Rred_712 vin.$143.GatPoly vin.P83.GatPoly 110.017140972
Rred_713 vin.$149.GatPoly vin.$153.GatPoly 10.9656296296
Rred_714 vin.$149.GatPoly vin.$429.Metal1 32.2606653979
Rred_715 vin.$149.GatPoly vin.$433.Metal1 20.7333333333
Rred_716 vin.$149.GatPoly vin.P83.GatPoly 791.023243591
Rred_717 vin.$149.GatPoly vin.P84.GatPoly 90.4615384615
Rred_718 vin.$150.GatPoly vin.$154.GatPoly 10.9656296296
Rred_719 vin.$150.GatPoly vin.$428.Metal1 17.2740900377
Rred_720 vin.$150.GatPoly vin.$434.Metal1 22.2630620995
Rred_721 vin.$150.GatPoly vin.$681.Metal2 1662.19395849
Rred_722 vin.$150.GatPoly vin.P29.GatPoly 405.217827404
Rred_723 vin.$150.GatPoly vin.P30.GatPoly 45.1439599386
Rred_724 vin.$153.GatPoly vin.$159.GatPoly 17.3428707176
Rred_725 vin.$153.GatPoly vin.$433.Metal1 22.2462051089
Rred_726 vin.$153.GatPoly vin.$439.Metal1 17.9562029449
Rred_727 vin.$153.GatPoly vin.$687.Metal2 1774.68529082
Rred_728 vin.$153.GatPoly vin.P85.GatPoly 110.017140972
Rred_729 vin.$154.GatPoly vin.$160.GatPoly 17.8026479167
Rred_730 vin.$154.GatPoly vin.$434.Metal1 20.7333333333
Rred_731 vin.$154.GatPoly vin.$438.Metal1 32.3463963964
Rred_732 vin.$154.GatPoly vin.P31.GatPoly 36.6153846154
Rred_733 vin.$154.GatPoly vin.P32.GatPoly 328.664269231
Rred_734 vin.$159.GatPoly vin.$163.GatPoly 10.9656296296
Rred_735 vin.$159.GatPoly vin.$439.Metal1 32.2606653979
Rred_736 vin.$159.GatPoly vin.$443.Metal1 20.7333333333
Rred_737 vin.$159.GatPoly vin.P85.GatPoly 791.023243591
Rred_738 vin.$159.GatPoly vin.P86.GatPoly 90.4615384615
Rred_739 vin.$160.GatPoly vin.$164.GatPoly 10.9656296296
Rred_740 vin.$160.GatPoly vin.$438.Metal1 18.1264226977
Rred_741 vin.$160.GatPoly vin.$446.Metal1 22.2573661566
Rred_742 vin.$160.GatPoly vin.$688.Metal2 4543.078818
Rred_743 vin.$160.GatPoly vin.$693.Metal2 3372.27982918
Rred_744 vin.$160.GatPoly vin.P32.GatPoly 45.7113030919
Rred_745 vin.$163.GatPoly vin.$169.GatPoly 17.3428707176
Rred_746 vin.$163.GatPoly vin.$443.Metal1 22.2630430651
Rred_747 vin.$163.GatPoly vin.$451.Metal1 17.9301192519
Rred_748 vin.$163.GatPoly vin.$694.Metal2 2302.14182496
Rred_749 vin.$163.GatPoly vin.$698.Metal2 12411.2235754
Rred_750 vin.$163.GatPoly vin.P87.GatPoly 110.017140972
Rred_751 vin.$164.GatPoly vin.$170.GatPoly 17.8026479167
Rred_752 vin.$164.GatPoly vin.$446.Metal1 20.7333333333
Rred_753 vin.$164.GatPoly vin.$450.Metal1 32.3463963964
Rred_754 vin.$164.GatPoly vin.P33.GatPoly 36.6153846154
Rred_755 vin.$164.GatPoly vin.P34.GatPoly 328.664269231
Rred_756 vin.$169.GatPoly vin.$173.GatPoly 10.9656296296
Rred_757 vin.$169.GatPoly vin.$451.Metal1 32.2606653979
Rred_758 vin.$169.GatPoly vin.$455.Metal1 20.7333333333
Rred_759 vin.$169.GatPoly vin.P87.GatPoly 791.023243591
Rred_760 vin.$169.GatPoly vin.P88.GatPoly 90.4615384615
Rred_761 vin.$170.GatPoly vin.$174.GatPoly 10.9656296296
Rred_762 vin.$170.GatPoly vin.$450.Metal1 18.1502502983
Rred_763 vin.$170.GatPoly vin.$456.Metal1 22.2719179575
Rred_764 vin.$170.GatPoly vin.$697.Metal2 1611.09899248
Rred_765 vin.$170.GatPoly vin.P34.GatPoly 45.7113030919
Rred_766 vin.$173.GatPoly vin.$179.GatPoly 17.3428707176
Rred_767 vin.$173.GatPoly vin.$455.Metal1 22.2382019303
Rred_768 vin.$173.GatPoly vin.$461.Metal1 17.9553366151
Rred_769 vin.$173.GatPoly vin.$703.Metal2 1836.80456241
Rred_770 vin.$173.GatPoly vin.P89.GatPoly 110.017140972
Rred_771 vin.$174.GatPoly vin.$180.GatPoly 17.8026479167
Rred_772 vin.$174.GatPoly vin.$456.Metal1 20.7333333333
Rred_773 vin.$174.GatPoly vin.$460.Metal1 32.3463963964
Rred_774 vin.$174.GatPoly vin.P35.GatPoly 36.6153846154
Rred_775 vin.$174.GatPoly vin.P36.GatPoly 328.664269231
Rred_776 vin.$179.GatPoly vin.$183.GatPoly 10.9656296296
Rred_777 vin.$179.GatPoly vin.$461.Metal1 32.2606653979
Rred_778 vin.$179.GatPoly vin.$465.Metal1 20.7333333333
Rred_779 vin.$179.GatPoly vin.P89.GatPoly 791.023243591
Rred_780 vin.$179.GatPoly vin.P90.GatPoly 90.4615384615
Rred_781 vin.$18.GatPoly vin.$22.GatPoly 10.9656296296
Rred_782 vin.$18.GatPoly vin.$284.Metal1 32.3463963964
Rred_783 vin.$18.GatPoly vin.$288.Metal1 20.7333333333
Rred_784 vin.$18.GatPoly vin.P3.GatPoly 328.664269231
Rred_785 vin.$18.GatPoly vin.P4.GatPoly 36.6153846154
Rred_786 vin.$180.GatPoly vin.$184.GatPoly 10.9656296296
Rred_787 vin.$180.GatPoly vin.$460.Metal1 18.1277167802
Rred_788 vin.$180.GatPoly vin.$468.Metal1 22.2554318336
Rred_789 vin.$180.GatPoly vin.$704.Metal2 4180.13309525
Rred_790 vin.$180.GatPoly vin.$709.Metal2 3604.42265737
Rred_791 vin.$180.GatPoly vin.P36.GatPoly 45.7113030919
Rred_792 vin.$183.GatPoly vin.$189.GatPoly 17.3428707176
Rred_793 vin.$183.GatPoly vin.$465.Metal1 22.2649812457
Rred_794 vin.$183.GatPoly vin.$473.Metal1 17.9288832916
Rred_795 vin.$183.GatPoly vin.$710.Metal2 2252.31520297
Rred_796 vin.$183.GatPoly vin.$714.Metal2 14064.409797
Rred_797 vin.$183.GatPoly vin.P91.GatPoly 110.017140972
Rred_798 vin.$184.GatPoly vin.$190.GatPoly 17.8026479167
Rred_799 vin.$184.GatPoly vin.$468.Metal1 20.7333333333
Rred_800 vin.$184.GatPoly vin.$472.Metal1 32.3463963964
Rred_801 vin.$184.GatPoly vin.P37.GatPoly 36.6153846154
Rred_802 vin.$184.GatPoly vin.P38.GatPoly 328.664269231
Rred_803 vin.$189.GatPoly vin.$193.GatPoly 10.9656296296
Rred_804 vin.$189.GatPoly vin.$473.Metal1 32.2606653979
Rred_805 vin.$189.GatPoly vin.$477.Metal1 20.7333333333
Rred_806 vin.$189.GatPoly vin.P91.GatPoly 791.023243591
Rred_807 vin.$189.GatPoly vin.P92.GatPoly 90.4615384615
Rred_808 vin.$19.GatPoly vin.$23.GatPoly 10.9656296296
Rred_809 vin.$19.GatPoly vin.$285.Metal1 32.2606653979
Rred_810 vin.$19.GatPoly vin.$289.Metal1 20.7333333333
Rred_811 vin.$19.GatPoly vin.P57.GatPoly 791.023243591
Rred_812 vin.$19.GatPoly vin.P58.GatPoly 90.4615384615
Rred_813 vin.$190.GatPoly vin.$198.GatPoly 41.3881955926
Rred_814 vin.$190.GatPoly vin.$472.Metal1 18.1503978571
Rred_815 vin.$190.GatPoly vin.$478.Metal1 16.2603803717
Rred_816 vin.$190.GatPoly vin.$482.Metal1 104.339988889
Rred_817 vin.$190.GatPoly vin.$713.Metal2 1563.02782058
Rred_818 vin.$190.GatPoly vin.P38.GatPoly 45.7113030919
Rred_819 vin.$190.GatPoly vin.P39.GatPoly 106.2711773
Rred_820 vin.$193.GatPoly vin.$199.GatPoly 17.3428707176
Rred_821 vin.$193.GatPoly vin.$477.Metal1 22.2304810183
Rred_822 vin.$193.GatPoly vin.$483.Metal1 17.9542897419
Rred_823 vin.$193.GatPoly vin.$719.Metal2 1903.40913269
Rred_824 vin.$193.GatPoly vin.P93.GatPoly 110.017140972
Rred_825 vin.$198.GatPoly vin.$202.GatPoly 10.9656296296
Rred_826 vin.$198.GatPoly vin.$478.Metal1 78.2549916667
Rred_827 vin.$198.GatPoly vin.$482.Metal1 28.4201894558
Rred_828 vin.$198.GatPoly vin.$486.Metal1 20.7333333333
Rred_829 vin.$198.GatPoly vin.P39.GatPoly 138.199515335
Rred_830 vin.$198.GatPoly vin.P40.GatPoly 36.6153846154
Rred_831 vin.$199.GatPoly vin.$203.GatPoly 10.9656296296
Rred_832 vin.$199.GatPoly vin.$483.Metal1 32.2606653979
Rred_833 vin.$199.GatPoly vin.$487.Metal1 20.7333333333
Rred_834 vin.$199.GatPoly vin.P93.GatPoly 791.023243591
Rred_835 vin.$199.GatPoly vin.P94.GatPoly 90.4615384615
Rred_836 vin.$202.GatPoly vin.$210.GatPoly 21.9492989844
Rred_837 vin.$202.GatPoly vin.$486.Metal1 22.2669127475
Rred_838 vin.$202.GatPoly vin.$494.Metal1 17.2465600982
Rred_839 vin.$202.GatPoly vin.$725.Metal2 2204.6317399
Rred_840 vin.$202.GatPoly vin.$729.Metal2 16226.2652933
Rred_841 vin.$202.GatPoly vin.P41.GatPoly 45.1439599386
Rred_842 vin.$202.GatPoly vin.P42.GatPoly 405.217827404
Rred_843 vin.$203.GatPoly vin.$211.GatPoly 20.8161349411
Rred_844 vin.$203.GatPoly vin.$487.Metal1 22.266970272
Rred_845 vin.$203.GatPoly vin.$495.Metal1 17.0264750634
Rred_846 vin.$203.GatPoly vin.$726.Metal2 2551.27661738
Rred_847 vin.$203.GatPoly vin.$728.Metal2 8032.89938468
Rred_848 vin.$203.GatPoly vin.P95.GatPoly 108.578309915
Rred_849 vin.$203.GatPoly vin.P96.GatPoly 949.441810889
Rred_850 vin.$210.GatPoly vin.$218.GatPoly 41.3881955926
Rred_851 vin.$210.GatPoly vin.$494.Metal1 17.2717171798
Rred_852 vin.$210.GatPoly vin.$500.Metal1 16.2628683823
Rred_853 vin.$210.GatPoly vin.$504.Metal1 104.339988889
Rred_854 vin.$210.GatPoly vin.$729.Metal2 1563.02782058
Rred_855 vin.$210.GatPoly vin.P41.GatPoly 405.217827404
Rred_856 vin.$210.GatPoly vin.P42.GatPoly 45.1439599386
Rred_857 vin.$210.GatPoly vin.P43.GatPoly 106.2711773
Rred_858 vin.$211.GatPoly vin.$215.GatPoly 10.9656296296
Rred_859 vin.$211.GatPoly vin.$495.Metal1 17.0501544428
Rred_860 vin.$211.GatPoly vin.$501.Metal1 22.2848242338
Rred_861 vin.$211.GatPoly vin.$728.Metal2 5477.94001591
Rred_862 vin.$211.GatPoly vin.$733.Metal2 2204.53683567
Rred_863 vin.$211.GatPoly vin.P95.GatPoly 949.441810889
Rred_864 vin.$211.GatPoly vin.P96.GatPoly 108.578309915
Rred_865 vin.$215.GatPoly vin.$223.GatPoly 38.8461385453
Rred_866 vin.$215.GatPoly vin.$501.Metal1 20.7333333333
Rred_867 vin.$215.GatPoly vin.$505.Metal1 28.0359186568
Rred_868 vin.$215.GatPoly vin.$509.Metal1 73.4485812831
Rred_869 vin.$215.GatPoly vin.P97.GatPoly 90.4615384615
Rred_870 vin.$215.GatPoly vin.P98.GatPoly 320.463263377
Rred_871 vin.$218.GatPoly vin.$222.GatPoly 10.9656296296
Rred_872 vin.$218.GatPoly vin.$500.Metal1 78.2549916667
Rred_873 vin.$218.GatPoly vin.$504.Metal1 28.4201894558
Rred_874 vin.$218.GatPoly vin.$508.Metal1 20.7333333333
Rred_875 vin.$218.GatPoly vin.P43.GatPoly 138.199515335
Rred_876 vin.$218.GatPoly vin.P44.GatPoly 36.6153846154
Rred_877 vin.$22.GatPoly vin.$28.GatPoly 17.8026479167
Rred_878 vin.$22.GatPoly vin.$288.Metal1 22.2495983144
Rred_879 vin.$22.GatPoly vin.$296.Metal1 18.1315779765
Rred_880 vin.$22.GatPoly vin.$578.Metal2 4543.078818
Rred_881 vin.$22.GatPoly vin.$583.Metal2 3372.27982918
Rred_882 vin.$22.GatPoly vin.P5.GatPoly 45.7113030919
Rred_883 vin.$222.GatPoly vin.$230.GatPoly 21.9492989844
Rred_884 vin.$222.GatPoly vin.$508.Metal1 22.2688377652
Rred_885 vin.$222.GatPoly vin.$516.Metal1 17.2454118135
Rred_886 vin.$222.GatPoly vin.$741.Metal2 2158.95604176
Rred_887 vin.$222.GatPoly vin.$745.Metal2 19174.2458069
Rred_888 vin.$222.GatPoly vin.P45.GatPoly 45.1439599386
Rred_889 vin.$222.GatPoly vin.P46.GatPoly 405.217827404
Rred_890 vin.$223.GatPoly vin.$231.GatPoly 20.8161349411
Rred_891 vin.$223.GatPoly vin.$505.Metal1 97.9314417107
Rred_892 vin.$223.GatPoly vin.$509.Metal1 15.9715847815
Rred_893 vin.$223.GatPoly vin.$517.Metal1 17.0253109334
Rred_894 vin.$223.GatPoly vin.$742.Metal2 2432.89765424
Rred_895 vin.$223.GatPoly vin.$744.Metal2 9492.26811973
Rred_896 vin.$223.GatPoly vin.P100.GatPoly 949.441810889
Rred_897 vin.$223.GatPoly vin.P98.GatPoly 246.426394462
Rred_898 vin.$223.GatPoly vin.P99.GatPoly 108.578309915
Rred_899 vin.$23.GatPoly vin.$289.Metal1 22.2495983144
Rred_900 vin.$23.GatPoly vin.$29.GatPoly 17.3428707176
Rred_901 vin.$23.GatPoly vin.$297.Metal1 17.9394405171
Rred_902 vin.$23.GatPoly vin.$579.Metal2 4543.078818
Rred_903 vin.$23.GatPoly vin.$584.Metal2 3372.27982918
Rred_904 vin.$23.GatPoly vin.P59.GatPoly 110.017140972
Rred_905 vin.$230.GatPoly vin.$234.GatPoly 10.9656296296
Rred_906 vin.$230.GatPoly vin.$516.Metal1 17.2662231511
Rred_907 vin.$230.GatPoly vin.$522.Metal1 22.2855095486
Rred_908 vin.$230.GatPoly vin.$745.Metal2 1611.09899248
Rred_909 vin.$230.GatPoly vin.P45.GatPoly 405.217827404
Rred_910 vin.$230.GatPoly vin.P46.GatPoly 45.1439599386
Rred_911 vin.$231.GatPoly vin.$235.GatPoly 10.9656296296
Rred_912 vin.$231.GatPoly vin.$517.Metal1 17.0448519762
Rred_913 vin.$231.GatPoly vin.$523.Metal1 22.2846426929
Rred_914 vin.$231.GatPoly vin.$744.Metal2 5904.69517765
Rred_915 vin.$231.GatPoly vin.$749.Metal2 2232.26281106
Rred_916 vin.$231.GatPoly vin.P100.GatPoly 108.578309915
Rred_917 vin.$231.GatPoly vin.P99.GatPoly 949.441810889
Rred_918 vin.$234.GatPoly vin.$240.GatPoly 17.8026479167
Rred_919 vin.$234.GatPoly vin.$522.Metal1 20.7333333333
Rred_920 vin.$234.GatPoly vin.$526.Metal1 32.3463963964
Rred_921 vin.$234.GatPoly vin.P47.GatPoly 36.6153846154
Rred_922 vin.$234.GatPoly vin.P48.GatPoly 328.664269231
Rred_923 vin.$235.GatPoly vin.$243.GatPoly 38.8461385453
Rred_924 vin.$235.GatPoly vin.$523.Metal1 20.7333333333
Rred_925 vin.$235.GatPoly vin.$527.Metal1 28.0359186568
Rred_926 vin.$235.GatPoly vin.$531.Metal1 73.4485812831
Rred_927 vin.$235.GatPoly vin.P101.GatPoly 90.4615384615
Rred_928 vin.$235.GatPoly vin.P102.GatPoly 320.463263377
Rred_929 vin.$240.GatPoly vin.$244.GatPoly 10.9656296296
Rred_930 vin.$240.GatPoly vin.$526.Metal1 18.1315779765
Rred_931 vin.$240.GatPoly vin.$534.Metal1 22.2495983144
Rred_932 vin.$240.GatPoly vin.$752.Metal2 3372.27982918
Rred_933 vin.$240.GatPoly vin.$757.Metal2 4543.078818
Rred_934 vin.$240.GatPoly vin.P48.GatPoly 45.7113030919
Rred_935 vin.$243.GatPoly vin.$251.GatPoly 20.8161349411
Rred_936 vin.$243.GatPoly vin.$527.Metal1 97.9314417107
Rred_937 vin.$243.GatPoly vin.$531.Metal1 15.9725647485
Rred_938 vin.$243.GatPoly vin.$539.Metal1 17.0241427952
Rred_939 vin.$243.GatPoly vin.$758.Metal2 2325.0407717
Rred_940 vin.$243.GatPoly vin.$760.Metal2 11600.2404591
Rred_941 vin.$243.GatPoly vin.P102.GatPoly 246.426394462
Rred_942 vin.$243.GatPoly vin.P103.GatPoly 108.578309915
Rred_943 vin.$243.GatPoly vin.P104.GatPoly 949.441810889
Rred_944 vin.$244.GatPoly vin.$250.GatPoly 17.8026479167
Rred_945 vin.$244.GatPoly vin.$534.Metal1 20.7333333333
Rred_946 vin.$244.GatPoly vin.$538.Metal1 32.3463963964
Rred_947 vin.$244.GatPoly vin.P49.GatPoly 36.6153846154
Rred_948 vin.$244.GatPoly vin.P50.GatPoly 328.664269231
Rred_949 vin.$250.GatPoly vin.$258.GatPoly 41.3881955926
Rred_950 vin.$250.GatPoly vin.$538.Metal1 18.1353577754
Rred_951 vin.$250.GatPoly vin.$544.Metal1 16.2624834653
Rred_952 vin.$250.GatPoly vin.$548.Metal1 104.339988889
Rred_953 vin.$250.GatPoly vin.$761.Metal2 1662.19395849
Rred_954 vin.$250.GatPoly vin.P50.GatPoly 45.7113030919
Rred_955 vin.$250.GatPoly vin.P51.GatPoly 106.2711773
Rred_956 vin.$251.GatPoly vin.$259.GatPoly 38.8461385453
Rred_957 vin.$251.GatPoly vin.$539.Metal1 17.0397133935
Rred_958 vin.$251.GatPoly vin.$545.Metal1 15.9794571737
Rred_959 vin.$251.GatPoly vin.$549.Metal1 97.9314417107
Rred_960 vin.$251.GatPoly vin.$760.Metal2 6395.18538618
Rred_961 vin.$251.GatPoly vin.$765.Metal2 2261.71190487
Rred_962 vin.$251.GatPoly vin.P103.GatPoly 949.441810889
Rred_963 vin.$251.GatPoly vin.P104.GatPoly 108.578309915
Rred_964 vin.$251.GatPoly vin.P105.GatPoly 246.426394462
Rred_965 vin.$258.GatPoly vin.$544.Metal1 78.2549916667
Rred_966 vin.$258.GatPoly vin.$548.Metal1 8.69310157671
Rred_967 vin.$258.GatPoly vin.$768.Metal2 278.949014455
Rred_968 vin.$258.GatPoly vin.$771.Metal2 918.19166042
Rred_969 vin.$258.GatPoly vin.P51.GatPoly 138.199515335
Rred_970 vin.$258.GatPoly vin.P52.GatPoly 36.6153846154
Rred_971 vin.$258.GatPoly vin.P53.GatPoly 103.191366747
Rred_972 vin.$259.GatPoly vin.$545.Metal1 73.4485812831
Rred_973 vin.$259.GatPoly vin.$549.Metal1 8.50930816261
Rred_974 vin.$259.GatPoly vin.$769.Metal2 268.110721736
Rred_975 vin.$259.GatPoly vin.$771.Metal2 915.106877705
Rred_976 vin.$259.GatPoly vin.P105.GatPoly 320.463263377
Rred_977 vin.$259.GatPoly vin.P106.GatPoly 90.4615384615
Rred_978 vin.$259.GatPoly vin.P107.GatPoly 201.837409246
Rred_979 vin.$271.Metal1 vin.$275.Metal1 0.178963775069
Rred_980 vin.$271.Metal1 vin.$279.Metal1 6048.68628041
Rred_981 vin.$271.Metal1 vin.$5.GatPoly 11.5016471115
Rred_982 vin.$271.Metal1 vin.$566.Metal2 4.0895556586
Rred_983 vin.$271.Metal1 vin.$573.Metal2 56.2441539202
Rred_984 vin.$271.Metal1 vin.P54.GatPoly 245.526232776
Rred_985 vin.$274.Metal1 vin.$278.Metal1 0.178642894163
Rred_986 vin.$274.Metal1 vin.$4.GatPoly 8.69896253355
Rred_987 vin.$274.Metal1 vin.$564.Metal2 3.9266879056
Rred_988 vin.$274.Metal1 vin.$569.Metal2 12.5729036223
Rred_989 vin.$274.Metal1 vin.P0.GatPoly 133.472578183
Rred_990 vin.$274.Metal1 vin.P2.GatPoly 348.402139501
Rred_991 vin.$275.Metal1 vin.$279.Metal1 0.178620000698
Rred_992 vin.$275.Metal1 vin.$5.GatPoly 28.0359186568
Rred_993 vin.$275.Metal1 vin.$566.Metal2 22.1954972157
Rred_994 vin.$275.Metal1 vin.$573.Metal2 24.1050307071
Rred_995 vin.$275.Metal1 vin.P56.GatPoly 807.890579942
Rred_996 vin.$278.Metal1 vin.$284.Metal1 0.361813012975
Rred_997 vin.$278.Metal1 vin.$4.GatPoly 78.2549916667
Rred_998 vin.$278.Metal1 vin.$569.Metal2 12.5395578231
Rred_999 vin.$278.Metal1 vin.$574.Metal2 17.0179562826
Rred_1000 vin.$278.Metal1 vin.P2.GatPoly 200.932898256
Rred_1001 vin.$279.Metal1 vin.$285.Metal1 0.361794737808
Rred_1002 vin.$279.Metal1 vin.$5.GatPoly 73.4485812831
Rred_1003 vin.$279.Metal1 vin.$566.Metal2 49.2667599741
Rred_1004 vin.$279.Metal1 vin.$573.Metal2 9.8481740104
Rred_1005 vin.$279.Metal1 vin.$577.Metal2 65.4755028827
Rred_1006 vin.$279.Metal1 vin.P56.GatPoly 465.932258437
Rred_1007 vin.$28.GatPoly vin.$296.Metal1 32.3463963964
Rred_1008 vin.$28.GatPoly vin.$300.Metal1 20.7333333333
Rred_1009 vin.$28.GatPoly vin.$32.GatPoly 10.9656296296
Rred_1010 vin.$28.GatPoly vin.P5.GatPoly 328.664269231
Rred_1011 vin.$28.GatPoly vin.P6.GatPoly 36.6153846154
Rred_1012 vin.$284.Metal1 vin.$288.Metal1 0.178495927512
Rred_1013 vin.$284.Metal1 vin.$574.Metal2 10.1741903444
Rred_1014 vin.$284.Metal1 vin.$578.Metal2 21.0008242131
Rred_1015 vin.$284.Metal1 vin.P3.GatPoly 828.565384617
Rred_1016 vin.$285.Metal1 vin.$289.Metal1 0.178499943311
Rred_1017 vin.$285.Metal1 vin.$573.Metal2 26.8533413466
Rred_1018 vin.$285.Metal1 vin.$577.Metal2 9.14439093406
Rred_1019 vin.$285.Metal1 vin.P57.GatPoly 1994.17624435
Rred_1020 vin.$288.Metal1 vin.$296.Metal1 0.362799427562
Rred_1021 vin.$288.Metal1 vin.$574.Metal2 137.672069842
Rred_1022 vin.$288.Metal1 vin.$578.Metal2 10.1085504235
Rred_1023 vin.$288.Metal1 vin.$583.Metal2 40.2164761345
Rred_1024 vin.$289.Metal1 vin.$297.Metal1 0.362799427562
Rred_1025 vin.$289.Metal1 vin.$577.Metal2 68.1545238097
Rred_1026 vin.$289.Metal1 vin.$579.Metal2 10.909585015
Rred_1027 vin.$289.Metal1 vin.$584.Metal2 40.2164761345
Rred_1028 vin.$29.GatPoly vin.$297.Metal1 32.2606653979
Rred_1029 vin.$29.GatPoly vin.$301.Metal1 20.7333333333
Rred_1030 vin.$29.GatPoly vin.$33.GatPoly 10.9656296296
Rred_1031 vin.$29.GatPoly vin.P59.GatPoly 791.023243591
Rred_1032 vin.$29.GatPoly vin.P60.GatPoly 90.4615384615
Rred_1033 vin.$296.Metal1 vin.$300.Metal1 0.178749808666
Rred_1034 vin.$296.Metal1 vin.$578.Metal2 54.2048156595
Rred_1035 vin.$296.Metal1 vin.$583.Metal2 10.2029221141
Rred_1036 vin.$296.Metal1 vin.$588.Metal2 299.560642406
Rred_1037 vin.$296.Metal1 vin.$590.Metal2 90.2365049871
Rred_1038 vin.$296.Metal1 vin.P5.GatPoly 828.565384617
Rred_1039 vin.$297.Metal1 vin.$301.Metal1 0.178751237195
Rred_1040 vin.$297.Metal1 vin.$579.Metal2 54.2048156595
Rred_1041 vin.$297.Metal1 vin.$584.Metal2 10.5234229532
Rred_1042 vin.$297.Metal1 vin.$589.Metal2 57.2578770034
Rred_1043 vin.$297.Metal1 vin.P59.GatPoly 1994.17624435
Rred_1044 vin.$300.Metal1 vin.$306.Metal1 0.361824121591
Rred_1045 vin.$300.Metal1 vin.$32.GatPoly 22.2855095486
Rred_1046 vin.$300.Metal1 vin.$583.Metal2 25.6501792476
Rred_1047 vin.$300.Metal1 vin.$588.Metal2 99.853547469
Rred_1048 vin.$300.Metal1 vin.$590.Metal2 11.0646416985
Rred_1049 vin.$301.Metal1 vin.$307.Metal1 0.361803146026
Rred_1050 vin.$301.Metal1 vin.$33.GatPoly 22.2845647667
Rred_1051 vin.$301.Metal1 vin.$584.Metal2 33.2989071935
Rred_1052 vin.$301.Metal1 vin.$589.Metal2 10.8460549704
Rred_1053 vin.$301.Metal1 vin.$593.Metal2 58.8585341937
Rred_1054 vin.$306.Metal1 vin.$310.Metal1 0.178568368537
Rred_1055 vin.$306.Metal1 vin.$32.GatPoly 18.1412337657
Rred_1056 vin.$306.Metal1 vin.$38.GatPoly 32.3463963964
Rred_1057 vin.$306.Metal1 vin.$590.Metal2 10.1768631746
Rred_1058 vin.$306.Metal1 vin.$594.Metal2 21.7465172932
Rred_1059 vin.$306.Metal1 vin.P7.GatPoly 828.565384617
Rred_1060 vin.$307.Metal1 vin.$311.Metal1 0.178573110356
Rred_1061 vin.$307.Metal1 vin.$33.GatPoly 17.9483319009
Rred_1062 vin.$307.Metal1 vin.$39.GatPoly 32.2606653979
Rred_1063 vin.$307.Metal1 vin.$589.Metal2 27.4553160307
Rred_1064 vin.$307.Metal1 vin.$593.Metal2 9.22217083443
Rred_1065 vin.$307.Metal1 vin.P61.GatPoly 1994.17624435
Rred_1066 vin.$310.Metal1 vin.$318.Metal1 0.362818155856
Rred_1067 vin.$310.Metal1 vin.$38.GatPoly 20.7333333333
Rred_1068 vin.$310.Metal1 vin.$42.GatPoly 22.2515481102
Rred_1069 vin.$310.Metal1 vin.$590.Metal2 112.686498702
Rred_1070 vin.$310.Metal1 vin.$594.Metal2 10.1142529907
Rred_1071 vin.$310.Metal1 vin.$599.Metal2 42.9922454274
Rred_1072 vin.$311.Metal1 vin.$319.Metal1 0.362818155856
Rred_1073 vin.$311.Metal1 vin.$39.GatPoly 20.7333333333
Rred_1074 vin.$311.Metal1 vin.$43.GatPoly 22.2515481102
Rred_1075 vin.$311.Metal1 vin.$593.Metal2 55.7856493508
Rred_1076 vin.$311.Metal1 vin.$595.Metal2 11.1115804144
Rred_1077 vin.$311.Metal1 vin.$600.Metal2 42.9922454274
Rred_1078 vin.$318.Metal1 vin.$322.Metal1 0.178695372592
Rred_1079 vin.$318.Metal1 vin.$42.GatPoly 18.130294288
Rred_1080 vin.$318.Metal1 vin.$48.GatPoly 32.3463963964
Rred_1081 vin.$318.Metal1 vin.$594.Metal2 49.8710046958
Rred_1082 vin.$318.Metal1 vin.$599.Metal2 10.1731050403
Rred_1083 vin.$318.Metal1 vin.$604.Metal2 387.699341379
Rred_1084 vin.$318.Metal1 vin.$606.Metal2 100.102698799
Rred_1085 vin.$318.Metal1 vin.P9.GatPoly 828.565384617
Rred_1086 vin.$319.Metal1 vin.$323.Metal1 0.17869647599
Rred_1087 vin.$319.Metal1 vin.$43.GatPoly 17.9381838896
Rred_1088 vin.$319.Metal1 vin.$49.GatPoly 32.2606653979
Rred_1089 vin.$319.Metal1 vin.$595.Metal2 49.8710046958
Rred_1090 vin.$319.Metal1 vin.$600.Metal2 10.4080908161
Rred_1091 vin.$319.Metal1 vin.$605.Metal2 67.4186191407
Rred_1092 vin.$319.Metal1 vin.P63.GatPoly 1994.17624435
Rred_1093 vin.$32.GatPoly vin.$38.GatPoly 17.8026479167
Rred_1094 vin.$32.GatPoly vin.$590.Metal2 1611.09899248
Rred_1095 vin.$32.GatPoly vin.P7.GatPoly 45.7113030919
Rred_1096 vin.$322.Metal1 vin.$328.Metal1 0.36182906056
Rred_1097 vin.$322.Metal1 vin.$48.GatPoly 20.7333333333
Rred_1098 vin.$322.Metal1 vin.$52.GatPoly 22.2857320055
Rred_1099 vin.$322.Metal1 vin.$599.Metal2 24.34485902
Rred_1100 vin.$322.Metal1 vin.$604.Metal2 109.726228692
Rred_1101 vin.$322.Metal1 vin.$606.Metal2 11.0131313485
Rred_1102 vin.$323.Metal1 vin.$329.Metal1 0.361810240775
Rred_1103 vin.$323.Metal1 vin.$49.GatPoly 20.7333333333
Rred_1104 vin.$323.Metal1 vin.$53.GatPoly 22.2848843319
Rred_1105 vin.$323.Metal1 vin.$600.Metal2 30.0888612274
Rred_1106 vin.$323.Metal1 vin.$605.Metal2 10.7723184457
Rred_1107 vin.$323.Metal1 vin.$609.Metal2 67.6205087067
Rred_1108 vin.$328.Metal1 vin.$332.Metal1 0.17863477281
Rred_1109 vin.$328.Metal1 vin.$52.GatPoly 18.1472988503
Rred_1110 vin.$328.Metal1 vin.$58.GatPoly 32.3463963964
Rred_1111 vin.$328.Metal1 vin.$606.Metal2 10.1791599015
Rred_1112 vin.$328.Metal1 vin.$610.Metal2 22.5456806926
Rred_1113 vin.$328.Metal1 vin.P11.GatPoly 828.565384617
Rred_1114 vin.$329.Metal1 vin.$333.Metal1 0.178640180146
Rred_1115 vin.$329.Metal1 vin.$53.GatPoly 17.9542956462
Rred_1116 vin.$329.Metal1 vin.$59.GatPoly 32.2606653979
Rred_1117 vin.$329.Metal1 vin.$605.Metal2 25.4820784136
Rred_1118 vin.$329.Metal1 vin.$609.Metal2 9.61978498081
Rred_1119 vin.$329.Metal1 vin.P65.GatPoly 1994.17624435
Rred_1120 vin.$33.GatPoly vin.$39.GatPoly 17.3428707176
Rred_1121 vin.$33.GatPoly vin.$589.Metal2 2312.4129812
Rred_1122 vin.$33.GatPoly vin.$593.Metal2 5417.65327025
Rred_1123 vin.$33.GatPoly vin.P61.GatPoly 110.017140972
Rred_1124 vin.$332.Metal1 vin.$340.Metal1 0.362824398622
Rred_1125 vin.$332.Metal1 vin.$58.GatPoly 20.7333333333
Rred_1126 vin.$332.Metal1 vin.$606.Metal2 95.3855721614
Rred_1127 vin.$332.Metal1 vin.$610.Metal2 10.1197316762
Rred_1128 vin.$332.Metal1 vin.$615.Metal2 46.1776507338
Rred_1129 vin.$332.Metal1 vin.$62.GatPoly 22.2534925507
Rred_1130 vin.$333.Metal1 vin.$337.Metal1 0.178938945578
Rred_1131 vin.$333.Metal1 vin.$59.GatPoly 20.7333333333
Rred_1132 vin.$333.Metal1 vin.$609.Metal2 47.2209706961
Rred_1133 vin.$333.Metal1 vin.$611.Metal2 14.997543554
Rred_1134 vin.$333.Metal1 vin.$63.GatPoly 82.9333333334
Rred_1135 vin.$337.Metal1 vin.$341.Metal1 0.178930593812
Rred_1136 vin.$337.Metal1 vin.$611.Metal2 15.5128368504
Rred_1137 vin.$337.Metal1 vin.$613.Metal2 807.597373678
Rred_1138 vin.$337.Metal1 vin.$618.Metal2 46.1134446949
Rred_1139 vin.$337.Metal1 vin.$63.GatPoly 15
Rred_1140 vin.$340.Metal1 vin.$344.Metal1 0.178635051196
Rred_1141 vin.$340.Metal1 vin.$610.Metal2 46.1776507338
Rred_1142 vin.$340.Metal1 vin.$615.Metal2 10.1753107977
Rred_1143 vin.$340.Metal1 vin.$62.GatPoly 18.1290072664
Rred_1144 vin.$340.Metal1 vin.$620.Metal2 391.481654878
Rred_1145 vin.$340.Metal1 vin.$622.Metal2 117.925826367
Rred_1146 vin.$340.Metal1 vin.$68.GatPoly 32.3463963964
Rred_1147 vin.$340.Metal1 vin.P13.GatPoly 828.565384617
Rred_1148 vin.$341.Metal1 vin.$345.Metal1 0.178640180146
Rred_1149 vin.$341.Metal1 vin.$611.Metal2 32.0407234719
Rred_1150 vin.$341.Metal1 vin.$613.Metal2 531.832416812
Rred_1151 vin.$341.Metal1 vin.$618.Metal2 18.4818654782
Rred_1152 vin.$341.Metal1 vin.$63.GatPoly 43.7215228174
Rred_1153 vin.$341.Metal1 vin.$69.GatPoly 32.2606653979
Rred_1154 vin.$341.Metal1 vin.P67.GatPoly 1994.17624435
Rred_1155 vin.$344.Metal1 vin.$350.Metal1 0.36182906056
Rred_1156 vin.$344.Metal1 vin.$615.Metal2 23.7694418686
Rred_1157 vin.$344.Metal1 vin.$620.Metal2 92.5320275164
Rred_1158 vin.$344.Metal1 vin.$622.Metal2 11.1405632121
Rred_1159 vin.$344.Metal1 vin.$68.GatPoly 20.7333333333
Rred_1160 vin.$344.Metal1 vin.$72.GatPoly 22.2810601744
Rred_1161 vin.$345.Metal1 vin.$351.Metal1 0.36182906056
Rred_1162 vin.$345.Metal1 vin.$618.Metal2 11.1613203463
Rred_1163 vin.$345.Metal1 vin.$623.Metal2 18.5578541237
Rred_1164 vin.$345.Metal1 vin.$69.GatPoly 20.7333333333
Rred_1165 vin.$345.Metal1 vin.$73.GatPoly 22.2810601744
Rred_1166 vin.$350.Metal1 vin.$354.Metal1 0.17869514033
Rred_1167 vin.$350.Metal1 vin.$622.Metal2 10.1801188009
Rred_1168 vin.$350.Metal1 vin.$626.Metal2 23.404367655
Rred_1169 vin.$350.Metal1 vin.$72.GatPoly 18.1503978571
Rred_1170 vin.$350.Metal1 vin.$78.GatPoly 32.3463963964
Rred_1171 vin.$350.Metal1 vin.P15.GatPoly 828.565384617
Rred_1172 vin.$351.Metal1 vin.$355.Metal1 0.17869514033
Rred_1173 vin.$351.Metal1 vin.$623.Metal2 10.1801188009
Rred_1174 vin.$351.Metal1 vin.$627.Metal2 23.404367655
Rred_1175 vin.$351.Metal1 vin.$73.GatPoly 17.9578634458
Rred_1176 vin.$351.Metal1 vin.$79.GatPoly 32.2606653979
Rred_1177 vin.$351.Metal1 vin.P69.GatPoly 1994.17624435
Rred_1178 vin.$354.Metal1 vin.$362.Metal1 0.362818155856
Rred_1179 vin.$354.Metal1 vin.$622.Metal2 82.6954323812
Rred_1180 vin.$354.Metal1 vin.$626.Metal2 10.1249863276
Rred_1181 vin.$354.Metal1 vin.$631.Metal2 49.8710046958
Rred_1182 vin.$354.Metal1 vin.$78.GatPoly 20.7333333333
Rred_1183 vin.$354.Metal1 vin.$82.GatPoly 22.2554318336
Rred_1184 vin.$355.Metal1 vin.$359.Metal1 0.17895723734
Rred_1185 vin.$355.Metal1 vin.$623.Metal2 82.6954323812
Rred_1186 vin.$355.Metal1 vin.$627.Metal2 13.2430853663
Rred_1187 vin.$355.Metal1 vin.$79.GatPoly 20.7333333333
Rred_1188 vin.$355.Metal1 vin.$83.GatPoly 82.9333333334
Rred_1189 vin.$359.Metal1 vin.$363.Metal1 0.178906436789
Rred_1190 vin.$359.Metal1 vin.$627.Metal2 15.0416956067
Rred_1191 vin.$359.Metal1 vin.$629.Metal2 1202.52035779
Rred_1192 vin.$359.Metal1 vin.$634.Metal2 49.7379496102
Rred_1193 vin.$359.Metal1 vin.$83.GatPoly 15
Rred_1194 vin.$362.Metal1 vin.$366.Metal1 0.17856863926
Rred_1195 vin.$362.Metal1 vin.$626.Metal2 42.9922454274
Rred_1196 vin.$362.Metal1 vin.$631.Metal2 10.166350592
Rred_1197 vin.$362.Metal1 vin.$636.Metal2 440.879237224
Rred_1198 vin.$362.Metal1 vin.$638.Metal2 140.394740706
Rred_1199 vin.$362.Metal1 vin.$82.GatPoly 18.1277167802
Rred_1200 vin.$362.Metal1 vin.$88.GatPoly 32.3463963964
Rred_1201 vin.$362.Metal1 vin.P17.GatPoly 828.565384617
Rred_1202 vin.$363.Metal1 vin.$367.Metal1 0.178573110356
Rred_1203 vin.$363.Metal1 vin.$627.Metal2 30.0859315594
Rred_1204 vin.$363.Metal1 vin.$629.Metal2 699.139742904
Rred_1205 vin.$363.Metal1 vin.$634.Metal2 19.0450805551
Rred_1206 vin.$363.Metal1 vin.$83.GatPoly 43.7215228174
Rred_1207 vin.$363.Metal1 vin.$89.GatPoly 32.2606653979
Rred_1208 vin.$363.Metal1 vin.P71.GatPoly 1994.17624435
Rred_1209 vin.$366.Metal1 vin.$372.Metal1 0.361824121591
Rred_1210 vin.$366.Metal1 vin.$631.Metal2 23.0632937347
Rred_1211 vin.$366.Metal1 vin.$636.Metal2 85.0819580605
Rred_1212 vin.$366.Metal1 vin.$638.Metal2 11.2124404285
Rred_1213 vin.$366.Metal1 vin.$88.GatPoly 20.7333333333
Rred_1214 vin.$366.Metal1 vin.$92.GatPoly 22.2719179575
Rred_1215 vin.$367.Metal1 vin.$373.Metal1 0.361824121591
Rred_1216 vin.$367.Metal1 vin.$634.Metal2 10.7656516291
Rred_1217 vin.$367.Metal1 vin.$639.Metal2 19.1286039107
Rred_1218 vin.$367.Metal1 vin.$89.GatPoly 20.7333333333
Rred_1219 vin.$367.Metal1 vin.$93.GatPoly 22.2719179575
Rred_1220 vin.$372.Metal1 vin.$376.Metal1 0.178749471098
Rred_1221 vin.$372.Metal1 vin.$638.Metal2 10.1797496142
Rred_1222 vin.$372.Metal1 vin.$642.Metal2 24.3295809524
Rred_1223 vin.$372.Metal1 vin.$92.GatPoly 18.1502502983
Rred_1224 vin.$372.Metal1 vin.$98.GatPoly 32.3463963964
Rred_1225 vin.$372.Metal1 vin.P19.GatPoly 828.565384617
Rred_1226 vin.$373.Metal1 vin.$377.Metal1 0.178749471098
Rred_1227 vin.$373.Metal1 vin.$639.Metal2 10.1797496142
Rred_1228 vin.$373.Metal1 vin.$643.Metal2 24.3295809524
Rred_1229 vin.$373.Metal1 vin.$93.GatPoly 17.9577190009
Rred_1230 vin.$373.Metal1 vin.$99.GatPoly 32.2606653979
Rred_1231 vin.$373.Metal1 vin.P73.GatPoly 1994.17624435
Rred_1232 vin.$376.Metal1 vin.$384.Metal1 0.362799427562
Rred_1233 vin.$376.Metal1 vin.$638.Metal2 72.988742857
Rred_1234 vin.$376.Metal1 vin.$642.Metal2 10.1300168006
Rred_1235 vin.$376.Metal1 vin.$647.Metal2 54.2048156595
Rred_1236 vin.$376.Metal1 vin.$98.GatPoly 20.7333333333
Rred_1237 vin.$377.Metal1 vin.$381.Metal1 0.178969431847
Rred_1238 vin.$377.Metal1 vin.$639.Metal2 72.988742857
Rred_1239 vin.$377.Metal1 vin.$643.Metal2 13.5385876067
Rred_1240 vin.$377.Metal1 vin.$99.GatPoly 20.7333333333
Rred_1241 vin.$38.GatPoly vin.$42.GatPoly 10.9656296296
Rred_1242 vin.$38.GatPoly vin.P7.GatPoly 328.664269231
Rred_1243 vin.$38.GatPoly vin.P8.GatPoly 36.6153846154
Rred_1244 vin.$381.Metal1 vin.$385.Metal1 0.178876246461
Rred_1245 vin.$381.Metal1 vin.$643.Metal2 14.6046143277
Rred_1246 vin.$381.Metal1 vin.$645.Metal2 2143.89339522
Rred_1247 vin.$381.Metal1 vin.$650.Metal2 54.0110958403
Rred_1248 vin.$384.Metal1 vin.$388.Metal1 0.178496180382
Rred_1249 vin.$384.Metal1 vin.$642.Metal2 40.2164761345
Rred_1250 vin.$384.Metal1 vin.$647.Metal2 10.1555051139
Rred_1251 vin.$384.Metal1 vin.$652.Metal2 514.767394242
Rred_1252 vin.$384.Metal1 vin.$654.Metal2 172.784629461
Rred_1253 vin.$384.Metal1 vin.P21.GatPoly 828.565384617
Rred_1254 vin.$385.Metal1 vin.$389.Metal1 0.178499943311
Rred_1255 vin.$385.Metal1 vin.$643.Metal2 28.2923636583
Rred_1256 vin.$385.Metal1 vin.$645.Metal2 1095.76773534
Rred_1257 vin.$385.Metal1 vin.$650.Metal2 19.6475307433
Rred_1258 vin.$385.Metal1 vin.P75.GatPoly 1994.17624435
Rred_1259 vin.$388.Metal1 vin.$394.Metal1 0.361813012975
Rred_1260 vin.$388.Metal1 vin.$647.Metal2 22.4121175929
Rred_1261 vin.$388.Metal1 vin.$652.Metal2 78.5238397994
Rred_1262 vin.$388.Metal1 vin.$654.Metal2 11.2852349852
Rred_1263 vin.$389.Metal1 vin.$395.Metal1 0.361813012975
Rred_1264 vin.$389.Metal1 vin.$650.Metal2 10.3964527845
Rred_1265 vin.$389.Metal1 vin.$655.Metal2 19.7352552532
Rred_1266 vin.$39.GatPoly vin.$43.GatPoly 10.9656296296
Rred_1267 vin.$39.GatPoly vin.P61.GatPoly 791.023243591
Rred_1268 vin.$39.GatPoly vin.P62.GatPoly 90.4615384615
Rred_1269 vin.$394.Metal1 vin.$398.Metal1 0.178797768325
Rred_1270 vin.$394.Metal1 vin.$654.Metal2 10.1808976008
Rred_1271 vin.$394.Metal1 vin.$659.Metal2 1005.87580772
Rred_1272 vin.$394.Metal1 vin.$661.Metal2 25.9713835601
Rred_1273 vin.$394.Metal1 vin.P23.GatPoly 828.565384617
Rred_1274 vin.$395.Metal1 vin.$399.Metal1 0.178797768325
Rred_1275 vin.$395.Metal1 vin.$655.Metal2 10.1808976008
Rred_1276 vin.$395.Metal1 vin.$659.Metal2 1005.87580772
Rred_1277 vin.$395.Metal1 vin.$662.Metal2 25.9713835601
Rred_1278 vin.$395.Metal1 vin.P77.GatPoly 1994.17624435
Rred_1279 vin.$398.Metal1 vin.$406.Metal1 0.362749735698
Rred_1280 vin.$398.Metal1 vin.$654.Metal2 65.3531679668
Rred_1281 vin.$398.Metal1 vin.$659.Metal2 2594.10076728
Rred_1282 vin.$398.Metal1 vin.$661.Metal2 9.3781082333
Rred_1283 vin.$398.Metal1 vin.$665.Metal2 119.907914453
Rred_1284 vin.$399.Metal1 vin.$407.Metal1 0.362749735698
Rred_1285 vin.$399.Metal1 vin.$655.Metal2 65.3531679668
Rred_1286 vin.$399.Metal1 vin.$659.Metal2 2594.10076728
Rred_1287 vin.$399.Metal1 vin.$662.Metal2 9.3781082333
Rred_1288 vin.$399.Metal1 vin.$666.Metal2 119.907914453
Rred_1289 vin.$4.GatPoly vin.$564.Metal2 226.93819871
Rred_1290 vin.$4.GatPoly vin.$569.Metal2 2882.9246542
Rred_1291 vin.$4.GatPoly vin.P0.GatPoly 103.193593906
Rred_1292 vin.$4.GatPoly vin.P1.GatPoly 36.6153846154
Rred_1293 vin.$4.GatPoly vin.P2.GatPoly 138.199515335
Rred_1294 vin.$406.Metal1 vin.$410.Metal1 0.178420679012
Rred_1295 vin.$406.Metal1 vin.$661.Metal2 13.7591940205
Rred_1296 vin.$406.Metal1 vin.$665.Metal2 17.3543491439
Rred_1297 vin.$407.Metal1 vin.$411.Metal1 0.178420679012
Rred_1298 vin.$407.Metal1 vin.$662.Metal2 13.7591940205
Rred_1299 vin.$407.Metal1 vin.$666.Metal2 17.3543491439
Rred_1300 vin.$407.Metal1 vin.P79.GatPoly 1994.17624435
Rred_1301 vin.$410.Metal1 vin.$416.Metal1 0.361795734713
Rred_1302 vin.$410.Metal1 vin.$665.Metal2 10.0511202186
Rred_1303 vin.$410.Metal1 vin.$670.Metal2 20.3813394518
Rred_1304 vin.$410.Metal1 vin.P26.GatPoly 254.169230769
Rred_1305 vin.$411.Metal1 vin.$417.Metal1 0.361795734713
Rred_1306 vin.$411.Metal1 vin.$666.Metal2 10.0511202186
Rred_1307 vin.$411.Metal1 vin.$671.Metal2 20.3813394518
Rred_1308 vin.$416.Metal1 vin.$420.Metal1 0.178840022379
Rred_1309 vin.$416.Metal1 vin.$670.Metal2 10.1779734769
Rred_1310 vin.$416.Metal1 vin.$674.Metal2 26.4135574468
Rred_1311 vin.$416.Metal1 vin.P27.GatPoly 828.565384617
Rred_1312 vin.$417.Metal1 vin.$421.Metal1 0.178840022379
Rred_1313 vin.$417.Metal1 vin.$671.Metal2 10.1779734769
Rred_1314 vin.$417.Metal1 vin.$678.Metal2 26.4135574468
Rred_1315 vin.$417.Metal1 vin.P81.GatPoly 1994.17624435
Rred_1316 vin.$42.GatPoly vin.$48.GatPoly 17.8026479167
Rred_1317 vin.$42.GatPoly vin.$594.Metal2 4180.13309525
Rred_1318 vin.$42.GatPoly vin.$599.Metal2 3604.42265737
Rred_1319 vin.$42.GatPoly vin.P9.GatPoly 45.7113030919
Rred_1320 vin.$420.Metal1 vin.$428.Metal1 0.362724514501
Rred_1321 vin.$420.Metal1 vin.$670.Metal2 59.1160571428
Rred_1322 vin.$420.Metal1 vin.$674.Metal2 10.1394046731
Rred_1323 vin.$420.Metal1 vin.$679.Metal2 65.6028069289
Rred_1324 vin.$421.Metal1 vin.$425.Metal1 0.178975529101
Rred_1325 vin.$421.Metal1 vin.$671.Metal2 59.1160571428
Rred_1326 vin.$421.Metal1 vin.$678.Metal2 14.1698789151
Rred_1327 vin.$425.Metal1 vin.$429.Metal1 0.178797766553
Rred_1328 vin.$425.Metal1 vin.$676.Metal2 3859.49509527
Rred_1329 vin.$425.Metal1 vin.$678.Metal2 13.896453864
Rred_1330 vin.$425.Metal1 vin.$682.Metal2 65.3367140588
Rred_1331 vin.$428.Metal1 vin.$434.Metal1 0.361813012975
Rred_1332 vin.$428.Metal1 vin.$674.Metal2 35.6129523328
Rred_1333 vin.$428.Metal1 vin.$679.Metal2 10.5257138212
Rred_1334 vin.$428.Metal1 vin.$681.Metal2 17.0179562826
Rred_1335 vin.$428.Metal1 vin.P29.GatPoly 736.257692309
Rred_1336 vin.$428.Metal1 vin.P30.GatPoly 736.257692309
Rred_1337 vin.$429.Metal1 vin.$433.Metal1 0.17833531746
Rred_1338 vin.$429.Metal1 vin.$676.Metal2 1496.5389145
Rred_1339 vin.$429.Metal1 vin.$678.Metal2 25.7600960692
Rred_1340 vin.$429.Metal1 vin.$682.Metal2 20.9949164239
Rred_1341 vin.$429.Metal1 vin.P83.GatPoly 1994.17624435
Rred_1342 vin.$43.GatPoly vin.$49.GatPoly 17.3428707176
Rred_1343 vin.$43.GatPoly vin.$595.Metal2 4180.13309525
Rred_1344 vin.$43.GatPoly vin.$600.Metal2 3604.42265737
Rred_1345 vin.$43.GatPoly vin.P63.GatPoly 110.017140972
Rred_1346 vin.$433.Metal1 vin.$439.Metal1 0.361772286805
Rred_1347 vin.$433.Metal1 vin.$682.Metal2 9.72738095238
Rred_1348 vin.$433.Metal1 vin.$687.Metal2 21.0708666274
Rred_1349 vin.$434.Metal1 vin.$438.Metal1 0.178496180382
Rred_1350 vin.$434.Metal1 vin.$681.Metal2 11.2852349852
Rred_1351 vin.$434.Metal1 vin.$684.Metal2 78.5238397994
Rred_1352 vin.$434.Metal1 vin.$688.Metal2 22.4121175929
Rred_1353 vin.$438.Metal1 vin.$446.Metal1 0.362799427562
Rred_1354 vin.$438.Metal1 vin.$681.Metal2 172.784629461
Rred_1355 vin.$438.Metal1 vin.$684.Metal2 514.767394242
Rred_1356 vin.$438.Metal1 vin.$688.Metal2 10.1555051139
Rred_1357 vin.$438.Metal1 vin.$693.Metal2 40.2164761345
Rred_1358 vin.$438.Metal1 vin.P32.GatPoly 828.565384617
Rred_1359 vin.$439.Metal1 vin.$443.Metal1 0.178876246461
Rred_1360 vin.$439.Metal1 vin.$687.Metal2 10.1782960276
Rred_1361 vin.$439.Metal1 vin.$691.Metal2 1095.76773534
Rred_1362 vin.$439.Metal1 vin.$694.Metal2 28.2923636583
Rred_1363 vin.$439.Metal1 vin.P85.GatPoly 1994.17624435
Rred_1364 vin.$443.Metal1 vin.$451.Metal1 0.362652838718
Rred_1365 vin.$443.Metal1 vin.$687.Metal2 54.0110958403
Rred_1366 vin.$443.Metal1 vin.$691.Metal2 2143.89339522
Rred_1367 vin.$443.Metal1 vin.$694.Metal2 9.53487658819
Rred_1368 vin.$443.Metal1 vin.$698.Metal2 148.081975454
Rred_1369 vin.$446.Metal1 vin.$450.Metal1 0.178749471098
Rred_1370 vin.$446.Metal1 vin.$688.Metal2 54.2048156595
Rred_1371 vin.$446.Metal1 vin.$693.Metal2 10.1300168006
Rred_1372 vin.$446.Metal1 vin.$697.Metal2 72.988742857
Rred_1373 vin.$450.Metal1 vin.$456.Metal1 0.361824121591
Rred_1374 vin.$450.Metal1 vin.$693.Metal2 24.3295809524
Rred_1375 vin.$450.Metal1 vin.$697.Metal2 10.1797496142
Rred_1376 vin.$450.Metal1 vin.P34.GatPoly 828.565384617
Rred_1377 vin.$451.Metal1 vin.$455.Metal1 0.178243858654
Rred_1378 vin.$451.Metal1 vin.$694.Metal2 12.8943003013
Rred_1379 vin.$451.Metal1 vin.$698.Metal2 18.9532396852
Rred_1380 vin.$451.Metal1 vin.P87.GatPoly 1994.17624435
Rred_1381 vin.$455.Metal1 vin.$461.Metal1 0.36174266925
Rred_1382 vin.$455.Metal1 vin.$698.Metal2 9.42324175824
Rred_1383 vin.$455.Metal1 vin.$703.Metal2 21.8084097251
Rred_1384 vin.$456.Metal1 vin.$460.Metal1 0.17856863926
Rred_1385 vin.$456.Metal1 vin.$697.Metal2 11.2124404285
Rred_1386 vin.$456.Metal1 vin.$700.Metal2 85.0819580605
Rred_1387 vin.$456.Metal1 vin.$704.Metal2 23.0632937347
Rred_1388 vin.$460.Metal1 vin.$468.Metal1 0.362818155856
Rred_1389 vin.$460.Metal1 vin.$697.Metal2 140.394740706
Rred_1390 vin.$460.Metal1 vin.$700.Metal2 440.879237224
Rred_1391 vin.$460.Metal1 vin.$704.Metal2 10.166350592
Rred_1392 vin.$460.Metal1 vin.$709.Metal2 42.9922454274
Rred_1393 vin.$460.Metal1 vin.P36.GatPoly 828.565384617
Rred_1394 vin.$461.Metal1 vin.$465.Metal1 0.178906436789
Rred_1395 vin.$461.Metal1 vin.$703.Metal2 10.1793436793
Rred_1396 vin.$461.Metal1 vin.$707.Metal2 699.139742904
Rred_1397 vin.$461.Metal1 vin.$710.Metal2 30.0859315594
Rred_1398 vin.$461.Metal1 vin.P89.GatPoly 1994.17624435
Rred_1399 vin.$465.Metal1 vin.$473.Metal1 0.362585756178
Rred_1400 vin.$465.Metal1 vin.$703.Metal2 49.7379496102
Rred_1401 vin.$465.Metal1 vin.$707.Metal2 1202.52035779
Rred_1402 vin.$465.Metal1 vin.$710.Metal2 9.64353436826
Rred_1403 vin.$465.Metal1 vin.$714.Metal2 167.795194805
Rred_1404 vin.$468.Metal1 vin.$472.Metal1 0.17869514033
Rred_1405 vin.$468.Metal1 vin.$704.Metal2 49.8710046958
Rred_1406 vin.$468.Metal1 vin.$709.Metal2 10.1249863276
Rred_1407 vin.$468.Metal1 vin.$713.Metal2 82.6954323812
Rred_1408 vin.$472.Metal1 vin.$478.Metal1 0.36182906056
Rred_1409 vin.$472.Metal1 vin.$709.Metal2 23.404367655
Rred_1410 vin.$472.Metal1 vin.$713.Metal2 10.1801188009
Rred_1411 vin.$472.Metal1 vin.P38.GatPoly 828.565384617
Rred_1412 vin.$473.Metal1 vin.$477.Metal1 0.178146302595
Rred_1413 vin.$473.Metal1 vin.$710.Metal2 12.500592885
Rred_1414 vin.$473.Metal1 vin.$714.Metal2 19.8692706875
Rred_1415 vin.$473.Metal1 vin.P91.GatPoly 1994.17624435
Rred_1416 vin.$477.Metal1 vin.$483.Metal1 0.361706882048
Rred_1417 vin.$477.Metal1 vin.$714.Metal2 9.13694740583
Rred_1418 vin.$477.Metal1 vin.$719.Metal2 22.5992068453
Rred_1419 vin.$478.Metal1 vin.$482.Metal1 0.178473446512
Rred_1420 vin.$478.Metal1 vin.$713.Metal2 11.1405632121
Rred_1421 vin.$478.Metal1 vin.$716.Metal2 92.5320275164
Rred_1422 vin.$478.Metal1 vin.$720.Metal2 23.7694418686
Rred_1423 vin.$478.Metal1 vin.P39.GatPoly 200.932898256
Rred_1424 vin.$48.GatPoly vin.$52.GatPoly 10.9656296296
Rred_1425 vin.$48.GatPoly vin.P10.GatPoly 36.6153846154
Rred_1426 vin.$48.GatPoly vin.P9.GatPoly 328.664269231
Rred_1427 vin.$482.Metal1 vin.$486.Metal1 0.178938945578
Rred_1428 vin.$482.Metal1 vin.$713.Metal2 117.925826367
Rred_1429 vin.$482.Metal1 vin.$716.Metal2 391.481654878
Rred_1430 vin.$482.Metal1 vin.$720.Metal2 13.0511502574
Rred_1431 vin.$482.Metal1 vin.P39.GatPoly 348.402139501
Rred_1432 vin.$483.Metal1 vin.$487.Metal1 0.178930622025
Rred_1433 vin.$483.Metal1 vin.$719.Metal2 10.1926194517
Rred_1434 vin.$483.Metal1 vin.$723.Metal2 348.233889008
Rred_1435 vin.$483.Metal1 vin.$726.Metal2 32.9680444102
Rred_1436 vin.$483.Metal1 vin.P93.GatPoly 1994.17624435
Rred_1437 vin.$486.Metal1 vin.$494.Metal1 0.362506251039
Rred_1438 vin.$486.Metal1 vin.$720.Metal2 22.7740476191
Rred_1439 vin.$486.Metal1 vin.$725.Metal2 12.2050980368
Rred_1440 vin.$486.Metal1 vin.$729.Metal2 193.567386817
Rred_1441 vin.$487.Metal1 vin.$495.Metal1 0.362518504504
Rred_1442 vin.$487.Metal1 vin.$719.Metal2 46.2697520712
Rred_1443 vin.$487.Metal1 vin.$723.Metal2 528.799609235
Rred_1444 vin.$487.Metal1 vin.$726.Metal2 10.3368044108
Rred_1445 vin.$487.Metal1 vin.$728.Metal2 95.8265697221
Rred_1446 vin.$49.GatPoly vin.$53.GatPoly 10.9656296296
Rred_1447 vin.$49.GatPoly vin.P63.GatPoly 791.023243591
Rred_1448 vin.$49.GatPoly vin.P64.GatPoly 90.4615384615
Rred_1449 vin.$494.Metal1 vin.$500.Metal1 0.36182906056
Rred_1450 vin.$494.Metal1 vin.$725.Metal2 12.1296684265
Rred_1451 vin.$494.Metal1 vin.$729.Metal2 9.66978734276
Rred_1452 vin.$494.Metal1 vin.P41.GatPoly 736.257692309
Rred_1453 vin.$494.Metal1 vin.P42.GatPoly 736.257692309
Rred_1454 vin.$495.Metal1 vin.$501.Metal1 0.361808906517
Rred_1455 vin.$495.Metal1 vin.$726.Metal2 30.3840343021
Rred_1456 vin.$495.Metal1 vin.$728.Metal2 8.66375909208
Rred_1457 vin.$495.Metal1 vin.$733.Metal2 26.1745008426
Rred_1458 vin.$495.Metal1 vin.P95.GatPoly 1766.1219457
Rred_1459 vin.$495.Metal1 vin.P96.GatPoly 1766.1219457
Rred_1460 vin.$5.GatPoly vin.$566.Metal2 941.458403431
Rred_1461 vin.$5.GatPoly vin.P54.GatPoly 204.299740027
Rred_1462 vin.$5.GatPoly vin.P55.GatPoly 90.4615384615
Rred_1463 vin.$5.GatPoly vin.P56.GatPoly 320.463263377
Rred_1464 vin.$500.Metal1 vin.$504.Metal1 0.178533703869
Rred_1465 vin.$500.Metal1 vin.$729.Metal2 11.0685792568
Rred_1466 vin.$500.Metal1 vin.$732.Metal2 101.053367196
Rred_1467 vin.$500.Metal1 vin.$736.Metal2 24.5365418471
Rred_1468 vin.$500.Metal1 vin.P43.GatPoly 200.932898256
Rred_1469 vin.$501.Metal1 vin.$505.Metal1 0.178696643622
Rred_1470 vin.$501.Metal1 vin.$728.Metal2 63.1435956815
Rred_1471 vin.$501.Metal1 vin.$733.Metal2 10.7554280734
Rred_1472 vin.$501.Metal1 vin.$737.Metal2 31.207490764
Rred_1473 vin.$504.Metal1 vin.$508.Metal1 0.17895723734
Rred_1474 vin.$504.Metal1 vin.$729.Metal2 101.4095389
Rred_1475 vin.$504.Metal1 vin.$732.Metal2 357.055230761
Rred_1476 vin.$504.Metal1 vin.$736.Metal2 13.3416719486
Rred_1477 vin.$504.Metal1 vin.P43.GatPoly 348.402139501
Rred_1478 vin.$505.Metal1 vin.$509.Metal1 0.178784446269
Rred_1479 vin.$505.Metal1 vin.$733.Metal2 65.8909378167
Rred_1480 vin.$505.Metal1 vin.$737.Metal2 13.795486134
Rred_1481 vin.$505.Metal1 vin.P98.GatPoly 807.890579942
Rred_1482 vin.$508.Metal1 vin.$516.Metal1 0.362414323399
Rred_1483 vin.$508.Metal1 vin.$736.Metal2 21.205591133
Rred_1484 vin.$508.Metal1 vin.$741.Metal2 12.5792995937
Rred_1485 vin.$508.Metal1 vin.$745.Metal2 228.703445732
Rred_1486 vin.$509.Metal1 vin.$517.Metal1 0.362424864042
Rred_1487 vin.$509.Metal1 vin.$737.Metal2 21.205591133
Rred_1488 vin.$509.Metal1 vin.$742.Metal2 13.3114811647
Rred_1489 vin.$509.Metal1 vin.$744.Metal2 113.220329428
Rred_1490 vin.$509.Metal1 vin.P98.GatPoly 465.932258437
Rred_1491 vin.$516.Metal1 vin.$522.Metal1 0.361824121591
Rred_1492 vin.$516.Metal1 vin.$741.Metal2 11.7795710108
Rred_1493 vin.$516.Metal1 vin.$745.Metal2 9.74250020188
Rred_1494 vin.$516.Metal1 vin.P45.GatPoly 736.257692309
Rred_1495 vin.$516.Metal1 vin.P46.GatPoly 736.257692309
Rred_1496 vin.$517.Metal1 vin.$523.Metal1 0.361804876079
Rred_1497 vin.$517.Metal1 vin.$742.Metal2 28.9633400862
Rred_1498 vin.$517.Metal1 vin.$744.Metal2 8.62059729263
Rred_1499 vin.$517.Metal1 vin.$749.Metal2 26.5036917885
Rred_1500 vin.$517.Metal1 vin.P100.GatPoly 1766.1219457
Rred_1501 vin.$517.Metal1 vin.P99.GatPoly 1766.1219457
Rred_1502 vin.$52.GatPoly vin.$58.GatPoly 17.8026479167
Rred_1503 vin.$52.GatPoly vin.$606.Metal2 1563.02782058
Rred_1504 vin.$52.GatPoly vin.P11.GatPoly 45.7113030919
Rred_1505 vin.$522.Metal1 vin.$526.Metal1 0.178749740367
Rred_1506 vin.$522.Metal1 vin.$745.Metal2 10.9966557164
Rred_1507 vin.$522.Metal1 vin.$748.Metal2 110.874442868
Rred_1508 vin.$522.Metal1 vin.$752.Metal2 25.3715455145
Rred_1509 vin.$523.Metal1 vin.$527.Metal1 0.178750987733
Rred_1510 vin.$523.Metal1 vin.$744.Metal2 64.1498607757
Rred_1511 vin.$523.Metal1 vin.$749.Metal2 10.8655968765
Rred_1512 vin.$523.Metal1 vin.$753.Metal2 31.6507620915
Rred_1513 vin.$526.Metal1 vin.$534.Metal1 0.362799427562
Rred_1514 vin.$526.Metal1 vin.$745.Metal2 88.7449946392
Rred_1515 vin.$526.Metal1 vin.$748.Metal2 332.623328602
Rred_1516 vin.$526.Metal1 vin.$752.Metal2 10.188086951
Rred_1517 vin.$526.Metal1 vin.$757.Metal2 54.2048156595
Rred_1518 vin.$526.Metal1 vin.P48.GatPoly 828.565384617
Rred_1519 vin.$527.Metal1 vin.$531.Metal1 0.178796617238
Rred_1520 vin.$527.Metal1 vin.$749.Metal2 59.0556902438
Rred_1521 vin.$527.Metal1 vin.$753.Metal2 14.1455098615
Rred_1522 vin.$527.Metal1 vin.P102.GatPoly 807.890579942
Rred_1523 vin.$53.GatPoly vin.$59.GatPoly 17.3428707176
Rred_1524 vin.$53.GatPoly vin.$605.Metal2 2146.2178343
Rred_1525 vin.$53.GatPoly vin.$609.Metal2 5866.32874709
Rred_1526 vin.$53.GatPoly vin.P65.GatPoly 110.017140972
Rred_1527 vin.$531.Metal1 vin.$539.Metal1 0.362318738522
Rred_1528 vin.$531.Metal1 vin.$753.Metal2 19.8388402458
Rred_1529 vin.$531.Metal1 vin.$758.Metal2 13.6089175956
Rred_1530 vin.$531.Metal1 vin.$760.Metal2 138.339881981
Rred_1531 vin.$531.Metal1 vin.P102.GatPoly 465.932258437
Rred_1532 vin.$534.Metal1 vin.$538.Metal1 0.178495927512
Rred_1533 vin.$534.Metal1 vin.$752.Metal2 40.2164761345
Rred_1534 vin.$534.Metal1 vin.$757.Metal2 10.1085504235
Rred_1535 vin.$534.Metal1 vin.$761.Metal2 137.672069842
Rred_1536 vin.$538.Metal1 vin.$544.Metal1 0.361813012975
Rred_1537 vin.$538.Metal1 vin.$757.Metal2 21.0008242131
Rred_1538 vin.$538.Metal1 vin.$761.Metal2 10.1741903444
Rred_1539 vin.$538.Metal1 vin.P50.GatPoly 828.565384617
Rred_1540 vin.$539.Metal1 vin.$545.Metal1 0.361794737808
Rred_1541 vin.$539.Metal1 vin.$758.Metal2 27.6679763963
Rred_1542 vin.$539.Metal1 vin.$760.Metal2 8.57627169071
Rred_1543 vin.$539.Metal1 vin.$765.Metal2 26.8533413466
Rred_1544 vin.$539.Metal1 vin.P103.GatPoly 1766.1219457
Rred_1545 vin.$539.Metal1 vin.P104.GatPoly 1766.1219457
Rred_1546 vin.$544.Metal1 vin.$548.Metal1 0.178636120884
Rred_1547 vin.$544.Metal1 vin.$761.Metal2 10.9260734323
Rred_1548 vin.$544.Metal1 vin.$764.Metal2 122.290440486
Rred_1549 vin.$544.Metal1 vin.$768.Metal2 26.2825738712
Rred_1550 vin.$544.Metal1 vin.P51.GatPoly 200.932898256
Rred_1551 vin.$545.Metal1 vin.$549.Metal1 0.178626779495
Rred_1552 vin.$545.Metal1 vin.$760.Metal2 65.4755028827
Rred_1553 vin.$545.Metal1 vin.$765.Metal2 10.9591456504
Rred_1554 vin.$545.Metal1 vin.$769.Metal2 32.1907341548
Rred_1555 vin.$545.Metal1 vin.P105.GatPoly 465.932258437
Rred_1556 vin.$548.Metal1 vin.$761.Metal2 78.7158980701
Rred_1557 vin.$548.Metal1 vin.$764.Metal2 315.380609673
Rred_1558 vin.$548.Metal1 vin.$768.Metal2 3.83063139151
Rred_1559 vin.$548.Metal1 vin.$771.Metal2 18.6277036683
Rred_1560 vin.$548.Metal1 vin.P51.GatPoly 348.402139501
Rred_1561 vin.$548.Metal1 vin.P53.GatPoly 133.29643833
Rred_1562 vin.$549.Metal1 vin.$765.Metal2 53.658110783
Rred_1563 vin.$549.Metal1 vin.$769.Metal2 3.84695400156
Rred_1564 vin.$549.Metal1 vin.$771.Metal2 19.1743788885
Rred_1565 vin.$549.Metal1 vin.P105.GatPoly 807.890579942
Rred_1566 vin.$549.Metal1 vin.P107.GatPoly 260.717579368
Rred_1567 vin.$564.Metal2 vin.$566.Metal2 50.6531889782
Rred_1568 vin.$564.Metal2 vin.$569.Metal2 0.335118335775
Rred_1569 vin.$564.Metal2 vin.P0.GatPoly 1858.18363505
Rred_1570 vin.$566.Metal2 vin.$573.Metal2 0.458110588428
Rred_1571 vin.$566.Metal2 vin.P54.GatPoly 8948.51360459
Rred_1572 vin.$569.Metal2 vin.$573.Metal2 6.3337665336
Rred_1573 vin.$569.Metal2 vin.$574.Metal2 0.205715148004
Rred_1574 vin.$569.Metal2 vin.$581.Metal2 2.22408654344
Rred_1575 vin.$569.Metal2 vin.P0.GatPoly 30694.8024698
Rred_1576 vin.$573.Metal2 vin.$574.Metal2 3.46564583914
Rred_1577 vin.$573.Metal2 vin.$577.Metal2 0.245466436425
Rred_1578 vin.$573.Metal2 vin.$581.Metal2 0.677304164771
Rred_1579 vin.$574.Metal2 vin.$578.Metal2 0.364407819337
Rred_1580 vin.$574.Metal2 vin.$581.Metal2 1.21695301433
Rred_1581 vin.$577.Metal2 vin.$579.Metal2 0.1804
Rred_1582 vin.$578.Metal2 vin.$581.Metal2 0.319421998659
Rred_1583 vin.$578.Metal2 vin.$583.Metal2 0.195181446497
Rred_1584 vin.$579.Metal2 vin.$581.Metal2 0.319421998659
Rred_1585 vin.$579.Metal2 vin.$584.Metal2 0.195181446497
Rred_1586 vin.$58.GatPoly vin.$62.GatPoly 10.9656296296
Rred_1587 vin.$58.GatPoly vin.P11.GatPoly 328.664269231
Rred_1588 vin.$58.GatPoly vin.P12.GatPoly 36.6153846154
Rred_1589 vin.$581.Metal2 vin.$583.Metal2 2.06172380952
Rred_1590 vin.$581.Metal2 vin.$584.Metal2 2.06172380952
Rred_1591 vin.$581.Metal2 vin.$588.Metal2 0.088
Rred_1592 vin.$583.Metal2 vin.$588.Metal2 1.49558257747
Rred_1593 vin.$583.Metal2 vin.$590.Metal2 0.450513604278
Rred_1594 vin.$584.Metal2 vin.$589.Metal2 0.285864933995
Rred_1595 vin.$588.Metal2 vin.$589.Metal2 0.255619047619
Rred_1596 vin.$588.Metal2 vin.$590.Metal2 0.402847095849
Rred_1597 vin.$588.Metal2 vin.$597.Metal2 0.09152
Rred_1598 vin.$589.Metal2 vin.$593.Metal2 0.258928410828
Rred_1599 vin.$59.GatPoly vin.$63.GatPoly 10.9656296296
Rred_1600 vin.$59.GatPoly vin.P65.GatPoly 791.023243591
Rred_1601 vin.$59.GatPoly vin.P66.GatPoly 90.4615384615
Rred_1602 vin.$590.Metal2 vin.$594.Metal2 0.364406341099
Rred_1603 vin.$593.Metal2 vin.$595.Metal2 0.1804
Rred_1604 vin.$594.Metal2 vin.$597.Metal2 0.306933724723
Rred_1605 vin.$594.Metal2 vin.$599.Metal2 0.192833625428
Rred_1606 vin.$595.Metal2 vin.$597.Metal2 0.306933724723
Rred_1607 vin.$595.Metal2 vin.$600.Metal2 0.192833625428
Rred_1608 vin.$597.Metal2 vin.$599.Metal2 2.48957354497
Rred_1609 vin.$597.Metal2 vin.$600.Metal2 2.48957354497
Rred_1610 vin.$597.Metal2 vin.$604.Metal2 0.09108
Rred_1611 vin.$599.Metal2 vin.$604.Metal2 1.7084268448
Rred_1612 vin.$599.Metal2 vin.$606.Metal2 0.441110209927
Rred_1613 vin.$600.Metal2 vin.$605.Metal2 0.297085309378
Rred_1614 vin.$604.Metal2 vin.$605.Metal2 0.255619047619
Rred_1615 vin.$604.Metal2 vin.$606.Metal2 0.379541391638
Rred_1616 vin.$604.Metal2 vin.$613.Metal2 0.08844
Rred_1617 vin.$605.Metal2 vin.$609.Metal2 0.247710048541
Rred_1618 vin.$606.Metal2 vin.$610.Metal2 0.364404987112
Rred_1619 vin.$609.Metal2 vin.$611.Metal2 0.1804
Rred_1620 vin.$610.Metal2 vin.$613.Metal2 0.294876825397
Rred_1621 vin.$610.Metal2 vin.$615.Metal2 0.190334409503
Rred_1622 vin.$610.Metal2 vin.$62.GatPoly 3870.9558658
Rred_1623 vin.$611.Metal2 vin.$613.Metal2 0.282533707884
Rred_1624 vin.$611.Metal2 vin.$618.Metal2 0.385406216259
Rred_1625 vin.$613.Metal2 vin.$615.Metal2 3.15939455782
Rred_1626 vin.$613.Metal2 vin.$618.Metal2 6.3972188277
Rred_1627 vin.$613.Metal2 vin.$620.Metal2 0.08976
Rred_1628 vin.$615.Metal2 vin.$62.GatPoly 3870.9558658
Rred_1629 vin.$615.Metal2 vin.$620.Metal2 1.49559167249
Rred_1630 vin.$615.Metal2 vin.$622.Metal2 0.450516343968
Rred_1631 vin.$618.Metal2 vin.$620.Metal2 0.702278911565
Rred_1632 vin.$618.Metal2 vin.$623.Metal2 0.211547131148
Rred_1633 vin.$62.GatPoly vin.$68.GatPoly 17.8026479167
Rred_1634 vin.$62.GatPoly vin.P13.GatPoly 45.7113030919
Rred_1635 vin.$620.Metal2 vin.$622.Metal2 0.402847658567
Rred_1636 vin.$620.Metal2 vin.$623.Metal2 0.522973657548
Rred_1637 vin.$620.Metal2 vin.$629.Metal2 0.08976
Rred_1638 vin.$622.Metal2 vin.$626.Metal2 0.364403757096
Rred_1639 vin.$622.Metal2 vin.$72.GatPoly 1563.02782058
Rred_1640 vin.$623.Metal2 vin.$627.Metal2 0.364403757096
Rred_1641 vin.$623.Metal2 vin.$73.GatPoly 1563.02782058
Rred_1642 vin.$626.Metal2 vin.$629.Metal2 0.283217687075
Rred_1643 vin.$626.Metal2 vin.$631.Metal2 0.187683793112
Rred_1644 vin.$626.Metal2 vin.$82.GatPoly 3604.42265737
Rred_1645 vin.$627.Metal2 vin.$629.Metal2 0.274739305706
Rred_1646 vin.$627.Metal2 vin.$634.Metal2 0.379597777432
Rred_1647 vin.$629.Metal2 vin.$631.Metal2 4.36155238095
Rred_1648 vin.$629.Metal2 vin.$634.Metal2 8.82112930413
Rred_1649 vin.$629.Metal2 vin.$636.Metal2 0.08976
Rred_1650 vin.$63.GatPoly vin.$69.GatPoly 17.3428707176
Rred_1651 vin.$63.GatPoly vin.P67.GatPoly 110.017140972
Rred_1652 vin.$631.Metal2 vin.$636.Metal2 1.42571817879
Rred_1653 vin.$631.Metal2 vin.$638.Metal2 0.454009436444
Rred_1654 vin.$631.Metal2 vin.$82.GatPoly 4180.13309525
Rred_1655 vin.$634.Metal2 vin.$636.Metal2 0.665507078507
Rred_1656 vin.$634.Metal2 vin.$639.Metal2 0.211925819672
Rred_1657 vin.$636.Metal2 vin.$638.Metal2 0.41244521726
Rred_1658 vin.$636.Metal2 vin.$639.Metal2 0.547194708995
Rred_1659 vin.$636.Metal2 vin.$645.Metal2 0.08976
Rred_1660 vin.$638.Metal2 vin.$642.Metal2 0.3644026508
Rred_1661 vin.$638.Metal2 vin.$92.GatPoly 1611.09899248
Rred_1662 vin.$639.Metal2 vin.$643.Metal2 0.3644026508
Rred_1663 vin.$639.Metal2 vin.$93.GatPoly 1611.09899248
Rred_1664 vin.$642.Metal2 vin.$645.Metal2 0.27192610006
Rred_1665 vin.$642.Metal2 vin.$647.Metal2 0.184881770143
Rred_1666 vin.$643.Metal2 vin.$645.Metal2 0.267030077807
Rred_1667 vin.$643.Metal2 vin.$650.Metal2 0.373634951922
Rred_1668 vin.$645.Metal2 vin.$647.Metal2 7.16072063492
Rred_1669 vin.$645.Metal2 vin.$650.Metal2 14.4709409951
Rred_1670 vin.$645.Metal2 vin.$652.Metal2 0.08976
Rred_1671 vin.$647.Metal2 vin.$652.Metal2 1.3625513426
Rred_1672 vin.$647.Metal2 vin.$654.Metal2 0.457348176062
Rred_1673 vin.$650.Metal2 vin.$652.Metal2 0.632055433455
Rred_1674 vin.$650.Metal2 vin.$655.Metal2 0.212153032787
Rred_1675 vin.$652.Metal2 vin.$654.Metal2 0.422211350255
Rred_1676 vin.$652.Metal2 vin.$655.Metal2 0.57325957918
Rred_1677 vin.$652.Metal2 vin.$659.Metal2 0.088
Rred_1678 vin.$654.Metal2 vin.$659.Metal2 14.4710043426
Rred_1679 vin.$654.Metal2 vin.$661.Metal2 0.373636587535
Rred_1680 vin.$655.Metal2 vin.$659.Metal2 14.4710043426
Rred_1681 vin.$655.Metal2 vin.$662.Metal2 0.373636587535
Rred_1682 vin.$659.Metal2 vin.$661.Metal2 0.267030098853
Rred_1683 vin.$659.Metal2 vin.$662.Metal2 0.267030098853
Rred_1684 vin.$659.Metal2 vin.$668.Metal2 0.09152
Rred_1685 vin.$661.Metal2 vin.$665.Metal2 0.364386821574
Rred_1686 vin.$662.Metal2 vin.$666.Metal2 0.364386821574
Rred_1687 vin.$665.Metal2 vin.$668.Metal2 0.601438095238
Rred_1688 vin.$665.Metal2 vin.$670.Metal2 0.212228770492
Rred_1689 vin.$666.Metal2 vin.$668.Metal2 0.601438095238
Rred_1690 vin.$666.Metal2 vin.$671.Metal2 0.212228770492
Rred_1691 vin.$668.Metal2 vin.$670.Metal2 0.601438095238
Rred_1692 vin.$668.Metal2 vin.$671.Metal2 0.601438095238
Rred_1693 vin.$668.Metal2 vin.$676.Metal2 0.09108
Rred_1694 vin.$670.Metal2 vin.$674.Metal2 0.364400808481
Rred_1695 vin.$671.Metal2 vin.$678.Metal2 0.364400808481
Rred_1696 vin.$674.Metal2 vin.$676.Metal2 0.266409523809
Rred_1697 vin.$674.Metal2 vin.$679.Metal2 0.183424284565
Rred_1698 vin.$676.Metal2 vin.$678.Metal2 0.263206418419
Rred_1699 vin.$676.Metal2 vin.$679.Metal2 10.6563809524
Rred_1700 vin.$676.Metal2 vin.$682.Metal2 21.5299154869
Rred_1701 vin.$676.Metal2 vin.$684.Metal2 0.08844
Rred_1702 vin.$678.Metal2 vin.$682.Metal2 0.370596905922
Rred_1703 vin.$679.Metal2 vin.$681.Metal2 0.1804
Rred_1704 vin.$68.GatPoly vin.$72.GatPoly 10.9656296296
Rred_1705 vin.$68.GatPoly vin.P13.GatPoly 328.664269231
Rred_1706 vin.$68.GatPoly vin.P14.GatPoly 36.6153846154
Rred_1707 vin.$681.Metal2 vin.$684.Metal2 0.422211350255
Rred_1708 vin.$681.Metal2 vin.$688.Metal2 0.457348176062
Rred_1709 vin.$682.Metal2 vin.$684.Metal2 0.57325957918
Rred_1710 vin.$682.Metal2 vin.$687.Metal2 0.212153032787
Rred_1711 vin.$684.Metal2 vin.$687.Metal2 0.632055433455
Rred_1712 vin.$684.Metal2 vin.$688.Metal2 1.3625513426
Rred_1713 vin.$684.Metal2 vin.$691.Metal2 0.08976
Rred_1714 vin.$687.Metal2 vin.$691.Metal2 14.4709409951
Rred_1715 vin.$687.Metal2 vin.$694.Metal2 0.373634951922
Rred_1716 vin.$688.Metal2 vin.$691.Metal2 7.16072063492
Rred_1717 vin.$688.Metal2 vin.$693.Metal2 0.184881770143
Rred_1718 vin.$69.GatPoly vin.$73.GatPoly 10.9656296296
Rred_1719 vin.$69.GatPoly vin.P67.GatPoly 791.023243591
Rred_1720 vin.$69.GatPoly vin.P68.GatPoly 90.4615384615
Rred_1721 vin.$691.Metal2 vin.$693.Metal2 0.27192610006
Rred_1722 vin.$691.Metal2 vin.$694.Metal2 0.267030077807
Rred_1723 vin.$691.Metal2 vin.$700.Metal2 0.08976
Rred_1724 vin.$693.Metal2 vin.$697.Metal2 0.3644026508
Rred_1725 vin.$694.Metal2 vin.$698.Metal2 0.364390797146
Rred_1726 vin.$697.Metal2 vin.$700.Metal2 0.41244521726
Rred_1727 vin.$697.Metal2 vin.$704.Metal2 0.454009436444
Rred_1728 vin.$698.Metal2 vin.$700.Metal2 0.547194708995
Rred_1729 vin.$698.Metal2 vin.$703.Metal2 0.211925819672
Rred_1730 vin.$700.Metal2 vin.$703.Metal2 0.665507078507
Rred_1731 vin.$700.Metal2 vin.$704.Metal2 1.42571817879
Rred_1732 vin.$700.Metal2 vin.$707.Metal2 0.08976
Rred_1733 vin.$703.Metal2 vin.$707.Metal2 8.82112930413
Rred_1734 vin.$703.Metal2 vin.$710.Metal2 0.379597777432
Rred_1735 vin.$704.Metal2 vin.$707.Metal2 4.36155238095
Rred_1736 vin.$704.Metal2 vin.$709.Metal2 0.187683793112
Rred_1737 vin.$707.Metal2 vin.$709.Metal2 0.283217687075
Rred_1738 vin.$707.Metal2 vin.$710.Metal2 0.274739305706
Rred_1739 vin.$707.Metal2 vin.$716.Metal2 0.08976
Rred_1740 vin.$709.Metal2 vin.$713.Metal2 0.364403757096
Rred_1741 vin.$710.Metal2 vin.$714.Metal2 0.36439306326
Rred_1742 vin.$713.Metal2 vin.$716.Metal2 0.402847658567
Rred_1743 vin.$713.Metal2 vin.$720.Metal2 0.450516343968
Rred_1744 vin.$714.Metal2 vin.$716.Metal2 0.522973657548
Rred_1745 vin.$714.Metal2 vin.$719.Metal2 0.211547131148
Rred_1746 vin.$716.Metal2 vin.$719.Metal2 0.702278911565
Rred_1747 vin.$716.Metal2 vin.$720.Metal2 1.49559167249
Rred_1748 vin.$716.Metal2 vin.$723.Metal2 0.088
Rred_1749 vin.$719.Metal2 vin.$723.Metal2 4.18877887241
Rred_1750 vin.$719.Metal2 vin.$726.Metal2 0.396560622757
Rred_1751 vin.$72.GatPoly vin.$78.GatPoly 17.8026479167
Rred_1752 vin.$72.GatPoly vin.P15.GatPoly 45.7113030919
Rred_1753 vin.$720.Metal2 vin.$723.Metal2 2.06172380952
Rred_1754 vin.$720.Metal2 vin.$725.Metal2 0.195187786885
Rred_1755 vin.$723.Metal2 vin.$725.Metal2 0.319421998659
Rred_1756 vin.$723.Metal2 vin.$726.Metal2 0.298391583284
Rred_1757 vin.$723.Metal2 vin.$732.Metal2 0.09152
Rred_1758 vin.$725.Metal2 vin.$729.Metal2 0.36439551537
Rred_1759 vin.$726.Metal2 vin.$728.Metal2 0.180395948068
Rred_1760 vin.$728.Metal2 vin.$733.Metal2 0.254441053395
Rred_1761 vin.$729.Metal2 vin.$732.Metal2 0.393410848474
Rred_1762 vin.$729.Metal2 vin.$736.Metal2 0.446868900937
Rred_1763 vin.$73.GatPoly vin.$79.GatPoly 17.3428707176
Rred_1764 vin.$73.GatPoly vin.P69.GatPoly 110.017140972
Rred_1765 vin.$732.Metal2 vin.$733.Metal2 0.255619047619
Rred_1766 vin.$732.Metal2 vin.$736.Metal2 1.57339122408
Rred_1767 vin.$732.Metal2 vin.$739.Metal2 0.09108
Rred_1768 vin.$733.Metal2 vin.$737.Metal2 0.290353464606
Rred_1769 vin.$736.Metal2 vin.$739.Metal2 3.66066031746
Rred_1770 vin.$736.Metal2 vin.$741.Metal2 0.189034098361
Rred_1771 vin.$737.Metal2 vin.$739.Metal2 3.66066031746
Rred_1772 vin.$737.Metal2 vin.$742.Metal2 0.189034098361
Rred_1773 vin.$739.Metal2 vin.$741.Metal2 0.288999498747
Rred_1774 vin.$739.Metal2 vin.$742.Metal2 0.288999498747
Rred_1775 vin.$739.Metal2 vin.$748.Metal2 0.08844
Rred_1776 vin.$741.Metal2 vin.$745.Metal2 0.364398153856
Rred_1777 vin.$742.Metal2 vin.$744.Metal2 0.180396403258
Rred_1778 vin.$744.Metal2 vin.$749.Metal2 0.249953735305
Rred_1779 vin.$745.Metal2 vin.$748.Metal2 0.384127438304
Rred_1780 vin.$745.Metal2 vin.$752.Metal2 0.443067109062
Rred_1781 vin.$748.Metal2 vin.$749.Metal2 0.255619047619
Rred_1782 vin.$748.Metal2 vin.$752.Metal2 1.66065091569
Rred_1783 vin.$748.Metal2 vin.$755.Metal2 0.08976
Rred_1784 vin.$749.Metal2 vin.$753.Metal2 0.294840673058
Rred_1785 vin.$752.Metal2 vin.$755.Metal2 2.06172380952
Rred_1786 vin.$752.Metal2 vin.$757.Metal2 0.195181446497
Rred_1787 vin.$753.Metal2 vin.$755.Metal2 2.06172380952
Rred_1788 vin.$753.Metal2 vin.$758.Metal2 0.195187786885
Rred_1789 vin.$755.Metal2 vin.$757.Metal2 0.319421998659
Rred_1790 vin.$755.Metal2 vin.$758.Metal2 0.319421998659
Rred_1791 vin.$755.Metal2 vin.$764.Metal2 0.08976
Rred_1792 vin.$757.Metal2 vin.$761.Metal2 0.364407819337
Rred_1793 vin.$758.Metal2 vin.$760.Metal2 0.180396919426
Rred_1794 vin.$760.Metal2 vin.$765.Metal2 0.245466436425
Rred_1795 vin.$761.Metal2 vin.$764.Metal2 0.374990520605
Rred_1796 vin.$761.Metal2 vin.$768.Metal2 0.439110969464
Rred_1797 vin.$764.Metal2 vin.$765.Metal2 0.255619047619
Rred_1798 vin.$764.Metal2 vin.$768.Metal2 1.75932802215
Rred_1799 vin.$764.Metal2 vin.$771.Metal2 0.0933293598967
Rred_1800 vin.$765.Metal2 vin.$769.Metal2 0.299327907363
Rred_1801 vin.$768.Metal2 vin.$771.Metal2 0.556550225703
Rred_1802 vin.$768.Metal2 vin.P53.GatPoly 2356.14988468
Rred_1803 vin.$769.Metal2 vin.$771.Metal2 0.573183175709
Rred_1804 vin.$769.Metal2 vin.P107.GatPoly 4567.2522625
Rred_1805 vin.$771.Metal2 vin.P107.GatPoly 14792.0621136
Rred_1806 vin.$771.Metal2 vin.P53.GatPoly 7343.12396728
Rred_1807 vin.$78.GatPoly vin.$82.GatPoly 10.9656296296
Rred_1808 vin.$78.GatPoly vin.P15.GatPoly 328.664269231
Rred_1809 vin.$78.GatPoly vin.P16.GatPoly 36.6153846154
Rred_1810 vin.$79.GatPoly vin.$83.GatPoly 10.9656296296
Rred_1811 vin.$79.GatPoly vin.P69.GatPoly 791.023243591
Rred_1812 vin.$79.GatPoly vin.P70.GatPoly 90.4615384615
Rred_1813 vin.$82.GatPoly vin.$88.GatPoly 17.8026479167
Rred_1814 vin.$82.GatPoly vin.P17.GatPoly 45.7113030919
Rred_1815 vin.$83.GatPoly vin.$89.GatPoly 17.3428707176
Rred_1816 vin.$83.GatPoly vin.P71.GatPoly 110.017140972
Rred_1817 vin.$88.GatPoly vin.$92.GatPoly 10.9656296296
Rred_1818 vin.$88.GatPoly vin.P17.GatPoly 328.664269231
Rred_1819 vin.$88.GatPoly vin.P18.GatPoly 36.6153846154
Rred_1820 vin.$89.GatPoly vin.$93.GatPoly 10.9656296296
Rred_1821 vin.$89.GatPoly vin.P71.GatPoly 791.023243591
Rred_1822 vin.$89.GatPoly vin.P72.GatPoly 90.4615384615
Rred_1823 vin.$92.GatPoly vin.$98.GatPoly 17.8026479167
Rred_1824 vin.$92.GatPoly vin.P19.GatPoly 45.7113030919
Rred_1825 vin.$93.GatPoly vin.$99.GatPoly 17.3428707176
Rred_1826 vin.$93.GatPoly vin.P73.GatPoly 110.017140972
Rred_1827 vin.$98.GatPoly vin.P19.GatPoly 328.664269231
Rred_1828 vin.$98.GatPoly vin.P20.GatPoly 36.6153846154
Rred_1829 vin.$99.GatPoly vin.P73.GatPoly 791.023243591
Rred_1830 vin.$99.GatPoly vin.P74.GatPoly 90.4615384615
Rred_1831 vin.P100.GatPoly vin.P99.GatPoly 43304.8572569
Rred_1832 vin.P103.GatPoly vin.P104.GatPoly 43304.8572569
Rred_1833 vin.P29.GatPoly vin.P30.GatPoly 7480.94450594
Rred_1834 vin.P41.GatPoly vin.P42.GatPoly 7480.94450594
Rred_1835 vin.P45.GatPoly vin.P46.GatPoly 7480.94450594
Rred_1836 vin.P95.GatPoly vin.P96.GatPoly 43304.8572569
Rred_1837 vout vout.$1170.Metal3 0.06776
Rred_1838 vout vout.P52.nSD 15.0304370708
Rred_1839 vout vout.P52.pSD 5.59638619332
Rred_1840 vout.$1008.Metal3 vout.$1026.Metal3 0.18152184601
Rred_1841 vout.$1008.Metal3 vout.$990.Metal3 0.18152184601
Rred_1842 vout.$1008.Metal3 vout.P12.nSD 30.2181234512
Rred_1843 vout.$1008.Metal3 vout.P12.pSD 11.1396215502
Rred_1844 vout.$1008.Metal3 vout.P14.nSD 14.9424370708
Rred_1845 vout.$1008.Metal3 vout.P14.pSD 5.50838619332
Rred_1846 vout.$1008.Metal3 vout.P16.nSD 30.2181234512
Rred_1847 vout.$1008.Metal3 vout.P16.pSD 11.1396215502
Rred_1848 vout.$1026.Metal3 vout.$1044.Metal3 0.18152184601
Rred_1849 vout.$1026.Metal3 vout.P16.nSD 30.2181234512
Rred_1850 vout.$1026.Metal3 vout.P16.pSD 11.1396215502
Rred_1851 vout.$1026.Metal3 vout.P18.nSD 14.9424370708
Rred_1852 vout.$1026.Metal3 vout.P18.pSD 5.50838619332
Rred_1853 vout.$1026.Metal3 vout.P20.nSD 30.2181234512
Rred_1854 vout.$1026.Metal3 vout.P20.pSD 11.1396215502
Rred_1855 vout.$1044.Metal3 vout.$1062.Metal3 0.18152184601
Rred_1856 vout.$1044.Metal3 vout.P20.nSD 30.2181234512
Rred_1857 vout.$1044.Metal3 vout.P20.pSD 11.1396215502
Rred_1858 vout.$1044.Metal3 vout.P22.nSD 14.9424370708
Rred_1859 vout.$1044.Metal3 vout.P22.pSD 5.50838619332
Rred_1860 vout.$1044.Metal3 vout.P24.nSD 30.2181234512
Rred_1861 vout.$1044.Metal3 vout.P24.pSD 11.1396215502
Rred_1862 vout.$1062.Metal3 vout.$1080.Metal3 0.18152184601
Rred_1863 vout.$1062.Metal3 vout.P24.nSD 30.2181234512
Rred_1864 vout.$1062.Metal3 vout.P24.pSD 11.1396215502
Rred_1865 vout.$1062.Metal3 vout.P26.nSD 14.9424370708
Rred_1866 vout.$1062.Metal3 vout.P26.pSD 5.50838619332
Rred_1867 vout.$1062.Metal3 vout.P28.nSD 30.2181234512
Rred_1868 vout.$1062.Metal3 vout.P28.pSD 11.1396215502
Rred_1869 vout.$1080.Metal3 vout.$1098.Metal3 0.18152184601
Rred_1870 vout.$1080.Metal3 vout.P28.nSD 30.2181234512
Rred_1871 vout.$1080.Metal3 vout.P28.pSD 11.1396215502
Rred_1872 vout.$1080.Metal3 vout.P30.nSD 14.9424370708
Rred_1873 vout.$1080.Metal3 vout.P30.pSD 5.50838619332
Rred_1874 vout.$1080.Metal3 vout.P32.nSD 30.2181234512
Rred_1875 vout.$1080.Metal3 vout.P32.pSD 11.1396215502
Rred_1876 vout.$1098.Metal3 vout.$1116.Metal3 0.18152184601
Rred_1877 vout.$1098.Metal3 vout.P32.nSD 30.2181234512
Rred_1878 vout.$1098.Metal3 vout.P32.pSD 11.1396215502
Rred_1879 vout.$1098.Metal3 vout.P34.nSD 14.9424370708
Rred_1880 vout.$1098.Metal3 vout.P34.pSD 5.50838619332
Rred_1881 vout.$1098.Metal3 vout.P36.nSD 30.2181234512
Rred_1882 vout.$1098.Metal3 vout.P36.pSD 11.1396215502
Rred_1883 vout.$1116.Metal3 vout.$1134.Metal3 0.18152184601
Rred_1884 vout.$1116.Metal3 vout.P36.nSD 30.2181234512
Rred_1885 vout.$1116.Metal3 vout.P36.pSD 11.1396215502
Rred_1886 vout.$1116.Metal3 vout.P38.nSD 14.9424370708
Rred_1887 vout.$1116.Metal3 vout.P38.pSD 5.50838619332
Rred_1888 vout.$1116.Metal3 vout.P40.nSD 30.2181234512
Rred_1889 vout.$1116.Metal3 vout.P40.pSD 11.1396215502
Rred_1890 vout.$1134.Metal3 vout.$1152.Metal3 0.18152184601
Rred_1891 vout.$1134.Metal3 vout.P40.nSD 30.2181234512
Rred_1892 vout.$1134.Metal3 vout.P40.pSD 11.1396215502
Rred_1893 vout.$1134.Metal3 vout.P42.nSD 14.9424370708
Rred_1894 vout.$1134.Metal3 vout.P42.pSD 5.50838619332
Rred_1895 vout.$1134.Metal3 vout.P44.nSD 30.2181234512
Rred_1896 vout.$1134.Metal3 vout.P44.pSD 11.1396215502
Rred_1897 vout.$1152.Metal3 vout.$1170.Metal3 0.18152184601
Rred_1898 vout.$1152.Metal3 vout.P44.nSD 30.2181234512
Rred_1899 vout.$1152.Metal3 vout.P44.pSD 11.1396215502
Rred_1900 vout.$1152.Metal3 vout.P46.nSD 14.9424370708
Rred_1901 vout.$1152.Metal3 vout.P46.pSD 5.50838619332
Rred_1902 vout.$1152.Metal3 vout.P48.nSD 30.2181234512
Rred_1903 vout.$1152.Metal3 vout.P48.pSD 11.1396215502
Rred_1904 vout.$1170.Metal3 vout.P48.nSD 30.2181234512
Rred_1905 vout.$1170.Metal3 vout.P48.pSD 11.1396215502
Rred_1906 vout.$1170.Metal3 vout.P50.nSD 14.9424370708
Rred_1907 vout.$1170.Metal3 vout.P50.pSD 5.50838619332
Rred_1908 vout.$954.Metal3 vout.$972.Metal3 0.18152184601
Rred_1909 vout.$954.Metal3 vout.P0.nSD 15.2801827988
Rred_1910 vout.$954.Metal3 vout.P0.pSD 5.68937574099
Rred_1911 vout.$954.Metal3 vout.P2.nSD 14.9424370708
Rred_1912 vout.$954.Metal3 vout.P2.pSD 5.50838619332
Rred_1913 vout.$954.Metal3 vout.P4.nSD 30.2181234512
Rred_1914 vout.$954.Metal3 vout.P4.pSD 11.1396215502
Rred_1915 vout.$972.Metal3 vout.$990.Metal3 0.18152184601
Rred_1916 vout.$972.Metal3 vout.P4.nSD 30.2181234512
Rred_1917 vout.$972.Metal3 vout.P4.pSD 11.1396215502
Rred_1918 vout.$972.Metal3 vout.P6.nSD 14.9424370708
Rred_1919 vout.$972.Metal3 vout.P6.pSD 5.50838619332
Rred_1920 vout.$972.Metal3 vout.P8.nSD 30.2181234512
Rred_1921 vout.$972.Metal3 vout.P8.pSD 11.1396215502
Rred_1922 vout.$990.Metal3 vout.P10.nSD 14.9424370708
Rred_1923 vout.$990.Metal3 vout.P10.pSD 5.50838619332
Rred_1924 vout.$990.Metal3 vout.P12.nSD 30.2181234512
Rred_1925 vout.$990.Metal3 vout.P12.pSD 11.1396215502
Rred_1926 vout.$990.Metal3 vout.P8.nSD 30.2181234512
Rred_1927 vout.$990.Metal3 vout.P8.pSD 11.1396215502
Rred_1928 vout.P0.nSD vout.P0.pSD 1262.01009514
Rred_1929 vout.P12.nSD vout.P12.pSD 1854.42395284
Rred_1930 vout.P16.nSD vout.P16.pSD 1854.42395284
Rred_1931 vout.P20.nSD vout.P20.pSD 1854.42395284
Rred_1932 vout.P24.nSD vout.P24.pSD 1854.42395284
Rred_1933 vout.P28.nSD vout.P28.pSD 1854.42395284
Rred_1934 vout.P32.nSD vout.P32.pSD 1854.42395284
Rred_1935 vout.P36.nSD vout.P36.pSD 1854.42395284
Rred_1936 vout.P4.nSD vout.P4.pSD 1854.42395284
Rred_1937 vout.P40.nSD vout.P40.pSD 1854.42395284
Rred_1938 vout.P44.nSD vout.P44.pSD 1854.42395284
Rred_1939 vout.P48.nSD vout.P48.pSD 1854.42395284
Rred_1940 vout.P8.nSD vout.P8.pSD 1854.42395284
Rred_1941 VSS VSS.$254.Metal1 0.0432441175152
Rred_1942 VSS VSS.$270.Metal1 0.0432441175152
Rred_1943 VSS VSS.$713.Metal2 6.50578469474
Rred_1944 VSS VSS.$721.Metal2 6.50578469474
Rred_1945 VSS VSS.$982.Metal3 1131.50554324
Rred_1946 VSS VSS.P0.pSD 24.1135601645
Rred_1947 VSS.$1002.Metal3 VSS.$1008.Metal3 0.109399445083
Rred_1948 VSS.$1002.Metal3 VSS.$332.Metal1 1131.50554324
Rred_1949 VSS.$1002.Metal3 VSS.$765.Metal2 4.52704202798
Rred_1950 VSS.$1002.Metal3 VSS.$773.Metal2 3.88510981734
Rred_1951 VSS.$1002.Metal3 VSS.$780.Metal2 13.6446092814
Rred_1952 VSS.$1002.Metal3 VSS.$998.Metal3 0.0724492814222
Rred_1953 VSS.$1008.Metal3 VSS.$1012.Metal3 0.0724492814222
Rred_1954 VSS.$1008.Metal3 VSS.$773.Metal2 13.6446092814
Rred_1955 VSS.$1008.Metal3 VSS.$780.Metal2 6.79506398421
Rred_1956 VSS.$1008.Metal3 VSS.$784.Metal2 4.5
Rred_1957 VSS.$1008.Metal3 VSS.$791.Metal2 9.03608
Rred_1958 VSS.$1012.Metal3 VSS.$1018.Metal3 0.109399445083
Rred_1959 VSS.$1012.Metal3 VSS.$366.Metal1 1131.50554324
Rred_1960 VSS.$1012.Metal3 VSS.$791.Metal2 4.52704202798
Rred_1961 VSS.$1012.Metal3 VSS.$799.Metal2 3.88510981734
Rred_1962 VSS.$1012.Metal3 VSS.$806.Metal2 13.6446092814
Rred_1963 VSS.$1018.Metal3 VSS.$1022.Metal3 0.0724492814222
Rred_1964 VSS.$1018.Metal3 VSS.$799.Metal2 13.6446092814
Rred_1965 VSS.$1018.Metal3 VSS.$806.Metal2 6.79506398421
Rred_1966 VSS.$1018.Metal3 VSS.$810.Metal2 4.5
Rred_1967 VSS.$1018.Metal3 VSS.$817.Metal2 9.03608
Rred_1968 VSS.$102.Metal1 VSS.$118.Metal1 0.0872287793389
Rred_1969 VSS.$102.Metal1 VSS.$591.Metal2 3.83482751327
Rred_1970 VSS.$102.Metal1 VSS.$598.Metal2 4.51517461661
Rred_1971 VSS.$102.Metal1 VSS.$602.Metal2 13.2485154879
Rred_1972 VSS.$102.Metal1 VSS.$94.Metal1 0.0475220913035
Rred_1973 VSS.$102.Metal1 VSS.P0.pSD 7.45252628727
Rred_1974 VSS.$102.Metal1 VSS.P10.nSD 7.01668962813
Rred_1975 VSS.$1022.Metal3 VSS.$1028.Metal3 0.109399445083
Rred_1976 VSS.$1022.Metal3 VSS.$400.Metal1 1131.50554324
Rred_1977 VSS.$1022.Metal3 VSS.$817.Metal2 4.52704202798
Rred_1978 VSS.$1022.Metal3 VSS.$825.Metal2 3.88510981734
Rred_1979 VSS.$1022.Metal3 VSS.$832.Metal2 13.6446092814
Rred_1980 VSS.$1028.Metal3 VSS.$1036.Metal3 0.147222110321
Rred_1981 VSS.$1028.Metal3 VSS.$434.Metal1 2299.30001576
Rred_1982 VSS.$1028.Metal3 VSS.$825.Metal2 13.6446092814
Rred_1983 VSS.$1028.Metal3 VSS.$832.Metal2 6.79506398421
Rred_1984 VSS.$1028.Metal3 VSS.$836.Metal2 4.5
Rred_1985 VSS.$1028.Metal3 VSS.$843.Metal2 4.55847300828
Rred_1986 VSS.$1028.Metal3 VSS.$851.Metal2 9.19927248124
Rred_1987 VSS.$1036.Metal3 VSS.$1042.Metal3 0.109399445083
Rred_1988 VSS.$1036.Metal3 VSS.$434.Metal1 2299.30001576
Rred_1989 VSS.$1036.Metal3 VSS.$843.Metal2 9.19927248124
Rred_1990 VSS.$1036.Metal3 VSS.$851.Metal2 4.55847300828
Rred_1991 VSS.$1036.Metal3 VSS.$858.Metal2 4.5
Rred_1992 VSS.$1036.Metal3 VSS.$862.Metal2 6.79506398421
Rred_1993 VSS.$1036.Metal3 VSS.$869.Metal2 13.6446092814
Rred_1994 VSS.$1042.Metal3 VSS.$1048.Metal3 0.109399445083
Rred_1995 VSS.$1042.Metal3 VSS.$468.Metal1 1131.50554324
Rred_1996 VSS.$1042.Metal3 VSS.$862.Metal2 13.6446092814
Rred_1997 VSS.$1042.Metal3 VSS.$869.Metal2 3.88510981734
Rred_1998 VSS.$1042.Metal3 VSS.$877.Metal2 3.88510981734
Rred_1999 VSS.$1042.Metal3 VSS.$884.Metal2 13.6446092814
Rred_2000 VSS.$1048.Metal3 VSS.$486.Metal1 1100.71886473
Rred_2001 VSS.$1048.Metal3 VSS.$490.Metal1 1012.50762939
Rred_2002 VSS.$1048.Metal3 VSS.$496.Metal1 6623.118996
Rred_2003 VSS.$1048.Metal3 VSS.$877.Metal2 13.6446092814
Rred_2004 VSS.$1048.Metal3 VSS.$884.Metal2 3.83912533356
Rred_2005 VSS.$1048.Metal3 VSS.$895.Metal2 2.53404256545
Rred_2006 VSS.$1048.Metal3 VSS.$904.Metal2 2.83350568258
Rred_2007 VSS.$118.Metal1 VSS.$128.Metal1 0.0398303720292
Rred_2008 VSS.$118.Metal1 VSS.$598.Metal2 17.8373331011
Rred_2009 VSS.$118.Metal1 VSS.$602.Metal2 5.96008614456
Rred_2010 VSS.$118.Metal1 VSS.$609.Metal2 3.064567845
Rred_2011 VSS.$118.Metal1 VSS.P0.pSD 7.95325273154
Rred_2012 VSS.$118.Metal1 VSS.P11.nSD 7.01721403545
Rred_2013 VSS.$128.Metal1 VSS.$136.Metal1 0.0466666322121
Rred_2014 VSS.$128.Metal1 VSS.$609.Metal2 7.21747657563
Rred_2015 VSS.$128.Metal1 VSS.$617.Metal2 6.00104546937
Rred_2016 VSS.$128.Metal1 VSS.$942.Metal3 1131.50554324
Rred_2017 VSS.$128.Metal1 VSS.P0.pSD 10.7480140374
Rred_2018 VSS.$136.Metal1 VSS.$152.Metal1 0.0872313477116
Rred_2019 VSS.$136.Metal1 VSS.$617.Metal2 3.7378015353
Rred_2020 VSS.$136.Metal1 VSS.$624.Metal2 4.64025317255
Rred_2021 VSS.$136.Metal1 VSS.$628.Metal2 13.6387252473
Rred_2022 VSS.$136.Metal1 VSS.P0.pSD 7.52240411843
Rred_2023 VSS.$136.Metal1 VSS.P13.nSD 7.01672456436
Rred_2024 VSS.$14.Metal1 VSS.$29.Metal1 0.0488471859724
Rred_2025 VSS.$14.Metal1 VSS.$31.Metal1 0.130308985472
Rred_2026 VSS.$14.Metal1 VSS.$520.Metal1 19099.867985
Rred_2027 VSS.$14.Metal1 VSS.$531.Metal2 5.25078889237
Rred_2028 VSS.$14.Metal1 VSS.$540.Metal2 31.6093576742
Rred_2029 VSS.$14.Metal1 VSS.$916.Metal3 1678.46494261
Rred_2030 VSS.$14.Metal1 VSS.P0.pSD 1.83724161514
Rred_2031 VSS.$152.Metal1 VSS.$162.Metal1 0.0406838090659
Rred_2032 VSS.$152.Metal1 VSS.$624.Metal2 17.1768024012
Rred_2033 VSS.$152.Metal1 VSS.$628.Metal2 5.75552268106
Rred_2034 VSS.$152.Metal1 VSS.$635.Metal2 3.14030815728
Rred_2035 VSS.$152.Metal1 VSS.P0.pSD 7.92433989575
Rred_2036 VSS.$152.Metal1 VSS.P15.nSD 7.01713240974
Rred_2037 VSS.$162.Metal1 VSS.$170.Metal1 0.0458111725817
Rred_2038 VSS.$162.Metal1 VSS.$635.Metal2 7.01359480942
Rred_2039 VSS.$162.Metal1 VSS.$643.Metal2 6.11297515126
Rred_2040 VSS.$162.Metal1 VSS.$952.Metal3 1131.50554324
Rred_2041 VSS.$162.Metal1 VSS.P0.pSD 10.6514438992
Rred_2042 VSS.$170.Metal1 VSS.$186.Metal1 0.0872332745045
Rred_2043 VSS.$170.Metal1 VSS.$643.Metal2 3.64408332806
Rred_2044 VSS.$170.Metal1 VSS.$650.Metal2 4.77242858714
Rred_2045 VSS.$170.Metal1 VSS.$654.Metal2 14.0524898581
Rred_2046 VSS.$170.Metal1 VSS.P0.pSD 7.59630185661
Rred_2047 VSS.$170.Metal1 VSS.P17.nSD 7.01676532768
Rred_2048 VSS.$186.Metal1 VSS.$196.Metal1 0.0415372456909
Rred_2049 VSS.$186.Metal1 VSS.$650.Metal2 16.5633578113
Rred_2050 VSS.$186.Metal1 VSS.$654.Metal2 5.56452280014
Rred_2051 VSS.$186.Metal1 VSS.$661.Metal2 3.21814260073
Rred_2052 VSS.$186.Metal1 VSS.P0.pSD 7.89682260524
Rred_2053 VSS.$186.Metal1 VSS.P19.nSD 7.01705663136
Rred_2054 VSS.$196.Metal1 VSS.$204.Metal1 0.0449557125074
Rred_2055 VSS.$196.Metal1 VSS.$661.Metal2 6.82862411992
Rred_2056 VSS.$196.Metal1 VSS.$669.Metal2 6.23366856258
Rred_2057 VSS.$196.Metal1 VSS.$962.Metal3 1131.50554324
Rred_2058 VSS.$196.Metal1 VSS.P0.pSD 10.5490093969
Rred_2059 VSS.$204.Metal1 VSS.$220.Metal1 0.0872345597175
Rred_2060 VSS.$204.Metal1 VSS.$669.Metal2 3.55346102529
Rred_2061 VSS.$204.Metal1 VSS.$676.Metal2 4.91232568796
Rred_2062 VSS.$204.Metal1 VSS.$680.Metal2 14.4920184664
Rred_2063 VSS.$204.Metal1 VSS.P0.pSD 7.6745759053
Rred_2064 VSS.$204.Metal1 VSS.P21.nSD 7.0168119201
Rred_2065 VSS.$220.Metal1 VSS.$230.Metal1 0.0423906818564
Rred_2066 VSS.$220.Metal1 VSS.$676.Metal2 15.9921256466
Rred_2067 VSS.$220.Metal1 VSS.$680.Metal2 5.385776949
Rred_2068 VSS.$220.Metal1 VSS.$687.Metal2 3.29821150821
Rred_2069 VSS.$220.Metal1 VSS.P0.pSD 7.87060279587
Rred_2070 VSS.$220.Metal1 VSS.P23.nSD 7.01698669653
Rred_2071 VSS.$230.Metal1 VSS.$238.Metal1 0.0441002520844
Rred_2072 VSS.$230.Metal1 VSS.$687.Metal2 6.66004996855
Rred_2073 VSS.$230.Metal1 VSS.$695.Metal2 6.36419690526
Rred_2074 VSS.$230.Metal1 VSS.$972.Metal3 1131.50554324
Rred_2075 VSS.$230.Metal1 VSS.P0.pSD 10.4409088958
Rred_2076 VSS.$238.Metal1 VSS.$254.Metal1 0.0872352033503
Rred_2077 VSS.$238.Metal1 VSS.$695.Metal2 3.46573785034
Rred_2078 VSS.$238.Metal1 VSS.$702.Metal2 5.06064486909
Rred_2079 VSS.$238.Metal1 VSS.$706.Metal2 14.9598053869
Rred_2080 VSS.$238.Metal1 VSS.P0.pSD 7.75762608647
Rred_2081 VSS.$238.Metal1 VSS.P25.nSD 7.01686434393
Rred_2082 VSS.$254.Metal1 VSS.$702.Metal2 15.4588823963
Rred_2083 VSS.$254.Metal1 VSS.$706.Metal2 5.21813890018
Rred_2084 VSS.$254.Metal1 VSS.$713.Metal2 3.38066427184
Rred_2085 VSS.$254.Metal1 VSS.P0.pSD 7.84559137844
Rred_2086 VSS.$254.Metal1 VSS.P27.nSD 7.01692260178
Rred_2087 VSS.$270.Metal1 VSS.$286.Metal1 0.0872352033503
Rred_2088 VSS.$270.Metal1 VSS.$721.Metal2 3.38066427184
Rred_2089 VSS.$270.Metal1 VSS.$728.Metal2 5.21813890018
Rred_2090 VSS.$270.Metal1 VSS.$732.Metal2 15.4588823963
Rred_2091 VSS.$270.Metal1 VSS.P0.pSD 7.84559137844
Rred_2092 VSS.$270.Metal1 VSS.P29.nSD 7.01692260178
Rred_2093 VSS.$286.Metal1 VSS.$298.Metal1 0.0441002520844
Rred_2094 VSS.$286.Metal1 VSS.$728.Metal2 14.9598053869
Rred_2095 VSS.$286.Metal1 VSS.$732.Metal2 5.06064486909
Rred_2096 VSS.$286.Metal1 VSS.$739.Metal2 3.46573785034
Rred_2097 VSS.$286.Metal1 VSS.P0.pSD 7.75762608647
Rred_2098 VSS.$286.Metal1 VSS.P31.nSD 7.01686434393
Rred_2099 VSS.$29.Metal1 VSS.$520.Metal1 11350.9518972
Rred_2100 VSS.$29.Metal1 VSS.$531.Metal2 1.94029588801
Rred_2101 VSS.$29.Metal1 VSS.P0.GatPoly 51.6153846154
Rred_2102 VSS.$29.Metal1 VSS.P0.nSD 5.87557265109
Rred_2103 VSS.$29.Metal1 VSS.P0.pSD 2.51315942555
Rred_2104 VSS.$29.Metal1 VSS.P1.nSD 5.87557265109
Rred_2105 VSS.$298.Metal1 VSS.$304.Metal1 0.0423906818564
Rred_2106 VSS.$298.Metal1 VSS.$739.Metal2 6.36419690526
Rred_2107 VSS.$298.Metal1 VSS.$747.Metal2 6.66004996855
Rred_2108 VSS.$298.Metal1 VSS.$992.Metal3 1131.50554324
Rred_2109 VSS.$298.Metal1 VSS.P0.pSD 10.4409088958
Rred_2110 VSS.$304.Metal1 VSS.$320.Metal1 0.0872345597175
Rred_2111 VSS.$304.Metal1 VSS.$747.Metal2 3.29821150821
Rred_2112 VSS.$304.Metal1 VSS.$754.Metal2 5.385776949
Rred_2113 VSS.$304.Metal1 VSS.$758.Metal2 15.9921256466
Rred_2114 VSS.$304.Metal1 VSS.P0.pSD 7.87060279587
Rred_2115 VSS.$304.Metal1 VSS.P33.nSD 7.01698669653
Rred_2116 VSS.$31.Metal1 VSS.$42.Metal1 0.0367151920338
Rred_2117 VSS.$31.Metal1 VSS.$531.Metal2 5.75294683667
Rred_2118 VSS.$31.Metal1 VSS.$540.Metal2 3.79493251751
Rred_2119 VSS.$31.Metal1 VSS.$916.Metal3 1908.27519553
Rred_2120 VSS.$31.Metal1 VSS.P0.pSD 122.940264235
Rred_2121 VSS.$320.Metal1 VSS.$332.Metal1 0.0449557125074
Rred_2122 VSS.$320.Metal1 VSS.$754.Metal2 14.4920184664
Rred_2123 VSS.$320.Metal1 VSS.$758.Metal2 4.91232568796
Rred_2124 VSS.$320.Metal1 VSS.$765.Metal2 3.55346102529
Rred_2125 VSS.$320.Metal1 VSS.P0.pSD 7.6745759053
Rred_2126 VSS.$320.Metal1 VSS.P35.nSD 7.0168119201
Rred_2127 VSS.$332.Metal1 VSS.$338.Metal1 0.0415372456909
Rred_2128 VSS.$332.Metal1 VSS.$765.Metal2 6.23366856258
Rred_2129 VSS.$332.Metal1 VSS.$773.Metal2 6.82862411992
Rred_2130 VSS.$332.Metal1 VSS.P0.pSD 10.5490093969
Rred_2131 VSS.$338.Metal1 VSS.$354.Metal1 0.0872332745045
Rred_2132 VSS.$338.Metal1 VSS.$773.Metal2 3.21814260073
Rred_2133 VSS.$338.Metal1 VSS.$780.Metal2 5.56452280014
Rred_2134 VSS.$338.Metal1 VSS.$784.Metal2 16.5633578113
Rred_2135 VSS.$338.Metal1 VSS.P0.pSD 7.89682260524
Rred_2136 VSS.$338.Metal1 VSS.P37.nSD 7.01705663136
Rred_2137 VSS.$354.Metal1 VSS.$366.Metal1 0.0458111725817
Rred_2138 VSS.$354.Metal1 VSS.$780.Metal2 14.0524898581
Rred_2139 VSS.$354.Metal1 VSS.$784.Metal2 4.77242858714
Rred_2140 VSS.$354.Metal1 VSS.$791.Metal2 3.64408332806
Rred_2141 VSS.$354.Metal1 VSS.P0.pSD 7.59630185661
Rred_2142 VSS.$354.Metal1 VSS.P39.nSD 7.01676532768
Rred_2143 VSS.$366.Metal1 VSS.$372.Metal1 0.0406838090659
Rred_2144 VSS.$366.Metal1 VSS.$791.Metal2 6.11297515126
Rred_2145 VSS.$366.Metal1 VSS.$799.Metal2 7.01359480942
Rred_2146 VSS.$366.Metal1 VSS.P0.pSD 10.6514438992
Rred_2147 VSS.$372.Metal1 VSS.$388.Metal1 0.0872313477116
Rred_2148 VSS.$372.Metal1 VSS.$799.Metal2 3.14030815728
Rred_2149 VSS.$372.Metal1 VSS.$806.Metal2 5.75552268106
Rred_2150 VSS.$372.Metal1 VSS.$810.Metal2 17.1768024012
Rred_2151 VSS.$372.Metal1 VSS.P0.pSD 7.92433989575
Rred_2152 VSS.$372.Metal1 VSS.P41.nSD 7.01713240974
Rred_2153 VSS.$388.Metal1 VSS.$400.Metal1 0.0466666322121
Rred_2154 VSS.$388.Metal1 VSS.$806.Metal2 13.6387252473
Rred_2155 VSS.$388.Metal1 VSS.$810.Metal2 4.64025317255
Rred_2156 VSS.$388.Metal1 VSS.$817.Metal2 3.7378015353
Rred_2157 VSS.$388.Metal1 VSS.P0.pSD 7.52240411843
Rred_2158 VSS.$388.Metal1 VSS.P43.nSD 7.01672456436
Rred_2159 VSS.$400.Metal1 VSS.$406.Metal1 0.0398303720292
Rred_2160 VSS.$400.Metal1 VSS.$817.Metal2 6.00104546937
Rred_2161 VSS.$400.Metal1 VSS.$825.Metal2 7.21747657563
Rred_2162 VSS.$400.Metal1 VSS.P0.pSD 10.7480140374
Rred_2163 VSS.$406.Metal1 VSS.$422.Metal1 0.0872287793389
Rred_2164 VSS.$406.Metal1 VSS.$825.Metal2 3.064567845
Rred_2165 VSS.$406.Metal1 VSS.$832.Metal2 5.96008614456
Rred_2166 VSS.$406.Metal1 VSS.$836.Metal2 17.8373331011
Rred_2167 VSS.$406.Metal1 VSS.P0.pSD 7.95325273154
Rred_2168 VSS.$406.Metal1 VSS.P45.nSD 7.01721403545
Rred_2169 VSS.$42.Metal1 VSS.$50.Metal1 0.0663423533901
Rred_2170 VSS.$42.Metal1 VSS.$540.Metal2 9.33751460386
Rred_2171 VSS.$42.Metal1 VSS.$550.Metal2 4.5823869092
Rred_2172 VSS.$42.Metal1 VSS.$916.Metal3 1100.71886473
Rred_2173 VSS.$42.Metal1 VSS.P0.pSD 9.97213098787
Rred_2174 VSS.$422.Metal1 VSS.$434.Metal1 0.0475220913035
Rred_2175 VSS.$422.Metal1 VSS.$832.Metal2 13.2485154879
Rred_2176 VSS.$422.Metal1 VSS.$836.Metal2 4.51517461661
Rred_2177 VSS.$422.Metal1 VSS.$843.Metal2 3.83482751327
Rred_2178 VSS.$422.Metal1 VSS.P0.pSD 7.45252628727
Rred_2179 VSS.$422.Metal1 VSS.P47.nSD 7.01668962813
Rred_2180 VSS.$434.Metal1 VSS.$440.Metal1 0.0389769346281
Rred_2181 VSS.$434.Metal1 VSS.$843.Metal2 5.89671640207
Rred_2182 VSS.$434.Metal1 VSS.$851.Metal2 7.44294022274
Rred_2183 VSS.$434.Metal1 VSS.P0.pSD 10.838511324
Rred_2184 VSS.$440.Metal1 VSS.$456.Metal1 0.0872255693867
Rred_2185 VSS.$440.Metal1 VSS.$851.Metal2 2.99078952228
Rred_2186 VSS.$440.Metal1 VSS.$858.Metal2 6.17971623358
Rred_2187 VSS.$440.Metal1 VSS.$862.Metal2 18.5506038882
Rred_2188 VSS.$440.Metal1 VSS.P0.pSD 7.98366931108
Rred_2189 VSS.$440.Metal1 VSS.P49.nSD 7.01730151252
Rred_2190 VSS.$456.Metal1 VSS.$468.Metal1 0.048377549761
Rred_2191 VSS.$456.Metal1 VSS.$858.Metal2 12.8798969812
Rred_2192 VSS.$456.Metal1 VSS.$862.Metal2 4.39663373469
Rred_2193 VSS.$456.Metal1 VSS.$869.Metal2 3.93538987694
Rred_2194 VSS.$456.Metal1 VSS.P0.pSD 7.38634964019
Rred_2195 VSS.$456.Metal1 VSS.P51.nSD 7.01666051724
Rred_2196 VSS.$468.Metal1 VSS.$474.Metal1 0.0381234969105
Rred_2197 VSS.$468.Metal1 VSS.$869.Metal2 5.79991764697
Rred_2198 VSS.$468.Metal1 VSS.$877.Metal2 7.69489508441
Rred_2199 VSS.$468.Metal1 VSS.P0.pSD 10.9227165225
Rred_2200 VSS.$474.Metal1 VSS.$486.Metal1 0.0663423533901
Rred_2201 VSS.$474.Metal1 VSS.$877.Metal2 2.91884844981
Rred_2202 VSS.$474.Metal1 VSS.$884.Metal2 7.60897365714
Rred_2203 VSS.$474.Metal1 VSS.P0.pSD 9.71523494043
Rred_2204 VSS.$474.Metal1 VSS.P53.nSD 7.01739484531
Rred_2205 VSS.$486.Metal1 VSS.$496.Metal1 0.0367151920338
Rred_2206 VSS.$486.Metal1 VSS.$884.Metal2 4.5823869092
Rred_2207 VSS.$486.Metal1 VSS.$895.Metal2 9.33751460386
Rred_2208 VSS.$486.Metal1 VSS.P0.pSD 9.97213098787
Rred_2209 VSS.$490.Metal1 VSS.$496.Metal1 0.0787239786651
Rred_2210 VSS.$490.Metal1 VSS.$500.Metal1 0.107764670348
Rred_2211 VSS.$490.Metal1 VSS.$520.Metal1 0.958344790269
Rred_2212 VSS.$490.Metal1 VSS.$895.Metal2 19.2212234495
Rred_2213 VSS.$490.Metal1 VSS.$904.Metal2 3.3923000181
Rred_2214 VSS.$490.Metal1 VSS.P0.pSD 6.41308878012
Rred_2215 VSS.$496.Metal1 VSS.$895.Metal2 4.10974337583
Rred_2216 VSS.$496.Metal1 VSS.$904.Metal2 15.4962345707
Rred_2217 VSS.$496.Metal1 VSS.P0.pSD 122.940264235
Rred_2218 VSS.$50.Metal1 VSS.$550.Metal2 7.60897365714
Rred_2219 VSS.$50.Metal1 VSS.$557.Metal2 2.91884844981
Rred_2220 VSS.$50.Metal1 VSS.$60.Metal1 0.0381234969105
Rred_2221 VSS.$50.Metal1 VSS.P0.pSD 9.71523494043
Rred_2222 VSS.$50.Metal1 VSS.P3.nSD 7.01739484531
Rred_2223 VSS.$500.Metal1 VSS.$520.Metal1 0.21573865785
Rred_2224 VSS.$500.Metal1 VSS.$904.Metal2 1.91339439744
Rred_2225 VSS.$500.Metal1 VSS.P0.pSD 5.72376819724
Rred_2226 VSS.$500.Metal1 VSS.P1.GatPoly 51.6153846154
Rred_2227 VSS.$500.Metal1 VSS.P55.nSD 5.87557265109
Rred_2228 VSS.$500.Metal1 VSS.P57.nSD 5.87557265109
Rred_2229 VSS.$520.Metal1 VSS.$904.Metal2 1227.2739005
Rred_2230 VSS.$520.Metal1 VSS.P0.pSD 1.47877364378
Rred_2231 VSS.$531.Metal2 VSS.$540.Metal2 0.10025490165
Rred_2232 VSS.$531.Metal2 VSS.$916.Metal3 2.83584441638
Rred_2233 VSS.$531.Metal2 VSS.P0.nSD 291.595673923
Rred_2234 VSS.$531.Metal2 VSS.P1.nSD 291.595673923
Rred_2235 VSS.$540.Metal2 VSS.$550.Metal2 0.0748661170905
Rred_2236 VSS.$540.Metal2 VSS.$916.Metal3 2.53199998601
Rred_2237 VSS.$550.Metal2 VSS.$557.Metal2 0.036099096542
Rred_2238 VSS.$550.Metal2 VSS.$916.Metal3 3.83912533356
Rred_2239 VSS.$550.Metal2 VSS.$922.Metal3 13.6446092814
Rred_2240 VSS.$550.Metal2 VSS.P0.pSD 4187.53768473
Rred_2241 VSS.$550.Metal2 VSS.P3.nSD 577.337976474
Rred_2242 VSS.$557.Metal2 VSS.$565.Metal2 0.0727385628444
Rred_2243 VSS.$557.Metal2 VSS.$60.Metal1 7.69489508441
Rred_2244 VSS.$557.Metal2 VSS.$916.Metal3 13.6446092814
Rred_2245 VSS.$557.Metal2 VSS.$922.Metal3 3.88510981734
Rred_2246 VSS.$557.Metal2 VSS.P0.pSD 37716.5312064
Rred_2247 VSS.$557.Metal2 VSS.P3.nSD 62.4149163755
Rred_2248 VSS.$565.Metal2 VSS.$572.Metal2 0.0361336819075
Rred_2249 VSS.$565.Metal2 VSS.$60.Metal1 5.79991764697
Rred_2250 VSS.$565.Metal2 VSS.$68.Metal1 3.93538987694
Rred_2251 VSS.$565.Metal2 VSS.$922.Metal3 4.52704202798
Rred_2252 VSS.$565.Metal2 VSS.$926.Metal3 9.03608
Rred_2253 VSS.$565.Metal2 VSS.P0.pSD 6728.80975083
Rred_2254 VSS.$565.Metal2 VSS.P5.nSD 92.4606154708
Rred_2255 VSS.$572.Metal2 VSS.$576.Metal2 0.0360795247734
Rred_2256 VSS.$572.Metal2 VSS.$68.Metal1 4.39663373469
Rred_2257 VSS.$572.Metal2 VSS.$84.Metal1 18.5506038882
Rred_2258 VSS.$572.Metal2 VSS.$926.Metal3 4.5
Rred_2259 VSS.$572.Metal2 VSS.P0.pSD 3059.13574035
Rred_2260 VSS.$572.Metal2 VSS.P5.nSD 144.469711673
Rred_2261 VSS.$576.Metal2 VSS.$583.Metal2 0.0361033909124
Rred_2262 VSS.$576.Metal2 VSS.$68.Metal1 12.8798969812
Rred_2263 VSS.$576.Metal2 VSS.$84.Metal1 6.17971623358
Rred_2264 VSS.$576.Metal2 VSS.$926.Metal3 6.79506398421
Rred_2265 VSS.$576.Metal2 VSS.$932.Metal3 13.6446092814
Rred_2266 VSS.$576.Metal2 VSS.P0.pSD 2598.11535914
Rred_2267 VSS.$576.Metal2 VSS.P7.nSD 461.925326725
Rred_2268 VSS.$583.Metal2 VSS.$591.Metal2 0.0727385628444
Rred_2269 VSS.$583.Metal2 VSS.$84.Metal1 2.99078952228
Rred_2270 VSS.$583.Metal2 VSS.$926.Metal3 13.6446092814
Rred_2271 VSS.$583.Metal2 VSS.$932.Metal3 3.88510981734
Rred_2272 VSS.$583.Metal2 VSS.$94.Metal1 7.44332582136
Rred_2273 VSS.$583.Metal2 VSS.P0.pSD 29746.948013
Rred_2274 VSS.$583.Metal2 VSS.P7.nSD 64.1562953785
Rred_2275 VSS.$591.Metal2 VSS.$598.Metal2 0.0361315727176
Rred_2276 VSS.$591.Metal2 VSS.$932.Metal3 3.88510981734
Rred_2277 VSS.$591.Metal2 VSS.$938.Metal3 13.6446092814
Rred_2278 VSS.$591.Metal2 VSS.$94.Metal1 5.89695842818
Rred_2279 VSS.$591.Metal2 VSS.P0.pSD 7357.21367385
Rred_2280 VSS.$591.Metal2 VSS.P10.nSD 88.9011359367
Rred_2281 VSS.$598.Metal2 VSS.$602.Metal2 0.0360795195038
Rred_2282 VSS.$598.Metal2 VSS.$932.Metal3 13.6446092814
Rred_2283 VSS.$598.Metal2 VSS.$938.Metal3 6.79506398421
Rred_2284 VSS.$598.Metal2 VSS.P0.pSD 3011.71231884
Rred_2285 VSS.$598.Metal2 VSS.P10.nSD 154.09530229
Rred_2286 VSS.$60.Metal1 VSS.$68.Metal1 0.048377549761
Rred_2287 VSS.$60.Metal1 VSS.$922.Metal3 1131.50554324
Rred_2288 VSS.$60.Metal1 VSS.P0.pSD 10.9227165225
Rred_2289 VSS.$602.Metal2 VSS.$609.Metal2 0.0361081830014
Rred_2290 VSS.$602.Metal2 VSS.$938.Metal3 4.5
Rred_2291 VSS.$602.Metal2 VSS.P0.pSD 2637.94201861
Rred_2292 VSS.$602.Metal2 VSS.P11.nSD 384.980698479
Rred_2293 VSS.$609.Metal2 VSS.$617.Metal2 0.0727385628444
Rred_2294 VSS.$609.Metal2 VSS.$938.Metal3 9.03608
Rred_2295 VSS.$609.Metal2 VSS.$942.Metal3 4.52704202798
Rred_2296 VSS.$609.Metal2 VSS.P0.pSD 24458.3910316
Rred_2297 VSS.$609.Metal2 VSS.P11.nSD 65.9966911678
Rred_2298 VSS.$617.Metal2 VSS.$624.Metal2 0.0361299623288
Rred_2299 VSS.$617.Metal2 VSS.$942.Metal3 3.88510981734
Rred_2300 VSS.$617.Metal2 VSS.$948.Metal3 13.6446092814
Rred_2301 VSS.$617.Metal2 VSS.P0.pSD 8092.91553003
Rred_2302 VSS.$617.Metal2 VSS.P13.nSD 85.6046856094
Rred_2303 VSS.$624.Metal2 VSS.$628.Metal2 0.0360795152881
Rred_2304 VSS.$624.Metal2 VSS.$942.Metal3 13.6446092814
Rred_2305 VSS.$624.Metal2 VSS.$948.Metal3 6.79506398421
Rred_2306 VSS.$624.Metal2 VSS.P0.pSD 2965.7204549
Rred_2307 VSS.$624.Metal2 VSS.P13.nSD 165.094750818
Rred_2308 VSS.$628.Metal2 VSS.$635.Metal2 0.036111940735
Rred_2309 VSS.$628.Metal2 VSS.$948.Metal3 4.5
Rred_2310 VSS.$628.Metal2 VSS.P0.pSD 2678.9960806
Rred_2311 VSS.$628.Metal2 VSS.P15.nSD 330.017796805
Rred_2312 VSS.$635.Metal2 VSS.$643.Metal2 0.0727385628444
Rred_2313 VSS.$635.Metal2 VSS.$948.Metal3 9.03608
Rred_2314 VSS.$635.Metal2 VSS.$952.Metal3 4.52704202798
Rred_2315 VSS.$635.Metal2 VSS.P0.pSD 20699.7491345
Rred_2316 VSS.$635.Metal2 VSS.P15.nSD 67.9448405187
Rred_2317 VSS.$643.Metal2 VSS.$650.Metal2 0.0361280835418
Rred_2318 VSS.$643.Metal2 VSS.$952.Metal3 3.88510981734
Rred_2319 VSS.$643.Metal2 VSS.$958.Metal3 13.6446092814
Rred_2320 VSS.$643.Metal2 VSS.P0.pSD 8963.37454531
Rred_2321 VSS.$643.Metal2 VSS.P17.nSD 82.5430827883
Rred_2322 VSS.$650.Metal2 VSS.$654.Metal2 0.036079512126
Rred_2323 VSS.$650.Metal2 VSS.$952.Metal3 13.6446092814
Rred_2324 VSS.$650.Metal2 VSS.$958.Metal3 6.79506398421
Rred_2325 VSS.$650.Metal2 VSS.P0.pSD 2921.09636554
Rred_2326 VSS.$650.Metal2 VSS.P17.nSD 177.78510139
Rred_2327 VSS.$654.Metal2 VSS.$661.Metal2 0.0361154300589
Rred_2328 VSS.$654.Metal2 VSS.$958.Metal3 4.5
Rred_2329 VSS.$654.Metal2 VSS.P0.pSD 2721.33522066
Rred_2330 VSS.$654.Metal2 VSS.P19.nSD 288.79347424
Rred_2331 VSS.$661.Metal2 VSS.$669.Metal2 0.0727385628444
Rred_2332 VSS.$661.Metal2 VSS.$958.Metal3 9.03608
Rred_2333 VSS.$661.Metal2 VSS.$962.Metal3 4.52704202798
Rred_2334 VSS.$661.Metal2 VSS.P0.pSD 17895.7038428
Rred_2335 VSS.$661.Metal2 VSS.P19.nSD 70.0105392096
Rred_2336 VSS.$669.Metal2 VSS.$676.Metal2 0.0361259363567
Rred_2337 VSS.$669.Metal2 VSS.$962.Metal3 3.88510981734
Rred_2338 VSS.$669.Metal2 VSS.$968.Metal3 13.6446092814
Rred_2339 VSS.$669.Metal2 VSS.P0.pSD 10005.7880435
Rred_2340 VSS.$669.Metal2 VSS.P21.nSD 79.6920329037
Rred_2341 VSS.$676.Metal2 VSS.$680.Metal2 0.0360795100174
Rred_2342 VSS.$676.Metal2 VSS.$962.Metal3 13.6446092814
Rred_2343 VSS.$676.Metal2 VSS.$968.Metal3 6.79506398421
Rred_2344 VSS.$676.Metal2 VSS.P0.pSD 2877.78000062
Rred_2345 VSS.$676.Metal2 VSS.P21.nSD 192.589079517
Rred_2346 VSS.$68.Metal1 VSS.$84.Metal1 0.0872255693867
Rred_2347 VSS.$68.Metal1 VSS.P0.pSD 7.38634964019
Rred_2348 VSS.$68.Metal1 VSS.P5.nSD 7.01666051724
Rred_2349 VSS.$680.Metal2 VSS.$687.Metal2 0.0361186509734
Rred_2350 VSS.$680.Metal2 VSS.$968.Metal3 4.5
Rred_2351 VSS.$680.Metal2 VSS.P0.pSD 2765.02078485
Rred_2352 VSS.$680.Metal2 VSS.P23.nSD 256.728204413
Rred_2353 VSS.$687.Metal2 VSS.$695.Metal2 0.0727385628444
Rred_2354 VSS.$687.Metal2 VSS.$968.Metal3 9.03608
Rred_2355 VSS.$687.Metal2 VSS.$972.Metal3 4.52704202798
Rred_2356 VSS.$687.Metal2 VSS.P0.pSD 15726.8115927
Rred_2357 VSS.$687.Metal2 VSS.P23.nSD 72.2048074911
Rred_2358 VSS.$695.Metal2 VSS.$702.Metal2 0.0361235207734
Rred_2359 VSS.$695.Metal2 VSS.$972.Metal3 3.88510981734
Rred_2360 VSS.$695.Metal2 VSS.$978.Metal3 13.6446092814
Rred_2361 VSS.$695.Metal2 VSS.P0.pSD 11271.6859306
Rred_2362 VSS.$695.Metal2 VSS.P25.nSD 77.030480662
Rred_2363 VSS.$702.Metal2 VSS.$706.Metal2 0.0360795089622
Rred_2364 VSS.$702.Metal2 VSS.$972.Metal3 13.6446092814
Rred_2365 VSS.$702.Metal2 VSS.$978.Metal3 6.79506398421
Rred_2366 VSS.$702.Metal2 VSS.P0.pSD 2835.7147738
Rred_2367 VSS.$702.Metal2 VSS.P25.nSD 210.083129078
Rred_2368 VSS.$706.Metal2 VSS.$713.Metal2 0.0361216034783
Rred_2369 VSS.$706.Metal2 VSS.$978.Metal3 4.5
Rred_2370 VSS.$706.Metal2 VSS.P0.pSD 2810.11808649
Rred_2371 VSS.$706.Metal2 VSS.P27.nSD 231.074271503
Rred_2372 VSS.$713.Metal2 VSS.$721.Metal2 0.0727385628444
Rred_2373 VSS.$713.Metal2 VSS.$978.Metal3 9.03608
Rred_2374 VSS.$713.Metal2 VSS.$982.Metal3 4.52704202798
Rred_2375 VSS.$713.Metal2 VSS.P0.pSD 14001.5420309
Rred_2376 VSS.$713.Metal2 VSS.P27.nSD 74.5400875816
Rred_2377 VSS.$721.Metal2 VSS.$728.Metal2 0.0361208367919
Rred_2378 VSS.$721.Metal2 VSS.$982.Metal3 3.88510981734
Rred_2379 VSS.$721.Metal2 VSS.$988.Metal3 13.6446092814
Rred_2380 VSS.$721.Metal2 VSS.P0.pSD 14001.5420309
Rred_2381 VSS.$721.Metal2 VSS.P29.nSD 74.5400875816
Rred_2382 VSS.$728.Metal2 VSS.$732.Metal2 0.0360795089622
Rred_2383 VSS.$728.Metal2 VSS.$982.Metal3 13.6446092814
Rred_2384 VSS.$728.Metal2 VSS.$988.Metal3 6.79506398421
Rred_2385 VSS.$728.Metal2 VSS.P0.pSD 2810.11808649
Rred_2386 VSS.$728.Metal2 VSS.P29.nSD 231.074271503
Rred_2387 VSS.$732.Metal2 VSS.$739.Metal2 0.0361242875737
Rred_2388 VSS.$732.Metal2 VSS.$988.Metal3 4.5
Rred_2389 VSS.$732.Metal2 VSS.P0.pSD 2835.7147738
Rred_2390 VSS.$732.Metal2 VSS.P31.nSD 210.083129078
Rred_2391 VSS.$739.Metal2 VSS.$747.Metal2 0.0727385628444
Rred_2392 VSS.$739.Metal2 VSS.$988.Metal3 9.03608
Rred_2393 VSS.$739.Metal2 VSS.$992.Metal3 4.52704202798
Rred_2394 VSS.$739.Metal2 VSS.P0.pSD 11271.6859306
Rred_2395 VSS.$739.Metal2 VSS.P31.nSD 77.030480662
Rred_2396 VSS.$747.Metal2 VSS.$754.Metal2 0.0361178844124
Rred_2397 VSS.$747.Metal2 VSS.$992.Metal3 3.88510981734
Rred_2398 VSS.$747.Metal2 VSS.$998.Metal3 13.6446092814
Rred_2399 VSS.$747.Metal2 VSS.P0.pSD 15726.8115927
Rred_2400 VSS.$747.Metal2 VSS.P33.nSD 72.2048074911
Rred_2401 VSS.$754.Metal2 VSS.$758.Metal2 0.0360795100174
Rred_2402 VSS.$754.Metal2 VSS.$992.Metal3 13.6446092814
Rred_2403 VSS.$754.Metal2 VSS.$998.Metal3 6.79506398421
Rred_2404 VSS.$754.Metal2 VSS.P0.pSD 2765.02078485
Rred_2405 VSS.$754.Metal2 VSS.P33.nSD 256.728204413
Rred_2406 VSS.$758.Metal2 VSS.$765.Metal2 0.0361267032595
Rred_2407 VSS.$758.Metal2 VSS.$998.Metal3 4.5
Rred_2408 VSS.$758.Metal2 VSS.P0.pSD 2877.78000062
Rred_2409 VSS.$758.Metal2 VSS.P35.nSD 192.589079517
Rred_2410 VSS.$765.Metal2 VSS.$773.Metal2 0.0727385628444
Rred_2411 VSS.$765.Metal2 VSS.$998.Metal3 9.03608
Rred_2412 VSS.$765.Metal2 VSS.P0.pSD 10005.7880435
Rred_2413 VSS.$765.Metal2 VSS.P35.nSD 79.6920329037
Rred_2414 VSS.$773.Metal2 VSS.$780.Metal2 0.0361146636346
Rred_2415 VSS.$773.Metal2 VSS.P0.pSD 17895.7038428
Rred_2416 VSS.$773.Metal2 VSS.P37.nSD 70.0105392096
Rred_2417 VSS.$780.Metal2 VSS.$784.Metal2 0.036079512126
Rred_2418 VSS.$780.Metal2 VSS.P0.pSD 2721.33522066
Rred_2419 VSS.$780.Metal2 VSS.P37.nSD 288.79347424
Rred_2420 VSS.$784.Metal2 VSS.$791.Metal2 0.0361288505358
Rred_2421 VSS.$784.Metal2 VSS.P0.pSD 2921.09636554
Rred_2422 VSS.$784.Metal2 VSS.P39.nSD 177.78510139
Rred_2423 VSS.$791.Metal2 VSS.$799.Metal2 0.0727385628444
Rred_2424 VSS.$791.Metal2 VSS.P0.pSD 8963.37454531
Rred_2425 VSS.$791.Metal2 VSS.P39.nSD 82.5430827883
Rred_2426 VSS.$799.Metal2 VSS.$806.Metal2 0.0361111744587
Rred_2427 VSS.$799.Metal2 VSS.P0.pSD 20699.7491345
Rred_2428 VSS.$799.Metal2 VSS.P41.nSD 67.9448405187
Rred_2429 VSS.$806.Metal2 VSS.$810.Metal2 0.0360795152881
Rred_2430 VSS.$806.Metal2 VSS.P0.pSD 2678.9960806
Rred_2431 VSS.$806.Metal2 VSS.P41.nSD 330.017796805
Rred_2432 VSS.$810.Metal2 VSS.$817.Metal2 0.0361307294026
Rred_2433 VSS.$810.Metal2 VSS.P0.pSD 2965.7204549
Rred_2434 VSS.$810.Metal2 VSS.P43.nSD 165.094750818
Rred_2435 VSS.$817.Metal2 VSS.$825.Metal2 0.0727385628444
Rred_2436 VSS.$817.Metal2 VSS.P0.pSD 8092.91553003
Rred_2437 VSS.$817.Metal2 VSS.P43.nSD 85.6046856094
Rred_2438 VSS.$825.Metal2 VSS.$832.Metal2 0.0361074168847
Rred_2439 VSS.$825.Metal2 VSS.P0.pSD 24458.3910316
Rred_2440 VSS.$825.Metal2 VSS.P45.nSD 65.9966911678
Rred_2441 VSS.$832.Metal2 VSS.$836.Metal2 0.0360795195038
Rred_2442 VSS.$832.Metal2 VSS.P0.pSD 2637.94201861
Rred_2443 VSS.$832.Metal2 VSS.P45.nSD 384.980698479
Rred_2444 VSS.$836.Metal2 VSS.$843.Metal2 0.0361323398598
Rred_2445 VSS.$836.Metal2 VSS.P0.pSD 3011.71231884
Rred_2446 VSS.$836.Metal2 VSS.P47.nSD 154.09530229
Rred_2447 VSS.$84.Metal1 VSS.$94.Metal1 0.0389769346281
Rred_2448 VSS.$84.Metal1 VSS.P0.pSD 7.98366931108
Rred_2449 VSS.$84.Metal1 VSS.P7.nSD 7.01730151252
Rred_2450 VSS.$843.Metal2 VSS.$851.Metal2 0.0727293596086
Rred_2451 VSS.$843.Metal2 VSS.P0.pSD 7357.21367385
Rred_2452 VSS.$843.Metal2 VSS.P47.nSD 88.9011359367
Rred_2453 VSS.$851.Metal2 VSS.$858.Metal2 0.0361041568584
Rred_2454 VSS.$851.Metal2 VSS.P0.pSD 29746.948013
Rred_2455 VSS.$851.Metal2 VSS.P49.nSD 64.1562953785
Rred_2456 VSS.$858.Metal2 VSS.$862.Metal2 0.0360795247734
Rred_2457 VSS.$858.Metal2 VSS.P0.pSD 2598.11535914
Rred_2458 VSS.$858.Metal2 VSS.P49.nSD 461.925326725
Rred_2459 VSS.$862.Metal2 VSS.$869.Metal2 0.0361329147083
Rred_2460 VSS.$862.Metal2 VSS.P0.pSD 3059.13574035
Rred_2461 VSS.$862.Metal2 VSS.P51.nSD 144.469711673
Rred_2462 VSS.$869.Metal2 VSS.$877.Metal2 0.0727385628444
Rred_2463 VSS.$869.Metal2 VSS.P0.pSD 6728.80975083
Rred_2464 VSS.$869.Metal2 VSS.P51.nSD 92.4606154708
Rred_2465 VSS.$877.Metal2 VSS.$884.Metal2 0.036099096542
Rred_2466 VSS.$877.Metal2 VSS.P0.pSD 37716.5312064
Rred_2467 VSS.$877.Metal2 VSS.P53.nSD 62.4149163755
Rred_2468 VSS.$884.Metal2 VSS.$895.Metal2 0.0748661170905
Rred_2469 VSS.$884.Metal2 VSS.P0.pSD 4187.53768473
Rred_2470 VSS.$884.Metal2 VSS.P53.nSD 577.337976474
Rred_2471 VSS.$895.Metal2 VSS.$904.Metal2 0.0993672001198
Rred_2472 VSS.$904.Metal2 VSS.P0.pSD 8212.71901442
Rred_2473 VSS.$904.Metal2 VSS.P55.nSD 291.595673923
Rred_2474 VSS.$904.Metal2 VSS.P57.nSD 291.595673923
Rred_2475 VSS.$916.Metal3 VSS.$922.Metal3 0.109399445083
Rred_2476 VSS.$922.Metal3 VSS.$926.Metal3 0.0724492814222
Rred_2477 VSS.$926.Metal3 VSS.$932.Metal3 0.109399445083
Rred_2478 VSS.$932.Metal3 VSS.$938.Metal3 0.109399445083
Rred_2479 VSS.$932.Metal3 VSS.$94.Metal1 1131.50554324
Rred_2480 VSS.$938.Metal3 VSS.$942.Metal3 0.0724492814222
Rred_2481 VSS.$94.Metal1 VSS.P0.pSD 10.838511324
Rred_2482 VSS.$942.Metal3 VSS.$948.Metal3 0.109399445083
Rred_2483 VSS.$948.Metal3 VSS.$952.Metal3 0.0724492814222
Rred_2484 VSS.$952.Metal3 VSS.$958.Metal3 0.109399445083
Rred_2485 VSS.$958.Metal3 VSS.$962.Metal3 0.0724492814222
Rred_2486 VSS.$962.Metal3 VSS.$968.Metal3 0.109399445083
Rred_2487 VSS.$968.Metal3 VSS.$972.Metal3 0.0724492814222
Rred_2488 VSS.$972.Metal3 VSS.$978.Metal3 0.109399445083
Rred_2489 VSS.$978.Metal3 VSS.$982.Metal3 0.0724492814222
Rred_2490 VSS.$982.Metal3 VSS.$988.Metal3 0.109399445083
Rred_2491 VSS.$988.Metal3 VSS.$992.Metal3 0.0724492814222
Rred_2492 VSS.$992.Metal3 VSS.$998.Metal3 0.109399445083
Rred_2493 VSS.P0.nSD VSS.P1.nSD 702.986321288
Rred_2494 VSS.P55.nSD VSS.P57.nSD 702.986321288
.ENDS iqmod_mixer_se2diff_inv_NF54_pex
