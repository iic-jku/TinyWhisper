* PEX produced on Sat Mar 28 10:03:40 PM CET 2026 using /foss/tools/sak/sak-pex.sh with m=3 and s=1
* NGSPICE file created from iqmod_mfb_lpf_pex.ext - technology: ihp-sg13g2

.subckt iqmod_mfb_lpf_pex voutp vinp voutn vinn VDD VSS di_filter_en
X0 VSS.t48 iqmod_mfb_lpf_pex_half_0.iqmod_mfb_lpf_pex_ota_core_hybrid_bm_half_0.iqmod_mfb_lpf_pex_ota_core_inv_NF20$1_1.vin.t0 voutn.t15 VSS.t47 sg13_lv_nmos ad=0.19p pd=1.38u as=0.19p ps=1.38u w=1u l=1u
X1 VSS.t205 iqmod_mfb_lpf_pex_half_1.iqmod_mfb_lpf_pex_ota_core_hybrid_bm_half_0.iqmod_mfb_lpf_pex_ota_core_tg$1_0.v_b.t38 voutn.t25 VSS.t204 sg13_lv_nmos ad=0.19p pd=1.38u as=0.19p ps=1.38u w=1u l=1u
X2 iqmod_mfb_lpf_pex_half_1.iqmod_mfb_lpf_pex_ota_core_hybrid_bm_half_0.iqmod_mfb_lpf_pex_ota_core_tg$1_0.v_b.t20 iqmod_mfb_lpf_pex_half_1.iqmod_mfb_lpf_pex_ota_core_hybrid_bm_half_0.iqmod_mfb_lpf_pex_ota_core_tg$1_0.v_a.t0 VDD.t50 VDD.t0 sg13_lv_pmos ad=1.14p pd=6.38u as=1.14p ps=6.38u w=6u l=1u
X3 VSS.t104 VSS.t101 VSS.t103 VSS.t102 sg13_lv_nmos ad=0.34p pd=2.68u as=0 ps=0 w=1u l=1u
X4 iqmod_mfb_lpf_pex_half_1.iqmod_mfb_lpf_pex_ota_core_hybrid_bm_half_0.iqmod_mfb_lpf_pex_ota_core_inv_NF20$1_0.vout.t41 voutp.t43 VSS.t334 VSS.t293 sg13_lv_nmos ad=0.19p pd=1.38u as=0.19p ps=1.38u w=1u l=1u
X5 VDD.t97 voutn.t43 iqmod_mfb_lpf_pex_half_1.iqmod_mfb_lpf_pex_ota_core_hybrid_bm_half_0.iqmod_mfb_lpf_pex_ota_core_inv_NF20$1_0.vout.t31 VDD.t6 sg13_lv_pmos ad=1.14p pd=6.38u as=1.14p ps=6.38u w=6u l=1u
X6 voutn.t12 iqmod_mfb_lpf_pex_half_0.iqmod_mfb_lpf_pex_ota_core_hybrid_bm_half_0.iqmod_mfb_lpf_pex_ota_core_inv_NF20$1_1.vin.t0 VDD.t28 VDD.t6 sg13_lv_pmos ad=1.14p pd=6.38u as=1.14p ps=6.38u w=6u l=1u
X7 iqmod_mfb_lpf_pex_half_1.iqmod_mfb_lpf_pex_ota_core_hybrid_bm_half_0.iqmod_mfb_lpf_pex_ota_core_tg$1_0.v_b.t29 iqmod_mfb_lpf_pex_half_1.iqmod_mfb_lpf_pex_ota_core_hybrid_bm_half_0.iqmod_mfb_lpf_pex_ota_core_tg$1_0.di_tg_ctrl_n.t3 iqmod_mfb_lpf_pex_half_1.iqmod_mfb_lpf_pex_ota_core_hybrid_bm_half_0.iqmod_mfb_lpf_pex_ota_core_tg$1_0.v_a.t0 VDD.t0 sg13_lv_pmos ad=1.14p pd=6.38u as=1.14p ps=6.38u w=6u l=0.13u
X8 VSS.t15 VSS.t16 VSS.t14 rhigh l=27u w=0.5u
X9 iqmod_mfb_lpf_pex_half_1.iqmod_mfb_lpf_pex_ota_core_hybrid_bm_half_0.iqmod_mfb_lpf_pex_ota_core_tg$1_0.v_a.t1 iqmod_mfb_lpf_pex_half_0.iqmod_mfb_lpf_pex_ota_core_hybrid_bm_half_0.iqmod_mfb_lpf_pex_ota_core_inv_NF20$1_1.vin.t0 VDD.t13 VDD.t6 sg13_lv_pmos ad=1.14p pd=6.38u as=1.14p ps=6.38u w=6u l=1u
X10 VSS.t269 iqmod_mfb_lpf_pex_half_1.iqmod_mfb_lpf_pex_ota_core_hybrid_bm_half_0.iqmod_mfb_lpf_pex_ota_core_tg$1_0.v_b.t37 voutp.t14 VSS.t225 sg13_lv_nmos ad=0.19p pd=1.38u as=0.19p ps=1.38u w=1u l=1u
X11 iqmod_mfb_lpf_pex_half_1.iqmod_mfb_lpf_pex_ota_core_hybrid_bm_half_0.iqmod_mfb_lpf_pex_ota_core_inv_NF6$1_1.vout.t11 iqmod_mfb_lpf_pex_half_1.iqmod_mfb_lpf_pex_ota_core_hybrid_bm_half_0.iqmod_mfb_lpf_pex_ota_core_inv_NF20$1_0.vout.t58 VSS.t392 VSS.t201 sg13_lv_nmos ad=0.19p pd=1.38u as=0.19p ps=1.38u w=1u l=1u
X12 VSS.t323 VSS.t324 VSS.t23 rhigh l=31u w=0.5u
X13 iqmod_mfb_lpf_pex_half_1.vinp.t1 iqmod_mfb_lpf_pex_half_1.iqmod_mfb_lpf_pex_ota_core_hybrid_bm_half_0.iqmod_mfb_lpf_pex_ota_core_tg$1_0.di_tg_ctrl_n.t4 iqmod_mfb_lpf_pex_half_1.iqmod_mfb_lpf_pex_ota_core_hybrid_bm_half_0.iqmod_mfb_lpf_pex_ota_core_inv_NF20$1_1.vin.t0 VDD.t0 sg13_lv_pmos ad=1.14p pd=6.38u as=1.14p ps=6.38u w=6u l=0.13u
X14 VSS.t248 VSS.t249 VSS.t71 rhigh l=60u w=0.5u
X15 voutp.t18 iqmod_mfb_lpf_pex_half_1.iqmod_mfb_lpf_pex_ota_core_hybrid_bm_half_0.iqmod_mfb_lpf_pex_ota_core_tg$1_0.v_b.t37 VSS.t271 VSS.t230 sg13_lv_nmos ad=0.19p pd=1.38u as=0.19p ps=1.38u w=1u l=1u
X16 VDD.t175 iqmod_mfb_lpf_pex_half_1.iqmod_mfb_lpf_pex_ota_core_hybrid_bm_half_0.iqmod_mfb_lpf_pex_ota_core_tg$1_0.v_b.t36 voutp.t5 VDD.t0 sg13_lv_pmos ad=1.14p pd=6.38u as=1.14p ps=6.38u w=6u l=1u
X17 iqmod_mfb_lpf_pex_half_1.C2_half.t7 iqmod_mfb_lpf_pex_half_1.iqmod_mfb_lpf_pex_R2_0.v_a.t0 cap_cmim l=8u w=8u
X18 iqmod_mfb_lpf_pex_half_1.iqmod_mfb_lpf_pex_ota_core_hybrid_bm_half_0.iqmod_mfb_lpf_pex_ota_core_inv_NF20$1_0.vout.t50 voutp.t42 VDD.t234 VDD.t0 sg13_lv_pmos ad=1.14p pd=6.38u as=1.14p ps=6.38u w=6u l=1u
X19 VDD.t70 VDD.t68 VDD.t69 VDD.t6 sg13_lv_pmos ad=2.04p pd=12.68u as=0 ps=0 w=6u l=1u
X20 VSS.t95 iqmod_mfb_lpf_pex_half_0.iqmod_mfb_lpf_pex_ota_core_hybrid_bm_half_0.iqmod_mfb_lpf_pex_ota_core_tg$1_0.di_tg_ctrl_n.t3 iqmod_mfb_lpf_pex_half_0.iqmod_mfb_lpf_pex_ota_core_hybrid_bm_half_0.iqmod_mfb_lpf_pex_ota_core_spdt_switch$1_0.iqmod_mfb_lpf_pex_ota_core_spdt_switch_inv$2_0.vout.t1 VSS.t79 sg13_lv_nmos ad=0.19p pd=1.38u as=0.19p ps=1.38u w=1u l=0.13u
X21 VSS.t173 VSS.t171 VSS.t172 VSS.t121 sg13_lv_nmos ad=0.34p pd=2.68u as=0 ps=0 w=1u l=1u
X22 voutn.t27 iqmod_mfb_lpf_pex_half_1.iqmod_mfb_lpf_pex_ota_core_hybrid_bm_half_0.iqmod_mfb_lpf_pex_ota_core_tg$1_0.v_b.t38 VSS.t226 VSS.t227 sg13_lv_nmos ad=0.19p pd=1.38u as=0.19p ps=1.38u w=1u l=1u
X23 iqmod_mfb_lpf_pex_half_1.iqmod_mfb_lpf_pex_ota_core_hybrid_bm_half_0.iqmod_mfb_lpf_pex_ota_core_inv_NF6$1_1.vout.t22 iqmod_mfb_lpf_pex_half_1.iqmod_mfb_lpf_pex_ota_core_hybrid_bm_half_0.iqmod_mfb_lpf_pex_ota_core_tg$1_0.di_tg_ctrl_n.t2 iqmod_mfb_lpf_pex_half_1.iqmod_mfb_lpf_pex_ota_core_hybrid_bm_half_0.iqmod_mfb_lpf_pex_ota_core_inv_NF20$1_0.vout.t32 VDD.t0 sg13_lv_pmos ad=1.14p pd=6.38u as=1.14p ps=6.38u w=6u l=0.13u
X24 iqmod_mfb_lpf_pex_half_1.iqmod_mfb_lpf_pex_ota_core_hybrid_bm_half_0.iqmod_mfb_lpf_pex_ota_core_inv_NF6$1_1.vout.t19 iqmod_mfb_lpf_pex_half_1.iqmod_mfb_lpf_pex_ota_core_hybrid_bm_half_0.iqmod_mfb_lpf_pex_ota_core_inv_NF20$1_0.vout.t56 VDD.t150 VDD.t0 sg13_lv_pmos ad=1.14p pd=6.38u as=1.14p ps=6.38u w=6u l=1u
X25 iqmod_mfb_lpf_pex_half_1.iqmod_mfb_lpf_pex_ota_core_hybrid_bm_half_0.iqmod_mfb_lpf_pex_ota_core_inv_NF6$1_1.vout.t5 di_filter_en.t4 iqmod_mfb_lpf_pex_half_1.iqmod_mfb_lpf_pex_ota_core_hybrid_bm_half_0.iqmod_mfb_lpf_pex_ota_core_inv_NF20$1_0.vout.t10 VSS.t244 sg13_lv_nmos ad=0.19p pd=1.38u as=0.19p ps=1.38u w=1u l=0.13u
X26 iqmod_mfb_lpf_pex_half_1.iqmod_mfb_lpf_pex_ota_core_hybrid_bm_half_0.iqmod_mfb_lpf_pex_ota_core_tg$1_0.v_b.t7 iqmod_mfb_lpf_pex_half_1.iqmod_mfb_lpf_pex_ota_core_hybrid_bm_half_0.iqmod_mfb_lpf_pex_ota_core_inv_NF6$1_1.vout.t25 VSS.t315 VSS.t316 sg13_lv_nmos ad=0.19p pd=1.38u as=0.19p ps=1.38u w=1u l=1u
X27 VDD.t39 iqmod_mfb_lpf_pex_half_0.iqmod_mfb_lpf_pex_ota_core_hybrid_bm_half_0.iqmod_mfb_lpf_pex_ota_core_tg$1_0.di_tg_ctrl_n.t8 iqmod_mfb_lpf_pex_half_0.iqmod_mfb_lpf_pex_ota_core_hybrid_bm_half_0.iqmod_mfb_lpf_pex_ota_core_spdt_switch$1_0.iqmod_mfb_lpf_pex_ota_core_spdt_switch_inv$2_0.vout.t0 VDD.t6 sg13_lv_pmos ad=1.14p pd=6.38u as=1.14p ps=6.38u w=6u l=0.13u
X28 iqmod_mfb_lpf_pex_half_0.vinp.t1 iqmod_mfb_lpf_pex_half_0.iqmod_mfb_lpf_pex_ota_core_hybrid_bm_half_0.iqmod_mfb_lpf_pex_ota_core_tg$1_0.di_tg_ctrl_n.t7 iqmod_mfb_lpf_pex_half_0.iqmod_mfb_lpf_pex_ota_core_hybrid_bm_half_0.iqmod_mfb_lpf_pex_ota_core_inv_NF20$1_1.vin.t0 VDD.t6 sg13_lv_pmos ad=1.14p pd=6.38u as=1.14p ps=6.38u w=6u l=0.13u
X29 VDD.t211 voutn.t43 iqmod_mfb_lpf_pex_half_1.iqmod_mfb_lpf_pex_ota_core_hybrid_bm_half_0.iqmod_mfb_lpf_pex_ota_core_inv_NF20$1_0.vout.t22 VDD.t6 sg13_lv_pmos ad=1.14p pd=6.38u as=1.14p ps=6.38u w=6u l=1u
X30 voutn.t15 iqmod_mfb_lpf_pex_half_0.iqmod_mfb_lpf_pex_ota_core_hybrid_bm_half_0.iqmod_mfb_lpf_pex_ota_core_inv_NF20$1_1.vin.t0 VSS.t45 VSS.t46 sg13_lv_nmos ad=0.19p pd=1.38u as=0.19p ps=1.38u w=1u l=1u
X31 iqmod_mfb_lpf_pex_half_1.iqmod_mfb_lpf_pex_R1_0.v_b.t8 iqmod_mfb_lpf_pex_half_1.C1_half.t3 cap_cmim l=8u w=8u
X32 iqmod_mfb_lpf_pex_half_1.iqmod_mfb_lpf_pex_ota_core_hybrid_bm_half_0.iqmod_mfb_lpf_pex_ota_core_inv_NF20$1_0.vout.t24 voutn.t43 VDD.t212 VDD.t6 sg13_lv_pmos ad=1.14p pd=6.38u as=1.14p ps=6.38u w=6u l=1u
X33 voutp.t41 iqmod_mfb_lpf_pex_half_1.vinp.t9 cap_cmim l=8u w=8u
X34 iqmod_mfb_lpf_pex_half_1.iqmod_mfb_lpf_pex_ota_core_hybrid_bm_half_0.iqmod_mfb_lpf_pex_ota_core_tg$1_0.v_b.t11 iqmod_mfb_lpf_pex_half_1.iqmod_mfb_lpf_pex_ota_core_hybrid_bm_half_0.iqmod_mfb_lpf_pex_ota_core_inv_NF6$1_1.vout.t27 VDD.t43 VDD.t6 sg13_lv_pmos ad=1.14p pd=6.38u as=1.14p ps=6.38u w=6u l=1u
X35 a_13404_n4303.t1 iqmod_mfb_lpf_pex_half_1.iqmod_mfb_lpf_pex_R2_0.v_a.t5 VSS.t20 rhigh l=59u w=0.5u
X36 vinn.t0 a_6122_n4303.t1 VSS.t194 rhigh l=27u w=0.5u
X37 VSS.t281 voutn.t42 iqmod_mfb_lpf_pex_half_1.iqmod_mfb_lpf_pex_ota_core_hybrid_bm_half_0.iqmod_mfb_lpf_pex_ota_core_inv_NF20$1_0.vout.t13 VSS.t280 sg13_lv_nmos ad=0.19p pd=1.38u as=0.19p ps=1.38u w=1u l=1u
X38 iqmod_mfb_lpf_pex_half_1.iqmod_mfb_lpf_pex_R1_0.v_b.t9 iqmod_mfb_lpf_pex_half_1.C1_half.t2 cap_cmim l=8u w=8u
X39 VDD.t52 VDD.t116 VDD.t52 VDD.t0 sg13_lv_pmos ad=1.14p pd=6.38u as=0 ps=0 w=6u l=1u
X40 VSS.t148 VSS.t146 VSS.t78 VSS.t90 sg13_lv_nmos ad=0.34p pd=2.68u as=0 ps=0 w=1u l=0.13u
X41 VSS.t311 VSS.t312 VSS.t74 rhigh l=59u w=0.5u
X42 iqmod_mfb_lpf_pex_half_1.C2_half.t6 iqmod_mfb_lpf_pex_half_1.iqmod_mfb_lpf_pex_R2_0.v_a.t3 cap_cmim l=8u w=8u
X43 VSS.t255 iqmod_mfb_lpf_pex_half_1.iqmod_mfb_lpf_pex_ota_core_hybrid_bm_half_0.iqmod_mfb_lpf_pex_ota_core_tg$1_0.v_b.t37 voutp.t11 VSS.t204 sg13_lv_nmos ad=0.19p pd=1.38u as=0.19p ps=1.38u w=1u l=1u
X44 VSS.t392 iqmod_mfb_lpf_pex_half_1.iqmod_mfb_lpf_pex_ota_core_hybrid_bm_half_0.iqmod_mfb_lpf_pex_ota_core_inv_NF20$1_0.vout.t58 iqmod_mfb_lpf_pex_half_1.iqmod_mfb_lpf_pex_ota_core_hybrid_bm_half_0.iqmod_mfb_lpf_pex_ota_core_inv_NF6$1_1.vout.t10 VSS.t199 sg13_lv_nmos ad=0.19p pd=1.38u as=0.19p ps=1.38u w=1u l=1u
X45 VSS.t257 iqmod_mfb_lpf_pex_half_1.iqmod_mfb_lpf_pex_ota_core_hybrid_bm_half_0.iqmod_mfb_lpf_pex_ota_core_tg$1_0.v_b.t37 voutp.t12 VSS.t207 sg13_lv_nmos ad=0.19p pd=1.38u as=0.19p ps=1.38u w=1u l=1u
X46 iqmod_mfb_lpf_pex_half_1.iqmod_mfb_lpf_pex_ota_core_hybrid_bm_half_0.iqmod_mfb_lpf_pex_ota_core_inv_NF6$1_1.vout.t18 iqmod_mfb_lpf_pex_half_1.iqmod_mfb_lpf_pex_ota_core_hybrid_bm_half_0.iqmod_mfb_lpf_pex_ota_core_inv_NF20$1_0.vout.t56 VDD.t134 VDD.t0 sg13_lv_pmos ad=1.14p pd=6.38u as=1.14p ps=6.38u w=6u l=1u
X47 VSS.t329 voutp.t43 iqmod_mfb_lpf_pex_half_1.iqmod_mfb_lpf_pex_ota_core_hybrid_bm_half_0.iqmod_mfb_lpf_pex_ota_core_inv_NF20$1_0.vout.t37 VSS.t280 sg13_lv_nmos ad=0.19p pd=1.38u as=0.19p ps=1.38u w=1u l=1u
X48 VDD.t189 iqmod_mfb_lpf_pex_half_1.iqmod_mfb_lpf_pex_ota_core_hybrid_bm_half_0.iqmod_mfb_lpf_pex_ota_core_tg$1_0.v_b.t39 voutn.t31 VDD.t6 sg13_lv_pmos ad=1.14p pd=6.38u as=1.14p ps=6.38u w=6u l=1u
X49 voutn.t25 iqmod_mfb_lpf_pex_half_1.iqmod_mfb_lpf_pex_ota_core_hybrid_bm_half_0.iqmod_mfb_lpf_pex_ota_core_tg$1_0.v_b.t38 VSS.t115 VSS.t203 sg13_lv_nmos ad=0.19p pd=1.38u as=0.19p ps=1.38u w=1u l=1u
X50 VSS.t95 VSS.t93 VSS.t95 VSS.t94 sg13_lv_nmos ad=0.19p pd=1.38u as=0 ps=0 w=1u l=0.13u
X51 iqmod_mfb_lpf_pex_half_1.iqmod_mfb_lpf_pex_ota_core_hybrid_bm_half_0.iqmod_mfb_lpf_pex_ota_core_inv_NF20$1_0.vout.t39 voutp.t43 VSS.t330 VSS.t290 sg13_lv_nmos ad=0.19p pd=1.38u as=0.19p ps=1.38u w=1u l=1u
X52 VSS.t126 iqmod_mfb_lpf_pex_half_1.iqmod_mfb_lpf_pex_ota_core_hybrid_bm_half_0.iqmod_mfb_lpf_pex_ota_core_inv_NF6$1_1.vout.t26 iqmod_mfb_lpf_pex_half_1.iqmod_mfb_lpf_pex_ota_core_hybrid_bm_half_0.iqmod_mfb_lpf_pex_ota_core_tg$1_0.v_b.t5 VSS.t320 sg13_lv_nmos ad=0.19p pd=1.38u as=0.19p ps=1.38u w=1u l=1u
X53 VSS.t163 VSS.t161 VSS.t162 VSS.t109 sg13_lv_nmos ad=0.34p pd=2.68u as=0 ps=0 w=1u l=1u
X54 iqmod_mfb_lpf_pex_half_1.iqmod_mfb_lpf_pex_ota_core_hybrid_bm_half_0.iqmod_mfb_lpf_pex_ota_core_inv_NF20$1_0.vout.t11 di_filter_en.t4 iqmod_mfb_lpf_pex_half_1.iqmod_mfb_lpf_pex_ota_core_hybrid_bm_half_0.iqmod_mfb_lpf_pex_ota_core_inv_NF6$1_1.vout.t5 VSS.t245 sg13_lv_nmos ad=0.34p pd=2.68u as=0.19p ps=1.38u w=1u l=0.13u
X55 voutn.t38 iqmod_mfb_lpf_pex_half_1.iqmod_mfb_lpf_pex_ota_core_hybrid_bm_half_0.iqmod_mfb_lpf_pex_ota_core_tg$1_0.v_b.t39 VDD.t191 VDD.t6 sg13_lv_pmos ad=1.14p pd=6.38u as=1.14p ps=6.38u w=6u l=1u
X56 iqmod_mfb_lpf_pex_half_1.C2_half.t8 iqmod_mfb_lpf_pex_half_1.iqmod_mfb_lpf_pex_R2_0.v_a.t2 cap_cmim l=8u w=8u
X57 iqmod_mfb_lpf_pex_half_1.iqmod_mfb_lpf_pex_ota_core_hybrid_bm_half_0.iqmod_mfb_lpf_pex_ota_core_inv_NF6$1_1.vout.t3 di_filter_en.t4 iqmod_mfb_lpf_pex_half_1.iqmod_mfb_lpf_pex_ota_core_hybrid_bm_half_0.iqmod_mfb_lpf_pex_ota_core_inv_NF20$1_0.vout.t8 VSS.t240 sg13_lv_nmos ad=0.19p pd=1.38u as=0.34p ps=2.68u w=1u l=0.13u
X58 VSS.t334 voutp.t43 iqmod_mfb_lpf_pex_half_1.iqmod_mfb_lpf_pex_ota_core_hybrid_bm_half_0.iqmod_mfb_lpf_pex_ota_core_inv_NF20$1_0.vout.t40 VSS.t291 sg13_lv_nmos ad=0.19p pd=1.38u as=0.19p ps=1.38u w=1u l=1u
X59 voutp.t25 iqmod_mfb_lpf_pex_half_1.iqmod_mfb_lpf_pex_ota_core_hybrid_bm_half_0.iqmod_mfb_lpf_pex_ota_core_inv_NF20$1_1.vin.t0 VSS.t362 VSS.t46 sg13_lv_nmos ad=0.19p pd=1.38u as=0.19p ps=1.38u w=1u l=1u
X60 voutp.t10 iqmod_mfb_lpf_pex_half_1.iqmod_mfb_lpf_pex_ota_core_hybrid_bm_half_0.iqmod_mfb_lpf_pex_ota_core_tg$1_0.v_b.t36 VDD.t124 VDD.t0 sg13_lv_pmos ad=1.14p pd=6.38u as=1.14p ps=6.38u w=6u l=1u
X61 iqmod_mfb_lpf_pex_half_1.iqmod_mfb_lpf_pex_ota_core_hybrid_bm_half_0.iqmod_mfb_lpf_pex_ota_core_inv_NF20$1_0.vout.t31 voutn.t43 VDD.t227 VDD.t6 sg13_lv_pmos ad=1.14p pd=6.38u as=1.14p ps=6.38u w=6u l=1u
X62 VDD.t148 iqmod_mfb_lpf_pex_half_1.iqmod_mfb_lpf_pex_ota_core_hybrid_bm_half_0.iqmod_mfb_lpf_pex_ota_core_inv_NF20$1_0.vout.t56 iqmod_mfb_lpf_pex_half_1.iqmod_mfb_lpf_pex_ota_core_hybrid_bm_half_0.iqmod_mfb_lpf_pex_ota_core_inv_NF6$1_1.vout.t19 VDD.t0 sg13_lv_pmos ad=1.14p pd=6.38u as=1.14p ps=6.38u w=6u l=1u
X63 iqmod_mfb_lpf_pex_half_1.iqmod_mfb_lpf_pex_ota_core_hybrid_bm_half_0.iqmod_mfb_lpf_pex_ota_core_inv_NF6$1_1.vout.t7 di_filter_en.t1 iqmod_mfb_lpf_pex_half_1.iqmod_mfb_lpf_pex_ota_core_hybrid_bm_half_0.iqmod_mfb_lpf_pex_ota_core_inv_NF20$1_0.vout.t7 VSS.t242 sg13_lv_nmos ad=0.19p pd=1.38u as=0.19p ps=1.38u w=1u l=0.13u
X64 VDD.t271 iqmod_mfb_lpf_pex_half_1.iqmod_mfb_lpf_pex_ota_core_hybrid_bm_half_0.iqmod_mfb_lpf_pex_ota_core_inv_NF20$1_1.vin.t0 voutp.t24 VDD.t0 sg13_lv_pmos ad=1.14p pd=6.38u as=1.14p ps=6.38u w=6u l=1u
X65 voutn.t10 iqmod_mfb_lpf_pex_half_0.iqmod_mfb_lpf_pex_ota_core_hybrid_bm_half_0.iqmod_mfb_lpf_pex_ota_core_inv_NF20$1_1.vin.t0 VSS.t64 VSS.t65 sg13_lv_nmos ad=0.19p pd=1.38u as=0.19p ps=1.38u w=1u l=1u
X66 iqmod_mfb_lpf_pex_half_1.iqmod_mfb_lpf_pex_ota_core_hybrid_bm_half_0.iqmod_mfb_lpf_pex_ota_core_inv_NF20$1_0.vout.t42 voutp.t43 VSS.t337 VSS.t285 sg13_lv_nmos ad=0.19p pd=1.38u as=0.19p ps=1.38u w=1u l=1u
X67 VSS.t286 voutn.t42 iqmod_mfb_lpf_pex_half_1.iqmod_mfb_lpf_pex_ota_core_hybrid_bm_half_0.iqmod_mfb_lpf_pex_ota_core_inv_NF20$1_0.vout.t17 VSS.t294 sg13_lv_nmos ad=0.19p pd=1.38u as=0.19p ps=1.38u w=1u l=1u
X68 VDD.t110 VDD.t108 VDD.t109 VDD.t0 sg13_lv_pmos ad=2.04p pd=12.68u as=0 ps=0 w=6u l=1u
X69 iqmod_mfb_lpf_pex_half_1.iqmod_mfb_lpf_pex_ota_core_hybrid_bm_half_0.iqmod_mfb_lpf_pex_ota_core_inv_NF20$1_0.vout.t9 di_filter_en.t4 iqmod_mfb_lpf_pex_half_1.iqmod_mfb_lpf_pex_ota_core_hybrid_bm_half_0.iqmod_mfb_lpf_pex_ota_core_inv_NF6$1_1.vout.t3 VSS.t241 sg13_lv_nmos ad=0.19p pd=1.38u as=0.19p ps=1.38u w=1u l=0.13u
X70 VSS.t54 iqmod_mfb_lpf_pex_half_0.iqmod_mfb_lpf_pex_ota_core_hybrid_bm_half_0.iqmod_mfb_lpf_pex_ota_core_inv_NF20$1_1.vin.t0 voutn.t1 VSS.t53 sg13_lv_nmos ad=0.19p pd=1.38u as=0.19p ps=1.38u w=1u l=1u
X71 iqmod_mfb_lpf_pex_half_1.iqmod_mfb_lpf_pex_ota_core_hybrid_bm_half_0.iqmod_mfb_lpf_pex_ota_core_inv_NF20$1_0.vout.t55 voutp.t42 VDD.t243 VDD.t0 sg13_lv_pmos ad=1.14p pd=6.38u as=1.14p ps=6.38u w=6u l=1u
X72 voutp.t14 iqmod_mfb_lpf_pex_half_1.iqmod_mfb_lpf_pex_ota_core_hybrid_bm_half_0.iqmod_mfb_lpf_pex_ota_core_tg$1_0.v_b.t37 VSS.t267 VSS.t224 sg13_lv_nmos ad=0.19p pd=1.38u as=0.19p ps=1.38u w=1u l=1u
X73 iqmod_mfb_lpf_pex_half_1.iqmod_mfb_lpf_pex_ota_core_hybrid_bm_half_0.iqmod_mfb_lpf_pex_ota_core_tg$1_0.v_b.t27 iqmod_mfb_lpf_pex_half_1.iqmod_mfb_lpf_pex_ota_core_hybrid_bm_half_0.iqmod_mfb_lpf_pex_ota_core_tg$1_0.di_tg_ctrl_n.t3 iqmod_mfb_lpf_pex_half_1.iqmod_mfb_lpf_pex_ota_core_hybrid_bm_half_0.iqmod_mfb_lpf_pex_ota_core_tg$1_0.v_a.t0 VDD.t0 sg13_lv_pmos ad=1.14p pd=6.38u as=2.04p ps=12.68u w=6u l=0.13u
X74 iqmod_mfb_lpf_pex_half_1.iqmod_mfb_lpf_pex_ota_core_hybrid_bm_half_0.iqmod_mfb_lpf_pex_ota_core_inv_NF20$1_0.vout.t13 voutn.t42 VSS.t277 VSS.t276 sg13_lv_nmos ad=0.19p pd=1.38u as=0.19p ps=1.38u w=1u l=1u
X75 voutp.t37 iqmod_mfb_lpf_pex_half_1.iqmod_mfb_lpf_pex_ota_core_hybrid_bm_half_0.iqmod_mfb_lpf_pex_ota_core_inv_NF20$1_1.vin.t0 VDD.t119 VDD.t0 sg13_lv_pmos ad=1.14p pd=6.38u as=1.14p ps=6.38u w=6u l=1u
X76 VDD.t24 iqmod_mfb_lpf_pex_half_0.iqmod_mfb_lpf_pex_ota_core_hybrid_bm_half_0.iqmod_mfb_lpf_pex_ota_core_inv_NF20$1_1.vin.t0 voutn.t19 VDD.t6 sg13_lv_pmos ad=1.14p pd=6.38u as=1.14p ps=6.38u w=6u l=1u
X77 iqmod_mfb_lpf_pex_half_1.iqmod_mfb_lpf_pex_ota_core_hybrid_bm_half_0.iqmod_mfb_lpf_pex_ota_core_inv_NF20$1_0.vout.t29 voutn.t43 VDD.t223 VDD.t6 sg13_lv_pmos ad=1.14p pd=6.38u as=1.14p ps=6.38u w=6u l=1u
X78 VSS.t271 iqmod_mfb_lpf_pex_half_1.iqmod_mfb_lpf_pex_ota_core_hybrid_bm_half_0.iqmod_mfb_lpf_pex_ota_core_tg$1_0.v_b.t37 voutp.t20 VSS.t228 sg13_lv_nmos ad=0.19p pd=1.38u as=0.19p ps=1.38u w=1u l=1u
X79 iqmod_mfb_lpf_pex_half_0.iqmod_mfb_lpf_pex_ota_core_hybrid_bm_half_0.iqmod_mfb_lpf_pex_ota_core_inv_NF20$1_1.vin.t0 iqmod_mfb_lpf_pex_half_0.iqmod_mfb_lpf_pex_ota_core_hybrid_bm_half_0.iqmod_mfb_lpf_pex_ota_core_tg$1_0.di_tg_ctrl_n.t7 iqmod_mfb_lpf_pex_half_0.vinp.t2 VDD.t6 sg13_lv_pmos ad=1.14p pd=6.38u as=1.14p ps=6.38u w=6u l=0.13u
X80 VDD.t244 voutp.t42 iqmod_mfb_lpf_pex_half_1.iqmod_mfb_lpf_pex_ota_core_hybrid_bm_half_0.iqmod_mfb_lpf_pex_ota_core_inv_NF20$1_0.vout.t52 VDD.t0 sg13_lv_pmos ad=1.14p pd=6.38u as=1.14p ps=6.38u w=6u l=1u
X81 VDD.t9 iqmod_mfb_lpf_pex_half_0.iqmod_mfb_lpf_pex_ota_core_hybrid_bm_half_0.iqmod_mfb_lpf_pex_ota_core_inv_NF20$1_1.vin.t0 iqmod_mfb_lpf_pex_half_1.iqmod_mfb_lpf_pex_ota_core_hybrid_bm_half_0.iqmod_mfb_lpf_pex_ota_core_tg$1_0.v_a.t1 VDD.t6 sg13_lv_pmos ad=1.14p pd=6.38u as=1.14p ps=6.38u w=6u l=1u
X82 iqmod_mfb_lpf_pex_half_1.iqmod_mfb_lpf_pex_ota_core_hybrid_bm_half_0.iqmod_mfb_lpf_pex_ota_core_tg$1_0.v_a.t1 iqmod_mfb_lpf_pex_half_0.iqmod_mfb_lpf_pex_ota_core_hybrid_bm_half_0.iqmod_mfb_lpf_pex_ota_core_tg$1_0.di_tg_ctrl_n.t5 iqmod_mfb_lpf_pex_half_1.iqmod_mfb_lpf_pex_ota_core_hybrid_bm_half_0.iqmod_mfb_lpf_pex_ota_core_tg$1_0.v_b.t1 VDD.t6 sg13_lv_pmos ad=1.14p pd=6.38u as=1.14p ps=6.38u w=6u l=0.13u
X83 VDD.t227 voutn.t43 iqmod_mfb_lpf_pex_half_1.iqmod_mfb_lpf_pex_ota_core_hybrid_bm_half_0.iqmod_mfb_lpf_pex_ota_core_inv_NF20$1_0.vout.t30 VDD.t6 sg13_lv_pmos ad=1.14p pd=6.38u as=1.14p ps=6.38u w=6u l=1u
X84 a_13404_n4303.t0 a_25290_n4603.t0 VSS.t20 rhigh l=59u w=0.5u
X85 a_636_n4603.t0 a_6122_n4303.t0 VSS.t194 rhigh l=27u w=0.5u
X86 iqmod_mfb_lpf_pex_half_1.iqmod_mfb_lpf_pex_ota_core_hybrid_bm_half_0.iqmod_mfb_lpf_pex_ota_core_tg$1_0.v_a.t0 di_filter_en.t2 iqmod_mfb_lpf_pex_half_1.iqmod_mfb_lpf_pex_ota_core_hybrid_bm_half_0.iqmod_mfb_lpf_pex_ota_core_tg$1_0.v_b.t23 VSS.t239 sg13_lv_nmos ad=0.34p pd=2.68u as=0.19p ps=1.38u w=1u l=0.13u
X87 iqmod_mfb_lpf_pex_half_1.iqmod_mfb_lpf_pex_ota_core_hybrid_bm_half_0.iqmod_mfb_lpf_pex_ota_core_inv_NF20$1_1.vin.t0 iqmod_mfb_lpf_pex_half_1.iqmod_mfb_lpf_pex_ota_core_hybrid_bm_half_0.iqmod_mfb_lpf_pex_ota_core_tg$1_0.di_tg_ctrl_n.t7 VDD.t4 VSS.t9 sg13_lv_nmos ad=0.19p pd=1.38u as=0.34p ps=2.68u w=1u l=0.13u
X88 a_6620_n4303.t0 iqmod_mfb_lpf_pex_half_1.iqmod_mfb_lpf_pex_R2_0.v_a.t1 VSS.t23 rhigh l=31u w=0.5u
X89 voutp.t32 iqmod_mfb_lpf_pex_half_1.iqmod_mfb_lpf_pex_ota_core_hybrid_bm_half_0.iqmod_mfb_lpf_pex_ota_core_inv_NF20$1_1.vin.t0 VDD.t273 VDD.t0 sg13_lv_pmos ad=1.14p pd=6.38u as=1.14p ps=6.38u w=6u l=1u
X90 VDD.t82 iqmod_mfb_lpf_pex_half_1.iqmod_mfb_lpf_pex_ota_core_hybrid_bm_half_0.iqmod_mfb_lpf_pex_ota_core_tg$1_0.v_b.t39 voutn.t37 VDD.t6 sg13_lv_pmos ad=1.14p pd=6.38u as=1.14p ps=6.38u w=6u l=1u
X91 iqmod_mfb_lpf_pex_half_1.iqmod_mfb_lpf_pex_ota_core_hybrid_bm_half_0.iqmod_mfb_lpf_pex_ota_core_tg$1_0.v_b.t22 di_filter_en.t2 iqmod_mfb_lpf_pex_half_1.iqmod_mfb_lpf_pex_ota_core_hybrid_bm_half_0.iqmod_mfb_lpf_pex_ota_core_tg$1_0.v_a.t0 VSS.t236 sg13_lv_nmos ad=0.19p pd=1.38u as=0.19p ps=1.38u w=1u l=0.13u
X92 iqmod_mfb_lpf_pex_half_1.iqmod_mfb_lpf_pex_R2_0.v_a.t4 a_37874_n4303.t0 VSS.t71 rhigh l=60u w=0.5u
X93 iqmod_mfb_lpf_pex_half_1.iqmod_mfb_lpf_pex_ota_core_hybrid_bm_half_0.iqmod_mfb_lpf_pex_ota_core_inv_NF20$1_1.vin.t0 iqmod_mfb_lpf_pex_half_1.iqmod_mfb_lpf_pex_ota_core_hybrid_bm_half_0.iqmod_mfb_lpf_pex_ota_core_spdt_switch$1_0.iqmod_mfb_lpf_pex_ota_core_spdt_switch_inv$2_0.vout.t4 iqmod_mfb_lpf_pex_half_1.vinp.t5 VSS.t5 sg13_lv_nmos ad=0.19p pd=1.38u as=0.19p ps=1.38u w=1u l=0.13u
X94 a_13404_3903.t0 iqmod_mfb_lpf_pex_half_1.C2_half.t3 VSS.t74 rhigh l=59u w=0.5u
X95 VSS.t45 iqmod_mfb_lpf_pex_half_0.iqmod_mfb_lpf_pex_ota_core_hybrid_bm_half_0.iqmod_mfb_lpf_pex_ota_core_inv_NF20$1_1.vin.t0 voutn.t0 VSS.t44 sg13_lv_nmos ad=0.19p pd=1.38u as=0.19p ps=1.38u w=1u l=1u
X96 iqmod_mfb_lpf_pex_half_1.iqmod_mfb_lpf_pex_ota_core_hybrid_bm_half_0.iqmod_mfb_lpf_pex_ota_core_tg$1_0.v_a.t0 iqmod_mfb_lpf_pex_half_1.iqmod_mfb_lpf_pex_ota_core_hybrid_bm_half_0.iqmod_mfb_lpf_pex_ota_core_inv_NF20$1_1.vin.t0 VDD.t257 VDD.t0 sg13_lv_pmos ad=1.14p pd=6.38u as=1.14p ps=6.38u w=6u l=1u
X97 VSS.t267 iqmod_mfb_lpf_pex_half_1.iqmod_mfb_lpf_pex_ota_core_hybrid_bm_half_0.iqmod_mfb_lpf_pex_ota_core_tg$1_0.v_b.t37 voutp.t13 VSS.t222 sg13_lv_nmos ad=0.19p pd=1.38u as=0.19p ps=1.38u w=1u l=1u
X98 voutn.t29 iqmod_mfb_lpf_pex_half_1.iqmod_mfb_lpf_pex_ota_core_hybrid_bm_half_0.iqmod_mfb_lpf_pex_ota_core_tg$1_0.v_b.t38 VSS.t211 VSS.t212 sg13_lv_nmos ad=0.19p pd=1.38u as=0.19p ps=1.38u w=1u l=1u
X99 iqmod_mfb_lpf_pex_half_1.iqmod_mfb_lpf_pex_ota_core_hybrid_bm_half_0.iqmod_mfb_lpf_pex_ota_core_tg$1_0.v_a.t1 iqmod_mfb_lpf_pex_half_0.iqmod_mfb_lpf_pex_ota_core_hybrid_bm_half_0.iqmod_mfb_lpf_pex_ota_core_inv_NF20$1_1.vin.t0 VSS.t37 VSS.t38 sg13_lv_nmos ad=0.19p pd=1.38u as=0.19p ps=1.38u w=1u l=1u
X100 iqmod_mfb_lpf_pex_half_1.C1_half.t7 iqmod_mfb_lpf_pex_half_1.iqmod_mfb_lpf_pex_R1_0.v_b.t6 cap_cmim l=8u w=8u
X101 VDD.t137 VDD.t136 VDD.t137 VDD.t0 sg13_lv_pmos ad=1.14p pd=6.38u as=0 ps=0 w=6u l=1u
X102 voutp.t20 iqmod_mfb_lpf_pex_half_1.iqmod_mfb_lpf_pex_ota_core_hybrid_bm_half_0.iqmod_mfb_lpf_pex_ota_core_tg$1_0.v_b.t37 VSS.t269 VSS.t227 sg13_lv_nmos ad=0.19p pd=1.38u as=0.19p ps=1.38u w=1u l=1u
X103 voutp.t34 iqmod_mfb_lpf_pex_half_1.iqmod_mfb_lpf_pex_ota_core_hybrid_bm_half_0.iqmod_mfb_lpf_pex_ota_core_inv_NF20$1_1.vin.t0 VSS.t376 VSS.t65 sg13_lv_nmos ad=0.19p pd=1.38u as=0.19p ps=1.38u w=1u l=1u
X104 iqmod_mfb_lpf_pex_half_1.iqmod_mfb_lpf_pex_ota_core_hybrid_bm_half_0.iqmod_mfb_lpf_pex_ota_core_inv_NF20$1_0.vout.t54 voutp.t42 VDD.t246 VDD.t0 sg13_lv_pmos ad=1.14p pd=6.38u as=1.14p ps=6.38u w=6u l=1u
X105 VDD.t43 iqmod_mfb_lpf_pex_half_1.iqmod_mfb_lpf_pex_ota_core_hybrid_bm_half_0.iqmod_mfb_lpf_pex_ota_core_inv_NF6$1_1.vout.t27 iqmod_mfb_lpf_pex_half_1.iqmod_mfb_lpf_pex_ota_core_hybrid_bm_half_0.iqmod_mfb_lpf_pex_ota_core_tg$1_0.v_b.t10 VDD.t6 sg13_lv_pmos ad=1.14p pd=6.38u as=1.14p ps=6.38u w=6u l=1u
X106 VSS.t155 VSS.t154 VSS.t155 VSS.t100 sg13_lv_nmos ad=0.19p pd=1.38u as=0 ps=0 w=1u l=1u
X107 VSS.t165 iqmod_mfb_lpf_pex_half_1.iqmod_mfb_lpf_pex_ota_core_hybrid_bm_half_0.iqmod_mfb_lpf_pex_ota_core_inv_NF20$1_1.vin.t0 voutp.t35 VSS.t69 sg13_lv_nmos ad=0.19p pd=1.38u as=0.19p ps=1.38u w=1u l=1u
X108 iqmod_mfb_lpf_pex_half_1.iqmod_mfb_lpf_pex_ota_core_hybrid_bm_half_0.iqmod_mfb_lpf_pex_ota_core_inv_NF6$1_1.vout.t16 iqmod_mfb_lpf_pex_half_1.iqmod_mfb_lpf_pex_ota_core_hybrid_bm_half_0.iqmod_mfb_lpf_pex_ota_core_inv_NF20$1_0.vout.t59 VDD.t155 VDD.t6 sg13_lv_pmos ad=1.14p pd=6.38u as=1.14p ps=6.38u w=6u l=1u
X109 VSS.t348 iqmod_mfb_lpf_pex_half_1.iqmod_mfb_lpf_pex_ota_core_hybrid_bm_half_0.iqmod_mfb_lpf_pex_ota_core_tg$1_0.v_a.t1 iqmod_mfb_lpf_pex_half_1.iqmod_mfb_lpf_pex_ota_core_hybrid_bm_half_0.iqmod_mfb_lpf_pex_ota_core_tg$1_0.v_b.t31 VSS.t190 sg13_lv_nmos ad=0.19p pd=1.38u as=0.19p ps=1.38u w=1u l=1u
X110 VDD.t295 iqmod_mfb_lpf_pex_half_1.iqmod_mfb_lpf_pex_ota_core_hybrid_bm_half_0.iqmod_mfb_lpf_pex_ota_core_spdt_switch$1_0.iqmod_mfb_lpf_pex_ota_core_spdt_switch_inv$2_0.vout.t2 iqmod_mfb_lpf_pex_half_1.iqmod_mfb_lpf_pex_ota_core_hybrid_bm_half_0.iqmod_mfb_lpf_pex_ota_core_inv_NF20$1_1.vin.t0 VDD.t0 sg13_lv_pmos ad=2.04p pd=12.68u as=1.14p ps=6.38u w=6u l=0.13u
X111 VDD.t45 VDD.t86 VDD.t45 VDD.t6 sg13_lv_pmos ad=1.14p pd=6.38u as=0 ps=0 w=6u l=1u
X112 VDD.t205 iqmod_mfb_lpf_pex_half_1.iqmod_mfb_lpf_pex_ota_core_hybrid_bm_half_0.iqmod_mfb_lpf_pex_ota_core_inv_NF6$1_1.vout.t24 iqmod_mfb_lpf_pex_half_1.iqmod_mfb_lpf_pex_ota_core_hybrid_bm_half_0.iqmod_mfb_lpf_pex_ota_core_tg$1_0.v_b.t12 VDD.t0 sg13_lv_pmos ad=1.14p pd=6.38u as=1.14p ps=6.38u w=6u l=1u
X113 voutp.t1 iqmod_mfb_lpf_pex_half_1.iqmod_mfb_lpf_pex_ota_core_hybrid_bm_half_0.iqmod_mfb_lpf_pex_ota_core_tg$1_0.v_b.t36 VDD.t165 VDD.t0 sg13_lv_pmos ad=1.14p pd=6.38u as=1.14p ps=6.38u w=6u l=1u
X114 iqmod_mfb_lpf_pex_half_1.iqmod_mfb_lpf_pex_ota_core_hybrid_bm_half_0.iqmod_mfb_lpf_pex_ota_core_inv_NF6$1_1.vout.t4 di_filter_en.t4 iqmod_mfb_lpf_pex_half_1.iqmod_mfb_lpf_pex_ota_core_hybrid_bm_half_0.iqmod_mfb_lpf_pex_ota_core_inv_NF20$1_0.vout.t9 VSS.t242 sg13_lv_nmos ad=0.19p pd=1.38u as=0.19p ps=1.38u w=1u l=0.13u
X115 voutp.t11 iqmod_mfb_lpf_pex_half_1.iqmod_mfb_lpf_pex_ota_core_hybrid_bm_half_0.iqmod_mfb_lpf_pex_ota_core_tg$1_0.v_b.t37 VSS.t167 VSS.t203 sg13_lv_nmos ad=0.19p pd=1.38u as=0.19p ps=1.38u w=1u l=1u
X116 iqmod_mfb_lpf_pex_half_1.iqmod_mfb_lpf_pex_ota_core_hybrid_bm_half_0.iqmod_mfb_lpf_pex_ota_core_inv_NF20$1_0.vout.t2 iqmod_mfb_lpf_pex_half_0.iqmod_mfb_lpf_pex_ota_core_hybrid_bm_half_0.iqmod_mfb_lpf_pex_ota_core_tg$1_0.di_tg_ctrl_n.t4 iqmod_mfb_lpf_pex_half_1.iqmod_mfb_lpf_pex_ota_core_hybrid_bm_half_0.iqmod_mfb_lpf_pex_ota_core_inv_NF6$1_1.vout.t1 VDD.t6 sg13_lv_pmos ad=1.14p pd=6.38u as=1.14p ps=6.38u w=6u l=0.13u
X117 VDD.t137 iqmod_mfb_lpf_pex_half_1.iqmod_mfb_lpf_pex_ota_core_hybrid_bm_half_0.iqmod_mfb_lpf_pex_ota_core_inv_NF20$1_0.vout.t56 iqmod_mfb_lpf_pex_half_1.iqmod_mfb_lpf_pex_ota_core_hybrid_bm_half_0.iqmod_mfb_lpf_pex_ota_core_inv_NF6$1_1.vout.t20 VDD.t0 sg13_lv_pmos ad=1.14p pd=6.38u as=1.14p ps=6.38u w=6u l=1u
X118 iqmod_mfb_lpf_pex_half_1.C1_half.t9 iqmod_mfb_lpf_pex_half_1.iqmod_mfb_lpf_pex_R1_0.v_b.t1 cap_cmim l=8u w=8u
X119 iqmod_mfb_lpf_pex_half_1.iqmod_mfb_lpf_pex_ota_core_hybrid_bm_half_0.iqmod_mfb_lpf_pex_ota_core_inv_NF20$1_0.vout.t5 di_filter_en.t1 iqmod_mfb_lpf_pex_half_1.iqmod_mfb_lpf_pex_ota_core_hybrid_bm_half_0.iqmod_mfb_lpf_pex_ota_core_inv_NF6$1_1.vout.t8 VSS.t245 sg13_lv_nmos ad=0.34p pd=2.68u as=0.19p ps=1.38u w=1u l=0.13u
X120 VSS.t191 iqmod_mfb_lpf_pex_half_1.iqmod_mfb_lpf_pex_ota_core_hybrid_bm_half_0.iqmod_mfb_lpf_pex_ota_core_tg$1_0.v_a.t0 iqmod_mfb_lpf_pex_half_1.iqmod_mfb_lpf_pex_ota_core_hybrid_bm_half_0.iqmod_mfb_lpf_pex_ota_core_tg$1_0.v_b.t16 VSS.t190 sg13_lv_nmos ad=0.19p pd=1.38u as=0.19p ps=1.38u w=1u l=1u
X121 VSS.t116 VSS.t113 VSS.t115 VSS.t114 sg13_lv_nmos ad=0.34p pd=2.68u as=0 ps=0 w=1u l=1u
X122 voutn.t36 iqmod_mfb_lpf_pex_half_1.iqmod_mfb_lpf_pex_ota_core_hybrid_bm_half_0.iqmod_mfb_lpf_pex_ota_core_tg$1_0.v_b.t39 VDD.t185 VDD.t6 sg13_lv_pmos ad=1.14p pd=6.38u as=1.14p ps=6.38u w=6u l=1u
X123 voutn.t31 iqmod_mfb_lpf_pex_half_1.iqmod_mfb_lpf_pex_ota_core_hybrid_bm_half_0.iqmod_mfb_lpf_pex_ota_core_tg$1_0.v_b.t39 VDD.t187 VDD.t6 sg13_lv_pmos ad=1.14p pd=6.38u as=1.14p ps=6.38u w=6u l=1u
X124 VDD.t281 iqmod_mfb_lpf_pex_half_1.iqmod_mfb_lpf_pex_ota_core_hybrid_bm_half_0.iqmod_mfb_lpf_pex_ota_core_inv_NF20$1_1.vin.t0 voutp.t22 VDD.t0 sg13_lv_pmos ad=1.14p pd=6.38u as=1.14p ps=6.38u w=6u l=1u
X125 VDD.t112 iqmod_mfb_lpf_pex_half_1.iqmod_mfb_lpf_pex_ota_core_hybrid_bm_half_0.iqmod_mfb_lpf_pex_ota_core_inv_NF20$1_1.vin.t0 iqmod_mfb_lpf_pex_half_1.iqmod_mfb_lpf_pex_ota_core_hybrid_bm_half_0.iqmod_mfb_lpf_pex_ota_core_tg$1_0.v_a.t0 VDD.t0 sg13_lv_pmos ad=1.14p pd=6.38u as=1.14p ps=6.38u w=6u l=1u
X126 iqmod_mfb_lpf_pex_half_0.iqmod_mfb_lpf_pex_ota_core_hybrid_bm_half_0.iqmod_mfb_lpf_pex_ota_core_inv_NF20$1_1.vin.t0 iqmod_mfb_lpf_pex_half_0.iqmod_mfb_lpf_pex_ota_core_hybrid_bm_half_0.iqmod_mfb_lpf_pex_ota_core_spdt_switch$1_0.iqmod_mfb_lpf_pex_ota_core_spdt_switch_inv$2_0.vout.t4 VDD.t146 VDD.t6 sg13_lv_pmos ad=1.14p pd=6.38u as=1.14p ps=6.38u w=6u l=0.13u
X127 VDD.t191 iqmod_mfb_lpf_pex_half_1.iqmod_mfb_lpf_pex_ota_core_hybrid_bm_half_0.iqmod_mfb_lpf_pex_ota_core_tg$1_0.v_b.t39 voutn.t32 VDD.t6 sg13_lv_pmos ad=1.14p pd=6.38u as=1.14p ps=6.38u w=6u l=1u
X128 VDD.t2 VDD.t106 VDD.t2 VDD.t0 sg13_lv_pmos ad=1.14p pd=6.38u as=0 ps=0 w=6u l=0.13u
X129 iqmod_mfb_lpf_pex_half_1.C1_half.t11 iqmod_mfb_lpf_pex_half_1.iqmod_mfb_lpf_pex_R1_0.v_b.t5 cap_cmim l=8u w=8u
X130 VDD.t100 VDD.t98 VDD.t99 VDD.t0 sg13_lv_pmos ad=2.04p pd=12.68u as=0 ps=0 w=6u l=0.13u
X131 VSS.t119 VSS.t117 VSS.t119 VSS.t118 sg13_lv_nmos ad=0.19p pd=1.38u as=0 ps=0 w=1u l=1u
X132 iqmod_mfb_lpf_pex_half_1.vinp.t8 a_25290_n4603.t1 VSS.t20 rhigh l=59u w=0.5u
X133 a_636_n4603.t1 iqmod_mfb_lpf_pex_half_1.iqmod_mfb_lpf_pex_R1_0.v_b.t2 VSS.t194 rhigh l=27u w=0.5u
X134 voutp.t33 iqmod_mfb_lpf_pex_half_1.iqmod_mfb_lpf_pex_ota_core_hybrid_bm_half_0.iqmod_mfb_lpf_pex_ota_core_inv_NF20$1_1.vin.t0 VDD.t275 VDD.t0 sg13_lv_pmos ad=1.14p pd=6.38u as=1.14p ps=6.38u w=6u l=1u
X135 iqmod_mfb_lpf_pex_half_1.iqmod_mfb_lpf_pex_ota_core_hybrid_bm_half_0.iqmod_mfb_lpf_pex_ota_core_inv_NF20$1_0.vout.t40 voutp.t43 VSS.t333 VSS.t274 sg13_lv_nmos ad=0.19p pd=1.38u as=0.19p ps=1.38u w=1u l=1u
X136 VSS.t180 VSS.t179 VSS.t180 VSS.t132 sg13_lv_nmos ad=0.19p pd=1.38u as=0 ps=0 w=1u l=1u
X137 VSS.t362 iqmod_mfb_lpf_pex_half_1.iqmod_mfb_lpf_pex_ota_core_hybrid_bm_half_0.iqmod_mfb_lpf_pex_ota_core_inv_NF20$1_1.vin.t0 voutp.t36 VSS.t44 sg13_lv_nmos ad=0.19p pd=1.38u as=0.19p ps=1.38u w=1u l=1u
X138 VSS.t64 iqmod_mfb_lpf_pex_half_0.iqmod_mfb_lpf_pex_ota_core_hybrid_bm_half_0.iqmod_mfb_lpf_pex_ota_core_inv_NF20$1_1.vin.t0 voutn.t9 VSS.t63 sg13_lv_nmos ad=0.19p pd=1.38u as=0.19p ps=1.38u w=1u l=1u
X139 iqmod_mfb_lpf_pex_half_1.iqmod_mfb_lpf_pex_ota_core_hybrid_bm_half_0.iqmod_mfb_lpf_pex_ota_core_inv_NF20$1_1.vin.t0 iqmod_mfb_lpf_pex_half_1.iqmod_mfb_lpf_pex_ota_core_hybrid_bm_half_0.iqmod_mfb_lpf_pex_ota_core_tg$1_0.di_tg_ctrl_n.t4 iqmod_mfb_lpf_pex_half_1.vinp.t1 VDD.t0 sg13_lv_pmos ad=1.14p pd=6.38u as=1.14p ps=6.38u w=6u l=0.13u
X140 a_6620_n4303.t1 a_12906_n4603.t1 VSS.t23 rhigh l=31u w=0.5u
X141 iqmod_mfb_lpf_pex_half_0.iqmod_mfb_lpf_pex_ota_core_hybrid_bm_half_0.iqmod_mfb_lpf_pex_ota_core_tg$1_0.di_tg_ctrl_n.t1 di_filter_en.t7 VDD.t54 VDD.t6 sg13_lv_pmos ad=1.14p pd=6.38u as=1.14p ps=6.38u w=6u l=0.13u
X142 VDD.t130 VDD.t128 VDD.t129 VDD.t0 sg13_lv_pmos ad=2.04p pd=12.68u as=0 ps=0 w=6u l=1u
X143 iqmod_mfb_lpf_pex_half_1.iqmod_mfb_lpf_pex_ota_core_hybrid_bm_half_0.iqmod_mfb_lpf_pex_ota_core_tg$1_0.v_a.t0 iqmod_mfb_lpf_pex_half_1.iqmod_mfb_lpf_pex_ota_core_hybrid_bm_half_0.iqmod_mfb_lpf_pex_ota_core_inv_NF20$1_1.vin.t0 VDD.t259 VDD.t0 sg13_lv_pmos ad=1.14p pd=6.38u as=1.14p ps=6.38u w=6u l=1u
X144 voutn.t1 iqmod_mfb_lpf_pex_half_0.iqmod_mfb_lpf_pex_ota_core_hybrid_bm_half_0.iqmod_mfb_lpf_pex_ota_core_inv_NF20$1_1.vin.t0 VSS.t51 VSS.t52 sg13_lv_nmos ad=0.19p pd=1.38u as=0.19p ps=1.38u w=1u l=1u
X145 a_25788_n4603.t1 a_37874_n4303.t1 VSS.t71 rhigh l=60u w=0.5u
X146 VSS.t145 VSS.t144 VSS.t145 VSS.t87 sg13_lv_nmos ad=0.19p pd=1.38u as=0 ps=0 w=1u l=0.13u
X147 voutp.t2 iqmod_mfb_lpf_pex_half_1.iqmod_mfb_lpf_pex_ota_core_hybrid_bm_half_0.iqmod_mfb_lpf_pex_ota_core_tg$1_0.v_b.t36 VDD.t167 VDD.t0 sg13_lv_pmos ad=1.14p pd=6.38u as=1.14p ps=6.38u w=6u l=1u
X148 VSS.t277 voutn.t42 iqmod_mfb_lpf_pex_half_1.iqmod_mfb_lpf_pex_ota_core_hybrid_bm_half_0.iqmod_mfb_lpf_pex_ota_core_inv_NF20$1_0.vout.t12 VSS.t279 sg13_lv_nmos ad=0.19p pd=1.38u as=0.19p ps=1.38u w=1u l=1u
X149 VSS.t220 iqmod_mfb_lpf_pex_half_1.iqmod_mfb_lpf_pex_ota_core_hybrid_bm_half_0.iqmod_mfb_lpf_pex_ota_core_tg$1_0.v_b.t38 voutn.t28 VSS.t219 sg13_lv_nmos ad=0.19p pd=1.38u as=0.19p ps=1.38u w=1u l=1u
X150 VDD.t20 iqmod_mfb_lpf_pex_half_0.iqmod_mfb_lpf_pex_ota_core_hybrid_bm_half_0.iqmod_mfb_lpf_pex_ota_core_inv_NF20$1_1.vin.t0 voutn.t13 VDD.t6 sg13_lv_pmos ad=1.14p pd=6.38u as=1.14p ps=6.38u w=6u l=1u
X151 VDD.t287 iqmod_mfb_lpf_pex_half_0.iqmod_mfb_lpf_pex_ota_core_hybrid_bm_half_0.iqmod_mfb_lpf_pex_ota_core_tg$1_0.di_tg_ctrl_n.t2 iqmod_mfb_lpf_pex_half_0.iqmod_mfb_lpf_pex_ota_core_hybrid_bm_half_0.iqmod_mfb_lpf_pex_ota_core_inv_NF20$1_1.vin.t0 VSS.t10 sg13_lv_nmos ad=0.19p pd=1.38u as=0.19p ps=1.38u w=1u l=0.13u
X152 iqmod_mfb_lpf_pex_half_1.C1_half.t8 iqmod_mfb_lpf_pex_half_1.iqmod_mfb_lpf_pex_R1_0.v_b.t3 cap_cmim l=8u w=8u
X153 VSS.t143 VSS.t141 VSS.t142 VSS.t83 sg13_lv_nmos ad=0.34p pd=2.68u as=0 ps=0 w=1u l=0.13u
X154 iqmod_mfb_lpf_pex_half_1.iqmod_mfb_lpf_pex_ota_core_hybrid_bm_half_0.iqmod_mfb_lpf_pex_ota_core_inv_NF20$1_1.vin.t0 iqmod_mfb_lpf_pex_half_1.iqmod_mfb_lpf_pex_ota_core_hybrid_bm_half_0.iqmod_mfb_lpf_pex_ota_core_tg$1_0.di_tg_ctrl_n.t7 VDD.t5 VSS.t11 sg13_lv_nmos ad=0.19p pd=1.38u as=0.19p ps=1.38u w=1u l=0.13u
X155 iqmod_mfb_lpf_pex_half_1.vinp.t3 iqmod_mfb_lpf_pex_half_1.iqmod_mfb_lpf_pex_ota_core_hybrid_bm_half_0.iqmod_mfb_lpf_pex_ota_core_tg$1_0.di_tg_ctrl_n.t4 iqmod_mfb_lpf_pex_half_1.iqmod_mfb_lpf_pex_ota_core_hybrid_bm_half_0.iqmod_mfb_lpf_pex_ota_core_inv_NF20$1_1.vin.t0 VDD.t0 sg13_lv_pmos ad=2.04p pd=12.68u as=1.14p ps=6.38u w=6u l=0.13u
X156 voutn.t19 iqmod_mfb_lpf_pex_half_0.iqmod_mfb_lpf_pex_ota_core_hybrid_bm_half_0.iqmod_mfb_lpf_pex_ota_core_inv_NF20$1_1.vin.t0 VDD.t22 VDD.t6 sg13_lv_pmos ad=1.14p pd=6.38u as=1.14p ps=6.38u w=6u l=1u
X157 VDD.t223 voutn.t43 iqmod_mfb_lpf_pex_half_1.iqmod_mfb_lpf_pex_ota_core_hybrid_bm_half_0.iqmod_mfb_lpf_pex_ota_core_inv_NF20$1_0.vout.t28 VDD.t6 sg13_lv_pmos ad=1.14p pd=6.38u as=1.14p ps=6.38u w=6u l=1u
X158 iqmod_mfb_lpf_pex_half_1.iqmod_mfb_lpf_pex_ota_core_hybrid_bm_half_0.iqmod_mfb_lpf_pex_ota_core_inv_NF20$1_0.vout.t33 iqmod_mfb_lpf_pex_half_1.iqmod_mfb_lpf_pex_ota_core_hybrid_bm_half_0.iqmod_mfb_lpf_pex_ota_core_tg$1_0.di_tg_ctrl_n.t2 iqmod_mfb_lpf_pex_half_1.iqmod_mfb_lpf_pex_ota_core_hybrid_bm_half_0.iqmod_mfb_lpf_pex_ota_core_inv_NF6$1_1.vout.t22 VDD.t0 sg13_lv_pmos ad=1.14p pd=6.38u as=1.14p ps=6.38u w=6u l=0.13u
X159 VDD.t115 VDD.t113 VDD.t47 VDD.t0 sg13_lv_pmos ad=2.04p pd=12.68u as=0 ps=0 w=6u l=1u
X160 VDD.t279 iqmod_mfb_lpf_pex_half_1.iqmod_mfb_lpf_pex_ota_core_hybrid_bm_half_0.iqmod_mfb_lpf_pex_ota_core_inv_NF20$1_1.vin.t0 voutp.t21 VDD.t0 sg13_lv_pmos ad=1.14p pd=6.38u as=1.14p ps=6.38u w=6u l=1u
X161 iqmod_mfb_lpf_pex_half_1.iqmod_mfb_lpf_pex_ota_core_hybrid_bm_half_0.iqmod_mfb_lpf_pex_ota_core_inv_NF20$1_1.vin.t0 iqmod_mfb_lpf_pex_half_1.iqmod_mfb_lpf_pex_ota_core_hybrid_bm_half_0.iqmod_mfb_lpf_pex_ota_core_spdt_switch$1_0.iqmod_mfb_lpf_pex_ota_core_spdt_switch_inv$2_0.vout.t2 VDD.t291 VDD.t0 sg13_lv_pmos ad=1.14p pd=6.38u as=1.14p ps=6.38u w=6u l=0.13u
X162 iqmod_mfb_lpf_pex_half_1.iqmod_mfb_lpf_pex_ota_core_hybrid_bm_half_0.iqmod_mfb_lpf_pex_ota_core_tg$1_0.v_a.t1 iqmod_mfb_lpf_pex_half_0.iqmod_mfb_lpf_pex_ota_core_hybrid_bm_half_0.iqmod_mfb_lpf_pex_ota_core_inv_NF20$1_1.vin.t0 VDD.t8 VDD.t6 sg13_lv_pmos ad=1.14p pd=6.38u as=1.14p ps=6.38u w=6u l=1u
X163 iqmod_mfb_lpf_pex_half_1.iqmod_mfb_lpf_pex_ota_core_hybrid_bm_half_0.iqmod_mfb_lpf_pex_ota_core_inv_NF20$1_0.vout.t30 voutn.t43 VDD.t225 VDD.t6 sg13_lv_pmos ad=1.14p pd=6.38u as=1.14p ps=6.38u w=6u l=1u
X164 VDD.t26 iqmod_mfb_lpf_pex_half_0.iqmod_mfb_lpf_pex_ota_core_hybrid_bm_half_0.iqmod_mfb_lpf_pex_ota_core_inv_NF20$1_1.vin.t0 voutn.t18 VDD.t6 sg13_lv_pmos ad=1.14p pd=6.38u as=1.14p ps=6.38u w=6u l=1u
X165 iqmod_mfb_lpf_pex_half_1.iqmod_mfb_lpf_pex_ota_core_hybrid_bm_half_0.iqmod_mfb_lpf_pex_ota_core_tg$1_0.v_b.t13 iqmod_mfb_lpf_pex_half_1.iqmod_mfb_lpf_pex_ota_core_hybrid_bm_half_0.iqmod_mfb_lpf_pex_ota_core_inv_NF6$1_1.vout.t24 VDD.t205 VDD.t0 sg13_lv_pmos ad=1.14p pd=6.38u as=1.14p ps=6.38u w=6u l=1u
X166 VSS.t263 iqmod_mfb_lpf_pex_half_1.iqmod_mfb_lpf_pex_ota_core_hybrid_bm_half_0.iqmod_mfb_lpf_pex_ota_core_tg$1_0.v_b.t37 voutp.t17 VSS.t216 sg13_lv_nmos ad=0.19p pd=1.38u as=0.19p ps=1.38u w=1u l=1u
X167 VDD.t263 iqmod_mfb_lpf_pex_half_1.iqmod_mfb_lpf_pex_ota_core_hybrid_bm_half_0.iqmod_mfb_lpf_pex_ota_core_inv_NF20$1_1.vin.t0 iqmod_mfb_lpf_pex_half_1.iqmod_mfb_lpf_pex_ota_core_hybrid_bm_half_0.iqmod_mfb_lpf_pex_ota_core_tg$1_0.v_a.t0 VDD.t0 sg13_lv_pmos ad=1.14p pd=6.38u as=1.14p ps=6.38u w=6u l=1u
X168 VSS.t299 voutn.t42 iqmod_mfb_lpf_pex_half_1.iqmod_mfb_lpf_pex_ota_core_hybrid_bm_half_0.iqmod_mfb_lpf_pex_ota_core_inv_NF20$1_0.vout.t19 VSS.t298 sg13_lv_nmos ad=0.19p pd=1.38u as=0.19p ps=1.38u w=1u l=1u
X169 VDD.t11 iqmod_mfb_lpf_pex_half_0.iqmod_mfb_lpf_pex_ota_core_hybrid_bm_half_0.iqmod_mfb_lpf_pex_ota_core_inv_NF20$1_1.vin.t0 iqmod_mfb_lpf_pex_half_1.iqmod_mfb_lpf_pex_ota_core_hybrid_bm_half_0.iqmod_mfb_lpf_pex_ota_core_tg$1_0.v_a.t1 VDD.t6 sg13_lv_pmos ad=1.14p pd=6.38u as=1.14p ps=6.38u w=6u l=1u
X170 iqmod_mfb_lpf_pex_half_1.C1_half.t10 iqmod_mfb_lpf_pex_half_1.iqmod_mfb_lpf_pex_R1_0.v_b.t4 cap_cmim l=8u w=8u
X171 VDD.t171 iqmod_mfb_lpf_pex_half_1.iqmod_mfb_lpf_pex_ota_core_hybrid_bm_half_0.iqmod_mfb_lpf_pex_ota_core_tg$1_0.v_b.t36 voutp.t7 VDD.t0 sg13_lv_pmos ad=1.14p pd=6.38u as=1.14p ps=6.38u w=6u l=1u
X172 voutp.t13 iqmod_mfb_lpf_pex_half_1.iqmod_mfb_lpf_pex_ota_core_hybrid_bm_half_0.iqmod_mfb_lpf_pex_ota_core_tg$1_0.v_b.t37 VSS.t265 VSS.t221 sg13_lv_nmos ad=0.19p pd=1.38u as=0.19p ps=1.38u w=1u l=1u
X173 VSS.t376 iqmod_mfb_lpf_pex_half_1.iqmod_mfb_lpf_pex_ota_core_hybrid_bm_half_0.iqmod_mfb_lpf_pex_ota_core_inv_NF20$1_1.vin.t0 voutp.t30 VSS.t63 sg13_lv_nmos ad=0.19p pd=1.38u as=0.19p ps=1.38u w=1u l=1u
X174 iqmod_mfb_lpf_pex_half_1.iqmod_mfb_lpf_pex_ota_core_hybrid_bm_half_0.iqmod_mfb_lpf_pex_ota_core_tg$1_0.di_tg_ctrl_n.t1 di_filter_en.t0 VDD.t99 VDD.t0 sg13_lv_pmos ad=1.14p pd=6.38u as=1.14p ps=6.38u w=6u l=0.13u
X175 a_13404_3903.t1 a_25290_4203.t1 VSS.t74 rhigh l=59u w=0.5u
X176 VSS.t155 iqmod_mfb_lpf_pex_half_1.iqmod_mfb_lpf_pex_ota_core_hybrid_bm_half_0.iqmod_mfb_lpf_pex_ota_core_inv_NF20$1_1.vin.t0 iqmod_mfb_lpf_pex_half_1.iqmod_mfb_lpf_pex_ota_core_hybrid_bm_half_0.iqmod_mfb_lpf_pex_ota_core_tg$1_0.v_a.t0 VSS.t42 sg13_lv_nmos ad=0.19p pd=1.38u as=0.19p ps=1.38u w=1u l=1u
X177 VDD.t105 VDD.t103 VDD.t1 VDD.t0 sg13_lv_pmos ad=2.04p pd=12.68u as=0 ps=0 w=6u l=0.13u
X178 iqmod_mfb_lpf_pex_half_1.iqmod_mfb_lpf_pex_ota_core_hybrid_bm_half_0.iqmod_mfb_lpf_pex_ota_core_tg$1_0.v_b.t3 iqmod_mfb_lpf_pex_half_1.iqmod_mfb_lpf_pex_ota_core_hybrid_bm_half_0.iqmod_mfb_lpf_pex_ota_core_inv_NF6$1_1.vout.t26 VSS.t122 VSS.t313 sg13_lv_nmos ad=0.19p pd=1.38u as=0.19p ps=1.38u w=1u l=1u
X179 iqmod_mfb_lpf_pex_half_1.iqmod_mfb_lpf_pex_ota_core_hybrid_bm_half_0.iqmod_mfb_lpf_pex_ota_core_inv_NF20$1_0.vout.t12 voutn.t42 VSS.t136 VSS.t278 sg13_lv_nmos ad=0.19p pd=1.38u as=0.19p ps=1.38u w=1u l=1u
X180 iqmod_mfb_lpf_pex_half_0.iqmod_mfb_lpf_pex_ota_core_hybrid_bm_half_0.iqmod_mfb_lpf_pex_ota_core_inv_NF20$1_1.vin.t0 iqmod_mfb_lpf_pex_half_0.iqmod_mfb_lpf_pex_ota_core_hybrid_bm_half_0.iqmod_mfb_lpf_pex_ota_core_tg$1_0.di_tg_ctrl_n.t2 VDD.t287 VSS.t11 sg13_lv_nmos ad=0.19p pd=1.38u as=0.19p ps=1.38u w=1u l=0.13u
X181 VSS.t250 VSS.t251 VSS.t20 rhigh l=59u w=0.5u
X182 VSS.t372 iqmod_mfb_lpf_pex_half_1.iqmod_mfb_lpf_pex_ota_core_hybrid_bm_half_0.iqmod_mfb_lpf_pex_ota_core_inv_NF20$1_1.vin.t0 voutp.t27 VSS.t59 sg13_lv_nmos ad=0.19p pd=1.38u as=0.19p ps=1.38u w=1u l=1u
X183 VSS.t70 VSS.t111 VSS.t70 VSS.t112 sg13_lv_nmos ad=0.19p pd=1.38u as=0 ps=0 w=1u l=1u
X184 VDD.t82 VDD.t81 VDD.t82 VDD.t6 sg13_lv_pmos ad=1.14p pd=6.38u as=0 ps=0 w=6u l=1u
X185 VSS.t252 VSS.t253 VSS.t194 rhigh l=27u w=0.5u
X186 VDD.t36 VDD.t76 VDD.t36 VDD.t6 sg13_lv_pmos ad=1.14p pd=6.38u as=0 ps=0 w=6u l=1u
X187 VSS.t168 VSS.t166 VSS.t167 VSS.t114 sg13_lv_nmos ad=0.34p pd=2.68u as=0 ps=0 w=1u l=1u
X188 VDD.t45 iqmod_mfb_lpf_pex_half_1.iqmod_mfb_lpf_pex_ota_core_hybrid_bm_half_0.iqmod_mfb_lpf_pex_ota_core_inv_NF6$1_1.vout.t27 iqmod_mfb_lpf_pex_half_1.iqmod_mfb_lpf_pex_ota_core_hybrid_bm_half_0.iqmod_mfb_lpf_pex_ota_core_tg$1_0.v_b.t11 VDD.t6 sg13_lv_pmos ad=1.14p pd=6.38u as=1.14p ps=6.38u w=6u l=1u
X189 iqmod_mfb_lpf_pex_half_1.iqmod_mfb_lpf_pex_ota_core_hybrid_bm_half_0.iqmod_mfb_lpf_pex_ota_core_tg$1_0.v_a.t1 di_filter_en.t5 iqmod_mfb_lpf_pex_half_1.iqmod_mfb_lpf_pex_ota_core_hybrid_bm_half_0.iqmod_mfb_lpf_pex_ota_core_tg$1_0.v_b.t24 VSS.t235 sg13_lv_nmos ad=0.19p pd=1.38u as=0.19p ps=1.38u w=1u l=0.13u
X190 iqmod_mfb_lpf_pex_half_1.iqmod_mfb_lpf_pex_R1_0.v_b.t0 a_12906_n4603.t0 VSS.t23 rhigh l=31u w=0.5u
X191 VSS.t356 iqmod_mfb_lpf_pex_half_1.iqmod_mfb_lpf_pex_ota_core_hybrid_bm_half_0.iqmod_mfb_lpf_pex_ota_core_inv_NF20$1_1.vin.t0 iqmod_mfb_lpf_pex_half_1.iqmod_mfb_lpf_pex_ota_core_hybrid_bm_half_0.iqmod_mfb_lpf_pex_ota_core_tg$1_0.v_a.t0 VSS.t36 sg13_lv_nmos ad=0.19p pd=1.38u as=0.19p ps=1.38u w=1u l=1u
X192 voutp.t30 iqmod_mfb_lpf_pex_half_1.iqmod_mfb_lpf_pex_ota_core_hybrid_bm_half_0.iqmod_mfb_lpf_pex_ota_core_inv_NF20$1_1.vin.t0 VSS.t374 VSS.t24 sg13_lv_nmos ad=0.19p pd=1.38u as=0.19p ps=1.38u w=1u l=1u
X193 VSS.t60 iqmod_mfb_lpf_pex_half_0.iqmod_mfb_lpf_pex_ota_core_hybrid_bm_half_0.iqmod_mfb_lpf_pex_ota_core_inv_NF20$1_1.vin.t0 voutn.t4 VSS.t59 sg13_lv_nmos ad=0.19p pd=1.38u as=0.19p ps=1.38u w=1u l=1u
X194 VDD.t39 VDD.t61 VDD.t39 VDD.t6 sg13_lv_pmos ad=1.14p pd=6.38u as=0 ps=0 w=6u l=0.13u
X195 a_25788_n4603.t0 voutp.t0 VSS.t71 rhigh l=60u w=0.5u
X196 iqmod_mfb_lpf_pex_half_1.iqmod_mfb_lpf_pex_ota_core_hybrid_bm_half_0.iqmod_mfb_lpf_pex_ota_core_inv_NF20$1_0.vout.t15 voutn.t42 VSS.t289 VSS.t290 sg13_lv_nmos ad=0.19p pd=1.38u as=0.19p ps=1.38u w=1u l=1u
X197 VDD.t122 VDD.t121 VDD.t122 VDD.t0 sg13_lv_pmos ad=1.14p pd=6.38u as=0 ps=0 w=6u l=1u
X198 iqmod_mfb_lpf_pex_half_1.iqmod_mfb_lpf_pex_ota_core_hybrid_bm_half_0.iqmod_mfb_lpf_pex_ota_core_tg$1_0.v_a.t0 iqmod_mfb_lpf_pex_half_1.iqmod_mfb_lpf_pex_ota_core_hybrid_bm_half_0.iqmod_mfb_lpf_pex_ota_core_inv_NF20$1_1.vin.t0 VSS.t358 VSS.t41 sg13_lv_nmos ad=0.19p pd=1.38u as=0.19p ps=1.38u w=1u l=1u
X199 VSS.t378 iqmod_mfb_lpf_pex_half_1.iqmod_mfb_lpf_pex_ota_core_hybrid_bm_half_0.iqmod_mfb_lpf_pex_ota_core_inv_NF20$1_1.vin.t0 voutp.t34 VSS.t66 sg13_lv_nmos ad=0.19p pd=1.38u as=0.19p ps=1.38u w=1u l=1u
X200 iqmod_mfb_lpf_pex_half_1.iqmod_mfb_lpf_pex_ota_core_hybrid_bm_half_0.iqmod_mfb_lpf_pex_ota_core_inv_NF6$1_1.vout.t15 iqmod_mfb_lpf_pex_half_1.iqmod_mfb_lpf_pex_ota_core_hybrid_bm_half_0.iqmod_mfb_lpf_pex_ota_core_inv_NF20$1_0.vout.t59 VDD.t89 VDD.t6 sg13_lv_pmos ad=1.14p pd=6.38u as=1.14p ps=6.38u w=6u l=1u
X201 voutp.t3 iqmod_mfb_lpf_pex_half_1.iqmod_mfb_lpf_pex_ota_core_hybrid_bm_half_0.iqmod_mfb_lpf_pex_ota_core_tg$1_0.v_b.t36 VDD.t177 VDD.t0 sg13_lv_pmos ad=1.14p pd=6.38u as=1.14p ps=6.38u w=6u l=1u
X202 VDD.t157 iqmod_mfb_lpf_pex_half_1.iqmod_mfb_lpf_pex_ota_core_hybrid_bm_half_0.iqmod_mfb_lpf_pex_ota_core_inv_NF20$1_0.vout.t59 iqmod_mfb_lpf_pex_half_1.iqmod_mfb_lpf_pex_ota_core_hybrid_bm_half_0.iqmod_mfb_lpf_pex_ota_core_inv_NF6$1_1.vout.t16 VDD.t6 sg13_lv_pmos ad=1.14p pd=6.38u as=1.14p ps=6.38u w=6u l=1u
X203 VDD.t230 voutp.t42 iqmod_mfb_lpf_pex_half_1.iqmod_mfb_lpf_pex_ota_core_hybrid_bm_half_0.iqmod_mfb_lpf_pex_ota_core_inv_NF20$1_0.vout.t46 VDD.t0 sg13_lv_pmos ad=1.14p pd=6.38u as=1.14p ps=6.38u w=6u l=1u
X204 iqmod_mfb_lpf_pex_half_1.iqmod_mfb_lpf_pex_ota_core_hybrid_bm_half_0.iqmod_mfb_lpf_pex_ota_core_tg$1_0.v_a.t0 iqmod_mfb_lpf_pex_half_1.iqmod_mfb_lpf_pex_ota_core_hybrid_bm_half_0.iqmod_mfb_lpf_pex_ota_core_tg$1_0.di_tg_ctrl_n.t3 iqmod_mfb_lpf_pex_half_1.iqmod_mfb_lpf_pex_ota_core_hybrid_bm_half_0.iqmod_mfb_lpf_pex_ota_core_tg$1_0.v_b.t29 VDD.t0 sg13_lv_pmos ad=2.04p pd=12.68u as=1.14p ps=6.38u w=6u l=0.13u
X205 iqmod_mfb_lpf_pex_half_1.iqmod_mfb_lpf_pex_ota_core_hybrid_bm_half_0.iqmod_mfb_lpf_pex_ota_core_tg$1_0.v_b.t21 di_filter_en.t2 iqmod_mfb_lpf_pex_half_1.iqmod_mfb_lpf_pex_ota_core_hybrid_bm_half_0.iqmod_mfb_lpf_pex_ota_core_tg$1_0.v_a.t0 VSS.t234 sg13_lv_nmos ad=0.19p pd=1.38u as=0.34p ps=2.68u w=1u l=0.13u
X206 iqmod_mfb_lpf_pex_half_1.iqmod_mfb_lpf_pex_ota_core_hybrid_bm_half_0.iqmod_mfb_lpf_pex_ota_core_inv_NF20$1_1.vin.t0 iqmod_mfb_lpf_pex_half_1.iqmod_mfb_lpf_pex_ota_core_hybrid_bm_half_0.iqmod_mfb_lpf_pex_ota_core_spdt_switch$1_0.iqmod_mfb_lpf_pex_ota_core_spdt_switch_inv$2_0.vout.t4 iqmod_mfb_lpf_pex_half_1.vinp.t4 VSS.t3 sg13_lv_nmos ad=0.19p pd=1.38u as=0.34p ps=2.68u w=1u l=0.13u
X207 iqmod_mfb_lpf_pex_half_1.iqmod_mfb_lpf_pex_ota_core_hybrid_bm_half_0.iqmod_mfb_lpf_pex_ota_core_spdt_switch$1_0.iqmod_mfb_lpf_pex_ota_core_spdt_switch_inv$2_0.vout.t1 iqmod_mfb_lpf_pex_half_1.iqmod_mfb_lpf_pex_ota_core_hybrid_bm_half_0.iqmod_mfb_lpf_pex_ota_core_tg$1_0.di_tg_ctrl_n.t8 VSS.t78 VSS.t77 sg13_lv_nmos ad=0.19p pd=1.38u as=0.19p ps=1.38u w=1u l=0.13u
X208 iqmod_mfb_lpf_pex_half_1.iqmod_mfb_lpf_pex_ota_core_hybrid_bm_half_0.iqmod_mfb_lpf_pex_ota_core_tg$1_0.v_b.t14 iqmod_mfb_lpf_pex_half_1.iqmod_mfb_lpf_pex_ota_core_hybrid_bm_half_0.iqmod_mfb_lpf_pex_ota_core_inv_NF6$1_1.vout.t24 VDD.t207 VDD.t0 sg13_lv_pmos ad=1.14p pd=6.38u as=1.14p ps=6.38u w=6u l=1u
X209 VSS.t51 iqmod_mfb_lpf_pex_half_0.iqmod_mfb_lpf_pex_ota_core_hybrid_bm_half_0.iqmod_mfb_lpf_pex_ota_core_inv_NF20$1_1.vin.t0 voutn.t14 VSS.t50 sg13_lv_nmos ad=0.19p pd=1.38u as=0.19p ps=1.38u w=1u l=1u
X210 VSS.t140 VSS.t138 VSS.t140 VSS.t139 sg13_lv_nmos ad=0.19p pd=1.38u as=0 ps=0 w=1u l=1u
X211 voutn.t32 iqmod_mfb_lpf_pex_half_1.iqmod_mfb_lpf_pex_ota_core_hybrid_bm_half_0.iqmod_mfb_lpf_pex_ota_core_tg$1_0.v_b.t39 VDD.t189 VDD.t6 sg13_lv_pmos ad=1.14p pd=6.38u as=1.14p ps=6.38u w=6u l=1u
X212 VDD.t173 iqmod_mfb_lpf_pex_half_1.iqmod_mfb_lpf_pex_ota_core_hybrid_bm_half_0.iqmod_mfb_lpf_pex_ota_core_tg$1_0.v_b.t36 voutp.t9 VDD.t0 sg13_lv_pmos ad=1.14p pd=6.38u as=1.14p ps=6.38u w=6u l=1u
X213 iqmod_mfb_lpf_pex_half_1.iqmod_mfb_lpf_pex_ota_core_hybrid_bm_half_0.iqmod_mfb_lpf_pex_ota_core_tg$1_0.v_a.t0 iqmod_mfb_lpf_pex_half_1.iqmod_mfb_lpf_pex_ota_core_hybrid_bm_half_0.iqmod_mfb_lpf_pex_ota_core_tg$1_0.di_tg_ctrl_n.t3 iqmod_mfb_lpf_pex_half_1.iqmod_mfb_lpf_pex_ota_core_hybrid_bm_half_0.iqmod_mfb_lpf_pex_ota_core_tg$1_0.v_b.t27 VDD.t0 sg13_lv_pmos ad=1.14p pd=6.38u as=1.14p ps=6.38u w=6u l=0.13u
X214 VSS.t188 iqmod_mfb_lpf_pex_half_1.iqmod_mfb_lpf_pex_ota_core_hybrid_bm_half_0.iqmod_mfb_lpf_pex_ota_core_tg$1_0.v_a.t0 iqmod_mfb_lpf_pex_half_1.iqmod_mfb_lpf_pex_ota_core_hybrid_bm_half_0.iqmod_mfb_lpf_pex_ota_core_tg$1_0.v_b.t15 VSS.t187 sg13_lv_nmos ad=0.19p pd=1.38u as=0.19p ps=1.38u w=1u l=1u
X215 voutn.t28 iqmod_mfb_lpf_pex_half_1.iqmod_mfb_lpf_pex_ota_core_hybrid_bm_half_0.iqmod_mfb_lpf_pex_ota_core_tg$1_0.v_b.t38 VSS.t217 VSS.t218 sg13_lv_nmos ad=0.19p pd=1.38u as=0.19p ps=1.38u w=1u l=1u
X216 VSS.t18 VSS.t19 VSS.t17 rhigh l=31u w=0.5u
X217 VSS.t43 VSS.t99 VSS.t43 VSS.t100 sg13_lv_nmos ad=0.19p pd=1.38u as=0 ps=0 w=1u l=1u
X218 VSS.t333 voutp.t43 iqmod_mfb_lpf_pex_half_1.iqmod_mfb_lpf_pex_ota_core_hybrid_bm_half_0.iqmod_mfb_lpf_pex_ota_core_inv_NF20$1_0.vout.t39 VSS.t284 sg13_lv_nmos ad=0.19p pd=1.38u as=0.19p ps=1.38u w=1u l=1u
X219 VSS.t29 iqmod_mfb_lpf_pex_half_0.iqmod_mfb_lpf_pex_ota_core_hybrid_bm_half_0.iqmod_mfb_lpf_pex_ota_core_inv_NF20$1_1.vin.t0 iqmod_mfb_lpf_pex_half_1.iqmod_mfb_lpf_pex_ota_core_hybrid_bm_half_0.iqmod_mfb_lpf_pex_ota_core_tg$1_0.v_a.t1 VSS.t28 sg13_lv_nmos ad=0.19p pd=1.38u as=0.19p ps=1.38u w=1u l=1u
X220 iqmod_mfb_lpf_pex_half_1.iqmod_mfb_lpf_pex_ota_core_hybrid_bm_half_0.iqmod_mfb_lpf_pex_ota_core_tg$1_0.v_b.t17 iqmod_mfb_lpf_pex_half_1.iqmod_mfb_lpf_pex_ota_core_hybrid_bm_half_0.iqmod_mfb_lpf_pex_ota_core_tg$1_0.v_a.t0 VSS.t191 VSS.t192 sg13_lv_nmos ad=0.19p pd=1.38u as=0.19p ps=1.38u w=1u l=1u
X221 VDD.t181 iqmod_mfb_lpf_pex_half_1.iqmod_mfb_lpf_pex_ota_core_hybrid_bm_half_0.iqmod_mfb_lpf_pex_ota_core_tg$1_0.v_b.t36 voutp.t4 VDD.t0 sg13_lv_pmos ad=1.14p pd=6.38u as=1.14p ps=6.38u w=6u l=1u
X222 VDD.t288 iqmod_mfb_lpf_pex_half_0.iqmod_mfb_lpf_pex_ota_core_hybrid_bm_half_0.iqmod_mfb_lpf_pex_ota_core_tg$1_0.di_tg_ctrl_n.t2 iqmod_mfb_lpf_pex_half_0.iqmod_mfb_lpf_pex_ota_core_hybrid_bm_half_0.iqmod_mfb_lpf_pex_ota_core_inv_NF20$1_1.vin.t0 VSS.t12 sg13_lv_nmos ad=0.19p pd=1.38u as=0.19p ps=1.38u w=1u l=0.13u
X223 voutp.t31 iqmod_mfb_lpf_pex_half_1.iqmod_mfb_lpf_pex_ota_core_hybrid_bm_half_0.iqmod_mfb_lpf_pex_ota_core_inv_NF20$1_1.vin.t0 VDD.t283 VDD.t0 sg13_lv_pmos ad=1.14p pd=6.38u as=1.14p ps=6.38u w=6u l=1u
X224 VDD.t22 iqmod_mfb_lpf_pex_half_0.iqmod_mfb_lpf_pex_ota_core_hybrid_bm_half_0.iqmod_mfb_lpf_pex_ota_core_inv_NF20$1_1.vin.t0 voutn.t17 VDD.t6 sg13_lv_pmos ad=1.14p pd=6.38u as=1.14p ps=6.38u w=6u l=1u
X225 iqmod_mfb_lpf_pex_half_1.iqmod_mfb_lpf_pex_ota_core_hybrid_bm_half_0.iqmod_mfb_lpf_pex_ota_core_inv_NF20$1_0.vout.t48 voutp.t42 VDD.t233 VDD.t0 sg13_lv_pmos ad=1.14p pd=6.38u as=1.14p ps=6.38u w=6u l=1u
X226 VSS.t70 iqmod_mfb_lpf_pex_half_0.iqmod_mfb_lpf_pex_ota_core_hybrid_bm_half_0.iqmod_mfb_lpf_pex_ota_core_inv_NF20$1_1.vin.t0 voutn.t16 VSS.t69 sg13_lv_nmos ad=0.19p pd=1.38u as=0.19p ps=1.38u w=1u l=1u
X227 iqmod_mfb_lpf_pex_half_0.vinp.t8 a_25290_4203.t0 VSS.t74 rhigh l=59u w=0.5u
X228 VDD.t72 VDD.t71 VDD.t72 VDD.t6 sg13_lv_pmos ad=1.14p pd=6.38u as=0 ps=0 w=6u l=1u
X229 iqmod_mfb_lpf_pex_half_1.iqmod_mfb_lpf_pex_ota_core_hybrid_bm_half_0.iqmod_mfb_lpf_pex_ota_core_tg$1_0.v_b.t25 di_filter_en.t5 iqmod_mfb_lpf_pex_half_1.iqmod_mfb_lpf_pex_ota_core_hybrid_bm_half_0.iqmod_mfb_lpf_pex_ota_core_tg$1_0.v_a.t1 VSS.t236 sg13_lv_nmos ad=0.19p pd=1.38u as=0.19p ps=1.38u w=1u l=0.13u
X230 VDD.t65 VDD.t63 VDD.t8 VDD.t6 sg13_lv_pmos ad=2.04p pd=12.68u as=0 ps=0 w=6u l=1u
X231 voutn.t18 iqmod_mfb_lpf_pex_half_0.iqmod_mfb_lpf_pex_ota_core_hybrid_bm_half_0.iqmod_mfb_lpf_pex_ota_core_inv_NF20$1_1.vin.t0 VDD.t24 VDD.t6 sg13_lv_pmos ad=1.14p pd=6.38u as=1.14p ps=6.38u w=6u l=1u
X232 iqmod_mfb_lpf_pex_half_1.iqmod_mfb_lpf_pex_ota_core_hybrid_bm_half_0.iqmod_mfb_lpf_pex_ota_core_inv_NF20$1_0.vout.t1 iqmod_mfb_lpf_pex_half_0.iqmod_mfb_lpf_pex_ota_core_hybrid_bm_half_0.iqmod_mfb_lpf_pex_ota_core_tg$1_0.di_tg_ctrl_n.t4 iqmod_mfb_lpf_pex_half_1.iqmod_mfb_lpf_pex_ota_core_hybrid_bm_half_0.iqmod_mfb_lpf_pex_ota_core_inv_NF6$1_1.vout.t0 VDD.t6 sg13_lv_pmos ad=1.14p pd=6.38u as=1.14p ps=6.38u w=6u l=0.13u
X233 voutp.t6 iqmod_mfb_lpf_pex_half_1.iqmod_mfb_lpf_pex_ota_core_hybrid_bm_half_0.iqmod_mfb_lpf_pex_ota_core_tg$1_0.v_b.t36 VDD.t175 VDD.t0 sg13_lv_pmos ad=1.14p pd=6.38u as=1.14p ps=6.38u w=6u l=1u
X234 VSS.t180 iqmod_mfb_lpf_pex_half_1.iqmod_mfb_lpf_pex_ota_core_hybrid_bm_half_0.iqmod_mfb_lpf_pex_ota_core_inv_NF20$1_0.vout.t57 iqmod_mfb_lpf_pex_half_1.iqmod_mfb_lpf_pex_ota_core_hybrid_bm_half_0.iqmod_mfb_lpf_pex_ota_core_inv_NF6$1_1.vout.t14 VSS.t202 sg13_lv_nmos ad=0.19p pd=1.38u as=0.19p ps=1.38u w=1u l=1u
X235 VSS.t289 voutn.t42 iqmod_mfb_lpf_pex_half_1.iqmod_mfb_lpf_pex_ota_core_hybrid_bm_half_0.iqmod_mfb_lpf_pex_ota_core_inv_NF20$1_0.vout.t14 VSS.t288 sg13_lv_nmos ad=0.19p pd=1.38u as=0.19p ps=1.38u w=1u l=1u
X236 iqmod_mfb_lpf_pex_half_1.iqmod_mfb_lpf_pex_ota_core_hybrid_bm_half_0.iqmod_mfb_lpf_pex_ota_core_tg$1_0.v_a.t1 iqmod_mfb_lpf_pex_half_0.iqmod_mfb_lpf_pex_ota_core_hybrid_bm_half_0.iqmod_mfb_lpf_pex_ota_core_inv_NF20$1_1.vin.t0 VDD.t9 VDD.t6 sg13_lv_pmos ad=1.14p pd=6.38u as=1.14p ps=6.38u w=6u l=1u
X237 VDD.t225 voutn.t43 iqmod_mfb_lpf_pex_half_1.iqmod_mfb_lpf_pex_ota_core_hybrid_bm_half_0.iqmod_mfb_lpf_pex_ota_core_inv_NF20$1_0.vout.t29 VDD.t6 sg13_lv_pmos ad=1.14p pd=6.38u as=1.14p ps=6.38u w=6u l=1u
X238 iqmod_mfb_lpf_pex_half_1.iqmod_mfb_lpf_pex_ota_core_hybrid_bm_half_0.iqmod_mfb_lpf_pex_ota_core_inv_NF6$1_1.vout.t6 di_filter_en.t1 iqmod_mfb_lpf_pex_half_1.iqmod_mfb_lpf_pex_ota_core_hybrid_bm_half_0.iqmod_mfb_lpf_pex_ota_core_inv_NF20$1_0.vout.t6 VSS.t240 sg13_lv_nmos ad=0.19p pd=1.38u as=0.34p ps=2.68u w=1u l=0.13u
X239 VSS.t307 VSS.t308 VSS.t23 rhigh l=31u w=0.5u
X240 iqmod_mfb_lpf_pex_half_1.iqmod_mfb_lpf_pex_ota_core_hybrid_bm_half_0.iqmod_mfb_lpf_pex_ota_core_tg$1_0.v_a.t1 di_filter_en.t5 iqmod_mfb_lpf_pex_half_1.iqmod_mfb_lpf_pex_ota_core_hybrid_bm_half_0.iqmod_mfb_lpf_pex_ota_core_tg$1_0.v_b.t25 VSS.t237 sg13_lv_nmos ad=0.19p pd=1.38u as=0.19p ps=1.38u w=1u l=0.13u
X241 VSS.t72 VSS.t73 VSS.t71 rhigh l=60u w=0.5u
X242 voutn.t17 iqmod_mfb_lpf_pex_half_0.iqmod_mfb_lpf_pex_ota_core_hybrid_bm_half_0.iqmod_mfb_lpf_pex_ota_core_inv_NF20$1_1.vin.t0 VDD.t20 VDD.t6 sg13_lv_pmos ad=1.14p pd=6.38u as=1.14p ps=6.38u w=6u l=1u
X243 iqmod_mfb_lpf_pex_half_1.iqmod_mfb_lpf_pex_R1_0.v_b.t7 iqmod_mfb_lpf_pex_half_1.C1_half.t4 cap_cmim l=8u w=8u
X244 VSS.t265 iqmod_mfb_lpf_pex_half_1.iqmod_mfb_lpf_pex_ota_core_hybrid_bm_half_0.iqmod_mfb_lpf_pex_ota_core_tg$1_0.v_b.t37 voutp.t15 VSS.t219 sg13_lv_nmos ad=0.19p pd=1.38u as=0.19p ps=1.38u w=1u l=1u
X245 VSS.t123 VSS.t120 VSS.t122 VSS.t121 sg13_lv_nmos ad=0.34p pd=2.68u as=0 ps=0 w=1u l=1u
X246 iqmod_mfb_lpf_pex_half_0.vinp.t3 iqmod_mfb_lpf_pex_half_0.iqmod_mfb_lpf_pex_ota_core_hybrid_bm_half_0.iqmod_mfb_lpf_pex_ota_core_tg$1_0.di_tg_ctrl_n.t6 iqmod_mfb_lpf_pex_half_0.iqmod_mfb_lpf_pex_ota_core_hybrid_bm_half_0.iqmod_mfb_lpf_pex_ota_core_inv_NF20$1_1.vin.t0 VDD.t6 sg13_lv_pmos ad=2.04p pd=12.68u as=1.14p ps=6.38u w=6u l=0.13u
X247 iqmod_mfb_lpf_pex_half_1.iqmod_mfb_lpf_pex_ota_core_hybrid_bm_half_0.iqmod_mfb_lpf_pex_ota_core_tg$1_0.v_b.t2 iqmod_mfb_lpf_pex_half_0.iqmod_mfb_lpf_pex_ota_core_hybrid_bm_half_0.iqmod_mfb_lpf_pex_ota_core_tg$1_0.di_tg_ctrl_n.t5 iqmod_mfb_lpf_pex_half_1.iqmod_mfb_lpf_pex_ota_core_hybrid_bm_half_0.iqmod_mfb_lpf_pex_ota_core_tg$1_0.v_a.t1 VDD.t6 sg13_lv_pmos ad=1.14p pd=6.38u as=1.14p ps=6.38u w=6u l=0.13u
X248 iqmod_mfb_lpf_pex_half_1.iqmod_mfb_lpf_pex_ota_core_hybrid_bm_half_0.iqmod_mfb_lpf_pex_ota_core_tg$1_0.v_a.t1 iqmod_mfb_lpf_pex_half_0.iqmod_mfb_lpf_pex_ota_core_hybrid_bm_half_0.iqmod_mfb_lpf_pex_ota_core_tg$1_0.di_tg_ctrl_n.t5 iqmod_mfb_lpf_pex_half_1.iqmod_mfb_lpf_pex_ota_core_hybrid_bm_half_0.iqmod_mfb_lpf_pex_ota_core_tg$1_0.v_b.t0 VDD.t6 sg13_lv_pmos ad=1.14p pd=6.38u as=1.14p ps=6.38u w=6u l=0.13u
X249 VDD.t233 voutp.t42 iqmod_mfb_lpf_pex_half_1.iqmod_mfb_lpf_pex_ota_core_hybrid_bm_half_0.iqmod_mfb_lpf_pex_ota_core_inv_NF20$1_0.vout.t47 VDD.t0 sg13_lv_pmos ad=1.14p pd=6.38u as=1.14p ps=6.38u w=6u l=1u
X250 VDD.t40 iqmod_mfb_lpf_pex_half_1.iqmod_mfb_lpf_pex_ota_core_hybrid_bm_half_0.iqmod_mfb_lpf_pex_ota_core_inv_NF6$1_1.vout.t27 iqmod_mfb_lpf_pex_half_1.iqmod_mfb_lpf_pex_ota_core_hybrid_bm_half_0.iqmod_mfb_lpf_pex_ota_core_tg$1_0.v_b.t9 VDD.t6 sg13_lv_pmos ad=1.14p pd=6.38u as=1.14p ps=6.38u w=6u l=1u
X251 voutp.t27 iqmod_mfb_lpf_pex_half_1.iqmod_mfb_lpf_pex_ota_core_hybrid_bm_half_0.iqmod_mfb_lpf_pex_ota_core_inv_NF20$1_1.vin.t0 VSS.t370 VSS.t58 sg13_lv_nmos ad=0.19p pd=1.38u as=0.19p ps=1.38u w=1u l=1u
X252 iqmod_mfb_lpf_pex_half_1.vinp.t6 iqmod_mfb_lpf_pex_half_1.iqmod_mfb_lpf_pex_ota_core_hybrid_bm_half_0.iqmod_mfb_lpf_pex_ota_core_spdt_switch$1_0.iqmod_mfb_lpf_pex_ota_core_spdt_switch_inv$2_0.vout.t4 iqmod_mfb_lpf_pex_half_1.iqmod_mfb_lpf_pex_ota_core_hybrid_bm_half_0.iqmod_mfb_lpf_pex_ota_core_inv_NF20$1_1.vin.t0 VSS.t6 sg13_lv_nmos ad=0.19p pd=1.38u as=0.19p ps=1.38u w=1u l=0.13u
X253 voutn.t4 iqmod_mfb_lpf_pex_half_0.iqmod_mfb_lpf_pex_ota_core_hybrid_bm_half_0.iqmod_mfb_lpf_pex_ota_core_inv_NF20$1_1.vin.t0 VSS.t57 VSS.t58 sg13_lv_nmos ad=0.19p pd=1.38u as=0.19p ps=1.38u w=1u l=1u
X254 VSS.t226 iqmod_mfb_lpf_pex_half_1.iqmod_mfb_lpf_pex_ota_core_hybrid_bm_half_0.iqmod_mfb_lpf_pex_ota_core_tg$1_0.v_b.t38 voutn.t24 VSS.t225 sg13_lv_nmos ad=0.19p pd=1.38u as=0.19p ps=1.38u w=1u l=1u
X255 iqmod_mfb_lpf_pex_half_1.iqmod_mfb_lpf_pex_ota_core_hybrid_bm_half_0.iqmod_mfb_lpf_pex_ota_core_tg$1_0.v_a.t0 iqmod_mfb_lpf_pex_half_1.iqmod_mfb_lpf_pex_ota_core_hybrid_bm_half_0.iqmod_mfb_lpf_pex_ota_core_inv_NF20$1_1.vin.t0 VSS.t354 VSS.t35 sg13_lv_nmos ad=0.19p pd=1.38u as=0.19p ps=1.38u w=1u l=1u
X256 iqmod_mfb_lpf_pex_half_0.iqmod_mfb_lpf_pex_ota_core_hybrid_bm_half_0.iqmod_mfb_lpf_pex_ota_core_inv_NF20$1_1.vin.t1 iqmod_mfb_lpf_pex_half_0.iqmod_mfb_lpf_pex_ota_core_hybrid_bm_half_0.iqmod_mfb_lpf_pex_ota_core_tg$1_0.di_tg_ctrl_n.t2 VDD.t288 VSS.t13 sg13_lv_nmos ad=0.19p pd=1.38u as=0.19p ps=1.38u w=1u l=0.13u
X257 VSS.t374 iqmod_mfb_lpf_pex_half_1.iqmod_mfb_lpf_pex_ota_core_hybrid_bm_half_0.iqmod_mfb_lpf_pex_ota_core_inv_NF20$1_1.vin.t0 voutp.t28 VSS.t62 sg13_lv_nmos ad=0.19p pd=1.38u as=0.19p ps=1.38u w=1u l=1u
X258 a_6620_3903.t1 iqmod_mfb_lpf_pex_half_1.C2_half.t4 VSS.t17 rhigh l=31u w=0.5u
X259 VDD.t241 voutp.t42 iqmod_mfb_lpf_pex_half_1.iqmod_mfb_lpf_pex_ota_core_hybrid_bm_half_0.iqmod_mfb_lpf_pex_ota_core_inv_NF20$1_0.vout.t51 VDD.t0 sg13_lv_pmos ad=1.14p pd=6.38u as=1.14p ps=6.38u w=6u l=1u
X260 VSS.t185 VSS.t184 VSS.t185 VSS.t139 sg13_lv_nmos ad=0.19p pd=1.38u as=0 ps=0 w=1u l=1u
X261 VSS.t358 iqmod_mfb_lpf_pex_half_1.iqmod_mfb_lpf_pex_ota_core_hybrid_bm_half_0.iqmod_mfb_lpf_pex_ota_core_inv_NF20$1_1.vin.t0 iqmod_mfb_lpf_pex_half_1.iqmod_mfb_lpf_pex_ota_core_hybrid_bm_half_0.iqmod_mfb_lpf_pex_ota_core_tg$1_0.v_a.t0 VSS.t39 sg13_lv_nmos ad=0.19p pd=1.38u as=0.19p ps=1.38u w=1u l=1u
X262 VDD.t127 iqmod_mfb_lpf_pex_half_1.iqmod_mfb_lpf_pex_ota_core_hybrid_bm_half_0.iqmod_mfb_lpf_pex_ota_core_tg$1_0.v_b.t36 voutp.t8 VDD.t0 sg13_lv_pmos ad=1.14p pd=6.38u as=1.14p ps=6.38u w=6u l=1u
X263 VDD.t90 VDD.t88 VDD.t89 VDD.t6 sg13_lv_pmos ad=2.04p pd=12.68u as=0 ps=0 w=6u l=1u
X264 iqmod_mfb_lpf_pex_half_1.iqmod_mfb_lpf_pex_ota_core_hybrid_bm_half_0.iqmod_mfb_lpf_pex_ota_core_inv_NF20$1_0.vout.t22 voutn.t43 VDD.t94 VDD.t6 sg13_lv_pmos ad=1.14p pd=6.38u as=1.14p ps=6.38u w=6u l=1u
X265 iqmod_mfb_lpf_pex_half_1.iqmod_mfb_lpf_pex_ota_core_hybrid_bm_half_0.iqmod_mfb_lpf_pex_ota_core_inv_NF20$1_0.vout.t49 voutp.t42 VDD.t236 VDD.t0 sg13_lv_pmos ad=1.14p pd=6.38u as=1.14p ps=6.38u w=6u l=1u
X266 iqmod_mfb_lpf_pex_half_1.iqmod_mfb_lpf_pex_ota_core_hybrid_bm_half_0.iqmod_mfb_lpf_pex_ota_core_tg$1_0.v_b.t9 iqmod_mfb_lpf_pex_half_1.iqmod_mfb_lpf_pex_ota_core_hybrid_bm_half_0.iqmod_mfb_lpf_pex_ota_core_inv_NF6$1_1.vout.t27 VDD.t41 VDD.t6 sg13_lv_pmos ad=1.14p pd=6.38u as=1.14p ps=6.38u w=6u l=1u
X267 VSS.t75 VSS.t76 VSS.t74 rhigh l=59u w=0.5u
X268 VSS.t140 voutn.t42 iqmod_mfb_lpf_pex_half_1.iqmod_mfb_lpf_pex_ota_core_hybrid_bm_half_0.iqmod_mfb_lpf_pex_ota_core_inv_NF20$1_0.vout.t21 VSS.t302 sg13_lv_nmos ad=0.19p pd=1.38u as=0.19p ps=1.38u w=1u l=1u
X269 voutn.t8 iqmod_mfb_lpf_pex_half_0.iqmod_mfb_lpf_pex_ota_core_hybrid_bm_half_0.iqmod_mfb_lpf_pex_ota_core_inv_NF20$1_1.vin.t0 VDD.t34 VDD.t6 sg13_lv_pmos ad=1.14p pd=6.38u as=1.14p ps=6.38u w=6u l=1u
X270 VDD.t267 iqmod_mfb_lpf_pex_half_1.iqmod_mfb_lpf_pex_ota_core_hybrid_bm_half_0.iqmod_mfb_lpf_pex_ota_core_inv_NF20$1_1.vin.t0 voutp.t37 VDD.t0 sg13_lv_pmos ad=1.14p pd=6.38u as=1.14p ps=6.38u w=6u l=1u
X271 VSS.t43 iqmod_mfb_lpf_pex_half_0.iqmod_mfb_lpf_pex_ota_core_hybrid_bm_half_0.iqmod_mfb_lpf_pex_ota_core_inv_NF20$1_1.vin.t0 iqmod_mfb_lpf_pex_half_1.iqmod_mfb_lpf_pex_ota_core_hybrid_bm_half_0.iqmod_mfb_lpf_pex_ota_core_tg$1_0.v_a.t1 VSS.t42 sg13_lv_nmos ad=0.19p pd=1.38u as=0.19p ps=1.38u w=1u l=1u
X272 iqmod_mfb_lpf_pex_half_1.iqmod_mfb_lpf_pex_ota_core_hybrid_bm_half_0.iqmod_mfb_lpf_pex_ota_core_tg$1_0.v_b.t26 di_filter_en.t5 iqmod_mfb_lpf_pex_half_1.iqmod_mfb_lpf_pex_ota_core_hybrid_bm_half_0.iqmod_mfb_lpf_pex_ota_core_tg$1_0.v_a.t1 VSS.t238 sg13_lv_nmos ad=0.19p pd=1.38u as=0.19p ps=1.38u w=1u l=0.13u
X273 iqmod_mfb_lpf_pex_half_1.iqmod_mfb_lpf_pex_ota_core_hybrid_bm_half_0.iqmod_mfb_lpf_pex_ota_core_inv_NF6$1_1.vout.t2 iqmod_mfb_lpf_pex_half_0.iqmod_mfb_lpf_pex_ota_core_hybrid_bm_half_0.iqmod_mfb_lpf_pex_ota_core_tg$1_0.di_tg_ctrl_n.t4 iqmod_mfb_lpf_pex_half_1.iqmod_mfb_lpf_pex_ota_core_hybrid_bm_half_0.iqmod_mfb_lpf_pex_ota_core_inv_NF20$1_0.vout.t2 VDD.t6 sg13_lv_pmos ad=1.14p pd=6.38u as=1.14p ps=6.38u w=6u l=0.13u
X274 iqmod_mfb_lpf_pex_half_1.iqmod_mfb_lpf_pex_ota_core_hybrid_bm_half_0.iqmod_mfb_lpf_pex_ota_core_inv_NF20$1_0.vout.t17 voutn.t42 VSS.t292 VSS.t293 sg13_lv_nmos ad=0.19p pd=1.38u as=0.19p ps=1.38u w=1u l=1u
X275 iqmod_mfb_lpf_pex_half_1.iqmod_mfb_lpf_pex_ota_core_hybrid_bm_half_0.iqmod_mfb_lpf_pex_ota_core_tg$1_0.v_b.t15 iqmod_mfb_lpf_pex_half_1.iqmod_mfb_lpf_pex_ota_core_hybrid_bm_half_0.iqmod_mfb_lpf_pex_ota_core_tg$1_0.v_a.t0 VSS.t157 VSS.t186 sg13_lv_nmos ad=0.19p pd=1.38u as=0.19p ps=1.38u w=1u l=1u
X276 iqmod_mfb_lpf_pex_half_1.iqmod_mfb_lpf_pex_ota_core_hybrid_bm_half_0.iqmod_mfb_lpf_pex_ota_core_tg$1_0.v_a.t1 iqmod_mfb_lpf_pex_half_0.iqmod_mfb_lpf_pex_ota_core_hybrid_bm_half_0.iqmod_mfb_lpf_pex_ota_core_inv_NF20$1_1.vin.t0 VSS.t27 VSS.t26 sg13_lv_nmos ad=0.19p pd=1.38u as=0.19p ps=1.38u w=1u l=1u
X277 iqmod_mfb_lpf_pex_half_1.iqmod_mfb_lpf_pex_ota_core_hybrid_bm_half_0.iqmod_mfb_lpf_pex_ota_core_inv_NF6$1_1.vout.t10 iqmod_mfb_lpf_pex_half_1.iqmod_mfb_lpf_pex_ota_core_hybrid_bm_half_0.iqmod_mfb_lpf_pex_ota_core_inv_NF20$1_0.vout.t58 VSS.t390 VSS.t195 sg13_lv_nmos ad=0.19p pd=1.38u as=0.19p ps=1.38u w=1u l=1u
X278 VDD.t239 voutp.t42 iqmod_mfb_lpf_pex_half_1.iqmod_mfb_lpf_pex_ota_core_hybrid_bm_half_0.iqmod_mfb_lpf_pex_ota_core_inv_NF20$1_0.vout.t50 VDD.t0 sg13_lv_pmos ad=1.14p pd=6.38u as=1.14p ps=6.38u w=6u l=1u
X279 iqmod_mfb_lpf_pex_half_1.iqmod_mfb_lpf_pex_ota_core_hybrid_bm_half_0.iqmod_mfb_lpf_pex_ota_core_tg$1_0.v_b.t34 iqmod_mfb_lpf_pex_half_1.iqmod_mfb_lpf_pex_ota_core_hybrid_bm_half_0.iqmod_mfb_lpf_pex_ota_core_tg$1_0.v_a.t1 VDD.t251 VDD.t6 sg13_lv_pmos ad=1.14p pd=6.38u as=1.14p ps=6.38u w=6u l=1u
X280 VSS.t183 VSS.t181 VSS.t182 VSS.t135 sg13_lv_nmos ad=0.34p pd=2.68u as=0 ps=0 w=1u l=1u
X281 iqmod_mfb_lpf_pex_half_1.iqmod_mfb_lpf_pex_ota_core_hybrid_bm_half_0.iqmod_mfb_lpf_pex_ota_core_tg$1_0.v_b.t5 iqmod_mfb_lpf_pex_half_1.iqmod_mfb_lpf_pex_ota_core_hybrid_bm_half_0.iqmod_mfb_lpf_pex_ota_core_inv_NF6$1_1.vout.t26 VSS.t384 VSS.t319 sg13_lv_nmos ad=0.19p pd=1.38u as=0.19p ps=1.38u w=1u l=1u
X282 VDD.t37 iqmod_mfb_lpf_pex_half_0.iqmod_mfb_lpf_pex_ota_core_hybrid_bm_half_0.iqmod_mfb_lpf_pex_ota_core_spdt_switch$1_0.iqmod_mfb_lpf_pex_ota_core_spdt_switch_inv$2_0.vout.t3 iqmod_mfb_lpf_pex_half_0.iqmod_mfb_lpf_pex_ota_core_hybrid_bm_half_0.iqmod_mfb_lpf_pex_ota_core_inv_NF20$1_1.vin.t0 VDD.t6 sg13_lv_pmos ad=2.04p pd=12.68u as=1.14p ps=6.38u w=6u l=0.13u
X283 VSS.t196 iqmod_mfb_lpf_pex_half_1.iqmod_mfb_lpf_pex_ota_core_hybrid_bm_half_0.iqmod_mfb_lpf_pex_ota_core_inv_NF20$1_0.vout.t57 iqmod_mfb_lpf_pex_half_1.iqmod_mfb_lpf_pex_ota_core_hybrid_bm_half_0.iqmod_mfb_lpf_pex_ota_core_inv_NF6$1_1.vout.t12 VSS.t198 sg13_lv_nmos ad=0.19p pd=1.38u as=0.19p ps=1.38u w=1u l=1u
X284 VSS.t57 iqmod_mfb_lpf_pex_half_0.iqmod_mfb_lpf_pex_ota_core_hybrid_bm_half_0.iqmod_mfb_lpf_pex_ota_core_inv_NF20$1_1.vin.t0 voutn.t2 VSS.t56 sg13_lv_nmos ad=0.19p pd=1.38u as=0.19p ps=1.38u w=1u l=1u
X285 iqmod_mfb_lpf_pex_half_1.iqmod_mfb_lpf_pex_ota_core_hybrid_bm_half_0.iqmod_mfb_lpf_pex_ota_core_inv_NF20$1_0.vout.t37 voutp.t43 VSS.t326 VSS.t276 sg13_lv_nmos ad=0.19p pd=1.38u as=0.19p ps=1.38u w=1u l=1u
X286 VDD.t72 iqmod_mfb_lpf_pex_half_1.iqmod_mfb_lpf_pex_ota_core_hybrid_bm_half_0.iqmod_mfb_lpf_pex_ota_core_tg$1_0.v_a.t1 iqmod_mfb_lpf_pex_half_1.iqmod_mfb_lpf_pex_ota_core_hybrid_bm_half_0.iqmod_mfb_lpf_pex_ota_core_tg$1_0.v_b.t35 VDD.t6 sg13_lv_pmos ad=1.14p pd=6.38u as=1.14p ps=6.38u w=6u l=1u
X287 iqmod_mfb_lpf_pex_half_1.iqmod_mfb_lpf_pex_ota_core_hybrid_bm_half_0.iqmod_mfb_lpf_pex_ota_core_inv_NF20$1_0.vout.t14 voutn.t42 VSS.t281 VSS.t287 sg13_lv_nmos ad=0.19p pd=1.38u as=0.19p ps=1.38u w=1u l=1u
X288 VDD.t289 iqmod_mfb_lpf_pex_half_0.iqmod_mfb_lpf_pex_ota_core_hybrid_bm_half_0.iqmod_mfb_lpf_pex_ota_core_tg$1_0.di_tg_ctrl_n.t2 iqmod_mfb_lpf_pex_half_0.iqmod_mfb_lpf_pex_ota_core_hybrid_bm_half_0.iqmod_mfb_lpf_pex_ota_core_inv_NF20$1_1.vin.t1 VSS.t81 sg13_lv_nmos ad=0.34p pd=2.68u as=0.19p ps=1.38u w=1u l=0.13u
X289 VDD.t217 voutn.t43 iqmod_mfb_lpf_pex_half_1.iqmod_mfb_lpf_pex_ota_core_hybrid_bm_half_0.iqmod_mfb_lpf_pex_ota_core_inv_NF20$1_0.vout.t27 VDD.t6 sg13_lv_pmos ad=1.14p pd=6.38u as=1.14p ps=6.38u w=6u l=1u
X290 iqmod_mfb_lpf_pex_half_0.iqmod_mfb_lpf_pex_ota_core_hybrid_bm_half_0.iqmod_mfb_lpf_pex_ota_core_inv_NF20$1_1.vin.t0 iqmod_mfb_lpf_pex_half_0.iqmod_mfb_lpf_pex_ota_core_hybrid_bm_half_0.iqmod_mfb_lpf_pex_ota_core_tg$1_0.di_tg_ctrl_n.t2 VDD.t286 VSS.t9 sg13_lv_nmos ad=0.19p pd=1.38u as=0.34p ps=2.68u w=1u l=0.13u
X291 iqmod_mfb_lpf_pex_half_1.iqmod_mfb_lpf_pex_ota_core_hybrid_bm_half_0.iqmod_mfb_lpf_pex_ota_core_inv_NF6$1_1.vout.t14 iqmod_mfb_lpf_pex_half_1.iqmod_mfb_lpf_pex_ota_core_hybrid_bm_half_0.iqmod_mfb_lpf_pex_ota_core_inv_NF20$1_0.vout.t57 VSS.t200 VSS.t201 sg13_lv_nmos ad=0.19p pd=1.38u as=0.19p ps=1.38u w=1u l=1u
X292 VSS.t330 voutp.t43 iqmod_mfb_lpf_pex_half_1.iqmod_mfb_lpf_pex_ota_core_hybrid_bm_half_0.iqmod_mfb_lpf_pex_ota_core_inv_NF20$1_0.vout.t38 VSS.t288 sg13_lv_nmos ad=0.19p pd=1.38u as=0.19p ps=1.38u w=1u l=1u
X293 VDD.t57 di_filter_en.t7 iqmod_mfb_lpf_pex_half_0.iqmod_mfb_lpf_pex_ota_core_hybrid_bm_half_0.iqmod_mfb_lpf_pex_ota_core_tg$1_0.di_tg_ctrl_n.t1 VDD.t6 sg13_lv_pmos ad=1.14p pd=6.38u as=1.14p ps=6.38u w=6u l=0.13u
X294 voutn.t3 iqmod_mfb_lpf_pex_half_0.iqmod_mfb_lpf_pex_ota_core_hybrid_bm_half_0.iqmod_mfb_lpf_pex_ota_core_inv_NF20$1_1.vin.t0 VDD.t7 VDD.t6 sg13_lv_pmos ad=1.14p pd=6.38u as=1.14p ps=6.38u w=6u l=1u
X295 VDD.t144 iqmod_mfb_lpf_pex_half_0.iqmod_mfb_lpf_pex_ota_core_hybrid_bm_half_0.iqmod_mfb_lpf_pex_ota_core_spdt_switch$1_0.iqmod_mfb_lpf_pex_ota_core_spdt_switch_inv$2_0.vout.t4 iqmod_mfb_lpf_pex_half_0.iqmod_mfb_lpf_pex_ota_core_hybrid_bm_half_0.iqmod_mfb_lpf_pex_ota_core_inv_NF20$1_1.vin.t0 VDD.t6 sg13_lv_pmos ad=1.14p pd=6.38u as=1.14p ps=6.38u w=6u l=0.13u
X296 VSS.t303 VSS.t304 VSS.t0 rhigh l=60u w=0.5u
X297 iqmod_mfb_lpf_pex_half_1.iqmod_mfb_lpf_pex_ota_core_hybrid_bm_half_0.iqmod_mfb_lpf_pex_ota_core_inv_NF20$1_0.vout.t52 voutp.t42 VDD.t241 VDD.t0 sg13_lv_pmos ad=1.14p pd=6.38u as=1.14p ps=6.38u w=6u l=1u
X298 VDD.t3 iqmod_mfb_lpf_pex_half_1.iqmod_mfb_lpf_pex_ota_core_hybrid_bm_half_0.iqmod_mfb_lpf_pex_ota_core_tg$1_0.di_tg_ctrl_n.t7 iqmod_mfb_lpf_pex_half_1.iqmod_mfb_lpf_pex_ota_core_hybrid_bm_half_0.iqmod_mfb_lpf_pex_ota_core_inv_NF20$1_1.vin.t0 VSS.t12 sg13_lv_nmos ad=0.19p pd=1.38u as=0.19p ps=1.38u w=1u l=0.13u
X299 voutp.t15 iqmod_mfb_lpf_pex_half_1.iqmod_mfb_lpf_pex_ota_core_hybrid_bm_half_0.iqmod_mfb_lpf_pex_ota_core_tg$1_0.v_b.t37 VSS.t263 VSS.t218 sg13_lv_nmos ad=0.19p pd=1.38u as=0.19p ps=1.38u w=1u l=1u
X300 iqmod_mfb_lpf_pex_half_1.iqmod_mfb_lpf_pex_ota_core_hybrid_bm_half_0.iqmod_mfb_lpf_pex_ota_core_tg$1_0.v_a.t1 di_filter_en.t5 iqmod_mfb_lpf_pex_half_1.iqmod_mfb_lpf_pex_ota_core_hybrid_bm_half_0.iqmod_mfb_lpf_pex_ota_core_tg$1_0.v_b.t26 VSS.t239 sg13_lv_nmos ad=0.34p pd=2.68u as=0.19p ps=1.38u w=1u l=0.13u
X301 VDD.t127 VDD.t126 VDD.t127 VDD.t0 sg13_lv_pmos ad=1.14p pd=6.38u as=0 ps=0 w=6u l=1u
X302 iqmod_mfb_lpf_pex_half_1.iqmod_mfb_lpf_pex_ota_core_hybrid_bm_half_0.iqmod_mfb_lpf_pex_ota_core_tg$1_0.v_b.t24 di_filter_en.t5 iqmod_mfb_lpf_pex_half_1.iqmod_mfb_lpf_pex_ota_core_hybrid_bm_half_0.iqmod_mfb_lpf_pex_ota_core_tg$1_0.v_a.t1 VSS.t234 sg13_lv_nmos ad=0.19p pd=1.38u as=0.34p ps=2.68u w=1u l=0.13u
X303 iqmod_mfb_lpf_pex_half_1.iqmod_mfb_lpf_pex_ota_core_hybrid_bm_half_0.iqmod_mfb_lpf_pex_ota_core_inv_NF20$1_0.vout.t27 voutn.t43 VDD.t220 VDD.t6 sg13_lv_pmos ad=1.14p pd=6.38u as=1.14p ps=6.38u w=6u l=1u
X304 iqmod_mfb_lpf_pex_half_0.iqmod_mfb_lpf_pex_ota_core_hybrid_bm_half_0.iqmod_mfb_lpf_pex_ota_core_inv_NF20$1_1.vin.t0 iqmod_mfb_lpf_pex_half_0.iqmod_mfb_lpf_pex_ota_core_hybrid_bm_half_0.iqmod_mfb_lpf_pex_ota_core_spdt_switch$1_0.iqmod_mfb_lpf_pex_ota_core_spdt_switch_inv$2_0.vout.t2 iqmod_mfb_lpf_pex_half_0.vinp.t5 VSS.t5 sg13_lv_nmos ad=0.19p pd=1.38u as=0.19p ps=1.38u w=1u l=0.13u
X305 VDD.t269 iqmod_mfb_lpf_pex_half_1.iqmod_mfb_lpf_pex_ota_core_hybrid_bm_half_0.iqmod_mfb_lpf_pex_ota_core_inv_NF20$1_1.vin.t0 voutp.t23 VDD.t0 sg13_lv_pmos ad=1.14p pd=6.38u as=1.14p ps=6.38u w=6u l=1u
X306 voutn.t24 iqmod_mfb_lpf_pex_half_1.iqmod_mfb_lpf_pex_ota_core_hybrid_bm_half_0.iqmod_mfb_lpf_pex_ota_core_tg$1_0.v_b.t38 VSS.t223 VSS.t224 sg13_lv_nmos ad=0.19p pd=1.38u as=0.19p ps=1.38u w=1u l=1u
X307 voutn.t0 iqmod_mfb_lpf_pex_half_0.iqmod_mfb_lpf_pex_ota_core_hybrid_bm_half_0.iqmod_mfb_lpf_pex_ota_core_inv_NF20$1_1.vin.t0 VSS.t31 VSS.t30 sg13_lv_nmos ad=0.19p pd=1.38u as=0.19p ps=1.38u w=1u l=1u
X308 VDD.t199 iqmod_mfb_lpf_pex_half_1.iqmod_mfb_lpf_pex_ota_core_hybrid_bm_half_0.iqmod_mfb_lpf_pex_ota_core_tg$1_0.v_b.t39 voutn.t33 VDD.t6 sg13_lv_pmos ad=1.14p pd=6.38u as=1.14p ps=6.38u w=6u l=1u
X309 VSS.t211 iqmod_mfb_lpf_pex_half_1.iqmod_mfb_lpf_pex_ota_core_hybrid_bm_half_0.iqmod_mfb_lpf_pex_ota_core_tg$1_0.v_b.t38 voutn.t22 VSS.t210 sg13_lv_nmos ad=0.19p pd=1.38u as=0.19p ps=1.38u w=1u l=1u
X310 VSS.t85 VSS.t82 VSS.t84 VSS.t83 sg13_lv_nmos ad=0.34p pd=2.68u as=0 ps=0 w=1u l=0.13u
X311 VSS.t37 iqmod_mfb_lpf_pex_half_0.iqmod_mfb_lpf_pex_ota_core_hybrid_bm_half_0.iqmod_mfb_lpf_pex_ota_core_inv_NF20$1_1.vin.t0 iqmod_mfb_lpf_pex_half_1.iqmod_mfb_lpf_pex_ota_core_hybrid_bm_half_0.iqmod_mfb_lpf_pex_ota_core_tg$1_0.v_a.t1 VSS.t36 sg13_lv_nmos ad=0.19p pd=1.38u as=0.19p ps=1.38u w=1u l=1u
X312 voutn.t37 iqmod_mfb_lpf_pex_half_1.iqmod_mfb_lpf_pex_ota_core_hybrid_bm_half_0.iqmod_mfb_lpf_pex_ota_core_tg$1_0.v_b.t39 VDD.t201 VDD.t6 sg13_lv_pmos ad=1.14p pd=6.38u as=1.14p ps=6.38u w=6u l=1u
X313 VDD.t165 iqmod_mfb_lpf_pex_half_1.iqmod_mfb_lpf_pex_ota_core_hybrid_bm_half_0.iqmod_mfb_lpf_pex_ota_core_tg$1_0.v_b.t36 voutp.t10 VDD.t0 sg13_lv_pmos ad=1.14p pd=6.38u as=1.14p ps=6.38u w=6u l=1u
X314 VSS.t185 voutp.t43 iqmod_mfb_lpf_pex_half_1.iqmod_mfb_lpf_pex_ota_core_hybrid_bm_half_0.iqmod_mfb_lpf_pex_ota_core_inv_NF20$1_0.vout.t45 VSS.t302 sg13_lv_nmos ad=0.19p pd=1.38u as=0.19p ps=1.38u w=1u l=1u
X315 voutp.t28 iqmod_mfb_lpf_pex_half_1.iqmod_mfb_lpf_pex_ota_core_hybrid_bm_half_0.iqmod_mfb_lpf_pex_ota_core_inv_NF20$1_1.vin.t0 VSS.t372 VSS.t61 sg13_lv_nmos ad=0.19p pd=1.38u as=0.19p ps=1.38u w=1u l=1u
X316 iqmod_mfb_lpf_pex_half_1.iqmod_mfb_lpf_pex_ota_core_hybrid_bm_half_0.iqmod_mfb_lpf_pex_ota_core_tg$1_0.v_b.t31 iqmod_mfb_lpf_pex_half_1.iqmod_mfb_lpf_pex_ota_core_hybrid_bm_half_0.iqmod_mfb_lpf_pex_ota_core_tg$1_0.v_a.t1 VSS.t346 VSS.t189 sg13_lv_nmos ad=0.19p pd=1.38u as=0.19p ps=1.38u w=1u l=1u
X317 iqmod_mfb_lpf_pex_half_1.iqmod_mfb_lpf_pex_ota_core_hybrid_bm_half_0.iqmod_mfb_lpf_pex_ota_core_inv_NF20$1_0.vout.t21 voutn.t42 VSS.t283 VSS.t282 sg13_lv_nmos ad=0.19p pd=1.38u as=0.19p ps=1.38u w=1u l=1u
X318 VDD.t85 VDD.t83 VDD.t41 VDD.t6 sg13_lv_pmos ad=2.04p pd=12.68u as=0 ps=0 w=6u l=1u
X319 iqmod_mfb_lpf_pex_half_0.iqmod_mfb_lpf_pex_ota_core_hybrid_bm_half_0.iqmod_mfb_lpf_pex_ota_core_tg$1_0.di_tg_ctrl_n.t0 di_filter_en.t6 VSS.t84 VSS.t232 sg13_lv_nmos ad=0.19p pd=1.38u as=0.19p ps=1.38u w=1u l=0.13u
X320 voutp.t39 iqmod_mfb_lpf_pex_half_1.iqmod_mfb_lpf_pex_ota_core_hybrid_bm_half_0.iqmod_mfb_lpf_pex_ota_core_inv_NF20$1_1.vin.t0 VDD.t271 VDD.t0 sg13_lv_pmos ad=1.14p pd=6.38u as=1.14p ps=6.38u w=6u l=1u
X321 iqmod_mfb_lpf_pex_half_1.iqmod_mfb_lpf_pex_ota_core_hybrid_bm_half_0.iqmod_mfb_lpf_pex_ota_core_tg$1_0.v_a.t0 iqmod_mfb_lpf_pex_half_1.iqmod_mfb_lpf_pex_ota_core_hybrid_bm_half_0.iqmod_mfb_lpf_pex_ota_core_inv_NF20$1_1.vin.t0 VSS.t356 VSS.t38 sg13_lv_nmos ad=0.19p pd=1.38u as=0.19p ps=1.38u w=1u l=1u
X322 voutn.t9 iqmod_mfb_lpf_pex_half_0.iqmod_mfb_lpf_pex_ota_core_hybrid_bm_half_0.iqmod_mfb_lpf_pex_ota_core_inv_NF20$1_1.vin.t0 VSS.t25 VSS.t24 sg13_lv_nmos ad=0.19p pd=1.38u as=0.19p ps=1.38u w=1u l=1u
X323 iqmod_mfb_lpf_pex_half_1.vinp.t2 iqmod_mfb_lpf_pex_half_1.iqmod_mfb_lpf_pex_ota_core_hybrid_bm_half_0.iqmod_mfb_lpf_pex_ota_core_tg$1_0.di_tg_ctrl_n.t4 iqmod_mfb_lpf_pex_half_1.iqmod_mfb_lpf_pex_ota_core_hybrid_bm_half_0.iqmod_mfb_lpf_pex_ota_core_inv_NF20$1_1.vin.t0 VDD.t0 sg13_lv_pmos ad=1.14p pd=6.38u as=1.14p ps=6.38u w=6u l=0.13u
X324 a_6620_3903.t0 a_12906_4203.t0 VSS.t17 rhigh l=31u w=0.5u
X325 VSS.t292 voutn.t42 iqmod_mfb_lpf_pex_half_1.iqmod_mfb_lpf_pex_ota_core_hybrid_bm_half_0.iqmod_mfb_lpf_pex_ota_core_inv_NF20$1_0.vout.t16 VSS.t291 sg13_lv_nmos ad=0.19p pd=1.38u as=0.19p ps=1.38u w=1u l=1u
X326 iqmod_mfb_lpf_pex_half_1.iqmod_mfb_lpf_pex_ota_core_hybrid_bm_half_0.iqmod_mfb_lpf_pex_ota_core_tg$1_0.v_a.t0 iqmod_mfb_lpf_pex_half_1.iqmod_mfb_lpf_pex_ota_core_hybrid_bm_half_0.iqmod_mfb_lpf_pex_ota_core_inv_NF20$1_1.vin.t0 VDD.t109 VDD.t0 sg13_lv_pmos ad=1.14p pd=6.38u as=1.14p ps=6.38u w=6u l=1u
X327 VDD.t142 voutp.t42 iqmod_mfb_lpf_pex_half_1.iqmod_mfb_lpf_pex_ota_core_hybrid_bm_half_0.iqmod_mfb_lpf_pex_ota_core_inv_NF20$1_0.vout.t55 VDD.t0 sg13_lv_pmos ad=1.14p pd=6.38u as=1.14p ps=6.38u w=6u l=1u
X328 iqmod_mfb_lpf_pex_half_1.iqmod_mfb_lpf_pex_ota_core_hybrid_bm_half_0.iqmod_mfb_lpf_pex_ota_core_tg$1_0.v_b.t10 iqmod_mfb_lpf_pex_half_1.iqmod_mfb_lpf_pex_ota_core_hybrid_bm_half_0.iqmod_mfb_lpf_pex_ota_core_inv_NF6$1_1.vout.t27 VDD.t40 VDD.t6 sg13_lv_pmos ad=1.14p pd=6.38u as=1.14p ps=6.38u w=6u l=1u
X329 VSS.t98 VSS.t96 VSS.t27 VSS.t97 sg13_lv_nmos ad=0.34p pd=2.68u as=0 ps=0 w=1u l=1u
X330 iqmod_mfb_lpf_pex_half_1.iqmod_mfb_lpf_pex_R2_0.v_a.t8 iqmod_mfb_lpf_pex_half_1.C2_half.t0 cap_cmim l=8u w=8u
X331 iqmod_mfb_lpf_pex_half_1.iqmod_mfb_lpf_pex_ota_core_hybrid_bm_half_0.iqmod_mfb_lpf_pex_ota_core_inv_NF20$1_0.vout.t53 voutp.t42 VDD.t244 VDD.t0 sg13_lv_pmos ad=1.14p pd=6.38u as=1.14p ps=6.38u w=6u l=1u
X332 iqmod_mfb_lpf_pex_half_1.C2_half.t5 a_37874_3903.t1 VSS.t0 rhigh l=60u w=0.5u
X333 iqmod_mfb_lpf_pex_half_1.iqmod_mfb_lpf_pex_ota_core_hybrid_bm_half_0.iqmod_mfb_lpf_pex_ota_core_inv_NF6$1_1.vout.t23 iqmod_mfb_lpf_pex_half_1.iqmod_mfb_lpf_pex_ota_core_hybrid_bm_half_0.iqmod_mfb_lpf_pex_ota_core_tg$1_0.di_tg_ctrl_n.t2 iqmod_mfb_lpf_pex_half_1.iqmod_mfb_lpf_pex_ota_core_hybrid_bm_half_0.iqmod_mfb_lpf_pex_ota_core_inv_NF20$1_0.vout.t33 VDD.t0 sg13_lv_pmos ad=1.14p pd=6.38u as=1.14p ps=6.38u w=6u l=0.13u
X334 VSS.t158 VSS.t156 VSS.t157 VSS.t102 sg13_lv_nmos ad=0.34p pd=2.68u as=0 ps=0 w=1u l=1u
X335 VSS.t384 iqmod_mfb_lpf_pex_half_1.iqmod_mfb_lpf_pex_ota_core_hybrid_bm_half_0.iqmod_mfb_lpf_pex_ota_core_inv_NF6$1_1.vout.t26 iqmod_mfb_lpf_pex_half_1.iqmod_mfb_lpf_pex_ota_core_hybrid_bm_half_0.iqmod_mfb_lpf_pex_ota_core_tg$1_0.v_b.t4 VSS.t317 sg13_lv_nmos ad=0.19p pd=1.38u as=0.19p ps=1.38u w=1u l=1u
X336 iqmod_mfb_lpf_pex_half_0.vinp.t6 iqmod_mfb_lpf_pex_half_0.iqmod_mfb_lpf_pex_ota_core_hybrid_bm_half_0.iqmod_mfb_lpf_pex_ota_core_spdt_switch$1_0.iqmod_mfb_lpf_pex_ota_core_spdt_switch_inv$2_0.vout.t2 iqmod_mfb_lpf_pex_half_0.iqmod_mfb_lpf_pex_ota_core_hybrid_bm_half_0.iqmod_mfb_lpf_pex_ota_core_inv_NF20$1_1.vin.t0 VSS.t6 sg13_lv_nmos ad=0.19p pd=1.38u as=0.19p ps=1.38u w=1u l=0.13u
X337 voutn.t2 iqmod_mfb_lpf_pex_half_0.iqmod_mfb_lpf_pex_ota_core_hybrid_bm_half_0.iqmod_mfb_lpf_pex_ota_core_inv_NF20$1_1.vin.t0 VSS.t54 VSS.t55 sg13_lv_nmos ad=0.19p pd=1.38u as=0.19p ps=1.38u w=1u l=1u
X338 voutn.t41 iqmod_mfb_lpf_pex_half_0.vinp.t9 cap_cmim l=8u w=8u
X339 VDD.t275 iqmod_mfb_lpf_pex_half_1.iqmod_mfb_lpf_pex_ota_core_hybrid_bm_half_0.iqmod_mfb_lpf_pex_ota_core_inv_NF20$1_1.vin.t0 voutp.t32 VDD.t0 sg13_lv_pmos ad=1.14p pd=6.38u as=1.14p ps=6.38u w=6u l=1u
X340 VDD.t293 iqmod_mfb_lpf_pex_half_1.iqmod_mfb_lpf_pex_ota_core_hybrid_bm_half_0.iqmod_mfb_lpf_pex_ota_core_spdt_switch$1_0.iqmod_mfb_lpf_pex_ota_core_spdt_switch_inv$2_0.vout.t2 iqmod_mfb_lpf_pex_half_1.iqmod_mfb_lpf_pex_ota_core_hybrid_bm_half_0.iqmod_mfb_lpf_pex_ota_core_inv_NF20$1_1.vin.t0 VDD.t0 sg13_lv_pmos ad=1.14p pd=6.38u as=1.14p ps=6.38u w=6u l=0.13u
X341 VDD.t60 VDD.t58 VDD.t38 VDD.t6 sg13_lv_pmos ad=2.04p pd=12.68u as=0 ps=0 w=6u l=0.13u
X342 iqmod_mfb_lpf_pex_half_1.iqmod_mfb_lpf_pex_ota_core_hybrid_bm_half_0.iqmod_mfb_lpf_pex_ota_core_tg$1_0.v_b.t18 iqmod_mfb_lpf_pex_half_1.iqmod_mfb_lpf_pex_ota_core_hybrid_bm_half_0.iqmod_mfb_lpf_pex_ota_core_tg$1_0.v_a.t0 VDD.t47 VDD.t0 sg13_lv_pmos ad=1.14p pd=6.38u as=1.14p ps=6.38u w=6u l=1u
X343 VDD.t259 iqmod_mfb_lpf_pex_half_1.iqmod_mfb_lpf_pex_ota_core_hybrid_bm_half_0.iqmod_mfb_lpf_pex_ota_core_inv_NF20$1_1.vin.t0 iqmod_mfb_lpf_pex_half_1.iqmod_mfb_lpf_pex_ota_core_hybrid_bm_half_0.iqmod_mfb_lpf_pex_ota_core_tg$1_0.v_a.t0 VDD.t0 sg13_lv_pmos ad=1.14p pd=6.38u as=1.14p ps=6.38u w=6u l=1u
X344 VSS.t326 voutp.t43 iqmod_mfb_lpf_pex_half_1.iqmod_mfb_lpf_pex_ota_core_hybrid_bm_half_0.iqmod_mfb_lpf_pex_ota_core_inv_NF20$1_0.vout.t36 VSS.t279 sg13_lv_nmos ad=0.19p pd=1.38u as=0.19p ps=1.38u w=1u l=1u
X345 iqmod_mfb_lpf_pex_half_1.vinp.t5 iqmod_mfb_lpf_pex_half_1.iqmod_mfb_lpf_pex_ota_core_hybrid_bm_half_0.iqmod_mfb_lpf_pex_ota_core_spdt_switch$1_0.iqmod_mfb_lpf_pex_ota_core_spdt_switch_inv$2_0.vout.t4 iqmod_mfb_lpf_pex_half_1.iqmod_mfb_lpf_pex_ota_core_hybrid_bm_half_0.iqmod_mfb_lpf_pex_ota_core_inv_NF20$1_1.vin.t0 VSS.t4 sg13_lv_nmos ad=0.19p pd=1.38u as=0.19p ps=1.38u w=1u l=0.13u
X346 VDD.t185 iqmod_mfb_lpf_pex_half_1.iqmod_mfb_lpf_pex_ota_core_hybrid_bm_half_0.iqmod_mfb_lpf_pex_ota_core_tg$1_0.v_b.t39 voutn.t35 VDD.t6 sg13_lv_pmos ad=1.14p pd=6.38u as=1.14p ps=6.38u w=6u l=1u
X347 VDD.t167 iqmod_mfb_lpf_pex_half_1.iqmod_mfb_lpf_pex_ota_core_hybrid_bm_half_0.iqmod_mfb_lpf_pex_ota_core_tg$1_0.v_b.t36 voutp.t1 VDD.t0 sg13_lv_pmos ad=1.14p pd=6.38u as=1.14p ps=6.38u w=6u l=1u
X348 VSS.t80 iqmod_mfb_lpf_pex_half_1.iqmod_mfb_lpf_pex_ota_core_hybrid_bm_half_0.iqmod_mfb_lpf_pex_ota_core_tg$1_0.di_tg_ctrl_n.t8 iqmod_mfb_lpf_pex_half_1.iqmod_mfb_lpf_pex_ota_core_hybrid_bm_half_0.iqmod_mfb_lpf_pex_ota_core_spdt_switch$1_0.iqmod_mfb_lpf_pex_ota_core_spdt_switch_inv$2_0.vout.t1 VSS.t79 sg13_lv_nmos ad=0.19p pd=1.38u as=0.19p ps=1.38u w=1u l=0.13u
X349 VDD.t187 iqmod_mfb_lpf_pex_half_1.iqmod_mfb_lpf_pex_ota_core_hybrid_bm_half_0.iqmod_mfb_lpf_pex_ota_core_tg$1_0.v_b.t39 voutn.t36 VDD.t6 sg13_lv_pmos ad=1.14p pd=6.38u as=1.14p ps=6.38u w=6u l=1u
X350 voutp.t24 iqmod_mfb_lpf_pex_half_1.iqmod_mfb_lpf_pex_ota_core_hybrid_bm_half_0.iqmod_mfb_lpf_pex_ota_core_inv_NF20$1_1.vin.t0 VDD.t269 VDD.t0 sg13_lv_pmos ad=1.14p pd=6.38u as=1.14p ps=6.38u w=6u l=1u
X351 VSS.t119 iqmod_mfb_lpf_pex_half_1.iqmod_mfb_lpf_pex_ota_core_hybrid_bm_half_0.iqmod_mfb_lpf_pex_ota_core_tg$1_0.v_b.t38 voutn.t26 VSS.t231 sg13_lv_nmos ad=0.19p pd=1.38u as=0.19p ps=1.38u w=1u l=1u
X352 iqmod_mfb_lpf_pex_half_1.iqmod_mfb_lpf_pex_ota_core_hybrid_bm_half_0.iqmod_mfb_lpf_pex_ota_core_inv_NF20$1_0.vout.t38 voutp.t43 VSS.t329 VSS.t287 sg13_lv_nmos ad=0.19p pd=1.38u as=0.19p ps=1.38u w=1u l=1u
X353 VDD.t243 voutp.t42 iqmod_mfb_lpf_pex_half_1.iqmod_mfb_lpf_pex_ota_core_hybrid_bm_half_0.iqmod_mfb_lpf_pex_ota_core_inv_NF20$1_0.vout.t54 VDD.t0 sg13_lv_pmos ad=1.14p pd=6.38u as=1.14p ps=6.38u w=6u l=1u
X354 iqmod_mfb_lpf_pex_half_1.iqmod_mfb_lpf_pex_ota_core_hybrid_bm_half_0.iqmod_mfb_lpf_pex_ota_core_tg$1_0.v_b.t8 iqmod_mfb_lpf_pex_half_1.iqmod_mfb_lpf_pex_ota_core_hybrid_bm_half_0.iqmod_mfb_lpf_pex_ota_core_inv_NF6$1_1.vout.t25 VSS.t318 VSS.t319 sg13_lv_nmos ad=0.19p pd=1.38u as=0.19p ps=1.38u w=1u l=1u
X355 VDD.t212 voutn.t43 iqmod_mfb_lpf_pex_half_1.iqmod_mfb_lpf_pex_ota_core_hybrid_bm_half_0.iqmod_mfb_lpf_pex_ota_core_inv_NF20$1_0.vout.t23 VDD.t6 sg13_lv_pmos ad=1.14p pd=6.38u as=1.14p ps=6.38u w=6u l=1u
X356 VDD.t102 di_filter_en.t0 iqmod_mfb_lpf_pex_half_1.iqmod_mfb_lpf_pex_ota_core_hybrid_bm_half_0.iqmod_mfb_lpf_pex_ota_core_tg$1_0.di_tg_ctrl_n.t1 VDD.t0 sg13_lv_pmos ad=1.14p pd=6.38u as=1.14p ps=6.38u w=6u l=0.13u
X357 VSS.t346 iqmod_mfb_lpf_pex_half_1.iqmod_mfb_lpf_pex_ota_core_hybrid_bm_half_0.iqmod_mfb_lpf_pex_ota_core_tg$1_0.v_a.t1 iqmod_mfb_lpf_pex_half_1.iqmod_mfb_lpf_pex_ota_core_hybrid_bm_half_0.iqmod_mfb_lpf_pex_ota_core_tg$1_0.v_b.t30 VSS.t187 sg13_lv_nmos ad=0.19p pd=1.38u as=0.19p ps=1.38u w=1u l=1u
X358 VSS.t88 di_filter_en.t6 iqmod_mfb_lpf_pex_half_0.iqmod_mfb_lpf_pex_ota_core_hybrid_bm_half_0.iqmod_mfb_lpf_pex_ota_core_tg$1_0.di_tg_ctrl_n.t0 VSS.t233 sg13_lv_nmos ad=0.19p pd=1.38u as=0.19p ps=1.38u w=1u l=0.13u
X359 VDD.t75 VDD.t73 VDD.t7 VDD.t6 sg13_lv_pmos ad=2.04p pd=12.68u as=0 ps=0 w=6u l=1u
X360 iqmod_mfb_lpf_pex_half_1.iqmod_mfb_lpf_pex_ota_core_hybrid_bm_half_0.iqmod_mfb_lpf_pex_ota_core_inv_NF20$1_0.vout.t25 voutn.t43 VDD.t215 VDD.t6 sg13_lv_pmos ad=1.14p pd=6.38u as=1.14p ps=6.38u w=6u l=1u
X361 iqmod_mfb_lpf_pex_half_1.iqmod_mfb_lpf_pex_ota_core_hybrid_bm_half_0.iqmod_mfb_lpf_pex_ota_core_spdt_switch$1_0.iqmod_mfb_lpf_pex_ota_core_spdt_switch_inv$2_0.vout.t0 iqmod_mfb_lpf_pex_half_1.iqmod_mfb_lpf_pex_ota_core_hybrid_bm_half_0.iqmod_mfb_lpf_pex_ota_core_tg$1_0.di_tg_ctrl_n.t5 VDD.t1 VDD.t0 sg13_lv_pmos ad=1.14p pd=6.38u as=1.14p ps=6.38u w=6u l=0.13u
X362 voutn.t13 iqmod_mfb_lpf_pex_half_0.iqmod_mfb_lpf_pex_ota_core_hybrid_bm_half_0.iqmod_mfb_lpf_pex_ota_core_inv_NF20$1_1.vin.t0 VDD.t18 VDD.t6 sg13_lv_pmos ad=1.14p pd=6.38u as=1.14p ps=6.38u w=6u l=1u
X363 VDD.t220 voutn.t43 iqmod_mfb_lpf_pex_half_1.iqmod_mfb_lpf_pex_ota_core_hybrid_bm_half_0.iqmod_mfb_lpf_pex_ota_core_inv_NF20$1_0.vout.t26 VDD.t6 sg13_lv_pmos ad=1.14p pd=6.38u as=1.14p ps=6.38u w=6u l=1u
X364 iqmod_mfb_lpf_pex_half_1.iqmod_mfb_lpf_pex_ota_core_hybrid_bm_half_0.iqmod_mfb_lpf_pex_ota_core_inv_NF20$1_0.vout.t19 voutn.t42 VSS.t296 VSS.t297 sg13_lv_nmos ad=0.19p pd=1.38u as=0.19p ps=1.38u w=1u l=1u
X365 iqmod_mfb_lpf_pex_half_1.iqmod_mfb_lpf_pex_ota_core_hybrid_bm_half_0.iqmod_mfb_lpf_pex_ota_core_inv_NF6$1_1.vout.t1 iqmod_mfb_lpf_pex_half_0.iqmod_mfb_lpf_pex_ota_core_hybrid_bm_half_0.iqmod_mfb_lpf_pex_ota_core_tg$1_0.di_tg_ctrl_n.t4 iqmod_mfb_lpf_pex_half_1.iqmod_mfb_lpf_pex_ota_core_hybrid_bm_half_0.iqmod_mfb_lpf_pex_ota_core_inv_NF20$1_0.vout.t1 VDD.t6 sg13_lv_pmos ad=1.14p pd=6.38u as=1.14p ps=6.38u w=6u l=0.13u
X366 iqmod_mfb_lpf_pex_half_1.C1_half.t5 a_12906_4203.t1 VSS.t17 rhigh l=31u w=0.5u
X367 iqmod_mfb_lpf_pex_half_1.iqmod_mfb_lpf_pex_ota_core_hybrid_bm_half_0.iqmod_mfb_lpf_pex_ota_core_inv_NF20$1_0.vout.t28 voutn.t43 VDD.t217 VDD.t6 sg13_lv_pmos ad=1.14p pd=6.38u as=1.14p ps=6.38u w=6u l=1u
X368 voutn.t22 iqmod_mfb_lpf_pex_half_1.iqmod_mfb_lpf_pex_ota_core_hybrid_bm_half_0.iqmod_mfb_lpf_pex_ota_core_tg$1_0.v_b.t38 VSS.t208 VSS.t209 sg13_lv_nmos ad=0.19p pd=1.38u as=0.19p ps=1.38u w=1u l=1u
X369 VSS.t259 iqmod_mfb_lpf_pex_half_1.iqmod_mfb_lpf_pex_ota_core_hybrid_bm_half_0.iqmod_mfb_lpf_pex_ota_core_tg$1_0.v_b.t37 voutp.t19 VSS.t210 sg13_lv_nmos ad=0.19p pd=1.38u as=0.19p ps=1.38u w=1u l=1u
X370 iqmod_mfb_lpf_pex_half_1.iqmod_mfb_lpf_pex_ota_core_hybrid_bm_half_0.iqmod_mfb_lpf_pex_ota_core_tg$1_0.v_a.t1 iqmod_mfb_lpf_pex_half_0.iqmod_mfb_lpf_pex_ota_core_hybrid_bm_half_0.iqmod_mfb_lpf_pex_ota_core_inv_NF20$1_1.vin.t0 VSS.t34 VSS.t35 sg13_lv_nmos ad=0.19p pd=1.38u as=0.19p ps=1.38u w=1u l=1u
X371 iqmod_mfb_lpf_pex_half_1.iqmod_mfb_lpf_pex_ota_core_hybrid_bm_half_0.iqmod_mfb_lpf_pex_ota_core_tg$1_0.v_b.t4 iqmod_mfb_lpf_pex_half_1.iqmod_mfb_lpf_pex_ota_core_hybrid_bm_half_0.iqmod_mfb_lpf_pex_ota_core_inv_NF6$1_1.vout.t26 VSS.t385 VSS.t316 sg13_lv_nmos ad=0.19p pd=1.38u as=0.19p ps=1.38u w=1u l=1u
X372 voutn.t33 iqmod_mfb_lpf_pex_half_1.iqmod_mfb_lpf_pex_ota_core_hybrid_bm_half_0.iqmod_mfb_lpf_pex_ota_core_tg$1_0.v_b.t39 VDD.t197 VDD.t6 sg13_lv_pmos ad=1.14p pd=6.38u as=1.14p ps=6.38u w=6u l=1u
X373 voutp.t40 iqmod_mfb_lpf_pex_half_1.iqmod_mfb_lpf_pex_ota_core_hybrid_bm_half_0.iqmod_mfb_lpf_pex_ota_core_inv_NF20$1_1.vin.t0 VDD.t281 VDD.t0 sg13_lv_pmos ad=1.14p pd=6.38u as=1.14p ps=6.38u w=6u l=1u
X374 voutp.t17 iqmod_mfb_lpf_pex_half_1.iqmod_mfb_lpf_pex_ota_core_hybrid_bm_half_0.iqmod_mfb_lpf_pex_ota_core_tg$1_0.v_b.t37 VSS.t261 VSS.t215 sg13_lv_nmos ad=0.19p pd=1.38u as=0.19p ps=1.38u w=1u l=1u
X375 VDD.t132 iqmod_mfb_lpf_pex_half_1.iqmod_mfb_lpf_pex_ota_core_hybrid_bm_half_0.iqmod_mfb_lpf_pex_ota_core_inv_NF6$1_1.vout.t24 iqmod_mfb_lpf_pex_half_1.iqmod_mfb_lpf_pex_ota_core_hybrid_bm_half_0.iqmod_mfb_lpf_pex_ota_core_tg$1_0.v_b.t14 VDD.t0 sg13_lv_pmos ad=1.14p pd=6.38u as=1.14p ps=6.38u w=6u l=1u
X376 VDD.t112 VDD.t111 VDD.t112 VDD.t0 sg13_lv_pmos ad=1.14p pd=6.38u as=0 ps=0 w=6u l=1u
X377 VDD.t201 iqmod_mfb_lpf_pex_half_1.iqmod_mfb_lpf_pex_ota_core_hybrid_bm_half_0.iqmod_mfb_lpf_pex_ota_core_tg$1_0.v_b.t39 voutn.t34 VDD.t6 sg13_lv_pmos ad=1.14p pd=6.38u as=1.14p ps=6.38u w=6u l=1u
X378 voutp.t5 iqmod_mfb_lpf_pex_half_1.iqmod_mfb_lpf_pex_ota_core_hybrid_bm_half_0.iqmod_mfb_lpf_pex_ota_core_tg$1_0.v_b.t36 VDD.t173 VDD.t0 sg13_lv_pmos ad=1.14p pd=6.38u as=1.14p ps=6.38u w=6u l=1u
X379 VDD.t277 iqmod_mfb_lpf_pex_half_1.iqmod_mfb_lpf_pex_ota_core_hybrid_bm_half_0.iqmod_mfb_lpf_pex_ota_core_inv_NF20$1_1.vin.t0 voutp.t33 VDD.t0 sg13_lv_pmos ad=1.14p pd=6.38u as=1.14p ps=6.38u w=6u l=1u
X380 iqmod_mfb_lpf_pex_half_1.iqmod_mfb_lpf_pex_ota_core_hybrid_bm_half_0.iqmod_mfb_lpf_pex_ota_core_inv_NF20$1_0.vout.t45 voutp.t43 VSS.t342 VSS.t282 sg13_lv_nmos ad=0.19p pd=1.38u as=0.19p ps=1.38u w=1u l=1u
X381 VSS.t25 iqmod_mfb_lpf_pex_half_0.iqmod_mfb_lpf_pex_ota_core_hybrid_bm_half_0.iqmod_mfb_lpf_pex_ota_core_inv_NF20$1_1.vin.t0 voutn.t5 VSS.t62 sg13_lv_nmos ad=0.19p pd=1.38u as=0.19p ps=1.38u w=1u l=1u
X382 iqmod_mfb_lpf_pex_half_0.iqmod_mfb_lpf_pex_ota_core_hybrid_bm_half_0.iqmod_mfb_lpf_pex_ota_core_inv_NF20$1_1.vin.t0 iqmod_mfb_lpf_pex_half_0.iqmod_mfb_lpf_pex_ota_core_hybrid_bm_half_0.iqmod_mfb_lpf_pex_ota_core_spdt_switch$1_0.iqmod_mfb_lpf_pex_ota_core_spdt_switch_inv$2_0.vout.t4 VDD.t143 VDD.t6 sg13_lv_pmos ad=1.14p pd=6.38u as=2.04p ps=12.68u w=6u l=0.13u
X383 iqmod_mfb_lpf_pex_half_1.iqmod_mfb_lpf_pex_ota_core_hybrid_bm_half_0.iqmod_mfb_lpf_pex_ota_core_tg$1_0.v_a.t1 iqmod_mfb_lpf_pex_half_0.iqmod_mfb_lpf_pex_ota_core_hybrid_bm_half_0.iqmod_mfb_lpf_pex_ota_core_tg$1_0.di_tg_ctrl_n.t5 iqmod_mfb_lpf_pex_half_1.iqmod_mfb_lpf_pex_ota_core_hybrid_bm_half_0.iqmod_mfb_lpf_pex_ota_core_tg$1_0.v_b.t2 VDD.t6 sg13_lv_pmos ad=2.04p pd=12.68u as=1.14p ps=6.38u w=6u l=0.13u
X384 iqmod_mfb_lpf_pex_half_1.iqmod_mfb_lpf_pex_ota_core_hybrid_bm_half_0.iqmod_mfb_lpf_pex_ota_core_tg$1_0.v_b.t12 iqmod_mfb_lpf_pex_half_1.iqmod_mfb_lpf_pex_ota_core_hybrid_bm_half_0.iqmod_mfb_lpf_pex_ota_core_inv_NF6$1_1.vout.t24 VDD.t129 VDD.t0 sg13_lv_pmos ad=1.14p pd=6.38u as=1.14p ps=6.38u w=6u l=1u
X385 iqmod_mfb_lpf_pex_half_1.iqmod_mfb_lpf_pex_ota_core_hybrid_bm_half_0.iqmod_mfb_lpf_pex_ota_core_inv_NF20$1_0.vout.t16 voutn.t42 VSS.t275 VSS.t274 sg13_lv_nmos ad=0.19p pd=1.38u as=0.19p ps=1.38u w=1u l=1u
X386 voutn.t26 iqmod_mfb_lpf_pex_half_1.iqmod_mfb_lpf_pex_ota_core_hybrid_bm_half_0.iqmod_mfb_lpf_pex_ota_core_tg$1_0.v_b.t38 VSS.t229 VSS.t230 sg13_lv_nmos ad=0.19p pd=1.38u as=0.19p ps=1.38u w=1u l=1u
X387 iqmod_mfb_lpf_pex_half_0.iqmod_mfb_lpf_pex_ota_core_hybrid_bm_half_0.iqmod_mfb_lpf_pex_ota_core_inv_NF20$1_1.vin.t0 iqmod_mfb_lpf_pex_half_0.iqmod_mfb_lpf_pex_ota_core_hybrid_bm_half_0.iqmod_mfb_lpf_pex_ota_core_spdt_switch$1_0.iqmod_mfb_lpf_pex_ota_core_spdt_switch_inv$2_0.vout.t2 iqmod_mfb_lpf_pex_half_0.vinp.t4 VSS.t3 sg13_lv_nmos ad=0.19p pd=1.38u as=0.34p ps=2.68u w=1u l=0.13u
X388 iqmod_mfb_lpf_pex_half_1.iqmod_mfb_lpf_pex_ota_core_hybrid_bm_half_0.iqmod_mfb_lpf_pex_ota_core_tg$1_0.v_b.t19 iqmod_mfb_lpf_pex_half_1.iqmod_mfb_lpf_pex_ota_core_hybrid_bm_half_0.iqmod_mfb_lpf_pex_ota_core_tg$1_0.v_a.t0 VDD.t48 VDD.t0 sg13_lv_pmos ad=1.14p pd=6.38u as=1.14p ps=6.38u w=6u l=1u
X389 VDD.t261 iqmod_mfb_lpf_pex_half_1.iqmod_mfb_lpf_pex_ota_core_hybrid_bm_half_0.iqmod_mfb_lpf_pex_ota_core_inv_NF20$1_1.vin.t0 iqmod_mfb_lpf_pex_half_1.iqmod_mfb_lpf_pex_ota_core_hybrid_bm_half_0.iqmod_mfb_lpf_pex_ota_core_tg$1_0.v_a.t0 VDD.t0 sg13_lv_pmos ad=1.14p pd=6.38u as=1.14p ps=6.38u w=6u l=1u
X390 iqmod_mfb_lpf_pex_half_1.iqmod_mfb_lpf_pex_ota_core_hybrid_bm_half_0.iqmod_mfb_lpf_pex_ota_core_tg$1_0.v_b.t1 iqmod_mfb_lpf_pex_half_0.iqmod_mfb_lpf_pex_ota_core_hybrid_bm_half_0.iqmod_mfb_lpf_pex_ota_core_tg$1_0.di_tg_ctrl_n.t5 iqmod_mfb_lpf_pex_half_1.iqmod_mfb_lpf_pex_ota_core_hybrid_bm_half_0.iqmod_mfb_lpf_pex_ota_core_tg$1_0.v_a.t1 VDD.t6 sg13_lv_pmos ad=1.14p pd=6.38u as=1.14p ps=6.38u w=6u l=0.13u
X391 voutn.t14 iqmod_mfb_lpf_pex_half_0.iqmod_mfb_lpf_pex_ota_core_hybrid_bm_half_0.iqmod_mfb_lpf_pex_ota_core_inv_NF20$1_1.vin.t0 VSS.t48 VSS.t49 sg13_lv_nmos ad=0.19p pd=1.38u as=0.19p ps=1.38u w=1u l=1u
X392 iqmod_mfb_lpf_pex_half_0.iqmod_mfb_lpf_pex_ota_core_hybrid_bm_half_0.iqmod_mfb_lpf_pex_ota_core_inv_NF20$1_1.vin.t0 iqmod_mfb_lpf_pex_half_0.iqmod_mfb_lpf_pex_ota_core_hybrid_bm_half_0.iqmod_mfb_lpf_pex_ota_core_tg$1_0.di_tg_ctrl_n.t7 iqmod_mfb_lpf_pex_half_0.vinp.t1 VDD.t6 sg13_lv_pmos ad=1.14p pd=6.38u as=1.14p ps=6.38u w=6u l=0.13u
X393 VDD.t169 iqmod_mfb_lpf_pex_half_1.iqmod_mfb_lpf_pex_ota_core_hybrid_bm_half_0.iqmod_mfb_lpf_pex_ota_core_tg$1_0.v_b.t36 voutp.t2 VDD.t0 sg13_lv_pmos ad=1.14p pd=6.38u as=1.14p ps=6.38u w=6u l=1u
X394 iqmod_mfb_lpf_pex_half_1.iqmod_mfb_lpf_pex_ota_core_hybrid_bm_half_0.iqmod_mfb_lpf_pex_ota_core_tg$1_0.v_b.t28 iqmod_mfb_lpf_pex_half_1.iqmod_mfb_lpf_pex_ota_core_hybrid_bm_half_0.iqmod_mfb_lpf_pex_ota_core_tg$1_0.di_tg_ctrl_n.t3 iqmod_mfb_lpf_pex_half_1.iqmod_mfb_lpf_pex_ota_core_hybrid_bm_half_0.iqmod_mfb_lpf_pex_ota_core_tg$1_0.v_a.t0 VDD.t0 sg13_lv_pmos ad=1.14p pd=6.38u as=1.14p ps=6.38u w=6u l=0.13u
X395 VDD.t197 iqmod_mfb_lpf_pex_half_1.iqmod_mfb_lpf_pex_ota_core_hybrid_bm_half_0.iqmod_mfb_lpf_pex_ota_core_tg$1_0.v_b.t39 voutn.t40 VDD.t6 sg13_lv_pmos ad=1.14p pd=6.38u as=1.14p ps=6.38u w=6u l=1u
X396 VSS.t88 VSS.t86 VSS.t88 VSS.t87 sg13_lv_nmos ad=0.19p pd=1.38u as=0 ps=0 w=1u l=0.13u
X397 VDD.t122 iqmod_mfb_lpf_pex_half_1.iqmod_mfb_lpf_pex_ota_core_hybrid_bm_half_0.iqmod_mfb_lpf_pex_ota_core_inv_NF20$1_1.vin.t0 voutp.t31 VDD.t0 sg13_lv_pmos ad=1.14p pd=6.38u as=1.14p ps=6.38u w=6u l=1u
X398 iqmod_mfb_lpf_pex_half_1.iqmod_mfb_lpf_pex_ota_core_hybrid_bm_half_0.iqmod_mfb_lpf_pex_ota_core_inv_NF20$1_0.vout.t43 voutp.t43 VSS.t339 VSS.t297 sg13_lv_nmos ad=0.19p pd=1.38u as=0.19p ps=1.38u w=1u l=1u
X399 VSS.t368 iqmod_mfb_lpf_pex_half_1.iqmod_mfb_lpf_pex_ota_core_hybrid_bm_half_0.iqmod_mfb_lpf_pex_ota_core_inv_NF20$1_1.vin.t0 voutp.t38 VSS.t53 sg13_lv_nmos ad=0.19p pd=1.38u as=0.19p ps=1.38u w=1u l=1u
X400 voutn.t34 iqmod_mfb_lpf_pex_half_1.iqmod_mfb_lpf_pex_ota_core_hybrid_bm_half_0.iqmod_mfb_lpf_pex_ota_core_tg$1_0.v_b.t39 VDD.t199 VDD.t6 sg13_lv_pmos ad=1.14p pd=6.38u as=1.14p ps=6.38u w=6u l=1u
X401 iqmod_mfb_lpf_pex_half_1.iqmod_mfb_lpf_pex_ota_core_hybrid_bm_half_0.iqmod_mfb_lpf_pex_ota_core_inv_NF20$1_1.vin.t0 iqmod_mfb_lpf_pex_half_1.iqmod_mfb_lpf_pex_ota_core_hybrid_bm_half_0.iqmod_mfb_lpf_pex_ota_core_spdt_switch$1_0.iqmod_mfb_lpf_pex_ota_core_spdt_switch_inv$2_0.vout.t4 iqmod_mfb_lpf_pex_half_1.vinp.t6 VSS.t7 sg13_lv_nmos ad=0.19p pd=1.38u as=0.19p ps=1.38u w=1u l=0.13u
X402 voutn.t7 iqmod_mfb_lpf_pex_half_0.iqmod_mfb_lpf_pex_ota_core_hybrid_bm_half_0.iqmod_mfb_lpf_pex_ota_core_inv_NF20$1_1.vin.t0 VDD.t32 VDD.t6 sg13_lv_pmos ad=1.14p pd=6.38u as=1.14p ps=6.38u w=6u l=1u
X403 iqmod_mfb_lpf_pex_half_1.iqmod_mfb_lpf_pex_ota_core_hybrid_bm_half_0.iqmod_mfb_lpf_pex_ota_core_tg$1_0.v_a.t0 di_filter_en.t2 iqmod_mfb_lpf_pex_half_1.iqmod_mfb_lpf_pex_ota_core_hybrid_bm_half_0.iqmod_mfb_lpf_pex_ota_core_tg$1_0.v_b.t22 VSS.t237 sg13_lv_nmos ad=0.19p pd=1.38u as=0.19p ps=1.38u w=1u l=0.13u
X404 VSS.t352 iqmod_mfb_lpf_pex_half_1.iqmod_mfb_lpf_pex_ota_core_hybrid_bm_half_0.iqmod_mfb_lpf_pex_ota_core_inv_NF20$1_1.vin.t0 iqmod_mfb_lpf_pex_half_1.iqmod_mfb_lpf_pex_ota_core_hybrid_bm_half_0.iqmod_mfb_lpf_pex_ota_core_tg$1_0.v_a.t0 VSS.t28 sg13_lv_nmos ad=0.19p pd=1.38u as=0.19p ps=1.38u w=1u l=1u
X405 VSS.t342 voutp.t43 iqmod_mfb_lpf_pex_half_1.iqmod_mfb_lpf_pex_ota_core_hybrid_bm_half_0.iqmod_mfb_lpf_pex_ota_core_inv_NF20$1_0.vout.t44 VSS.t301 sg13_lv_nmos ad=0.19p pd=1.38u as=0.19p ps=1.38u w=1u l=1u
X406 VSS.t107 VSS.t105 VSS.t107 VSS.t106 sg13_lv_nmos ad=0.19p pd=1.38u as=0 ps=0 w=1u l=1u
X407 voutp.t22 iqmod_mfb_lpf_pex_half_1.iqmod_mfb_lpf_pex_ota_core_hybrid_bm_half_0.iqmod_mfb_lpf_pex_ota_core_inv_NF20$1_1.vin.t0 VDD.t279 VDD.t0 sg13_lv_pmos ad=1.14p pd=6.38u as=1.14p ps=6.38u w=6u l=1u
X408 VDD.t17 VDD.t66 VDD.t17 VDD.t6 sg13_lv_pmos ad=1.14p pd=6.38u as=0 ps=0 w=6u l=1u
X409 VDD.t36 iqmod_mfb_lpf_pex_half_0.iqmod_mfb_lpf_pex_ota_core_hybrid_bm_half_0.iqmod_mfb_lpf_pex_ota_core_inv_NF20$1_1.vin.t0 voutn.t8 VDD.t6 sg13_lv_pmos ad=1.14p pd=6.38u as=1.14p ps=6.38u w=6u l=1u
X410 iqmod_mfb_lpf_pex_half_1.iqmod_mfb_lpf_pex_ota_core_hybrid_bm_half_0.iqmod_mfb_lpf_pex_ota_core_inv_NF20$1_0.vout.t46 voutp.t42 VDD.t139 VDD.t0 sg13_lv_pmos ad=1.14p pd=6.38u as=1.14p ps=6.38u w=6u l=1u
X411 VSS.t170 iqmod_mfb_lpf_pex_half_1.iqmod_mfb_lpf_pex_ota_core_hybrid_bm_half_0.iqmod_mfb_lpf_pex_ota_core_tg$1_0.v_b.t37 voutp.t18 VSS.t231 sg13_lv_nmos ad=0.19p pd=1.38u as=0.19p ps=1.38u w=1u l=1u
X412 VDD.t52 iqmod_mfb_lpf_pex_half_1.iqmod_mfb_lpf_pex_ota_core_hybrid_bm_half_0.iqmod_mfb_lpf_pex_ota_core_tg$1_0.v_a.t0 iqmod_mfb_lpf_pex_half_1.iqmod_mfb_lpf_pex_ota_core_hybrid_bm_half_0.iqmod_mfb_lpf_pex_ota_core_tg$1_0.v_b.t20 VDD.t0 sg13_lv_pmos ad=1.14p pd=6.38u as=1.14p ps=6.38u w=6u l=1u
X413 iqmod_mfb_lpf_pex_half_1.iqmod_mfb_lpf_pex_ota_core_hybrid_bm_half_0.iqmod_mfb_lpf_pex_ota_core_tg$1_0.v_a.t0 iqmod_mfb_lpf_pex_half_1.iqmod_mfb_lpf_pex_ota_core_hybrid_bm_half_0.iqmod_mfb_lpf_pex_ota_core_inv_NF20$1_1.vin.t0 VDD.t263 VDD.t0 sg13_lv_pmos ad=1.14p pd=6.38u as=1.14p ps=6.38u w=6u l=1u
X414 voutp.t9 iqmod_mfb_lpf_pex_half_1.iqmod_mfb_lpf_pex_ota_core_hybrid_bm_half_0.iqmod_mfb_lpf_pex_ota_core_tg$1_0.v_b.t36 VDD.t171 VDD.t0 sg13_lv_pmos ad=1.14p pd=6.38u as=1.14p ps=6.38u w=6u l=1u
X415 VSS.t208 iqmod_mfb_lpf_pex_half_1.iqmod_mfb_lpf_pex_ota_core_hybrid_bm_half_0.iqmod_mfb_lpf_pex_ota_core_tg$1_0.v_b.t38 voutn.t21 VSS.t207 sg13_lv_nmos ad=0.19p pd=1.38u as=0.19p ps=1.38u w=1u l=1u
X416 VSS.t309 VSS.t310 VSS.t14 rhigh l=27u w=0.5u
X417 VSS.t34 iqmod_mfb_lpf_pex_half_0.iqmod_mfb_lpf_pex_ota_core_hybrid_bm_half_0.iqmod_mfb_lpf_pex_ota_core_inv_NF20$1_1.vin.t0 iqmod_mfb_lpf_pex_half_1.iqmod_mfb_lpf_pex_ota_core_hybrid_bm_half_0.iqmod_mfb_lpf_pex_ota_core_tg$1_0.v_a.t1 VSS.t33 sg13_lv_nmos ad=0.19p pd=1.38u as=0.19p ps=1.38u w=1u l=1u
X418 voutn.t35 iqmod_mfb_lpf_pex_half_1.iqmod_mfb_lpf_pex_ota_core_hybrid_bm_half_0.iqmod_mfb_lpf_pex_ota_core_tg$1_0.v_b.t39 VDD.t79 VDD.t6 sg13_lv_pmos ad=1.14p pd=6.38u as=1.14p ps=6.38u w=6u l=1u
X419 iqmod_mfb_lpf_pex_half_1.iqmod_mfb_lpf_pex_ota_core_hybrid_bm_half_0.iqmod_mfb_lpf_pex_ota_core_inv_NF6$1_1.vout.t21 iqmod_mfb_lpf_pex_half_1.iqmod_mfb_lpf_pex_ota_core_hybrid_bm_half_0.iqmod_mfb_lpf_pex_ota_core_tg$1_0.di_tg_ctrl_n.t2 iqmod_mfb_lpf_pex_half_1.iqmod_mfb_lpf_pex_ota_core_hybrid_bm_half_0.iqmod_mfb_lpf_pex_ota_core_inv_NF20$1_0.vout.t34 VDD.t0 sg13_lv_pmos ad=1.14p pd=6.38u as=2.04p ps=12.68u w=6u l=0.13u
X420 a_25788_4203.t1 a_37874_3903.t0 VSS.t0 rhigh l=60u w=0.5u
X421 iqmod_mfb_lpf_pex_half_1.iqmod_mfb_lpf_pex_ota_core_hybrid_bm_half_0.iqmod_mfb_lpf_pex_ota_core_inv_NF20$1_0.vout.t3 iqmod_mfb_lpf_pex_half_0.iqmod_mfb_lpf_pex_ota_core_hybrid_bm_half_0.iqmod_mfb_lpf_pex_ota_core_tg$1_0.di_tg_ctrl_n.t4 iqmod_mfb_lpf_pex_half_1.iqmod_mfb_lpf_pex_ota_core_hybrid_bm_half_0.iqmod_mfb_lpf_pex_ota_core_inv_NF6$1_1.vout.t2 VDD.t6 sg13_lv_pmos ad=2.04p pd=12.68u as=1.14p ps=6.38u w=6u l=0.13u
X422 VDD.t135 VDD.t133 VDD.t134 VDD.t0 sg13_lv_pmos ad=2.04p pd=12.68u as=0 ps=0 w=6u l=1u
X423 VSS.t217 iqmod_mfb_lpf_pex_half_1.iqmod_mfb_lpf_pex_ota_core_hybrid_bm_half_0.iqmod_mfb_lpf_pex_ota_core_tg$1_0.v_b.t38 voutn.t30 VSS.t216 sg13_lv_nmos ad=0.19p pd=1.38u as=0.19p ps=1.38u w=1u l=1u
X424 VSS.t321 VSS.t322 VSS.t17 rhigh l=31u w=0.5u
X425 VDD.t253 iqmod_mfb_lpf_pex_half_1.iqmod_mfb_lpf_pex_ota_core_hybrid_bm_half_0.iqmod_mfb_lpf_pex_ota_core_tg$1_0.v_a.t1 iqmod_mfb_lpf_pex_half_1.iqmod_mfb_lpf_pex_ota_core_hybrid_bm_half_0.iqmod_mfb_lpf_pex_ota_core_tg$1_0.v_b.t34 VDD.t6 sg13_lv_pmos ad=1.14p pd=6.38u as=1.14p ps=6.38u w=6u l=1u
X426 iqmod_mfb_lpf_pex_half_1.iqmod_mfb_lpf_pex_ota_core_hybrid_bm_half_0.iqmod_mfb_lpf_pex_ota_core_tg$1_0.v_b.t30 iqmod_mfb_lpf_pex_half_1.iqmod_mfb_lpf_pex_ota_core_hybrid_bm_half_0.iqmod_mfb_lpf_pex_ota_core_tg$1_0.v_a.t1 VSS.t103 VSS.t186 sg13_lv_nmos ad=0.19p pd=1.38u as=0.19p ps=1.38u w=1u l=1u
X427 VDD.t283 iqmod_mfb_lpf_pex_half_1.iqmod_mfb_lpf_pex_ota_core_hybrid_bm_half_0.iqmod_mfb_lpf_pex_ota_core_inv_NF20$1_1.vin.t0 voutp.t40 VDD.t0 sg13_lv_pmos ad=1.14p pd=6.38u as=1.14p ps=6.38u w=6u l=1u
X428 VSS.t318 iqmod_mfb_lpf_pex_half_1.iqmod_mfb_lpf_pex_ota_core_hybrid_bm_half_0.iqmod_mfb_lpf_pex_ota_core_inv_NF6$1_1.vout.t25 iqmod_mfb_lpf_pex_half_1.iqmod_mfb_lpf_pex_ota_core_hybrid_bm_half_0.iqmod_mfb_lpf_pex_ota_core_tg$1_0.v_b.t7 VSS.t317 sg13_lv_nmos ad=0.19p pd=1.38u as=0.19p ps=1.38u w=1u l=1u
X429 iqmod_mfb_lpf_pex_half_1.iqmod_mfb_lpf_pex_ota_core_hybrid_bm_half_0.iqmod_mfb_lpf_pex_ota_core_inv_NF6$1_1.vout.t13 iqmod_mfb_lpf_pex_half_1.iqmod_mfb_lpf_pex_ota_core_hybrid_bm_half_0.iqmod_mfb_lpf_pex_ota_core_inv_NF20$1_0.vout.t57 VSS.t196 VSS.t195 sg13_lv_nmos ad=0.19p pd=1.38u as=0.19p ps=1.38u w=1u l=1u
X430 iqmod_mfb_lpf_pex_half_0.vinp.t5 iqmod_mfb_lpf_pex_half_0.iqmod_mfb_lpf_pex_ota_core_hybrid_bm_half_0.iqmod_mfb_lpf_pex_ota_core_spdt_switch$1_0.iqmod_mfb_lpf_pex_ota_core_spdt_switch_inv$2_0.vout.t2 iqmod_mfb_lpf_pex_half_0.iqmod_mfb_lpf_pex_ota_core_hybrid_bm_half_0.iqmod_mfb_lpf_pex_ota_core_inv_NF20$1_1.vin.t0 VSS.t4 sg13_lv_nmos ad=0.19p pd=1.38u as=0.19p ps=1.38u w=1u l=0.13u
X431 VSS.t175 VSS.t174 VSS.t175 VSS.t125 sg13_lv_nmos ad=0.19p pd=1.38u as=0 ps=0 w=1u l=1u
X432 iqmod_mfb_lpf_pex_half_1.iqmod_mfb_lpf_pex_ota_core_hybrid_bm_half_0.iqmod_mfb_lpf_pex_ota_core_tg$1_0.v_a.t0 iqmod_mfb_lpf_pex_half_1.iqmod_mfb_lpf_pex_ota_core_hybrid_bm_half_0.iqmod_mfb_lpf_pex_ota_core_tg$1_0.di_tg_ctrl_n.t3 iqmod_mfb_lpf_pex_half_1.iqmod_mfb_lpf_pex_ota_core_hybrid_bm_half_0.iqmod_mfb_lpf_pex_ota_core_tg$1_0.v_b.t28 VDD.t0 sg13_lv_pmos ad=1.14p pd=6.38u as=1.14p ps=6.38u w=6u l=0.13u
X433 VDD.t140 VDD.t138 VDD.t139 VDD.t0 sg13_lv_pmos ad=2.04p pd=12.68u as=0 ps=0 w=6u l=1u
X434 iqmod_mfb_lpf_pex_half_1.iqmod_mfb_lpf_pex_ota_core_hybrid_bm_half_0.iqmod_mfb_lpf_pex_ota_core_inv_NF20$1_0.vout.t4 di_filter_en.t1 iqmod_mfb_lpf_pex_half_1.iqmod_mfb_lpf_pex_ota_core_hybrid_bm_half_0.iqmod_mfb_lpf_pex_ota_core_inv_NF6$1_1.vout.t7 VSS.t243 sg13_lv_nmos ad=0.19p pd=1.38u as=0.19p ps=1.38u w=1u l=0.13u
X435 voutn.t16 iqmod_mfb_lpf_pex_half_0.iqmod_mfb_lpf_pex_ota_core_hybrid_bm_half_0.iqmod_mfb_lpf_pex_ota_core_inv_NF20$1_1.vin.t0 VSS.t67 VSS.t68 sg13_lv_nmos ad=0.19p pd=1.38u as=0.19p ps=1.38u w=1u l=1u
X436 VDD.t125 VDD.t123 VDD.t124 VDD.t0 sg13_lv_pmos ad=2.04p pd=12.68u as=0 ps=0 w=6u l=1u
X437 VSS.t296 voutn.t42 iqmod_mfb_lpf_pex_half_1.iqmod_mfb_lpf_pex_ota_core_hybrid_bm_half_0.iqmod_mfb_lpf_pex_ota_core_inv_NF20$1_0.vout.t18 VSS.t295 sg13_lv_nmos ad=0.19p pd=1.38u as=0.19p ps=1.38u w=1u l=1u
X438 iqmod_mfb_lpf_pex_half_1.iqmod_mfb_lpf_pex_ota_core_hybrid_bm_half_0.iqmod_mfb_lpf_pex_ota_core_inv_NF20$1_0.vout.t26 voutn.t43 VDD.t218 VDD.t6 sg13_lv_pmos ad=1.14p pd=6.38u as=1.14p ps=6.38u w=6u l=1u
X439 VDD.t18 iqmod_mfb_lpf_pex_half_0.iqmod_mfb_lpf_pex_ota_core_hybrid_bm_half_0.iqmod_mfb_lpf_pex_ota_core_inv_NF20$1_1.vin.t0 voutn.t3 VDD.t6 sg13_lv_pmos ad=1.14p pd=6.38u as=1.14p ps=6.38u w=6u l=1u
X440 VDD.t92 VDD.t91 VDD.t92 VDD.t6 sg13_lv_pmos ad=1.14p pd=6.38u as=0 ps=0 w=6u l=1u
X441 iqmod_mfb_lpf_pex_half_1.iqmod_mfb_lpf_pex_ota_core_hybrid_bm_half_0.iqmod_mfb_lpf_pex_ota_core_inv_NF20$1_1.vin.t0 iqmod_mfb_lpf_pex_half_1.iqmod_mfb_lpf_pex_ota_core_hybrid_bm_half_0.iqmod_mfb_lpf_pex_ota_core_tg$1_0.di_tg_ctrl_n.t4 iqmod_mfb_lpf_pex_half_1.vinp.t0 VDD.t0 sg13_lv_pmos ad=1.14p pd=6.38u as=2.04p ps=12.68u w=6u l=0.13u
X442 voutp.t12 iqmod_mfb_lpf_pex_half_1.iqmod_mfb_lpf_pex_ota_core_hybrid_bm_half_0.iqmod_mfb_lpf_pex_ota_core_tg$1_0.v_b.t37 VSS.t255 VSS.t206 sg13_lv_nmos ad=0.19p pd=1.38u as=0.19p ps=1.38u w=1u l=1u
X443 VDD.t57 VDD.t56 VDD.t57 VDD.t6 sg13_lv_pmos ad=1.14p pd=6.38u as=0 ps=0 w=6u l=0.13u
X444 voutp.t19 iqmod_mfb_lpf_pex_half_1.iqmod_mfb_lpf_pex_ota_core_hybrid_bm_half_0.iqmod_mfb_lpf_pex_ota_core_tg$1_0.v_b.t37 VSS.t257 VSS.t209 sg13_lv_nmos ad=0.19p pd=1.38u as=0.19p ps=1.38u w=1u l=1u
X445 VDD.t234 voutp.t42 iqmod_mfb_lpf_pex_half_1.iqmod_mfb_lpf_pex_ota_core_hybrid_bm_half_0.iqmod_mfb_lpf_pex_ota_core_inv_NF20$1_0.vout.t49 VDD.t0 sg13_lv_pmos ad=1.14p pd=6.38u as=1.14p ps=6.38u w=6u l=1u
X446 VDD.t55 VDD.t53 VDD.t54 VDD.t6 sg13_lv_pmos ad=2.04p pd=12.68u as=0 ps=0 w=6u l=0.13u
X447 iqmod_mfb_lpf_pex_half_0.iqmod_mfb_lpf_pex_ota_core_hybrid_bm_half_0.iqmod_mfb_lpf_pex_ota_core_inv_NF20$1_1.vin.t0 iqmod_mfb_lpf_pex_half_0.iqmod_mfb_lpf_pex_ota_core_hybrid_bm_half_0.iqmod_mfb_lpf_pex_ota_core_spdt_switch$1_0.iqmod_mfb_lpf_pex_ota_core_spdt_switch_inv$2_0.vout.t4 VDD.t144 VDD.t6 sg13_lv_pmos ad=1.14p pd=6.38u as=1.14p ps=6.38u w=6u l=0.13u
X448 iqmod_mfb_lpf_pex_half_1.iqmod_mfb_lpf_pex_ota_core_hybrid_bm_half_0.iqmod_mfb_lpf_pex_ota_core_inv_NF20$1_1.vin.t1 iqmod_mfb_lpf_pex_half_1.iqmod_mfb_lpf_pex_ota_core_hybrid_bm_half_0.iqmod_mfb_lpf_pex_ota_core_tg$1_0.di_tg_ctrl_n.t7 VDD.t3 VSS.t13 sg13_lv_nmos ad=0.19p pd=1.38u as=0.19p ps=1.38u w=1u l=0.13u
X449 VDD.t179 iqmod_mfb_lpf_pex_half_1.iqmod_mfb_lpf_pex_ota_core_hybrid_bm_half_0.iqmod_mfb_lpf_pex_ota_core_tg$1_0.v_b.t36 voutp.t3 VDD.t0 sg13_lv_pmos ad=1.14p pd=6.38u as=1.14p ps=6.38u w=6u l=1u
X450 VSS.t261 iqmod_mfb_lpf_pex_half_1.iqmod_mfb_lpf_pex_ota_core_hybrid_bm_half_0.iqmod_mfb_lpf_pex_ota_core_tg$1_0.v_b.t37 voutp.t16 VSS.t213 sg13_lv_nmos ad=0.19p pd=1.38u as=0.19p ps=1.38u w=1u l=1u
X451 iqmod_mfb_lpf_pex_half_1.iqmod_mfb_lpf_pex_ota_core_hybrid_bm_half_0.iqmod_mfb_lpf_pex_ota_core_inv_NF20$1_0.vout.t47 voutp.t42 VDD.t230 VDD.t0 sg13_lv_pmos ad=1.14p pd=6.38u as=1.14p ps=6.38u w=6u l=1u
X452 VSS.t229 iqmod_mfb_lpf_pex_half_1.iqmod_mfb_lpf_pex_ota_core_hybrid_bm_half_0.iqmod_mfb_lpf_pex_ota_core_tg$1_0.v_b.t38 voutn.t27 VSS.t228 sg13_lv_nmos ad=0.19p pd=1.38u as=0.19p ps=1.38u w=1u l=1u
X453 iqmod_mfb_lpf_pex_half_1.iqmod_mfb_lpf_pex_ota_core_hybrid_bm_half_0.iqmod_mfb_lpf_pex_ota_core_inv_NF20$1_0.vout.t32 iqmod_mfb_lpf_pex_half_1.iqmod_mfb_lpf_pex_ota_core_hybrid_bm_half_0.iqmod_mfb_lpf_pex_ota_core_tg$1_0.di_tg_ctrl_n.t2 iqmod_mfb_lpf_pex_half_1.iqmod_mfb_lpf_pex_ota_core_hybrid_bm_half_0.iqmod_mfb_lpf_pex_ota_core_inv_NF6$1_1.vout.t21 VDD.t0 sg13_lv_pmos ad=1.14p pd=6.38u as=1.14p ps=6.38u w=6u l=0.13u
X454 iqmod_mfb_lpf_pex_half_1.iqmod_mfb_lpf_pex_ota_core_hybrid_bm_half_0.iqmod_mfb_lpf_pex_ota_core_tg$1_0.di_tg_ctrl_n.t0 di_filter_en.t3 VSS.t142 VSS.t232 sg13_lv_nmos ad=0.19p pd=1.38u as=0.19p ps=1.38u w=1u l=0.13u
X455 VDD.t193 iqmod_mfb_lpf_pex_half_1.iqmod_mfb_lpf_pex_ota_core_hybrid_bm_half_0.iqmod_mfb_lpf_pex_ota_core_tg$1_0.v_b.t39 voutn.t38 VDD.t6 sg13_lv_pmos ad=1.14p pd=6.38u as=1.14p ps=6.38u w=6u l=1u
X456 voutn.t30 iqmod_mfb_lpf_pex_half_1.iqmod_mfb_lpf_pex_ota_core_hybrid_bm_half_0.iqmod_mfb_lpf_pex_ota_core_tg$1_0.v_b.t38 VSS.t214 VSS.t215 sg13_lv_nmos ad=0.19p pd=1.38u as=0.19p ps=1.38u w=1u l=1u
X457 iqmod_mfb_lpf_pex_half_1.iqmod_mfb_lpf_pex_ota_core_hybrid_bm_half_0.iqmod_mfb_lpf_pex_ota_core_tg$1_0.v_a.t1 iqmod_mfb_lpf_pex_half_0.iqmod_mfb_lpf_pex_ota_core_hybrid_bm_half_0.iqmod_mfb_lpf_pex_ota_core_inv_NF20$1_1.vin.t0 VSS.t40 VSS.t41 sg13_lv_nmos ad=0.19p pd=1.38u as=0.19p ps=1.38u w=1u l=1u
X458 vinp.t0 a_6122_3903.t1 VSS.t14 rhigh l=27u w=0.5u
X459 VSS.t364 iqmod_mfb_lpf_pex_half_1.iqmod_mfb_lpf_pex_ota_core_hybrid_bm_half_0.iqmod_mfb_lpf_pex_ota_core_inv_NF20$1_1.vin.t0 voutp.t25 VSS.t47 sg13_lv_nmos ad=0.19p pd=1.38u as=0.19p ps=1.38u w=1u l=1u
X460 voutn.t40 iqmod_mfb_lpf_pex_half_1.iqmod_mfb_lpf_pex_ota_core_hybrid_bm_half_0.iqmod_mfb_lpf_pex_ota_core_tg$1_0.v_b.t39 VDD.t195 VDD.t6 sg13_lv_pmos ad=1.14p pd=6.38u as=1.14p ps=6.38u w=6u l=1u
X461 VDD.t150 iqmod_mfb_lpf_pex_half_1.iqmod_mfb_lpf_pex_ota_core_hybrid_bm_half_0.iqmod_mfb_lpf_pex_ota_core_inv_NF20$1_0.vout.t56 iqmod_mfb_lpf_pex_half_1.iqmod_mfb_lpf_pex_ota_core_hybrid_bm_half_0.iqmod_mfb_lpf_pex_ota_core_inv_NF6$1_1.vout.t18 VDD.t0 sg13_lv_pmos ad=1.14p pd=6.38u as=1.14p ps=6.38u w=6u l=1u
X462 iqmod_mfb_lpf_pex_half_1.iqmod_mfb_lpf_pex_R1_0.v_b.t10 iqmod_mfb_lpf_pex_half_1.C1_half.t1 cap_cmim l=8u w=8u
X463 a_25788_4203.t0 voutn.t20 VSS.t0 rhigh l=60u w=0.5u
X464 VSS.t339 voutp.t43 iqmod_mfb_lpf_pex_half_1.iqmod_mfb_lpf_pex_ota_core_hybrid_bm_half_0.iqmod_mfb_lpf_pex_ota_core_inv_NF20$1_0.vout.t42 VSS.t295 sg13_lv_nmos ad=0.19p pd=1.38u as=0.19p ps=1.38u w=1u l=1u
X465 voutp.t38 iqmod_mfb_lpf_pex_half_1.iqmod_mfb_lpf_pex_ota_core_hybrid_bm_half_0.iqmod_mfb_lpf_pex_ota_core_inv_NF20$1_1.vin.t0 VSS.t366 VSS.t52 sg13_lv_nmos ad=0.19p pd=1.38u as=0.19p ps=1.38u w=1u l=1u
X466 voutp.t8 iqmod_mfb_lpf_pex_half_1.iqmod_mfb_lpf_pex_ota_core_hybrid_bm_half_0.iqmod_mfb_lpf_pex_ota_core_tg$1_0.v_b.t36 VDD.t181 VDD.t0 sg13_lv_pmos ad=1.14p pd=6.38u as=1.14p ps=6.38u w=6u l=1u
X467 VSS.t107 iqmod_mfb_lpf_pex_half_1.iqmod_mfb_lpf_pex_ota_core_hybrid_bm_half_0.iqmod_mfb_lpf_pex_ota_core_tg$1_0.v_a.t1 iqmod_mfb_lpf_pex_half_1.iqmod_mfb_lpf_pex_ota_core_hybrid_bm_half_0.iqmod_mfb_lpf_pex_ota_core_tg$1_0.v_b.t32 VSS.t193 sg13_lv_nmos ad=0.19p pd=1.38u as=0.19p ps=1.38u w=1u l=1u
X468 VDD.t32 iqmod_mfb_lpf_pex_half_0.iqmod_mfb_lpf_pex_ota_core_hybrid_bm_half_0.iqmod_mfb_lpf_pex_ota_core_inv_NF20$1_1.vin.t0 voutn.t6 VDD.t6 sg13_lv_pmos ad=1.14p pd=6.38u as=1.14p ps=6.38u w=6u l=1u
X469 VDD.t236 voutp.t42 iqmod_mfb_lpf_pex_half_1.iqmod_mfb_lpf_pex_ota_core_hybrid_bm_half_0.iqmod_mfb_lpf_pex_ota_core_inv_NF20$1_0.vout.t48 VDD.t0 sg13_lv_pmos ad=1.14p pd=6.38u as=1.14p ps=6.38u w=6u l=1u
X470 VSS.t67 iqmod_mfb_lpf_pex_half_0.iqmod_mfb_lpf_pex_ota_core_hybrid_bm_half_0.iqmod_mfb_lpf_pex_ota_core_inv_NF20$1_1.vin.t0 voutn.t10 VSS.t66 sg13_lv_nmos ad=0.19p pd=1.38u as=0.19p ps=1.38u w=1u l=1u
X471 iqmod_mfb_lpf_pex_half_1.iqmod_mfb_lpf_pex_ota_core_hybrid_bm_half_0.iqmod_mfb_lpf_pex_ota_core_tg$1_0.v_a.t0 iqmod_mfb_lpf_pex_half_1.iqmod_mfb_lpf_pex_ota_core_hybrid_bm_half_0.iqmod_mfb_lpf_pex_ota_core_inv_NF20$1_1.vin.t0 VSS.t152 VSS.t26 sg13_lv_nmos ad=0.19p pd=1.38u as=0.19p ps=1.38u w=1u l=1u
X472 iqmod_mfb_lpf_pex_half_1.iqmod_mfb_lpf_pex_ota_core_hybrid_bm_half_0.iqmod_mfb_lpf_pex_ota_core_inv_NF20$1_0.vout.t44 voutp.t43 VSS.t327 VSS.t300 sg13_lv_nmos ad=0.19p pd=1.38u as=0.19p ps=1.38u w=1u l=1u
X473 VSS.t370 iqmod_mfb_lpf_pex_half_1.iqmod_mfb_lpf_pex_ota_core_hybrid_bm_half_0.iqmod_mfb_lpf_pex_ota_core_inv_NF20$1_1.vin.t0 voutp.t29 VSS.t56 sg13_lv_nmos ad=0.19p pd=1.38u as=0.19p ps=1.38u w=1u l=1u
X474 iqmod_mfb_lpf_pex_half_1.iqmod_mfb_lpf_pex_ota_core_hybrid_bm_half_0.iqmod_mfb_lpf_pex_ota_core_inv_NF20$1_0.vout.t18 voutn.t42 VSS.t286 VSS.t285 sg13_lv_nmos ad=0.19p pd=1.38u as=0.19p ps=1.38u w=1u l=1u
X475 VDD.t17 iqmod_mfb_lpf_pex_half_0.iqmod_mfb_lpf_pex_ota_core_hybrid_bm_half_0.iqmod_mfb_lpf_pex_ota_core_inv_NF20$1_1.vin.t0 iqmod_mfb_lpf_pex_half_1.iqmod_mfb_lpf_pex_ota_core_hybrid_bm_half_0.iqmod_mfb_lpf_pex_ota_core_tg$1_0.v_a.t1 VDD.t6 sg13_lv_pmos ad=1.14p pd=6.38u as=1.14p ps=6.38u w=6u l=1u
X476 iqmod_mfb_lpf_pex_half_1.iqmod_mfb_lpf_pex_R1_0.v_b.t11 iqmod_mfb_lpf_pex_half_1.C1_half.t0 cap_cmim l=8u w=8u
X477 VDD.t177 iqmod_mfb_lpf_pex_half_1.iqmod_mfb_lpf_pex_ota_core_hybrid_bm_half_0.iqmod_mfb_lpf_pex_ota_core_tg$1_0.v_b.t36 voutp.t6 VDD.t0 sg13_lv_pmos ad=1.14p pd=6.38u as=1.14p ps=6.38u w=6u l=1u
X478 iqmod_mfb_lpf_pex_half_1.iqmod_mfb_lpf_pex_ota_core_hybrid_bm_half_0.iqmod_mfb_lpf_pex_ota_core_tg$1_0.v_a.t1 iqmod_mfb_lpf_pex_half_0.iqmod_mfb_lpf_pex_ota_core_hybrid_bm_half_0.iqmod_mfb_lpf_pex_ota_core_inv_NF20$1_1.vin.t0 VSS.t29 VSS.t32 sg13_lv_nmos ad=0.19p pd=1.38u as=0.19p ps=1.38u w=1u l=1u
X479 VSS.t354 iqmod_mfb_lpf_pex_half_1.iqmod_mfb_lpf_pex_ota_core_hybrid_bm_half_0.iqmod_mfb_lpf_pex_ota_core_inv_NF20$1_1.vin.t0 iqmod_mfb_lpf_pex_half_1.iqmod_mfb_lpf_pex_ota_core_hybrid_bm_half_0.iqmod_mfb_lpf_pex_ota_core_tg$1_0.v_a.t0 VSS.t33 sg13_lv_nmos ad=0.19p pd=1.38u as=0.19p ps=1.38u w=1u l=1u
X480 VDD.t28 iqmod_mfb_lpf_pex_half_0.iqmod_mfb_lpf_pex_ota_core_hybrid_bm_half_0.iqmod_mfb_lpf_pex_ota_core_inv_NF20$1_1.vin.t0 voutn.t11 VDD.t6 sg13_lv_pmos ad=1.14p pd=6.38u as=1.14p ps=6.38u w=6u l=1u
X481 iqmod_mfb_lpf_pex_half_1.iqmod_mfb_lpf_pex_ota_core_hybrid_bm_half_0.iqmod_mfb_lpf_pex_ota_core_inv_NF6$1_1.vout.t20 iqmod_mfb_lpf_pex_half_1.iqmod_mfb_lpf_pex_ota_core_hybrid_bm_half_0.iqmod_mfb_lpf_pex_ota_core_inv_NF20$1_0.vout.t56 VDD.t148 VDD.t0 sg13_lv_pmos ad=1.14p pd=6.38u as=1.14p ps=6.38u w=6u l=1u
X482 VDD.t80 VDD.t78 VDD.t79 VDD.t6 sg13_lv_pmos ad=2.04p pd=12.68u as=0 ps=0 w=6u l=1u
X483 VSS.t126 VSS.t124 VSS.t126 VSS.t125 sg13_lv_nmos ad=0.19p pd=1.38u as=0 ps=0 w=1u l=1u
X484 VDD.t13 iqmod_mfb_lpf_pex_half_0.iqmod_mfb_lpf_pex_ota_core_hybrid_bm_half_0.iqmod_mfb_lpf_pex_ota_core_inv_NF20$1_1.vin.t0 iqmod_mfb_lpf_pex_half_1.iqmod_mfb_lpf_pex_ota_core_hybrid_bm_half_0.iqmod_mfb_lpf_pex_ota_core_tg$1_0.v_a.t1 VDD.t6 sg13_lv_pmos ad=1.14p pd=6.38u as=1.14p ps=6.38u w=6u l=1u
X485 voutn.t6 iqmod_mfb_lpf_pex_half_0.iqmod_mfb_lpf_pex_ota_core_hybrid_bm_half_0.iqmod_mfb_lpf_pex_ota_core_inv_NF20$1_1.vin.t0 VDD.t30 VDD.t6 sg13_lv_pmos ad=1.14p pd=6.38u as=1.14p ps=6.38u w=6u l=1u
X486 VSS.t390 iqmod_mfb_lpf_pex_half_1.iqmod_mfb_lpf_pex_ota_core_hybrid_bm_half_0.iqmod_mfb_lpf_pex_ota_core_inv_NF20$1_0.vout.t58 iqmod_mfb_lpf_pex_half_1.iqmod_mfb_lpf_pex_ota_core_hybrid_bm_half_0.iqmod_mfb_lpf_pex_ota_core_inv_NF6$1_1.vout.t9 VSS.t198 sg13_lv_nmos ad=0.19p pd=1.38u as=0.19p ps=1.38u w=1u l=1u
X487 iqmod_mfb_lpf_pex_half_1.iqmod_mfb_lpf_pex_ota_core_hybrid_bm_half_0.iqmod_mfb_lpf_pex_ota_core_tg$1_0.v_a.t1 iqmod_mfb_lpf_pex_half_0.iqmod_mfb_lpf_pex_ota_core_hybrid_bm_half_0.iqmod_mfb_lpf_pex_ota_core_inv_NF20$1_1.vin.t0 VDD.t15 VDD.t6 sg13_lv_pmos ad=1.14p pd=6.38u as=1.14p ps=6.38u w=6u l=1u
X488 VDD.t34 iqmod_mfb_lpf_pex_half_0.iqmod_mfb_lpf_pex_ota_core_hybrid_bm_half_0.iqmod_mfb_lpf_pex_ota_core_inv_NF20$1_1.vin.t0 voutn.t7 VDD.t6 sg13_lv_pmos ad=1.14p pd=6.38u as=1.14p ps=6.38u w=6u l=1u
X489 voutp.t4 iqmod_mfb_lpf_pex_half_1.iqmod_mfb_lpf_pex_ota_core_hybrid_bm_half_0.iqmod_mfb_lpf_pex_ota_core_tg$1_0.v_b.t36 VDD.t179 VDD.t0 sg13_lv_pmos ad=1.14p pd=6.38u as=1.14p ps=6.38u w=6u l=1u
X490 VSS.t170 VSS.t169 VSS.t170 VSS.t118 sg13_lv_nmos ad=0.19p pd=1.38u as=0 ps=0 w=1u l=1u
X491 VSS.t165 VSS.t164 VSS.t165 VSS.t112 sg13_lv_nmos ad=0.19p pd=1.38u as=0 ps=0 w=1u l=1u
X492 iqmod_mfb_lpf_pex_half_0.iqmod_mfb_lpf_pex_ota_core_hybrid_bm_half_0.iqmod_mfb_lpf_pex_ota_core_spdt_switch$1_0.iqmod_mfb_lpf_pex_ota_core_spdt_switch_inv$2_0.vout.t0 iqmod_mfb_lpf_pex_half_0.iqmod_mfb_lpf_pex_ota_core_hybrid_bm_half_0.iqmod_mfb_lpf_pex_ota_core_tg$1_0.di_tg_ctrl_n.t8 VDD.t38 VDD.t6 sg13_lv_pmos ad=1.14p pd=6.38u as=1.14p ps=6.38u w=6u l=0.13u
X493 iqmod_mfb_lpf_pex_half_0.iqmod_mfb_lpf_pex_ota_core_hybrid_bm_half_0.iqmod_mfb_lpf_pex_ota_core_inv_NF20$1_1.vin.t0 iqmod_mfb_lpf_pex_half_0.iqmod_mfb_lpf_pex_ota_core_hybrid_bm_half_0.iqmod_mfb_lpf_pex_ota_core_tg$1_0.di_tg_ctrl_n.t7 iqmod_mfb_lpf_pex_half_0.vinp.t0 VDD.t6 sg13_lv_pmos ad=1.14p pd=6.38u as=2.04p ps=12.68u w=6u l=0.13u
X494 iqmod_mfb_lpf_pex_half_1.iqmod_mfb_lpf_pex_ota_core_hybrid_bm_half_0.iqmod_mfb_lpf_pex_ota_core_tg$1_0.v_b.t0 iqmod_mfb_lpf_pex_half_0.iqmod_mfb_lpf_pex_ota_core_hybrid_bm_half_0.iqmod_mfb_lpf_pex_ota_core_tg$1_0.di_tg_ctrl_n.t5 iqmod_mfb_lpf_pex_half_1.iqmod_mfb_lpf_pex_ota_core_hybrid_bm_half_0.iqmod_mfb_lpf_pex_ota_core_tg$1_0.v_a.t1 VDD.t6 sg13_lv_pmos ad=1.14p pd=6.38u as=2.04p ps=12.68u w=6u l=0.13u
X495 VDD.t120 VDD.t118 VDD.t119 VDD.t0 sg13_lv_pmos ad=2.04p pd=12.68u as=0 ps=0 w=6u l=1u
X496 VSS.t175 iqmod_mfb_lpf_pex_half_1.iqmod_mfb_lpf_pex_ota_core_hybrid_bm_half_0.iqmod_mfb_lpf_pex_ota_core_inv_NF6$1_1.vout.t25 iqmod_mfb_lpf_pex_half_1.iqmod_mfb_lpf_pex_ota_core_hybrid_bm_half_0.iqmod_mfb_lpf_pex_ota_core_tg$1_0.v_b.t8 VSS.t320 sg13_lv_nmos ad=0.19p pd=1.38u as=0.19p ps=1.38u w=1u l=1u
X497 VSS.t80 VSS.t149 VSS.t80 VSS.t94 sg13_lv_nmos ad=0.19p pd=1.38u as=0 ps=0 w=1u l=0.13u
X498 VSS.t223 iqmod_mfb_lpf_pex_half_1.iqmod_mfb_lpf_pex_ota_core_hybrid_bm_half_0.iqmod_mfb_lpf_pex_ota_core_tg$1_0.v_b.t38 voutn.t23 VSS.t222 sg13_lv_nmos ad=0.19p pd=1.38u as=0.19p ps=1.38u w=1u l=1u
X499 iqmod_mfb_lpf_pex_half_1.iqmod_mfb_lpf_pex_ota_core_hybrid_bm_half_0.iqmod_mfb_lpf_pex_ota_core_tg$1_0.v_b.t32 iqmod_mfb_lpf_pex_half_1.iqmod_mfb_lpf_pex_ota_core_hybrid_bm_half_0.iqmod_mfb_lpf_pex_ota_core_tg$1_0.v_a.t1 VSS.t348 VSS.t192 sg13_lv_nmos ad=0.19p pd=1.38u as=0.19p ps=1.38u w=1u l=1u
X500 VDD.t251 iqmod_mfb_lpf_pex_half_1.iqmod_mfb_lpf_pex_ota_core_hybrid_bm_half_0.iqmod_mfb_lpf_pex_ota_core_tg$1_0.v_a.t1 iqmod_mfb_lpf_pex_half_1.iqmod_mfb_lpf_pex_ota_core_hybrid_bm_half_0.iqmod_mfb_lpf_pex_ota_core_tg$1_0.v_b.t33 VDD.t6 sg13_lv_pmos ad=1.14p pd=6.38u as=1.14p ps=6.38u w=6u l=1u
X501 VDD.t218 voutn.t43 iqmod_mfb_lpf_pex_half_1.iqmod_mfb_lpf_pex_ota_core_hybrid_bm_half_0.iqmod_mfb_lpf_pex_ota_core_inv_NF20$1_0.vout.t25 VDD.t6 sg13_lv_pmos ad=1.14p pd=6.38u as=1.14p ps=6.38u w=6u l=1u
X502 VSS.t110 VSS.t108 VSS.t31 VSS.t109 sg13_lv_nmos ad=0.34p pd=2.68u as=0 ps=0 w=1u l=1u
X503 iqmod_mfb_lpf_pex_half_1.iqmod_mfb_lpf_pex_ota_core_hybrid_bm_half_0.iqmod_mfb_lpf_pex_ota_core_inv_NF6$1_1.vout.t12 iqmod_mfb_lpf_pex_half_1.iqmod_mfb_lpf_pex_ota_core_hybrid_bm_half_0.iqmod_mfb_lpf_pex_ota_core_inv_NF20$1_0.vout.t57 VSS.t177 VSS.t197 sg13_lv_nmos ad=0.19p pd=1.38u as=0.19p ps=1.38u w=1u l=1u
X504 VSS.t1 VSS.t2 VSS.t0 rhigh l=60u w=0.5u
X505 iqmod_mfb_lpf_pex_half_1.iqmod_mfb_lpf_pex_ota_core_hybrid_bm_half_0.iqmod_mfb_lpf_pex_ota_core_tg$1_0.v_b.t35 iqmod_mfb_lpf_pex_half_1.iqmod_mfb_lpf_pex_ota_core_hybrid_bm_half_0.iqmod_mfb_lpf_pex_ota_core_tg$1_0.v_a.t1 VDD.t253 VDD.t6 sg13_lv_pmos ad=1.14p pd=6.38u as=1.14p ps=6.38u w=6u l=1u
X506 iqmod_mfb_lpf_pex_half_0.iqmod_mfb_lpf_pex_ota_core_hybrid_bm_half_0.iqmod_mfb_lpf_pex_ota_core_inv_NF20$1_1.vin.t0 iqmod_mfb_lpf_pex_half_0.iqmod_mfb_lpf_pex_ota_core_hybrid_bm_half_0.iqmod_mfb_lpf_pex_ota_core_spdt_switch$1_0.iqmod_mfb_lpf_pex_ota_core_spdt_switch_inv$2_0.vout.t2 iqmod_mfb_lpf_pex_half_0.vinp.t6 VSS.t7 sg13_lv_nmos ad=0.19p pd=1.38u as=0.19p ps=1.38u w=1u l=0.13u
X507 VSS.t200 iqmod_mfb_lpf_pex_half_1.iqmod_mfb_lpf_pex_ota_core_hybrid_bm_half_0.iqmod_mfb_lpf_pex_ota_core_inv_NF20$1_0.vout.t57 iqmod_mfb_lpf_pex_half_1.iqmod_mfb_lpf_pex_ota_core_hybrid_bm_half_0.iqmod_mfb_lpf_pex_ota_core_inv_NF6$1_1.vout.t13 VSS.t199 sg13_lv_nmos ad=0.19p pd=1.38u as=0.19p ps=1.38u w=1u l=1u
X508 VSS.t283 voutn.t42 iqmod_mfb_lpf_pex_half_1.iqmod_mfb_lpf_pex_ota_core_hybrid_bm_half_0.iqmod_mfb_lpf_pex_ota_core_inv_NF20$1_0.vout.t20 VSS.t301 sg13_lv_nmos ad=0.19p pd=1.38u as=0.19p ps=1.38u w=1u l=1u
X509 voutp.t23 iqmod_mfb_lpf_pex_half_1.iqmod_mfb_lpf_pex_ota_core_hybrid_bm_half_0.iqmod_mfb_lpf_pex_ota_core_inv_NF20$1_1.vin.t0 VDD.t267 VDD.t0 sg13_lv_pmos ad=1.14p pd=6.38u as=1.14p ps=6.38u w=6u l=1u
X510 VSS.t214 iqmod_mfb_lpf_pex_half_1.iqmod_mfb_lpf_pex_ota_core_hybrid_bm_half_0.iqmod_mfb_lpf_pex_ota_core_tg$1_0.v_b.t38 voutn.t29 VSS.t213 sg13_lv_nmos ad=0.19p pd=1.38u as=0.19p ps=1.38u w=1u l=1u
X511 VSS.t40 iqmod_mfb_lpf_pex_half_0.iqmod_mfb_lpf_pex_ota_core_hybrid_bm_half_0.iqmod_mfb_lpf_pex_ota_core_inv_NF20$1_1.vin.t0 iqmod_mfb_lpf_pex_half_1.iqmod_mfb_lpf_pex_ota_core_hybrid_bm_half_0.iqmod_mfb_lpf_pex_ota_core_tg$1_0.v_a.t1 VSS.t39 sg13_lv_nmos ad=0.19p pd=1.38u as=0.19p ps=1.38u w=1u l=1u
X512 voutp.t16 iqmod_mfb_lpf_pex_half_1.iqmod_mfb_lpf_pex_ota_core_hybrid_bm_half_0.iqmod_mfb_lpf_pex_ota_core_tg$1_0.v_b.t37 VSS.t259 VSS.t212 sg13_lv_nmos ad=0.19p pd=1.38u as=0.19p ps=1.38u w=1u l=1u
X513 VDD.t92 iqmod_mfb_lpf_pex_half_1.iqmod_mfb_lpf_pex_ota_core_hybrid_bm_half_0.iqmod_mfb_lpf_pex_ota_core_inv_NF20$1_0.vout.t59 iqmod_mfb_lpf_pex_half_1.iqmod_mfb_lpf_pex_ota_core_hybrid_bm_half_0.iqmod_mfb_lpf_pex_ota_core_inv_NF6$1_1.vout.t17 VDD.t6 sg13_lv_pmos ad=1.14p pd=6.38u as=1.14p ps=6.38u w=6u l=1u
X514 VDD.t246 voutp.t42 iqmod_mfb_lpf_pex_half_1.iqmod_mfb_lpf_pex_ota_core_hybrid_bm_half_0.iqmod_mfb_lpf_pex_ota_core_inv_NF20$1_0.vout.t53 VDD.t0 sg13_lv_pmos ad=1.14p pd=6.38u as=1.14p ps=6.38u w=6u l=1u
X515 iqmod_mfb_lpf_pex_half_1.iqmod_mfb_lpf_pex_R2_0.v_a.t6 iqmod_mfb_lpf_pex_half_1.C2_half.t2 cap_cmim l=8u w=8u
X516 iqmod_mfb_lpf_pex_half_1.iqmod_mfb_lpf_pex_ota_core_hybrid_bm_half_0.iqmod_mfb_lpf_pex_ota_core_inv_NF6$1_1.vout.t9 iqmod_mfb_lpf_pex_half_1.iqmod_mfb_lpf_pex_ota_core_hybrid_bm_half_0.iqmod_mfb_lpf_pex_ota_core_inv_NF20$1_0.vout.t58 VSS.t129 VSS.t197 sg13_lv_nmos ad=0.19p pd=1.38u as=0.19p ps=1.38u w=1u l=1u
X517 iqmod_mfb_lpf_pex_half_1.iqmod_mfb_lpf_pex_ota_core_hybrid_bm_half_0.iqmod_mfb_lpf_pex_ota_core_inv_NF6$1_1.vout.t0 iqmod_mfb_lpf_pex_half_0.iqmod_mfb_lpf_pex_ota_core_hybrid_bm_half_0.iqmod_mfb_lpf_pex_ota_core_tg$1_0.di_tg_ctrl_n.t4 iqmod_mfb_lpf_pex_half_1.iqmod_mfb_lpf_pex_ota_core_hybrid_bm_half_0.iqmod_mfb_lpf_pex_ota_core_inv_NF20$1_0.vout.t0 VDD.t6 sg13_lv_pmos ad=1.14p pd=6.38u as=2.04p ps=12.68u w=6u l=0.13u
X518 iqmod_mfb_lpf_pex_half_1.iqmod_mfb_lpf_pex_ota_core_hybrid_bm_half_0.iqmod_mfb_lpf_pex_ota_core_inv_NF20$1_0.vout.t51 voutp.t42 VDD.t239 VDD.t0 sg13_lv_pmos ad=1.14p pd=6.38u as=1.14p ps=6.38u w=6u l=1u
X519 VSS.t366 iqmod_mfb_lpf_pex_half_1.iqmod_mfb_lpf_pex_ota_core_hybrid_bm_half_0.iqmod_mfb_lpf_pex_ota_core_inv_NF20$1_1.vin.t0 voutp.t26 VSS.t50 sg13_lv_nmos ad=0.19p pd=1.38u as=0.19p ps=1.38u w=1u l=1u
X520 iqmod_mfb_lpf_pex_half_1.iqmod_mfb_lpf_pex_ota_core_hybrid_bm_half_0.iqmod_mfb_lpf_pex_ota_core_inv_NF20$1_0.vout.t35 iqmod_mfb_lpf_pex_half_1.iqmod_mfb_lpf_pex_ota_core_hybrid_bm_half_0.iqmod_mfb_lpf_pex_ota_core_tg$1_0.di_tg_ctrl_n.t2 iqmod_mfb_lpf_pex_half_1.iqmod_mfb_lpf_pex_ota_core_hybrid_bm_half_0.iqmod_mfb_lpf_pex_ota_core_inv_NF6$1_1.vout.t23 VDD.t0 sg13_lv_pmos ad=2.04p pd=12.68u as=1.14p ps=6.38u w=6u l=0.13u
X521 iqmod_mfb_lpf_pex_half_1.iqmod_mfb_lpf_pex_R2_0.v_a.t7 iqmod_mfb_lpf_pex_half_1.C2_half.t1 cap_cmim l=8u w=8u
X522 VDD.t195 iqmod_mfb_lpf_pex_half_1.iqmod_mfb_lpf_pex_ota_core_hybrid_bm_half_0.iqmod_mfb_lpf_pex_ota_core_tg$1_0.v_b.t39 voutn.t39 VDD.t6 sg13_lv_pmos ad=1.14p pd=6.38u as=1.14p ps=6.38u w=6u l=1u
X523 VSS.t160 VSS.t159 VSS.t160 VSS.t106 sg13_lv_nmos ad=0.19p pd=1.38u as=0 ps=0 w=1u l=1u
X524 a_636_4203.t0 a_6122_3903.t0 VSS.t14 rhigh l=27u w=0.5u
X525 iqmod_mfb_lpf_pex_half_1.iqmod_mfb_lpf_pex_ota_core_hybrid_bm_half_0.iqmod_mfb_lpf_pex_ota_core_inv_NF20$1_1.vin.t0 iqmod_mfb_lpf_pex_half_1.iqmod_mfb_lpf_pex_ota_core_hybrid_bm_half_0.iqmod_mfb_lpf_pex_ota_core_spdt_switch$1_0.iqmod_mfb_lpf_pex_ota_core_spdt_switch_inv$2_0.vout.t2 VDD.t293 VDD.t0 sg13_lv_pmos ad=1.14p pd=6.38u as=1.14p ps=6.38u w=6u l=0.13u
X526 VSS.t153 VSS.t151 VSS.t152 VSS.t97 sg13_lv_nmos ad=0.34p pd=2.68u as=0 ps=0 w=1u l=1u
X527 voutp.t29 iqmod_mfb_lpf_pex_half_1.iqmod_mfb_lpf_pex_ota_core_hybrid_bm_half_0.iqmod_mfb_lpf_pex_ota_core_inv_NF20$1_1.vin.t0 VSS.t368 VSS.t55 sg13_lv_nmos ad=0.19p pd=1.38u as=0.19p ps=1.38u w=1u l=1u
X528 iqmod_mfb_lpf_pex_half_1.iqmod_mfb_lpf_pex_ota_core_hybrid_bm_half_0.iqmod_mfb_lpf_pex_ota_core_inv_NF20$1_0.vout.t7 di_filter_en.t1 iqmod_mfb_lpf_pex_half_1.iqmod_mfb_lpf_pex_ota_core_hybrid_bm_half_0.iqmod_mfb_lpf_pex_ota_core_inv_NF6$1_1.vout.t6 VSS.t241 sg13_lv_nmos ad=0.19p pd=1.38u as=0.19p ps=1.38u w=1u l=0.13u
X529 VSS.t327 voutp.t43 iqmod_mfb_lpf_pex_half_1.iqmod_mfb_lpf_pex_ota_core_hybrid_bm_half_0.iqmod_mfb_lpf_pex_ota_core_inv_NF20$1_0.vout.t43 VSS.t298 sg13_lv_nmos ad=0.19p pd=1.38u as=0.19p ps=1.38u w=1u l=1u
X530 iqmod_mfb_lpf_pex_half_1.iqmod_mfb_lpf_pex_ota_core_hybrid_bm_half_0.iqmod_mfb_lpf_pex_ota_core_tg$1_0.v_a.t0 iqmod_mfb_lpf_pex_half_1.iqmod_mfb_lpf_pex_ota_core_hybrid_bm_half_0.iqmod_mfb_lpf_pex_ota_core_inv_NF20$1_1.vin.t0 VSS.t352 VSS.t32 sg13_lv_nmos ad=0.19p pd=1.38u as=0.19p ps=1.38u w=1u l=1u
X531 iqmod_mfb_lpf_pex_half_0.vinp.t2 iqmod_mfb_lpf_pex_half_0.iqmod_mfb_lpf_pex_ota_core_hybrid_bm_half_0.iqmod_mfb_lpf_pex_ota_core_tg$1_0.di_tg_ctrl_n.t7 iqmod_mfb_lpf_pex_half_0.iqmod_mfb_lpf_pex_ota_core_hybrid_bm_half_0.iqmod_mfb_lpf_pex_ota_core_inv_NF20$1_1.vin.t0 VDD.t6 sg13_lv_pmos ad=1.14p pd=6.38u as=1.14p ps=6.38u w=6u l=0.13u
X532 voutn.t11 iqmod_mfb_lpf_pex_half_0.iqmod_mfb_lpf_pex_ota_core_hybrid_bm_half_0.iqmod_mfb_lpf_pex_ota_core_inv_NF20$1_1.vin.t0 VDD.t26 VDD.t6 sg13_lv_pmos ad=1.14p pd=6.38u as=1.14p ps=6.38u w=6u l=1u
X533 voutp.t26 iqmod_mfb_lpf_pex_half_1.iqmod_mfb_lpf_pex_ota_core_hybrid_bm_half_0.iqmod_mfb_lpf_pex_ota_core_inv_NF20$1_1.vin.t0 VSS.t364 VSS.t49 sg13_lv_nmos ad=0.19p pd=1.38u as=0.19p ps=1.38u w=1u l=1u
X534 iqmod_mfb_lpf_pex_half_1.iqmod_mfb_lpf_pex_ota_core_hybrid_bm_half_0.iqmod_mfb_lpf_pex_ota_core_tg$1_0.v_a.t1 iqmod_mfb_lpf_pex_half_0.iqmod_mfb_lpf_pex_ota_core_hybrid_bm_half_0.iqmod_mfb_lpf_pex_ota_core_inv_NF20$1_1.vin.t0 VDD.t11 VDD.t6 sg13_lv_pmos ad=1.14p pd=6.38u as=1.14p ps=6.38u w=6u l=1u
X535 iqmod_mfb_lpf_pex_half_0.vinp.t7 iqmod_mfb_lpf_pex_half_0.iqmod_mfb_lpf_pex_ota_core_hybrid_bm_half_0.iqmod_mfb_lpf_pex_ota_core_spdt_switch$1_0.iqmod_mfb_lpf_pex_ota_core_spdt_switch_inv$2_0.vout.t2 iqmod_mfb_lpf_pex_half_0.iqmod_mfb_lpf_pex_ota_core_hybrid_bm_half_0.iqmod_mfb_lpf_pex_ota_core_inv_NF20$1_1.vin.t0 VSS.t8 sg13_lv_nmos ad=0.34p pd=2.68u as=0.19p ps=1.38u w=1u l=0.13u
X536 VDD.t30 iqmod_mfb_lpf_pex_half_0.iqmod_mfb_lpf_pex_ota_core_hybrid_bm_half_0.iqmod_mfb_lpf_pex_ota_core_inv_NF20$1_1.vin.t0 voutn.t12 VDD.t6 sg13_lv_pmos ad=1.14p pd=6.38u as=1.14p ps=6.38u w=6u l=1u
X537 VDD.t102 VDD.t101 VDD.t102 VDD.t0 sg13_lv_pmos ad=1.14p pd=6.38u as=0 ps=0 w=6u l=0.13u
X538 iqmod_mfb_lpf_pex_half_1.vinp.t7 iqmod_mfb_lpf_pex_half_1.iqmod_mfb_lpf_pex_ota_core_hybrid_bm_half_0.iqmod_mfb_lpf_pex_ota_core_spdt_switch$1_0.iqmod_mfb_lpf_pex_ota_core_spdt_switch_inv$2_0.vout.t3 iqmod_mfb_lpf_pex_half_1.iqmod_mfb_lpf_pex_ota_core_hybrid_bm_half_0.iqmod_mfb_lpf_pex_ota_core_inv_NF20$1_1.vin.t0 VSS.t8 sg13_lv_nmos ad=0.34p pd=2.68u as=0.19p ps=1.38u w=1u l=0.13u
X539 VSS.t137 VSS.t134 VSS.t136 VSS.t135 sg13_lv_nmos ad=0.34p pd=2.68u as=0 ps=0 w=1u l=1u
X540 iqmod_mfb_lpf_pex_half_1.iqmod_mfb_lpf_pex_ota_core_hybrid_bm_half_0.iqmod_mfb_lpf_pex_ota_core_tg$1_0.v_b.t23 di_filter_en.t2 iqmod_mfb_lpf_pex_half_1.iqmod_mfb_lpf_pex_ota_core_hybrid_bm_half_0.iqmod_mfb_lpf_pex_ota_core_tg$1_0.v_a.t0 VSS.t238 sg13_lv_nmos ad=0.19p pd=1.38u as=0.19p ps=1.38u w=1u l=0.13u
X541 VDD.t15 iqmod_mfb_lpf_pex_half_0.iqmod_mfb_lpf_pex_ota_core_hybrid_bm_half_0.iqmod_mfb_lpf_pex_ota_core_inv_NF20$1_1.vin.t0 iqmod_mfb_lpf_pex_half_1.iqmod_mfb_lpf_pex_ota_core_hybrid_bm_half_0.iqmod_mfb_lpf_pex_ota_core_tg$1_0.v_a.t1 VDD.t6 sg13_lv_pmos ad=1.14p pd=6.38u as=1.14p ps=6.38u w=6u l=1u
X542 VDD.t97 VDD.t96 VDD.t97 VDD.t6 sg13_lv_pmos ad=1.14p pd=6.38u as=0 ps=0 w=6u l=1u
X543 VDD.t2 iqmod_mfb_lpf_pex_half_1.iqmod_mfb_lpf_pex_ota_core_hybrid_bm_half_0.iqmod_mfb_lpf_pex_ota_core_tg$1_0.di_tg_ctrl_n.t5 iqmod_mfb_lpf_pex_half_1.iqmod_mfb_lpf_pex_ota_core_hybrid_bm_half_0.iqmod_mfb_lpf_pex_ota_core_spdt_switch$1_0.iqmod_mfb_lpf_pex_ota_core_spdt_switch_inv$2_0.vout.t0 VDD.t0 sg13_lv_pmos ad=1.14p pd=6.38u as=1.14p ps=6.38u w=6u l=0.13u
X544 iqmod_mfb_lpf_pex_half_1.iqmod_mfb_lpf_pex_ota_core_hybrid_bm_half_0.iqmod_mfb_lpf_pex_ota_core_tg$1_0.v_a.t0 di_filter_en.t2 iqmod_mfb_lpf_pex_half_1.iqmod_mfb_lpf_pex_ota_core_hybrid_bm_half_0.iqmod_mfb_lpf_pex_ota_core_tg$1_0.v_b.t21 VSS.t235 sg13_lv_nmos ad=0.19p pd=1.38u as=0.19p ps=1.38u w=1u l=0.13u
X545 VSS.t315 iqmod_mfb_lpf_pex_half_1.iqmod_mfb_lpf_pex_ota_core_hybrid_bm_half_0.iqmod_mfb_lpf_pex_ota_core_inv_NF6$1_1.vout.t25 iqmod_mfb_lpf_pex_half_1.iqmod_mfb_lpf_pex_ota_core_hybrid_bm_half_0.iqmod_mfb_lpf_pex_ota_core_tg$1_0.v_b.t6 VSS.t314 sg13_lv_nmos ad=0.19p pd=1.38u as=0.19p ps=1.38u w=1u l=1u
X546 voutn.t23 iqmod_mfb_lpf_pex_half_1.iqmod_mfb_lpf_pex_ota_core_hybrid_bm_half_0.iqmod_mfb_lpf_pex_ota_core_tg$1_0.v_b.t38 VSS.t220 VSS.t221 sg13_lv_nmos ad=0.19p pd=1.38u as=0.19p ps=1.38u w=1u l=1u
X547 VDD.t207 iqmod_mfb_lpf_pex_half_1.iqmod_mfb_lpf_pex_ota_core_hybrid_bm_half_0.iqmod_mfb_lpf_pex_ota_core_inv_NF6$1_1.vout.t24 iqmod_mfb_lpf_pex_half_1.iqmod_mfb_lpf_pex_ota_core_hybrid_bm_half_0.iqmod_mfb_lpf_pex_ota_core_tg$1_0.v_b.t13 VDD.t0 sg13_lv_pmos ad=1.14p pd=6.38u as=1.14p ps=6.38u w=6u l=1u
X548 VSS.t133 iqmod_mfb_lpf_pex_half_1.iqmod_mfb_lpf_pex_ota_core_hybrid_bm_half_0.iqmod_mfb_lpf_pex_ota_core_inv_NF20$1_0.vout.t58 iqmod_mfb_lpf_pex_half_1.iqmod_mfb_lpf_pex_ota_core_hybrid_bm_half_0.iqmod_mfb_lpf_pex_ota_core_inv_NF6$1_1.vout.t11 VSS.t202 sg13_lv_nmos ad=0.19p pd=1.38u as=0.19p ps=1.38u w=1u l=1u
X549 iqmod_mfb_lpf_pex_half_1.iqmod_mfb_lpf_pex_ota_core_hybrid_bm_half_0.iqmod_mfb_lpf_pex_ota_core_tg$1_0.v_b.t33 iqmod_mfb_lpf_pex_half_1.iqmod_mfb_lpf_pex_ota_core_hybrid_bm_half_0.iqmod_mfb_lpf_pex_ota_core_tg$1_0.v_a.t1 VDD.t69 VDD.t6 sg13_lv_pmos ad=1.14p pd=6.38u as=1.14p ps=6.38u w=6u l=1u
X550 voutp.t21 iqmod_mfb_lpf_pex_half_1.iqmod_mfb_lpf_pex_ota_core_hybrid_bm_half_0.iqmod_mfb_lpf_pex_ota_core_inv_NF20$1_1.vin.t0 VDD.t277 VDD.t0 sg13_lv_pmos ad=1.14p pd=6.38u as=1.14p ps=6.38u w=6u l=1u
X551 VSS.t92 VSS.t89 VSS.t91 VSS.t90 sg13_lv_nmos ad=0.34p pd=2.68u as=0 ps=0 w=1u l=0.13u
X552 iqmod_mfb_lpf_pex_half_1.iqmod_mfb_lpf_pex_ota_core_hybrid_bm_half_0.iqmod_mfb_lpf_pex_ota_core_inv_NF20$1_1.vin.t0 iqmod_mfb_lpf_pex_half_1.iqmod_mfb_lpf_pex_ota_core_hybrid_bm_half_0.iqmod_mfb_lpf_pex_ota_core_tg$1_0.di_tg_ctrl_n.t4 iqmod_mfb_lpf_pex_half_1.vinp.t2 VDD.t0 sg13_lv_pmos ad=1.14p pd=6.38u as=1.14p ps=6.38u w=6u l=0.13u
X553 VDD.t50 iqmod_mfb_lpf_pex_half_1.iqmod_mfb_lpf_pex_ota_core_hybrid_bm_half_0.iqmod_mfb_lpf_pex_ota_core_tg$1_0.v_a.t0 iqmod_mfb_lpf_pex_half_1.iqmod_mfb_lpf_pex_ota_core_hybrid_bm_half_0.iqmod_mfb_lpf_pex_ota_core_tg$1_0.v_b.t19 VDD.t0 sg13_lv_pmos ad=1.14p pd=6.38u as=1.14p ps=6.38u w=6u l=1u
X554 iqmod_mfb_lpf_pex_half_1.iqmod_mfb_lpf_pex_ota_core_hybrid_bm_half_0.iqmod_mfb_lpf_pex_ota_core_tg$1_0.v_a.t0 iqmod_mfb_lpf_pex_half_1.iqmod_mfb_lpf_pex_ota_core_hybrid_bm_half_0.iqmod_mfb_lpf_pex_ota_core_inv_NF20$1_1.vin.t0 VDD.t261 VDD.t0 sg13_lv_pmos ad=1.14p pd=6.38u as=1.14p ps=6.38u w=6u l=1u
X555 VSS.t178 VSS.t176 VSS.t177 VSS.t128 sg13_lv_nmos ad=0.34p pd=2.68u as=0 ps=0 w=1u l=1u
X556 iqmod_mfb_lpf_pex_half_1.iqmod_mfb_lpf_pex_ota_core_hybrid_bm_half_0.iqmod_mfb_lpf_pex_ota_core_inv_NF20$1_0.vout.t36 voutp.t43 VSS.t182 VSS.t278 sg13_lv_nmos ad=0.19p pd=1.38u as=0.19p ps=1.38u w=1u l=1u
X557 iqmod_mfb_lpf_pex_half_1.iqmod_mfb_lpf_pex_ota_core_hybrid_bm_half_0.iqmod_mfb_lpf_pex_ota_core_tg$1_0.v_b.t6 iqmod_mfb_lpf_pex_half_1.iqmod_mfb_lpf_pex_ota_core_hybrid_bm_half_0.iqmod_mfb_lpf_pex_ota_core_inv_NF6$1_1.vout.t25 VSS.t172 VSS.t313 sg13_lv_nmos ad=0.19p pd=1.38u as=0.19p ps=1.38u w=1u l=1u
X558 iqmod_mfb_lpf_pex_half_1.iqmod_mfb_lpf_pex_ota_core_hybrid_bm_half_0.iqmod_mfb_lpf_pex_ota_core_inv_NF20$1_0.vout.t20 voutn.t42 VSS.t299 VSS.t300 sg13_lv_nmos ad=0.19p pd=1.38u as=0.19p ps=1.38u w=1u l=1u
X559 VDD.t95 VDD.t93 VDD.t94 VDD.t6 sg13_lv_pmos ad=2.04p pd=12.68u as=0 ps=0 w=6u l=1u
X560 voutp.t7 iqmod_mfb_lpf_pex_half_1.iqmod_mfb_lpf_pex_ota_core_hybrid_bm_half_0.iqmod_mfb_lpf_pex_ota_core_tg$1_0.v_b.t36 VDD.t169 VDD.t0 sg13_lv_pmos ad=1.14p pd=6.38u as=1.14p ps=6.38u w=6u l=1u
X561 VDD.t291 iqmod_mfb_lpf_pex_half_1.iqmod_mfb_lpf_pex_ota_core_hybrid_bm_half_0.iqmod_mfb_lpf_pex_ota_core_spdt_switch$1_0.iqmod_mfb_lpf_pex_ota_core_spdt_switch_inv$2_0.vout.t2 iqmod_mfb_lpf_pex_half_1.iqmod_mfb_lpf_pex_ota_core_hybrid_bm_half_0.iqmod_mfb_lpf_pex_ota_core_inv_NF20$1_1.vin.t0 VDD.t0 sg13_lv_pmos ad=1.14p pd=6.38u as=1.14p ps=6.38u w=6u l=0.13u
X562 VDD.t273 iqmod_mfb_lpf_pex_half_1.iqmod_mfb_lpf_pex_ota_core_hybrid_bm_half_0.iqmod_mfb_lpf_pex_ota_core_inv_NF20$1_1.vin.t0 voutp.t39 VDD.t0 sg13_lv_pmos ad=1.14p pd=6.38u as=1.14p ps=6.38u w=6u l=1u
X563 voutn.t21 iqmod_mfb_lpf_pex_half_1.iqmod_mfb_lpf_pex_ota_core_hybrid_bm_half_0.iqmod_mfb_lpf_pex_ota_core_tg$1_0.v_b.t38 VSS.t205 VSS.t206 sg13_lv_nmos ad=0.19p pd=1.38u as=0.19p ps=1.38u w=1u l=1u
X564 voutp.t35 iqmod_mfb_lpf_pex_half_1.iqmod_mfb_lpf_pex_ota_core_hybrid_bm_half_0.iqmod_mfb_lpf_pex_ota_core_inv_NF20$1_1.vin.t0 VSS.t378 VSS.t68 sg13_lv_nmos ad=0.19p pd=1.38u as=0.19p ps=1.38u w=1u l=1u
X565 a_636_4203.t1 iqmod_mfb_lpf_pex_half_1.C1_half.t6 VSS.t14 rhigh l=27u w=0.5u
X566 VDD.t132 VDD.t131 VDD.t132 VDD.t0 sg13_lv_pmos ad=1.14p pd=6.38u as=0 ps=0 w=6u l=1u
X567 VSS.t21 VSS.t22 VSS.t20 rhigh l=59u w=0.5u
X568 VDD.t155 iqmod_mfb_lpf_pex_half_1.iqmod_mfb_lpf_pex_ota_core_hybrid_bm_half_0.iqmod_mfb_lpf_pex_ota_core_inv_NF20$1_0.vout.t59 iqmod_mfb_lpf_pex_half_1.iqmod_mfb_lpf_pex_ota_core_hybrid_bm_half_0.iqmod_mfb_lpf_pex_ota_core_inv_NF6$1_1.vout.t15 VDD.t6 sg13_lv_pmos ad=1.14p pd=6.38u as=1.14p ps=6.38u w=6u l=1u
X569 VDD.t142 VDD.t141 VDD.t142 VDD.t0 sg13_lv_pmos ad=1.14p pd=6.38u as=0 ps=0 w=6u l=1u
X570 VSS.t305 VSS.t306 VSS.t194 rhigh l=27u w=0.5u
X571 VDD.t257 iqmod_mfb_lpf_pex_half_1.iqmod_mfb_lpf_pex_ota_core_hybrid_bm_half_0.iqmod_mfb_lpf_pex_ota_core_inv_NF20$1_1.vin.t0 iqmod_mfb_lpf_pex_half_1.iqmod_mfb_lpf_pex_ota_core_hybrid_bm_half_0.iqmod_mfb_lpf_pex_ota_core_tg$1_0.v_a.t0 VDD.t0 sg13_lv_pmos ad=1.14p pd=6.38u as=1.14p ps=6.38u w=6u l=1u
X572 iqmod_mfb_lpf_pex_half_1.iqmod_mfb_lpf_pex_ota_core_hybrid_bm_half_0.iqmod_mfb_lpf_pex_ota_core_inv_NF20$1_0.vout.t23 voutn.t43 VDD.t211 VDD.t6 sg13_lv_pmos ad=1.14p pd=6.38u as=1.14p ps=6.38u w=6u l=1u
X573 iqmod_mfb_lpf_pex_half_1.iqmod_mfb_lpf_pex_ota_core_hybrid_bm_half_0.iqmod_mfb_lpf_pex_ota_core_inv_NF6$1_1.vout.t8 di_filter_en.t1 iqmod_mfb_lpf_pex_half_1.iqmod_mfb_lpf_pex_ota_core_hybrid_bm_half_0.iqmod_mfb_lpf_pex_ota_core_inv_NF20$1_0.vout.t4 VSS.t244 sg13_lv_nmos ad=0.19p pd=1.38u as=0.19p ps=1.38u w=1u l=0.13u
X574 voutn.t5 iqmod_mfb_lpf_pex_half_0.iqmod_mfb_lpf_pex_ota_core_hybrid_bm_half_0.iqmod_mfb_lpf_pex_ota_core_inv_NF20$1_1.vin.t0 VSS.t60 VSS.t61 sg13_lv_nmos ad=0.19p pd=1.38u as=0.19p ps=1.38u w=1u l=1u
X575 VSS.t133 VSS.t131 VSS.t133 VSS.t132 sg13_lv_nmos ad=0.19p pd=1.38u as=0 ps=0 w=1u l=1u
X576 VSS.t130 VSS.t127 VSS.t129 VSS.t128 sg13_lv_nmos ad=0.34p pd=2.68u as=0 ps=0 w=1u l=1u
X577 VSS.t275 voutn.t42 iqmod_mfb_lpf_pex_half_1.iqmod_mfb_lpf_pex_ota_core_hybrid_bm_half_0.iqmod_mfb_lpf_pex_ota_core_inv_NF20$1_0.vout.t15 VSS.t284 sg13_lv_nmos ad=0.19p pd=1.38u as=0.19p ps=1.38u w=1u l=1u
X578 iqmod_mfb_lpf_pex_half_1.iqmod_mfb_lpf_pex_ota_core_hybrid_bm_half_0.iqmod_mfb_lpf_pex_ota_core_inv_NF6$1_1.vout.t17 iqmod_mfb_lpf_pex_half_1.iqmod_mfb_lpf_pex_ota_core_hybrid_bm_half_0.iqmod_mfb_lpf_pex_ota_core_inv_NF20$1_0.vout.t59 VDD.t157 VDD.t6 sg13_lv_pmos ad=1.14p pd=6.38u as=1.14p ps=6.38u w=6u l=1u
X579 VDD.t215 voutn.t43 iqmod_mfb_lpf_pex_half_1.iqmod_mfb_lpf_pex_ota_core_hybrid_bm_half_0.iqmod_mfb_lpf_pex_ota_core_inv_NF20$1_0.vout.t24 VDD.t6 sg13_lv_pmos ad=1.14p pd=6.38u as=1.14p ps=6.38u w=6u l=1u
X580 iqmod_mfb_lpf_pex_half_1.iqmod_mfb_lpf_pex_ota_core_hybrid_bm_half_0.iqmod_mfb_lpf_pex_ota_core_tg$1_0.v_b.t16 iqmod_mfb_lpf_pex_half_1.iqmod_mfb_lpf_pex_ota_core_hybrid_bm_half_0.iqmod_mfb_lpf_pex_ota_core_tg$1_0.v_a.t0 VSS.t188 VSS.t189 sg13_lv_nmos ad=0.19p pd=1.38u as=0.19p ps=1.38u w=1u l=1u
X581 VDD.t146 iqmod_mfb_lpf_pex_half_0.iqmod_mfb_lpf_pex_ota_core_hybrid_bm_half_0.iqmod_mfb_lpf_pex_ota_core_spdt_switch$1_0.iqmod_mfb_lpf_pex_ota_core_spdt_switch_inv$2_0.vout.t4 iqmod_mfb_lpf_pex_half_0.iqmod_mfb_lpf_pex_ota_core_hybrid_bm_half_0.iqmod_mfb_lpf_pex_ota_core_inv_NF20$1_1.vin.t0 VDD.t6 sg13_lv_pmos ad=1.14p pd=6.38u as=1.14p ps=6.38u w=6u l=0.13u
X582 VDD.t46 iqmod_mfb_lpf_pex_half_1.iqmod_mfb_lpf_pex_ota_core_hybrid_bm_half_0.iqmod_mfb_lpf_pex_ota_core_tg$1_0.di_tg_ctrl_n.t6 iqmod_mfb_lpf_pex_half_1.iqmod_mfb_lpf_pex_ota_core_hybrid_bm_half_0.iqmod_mfb_lpf_pex_ota_core_inv_NF20$1_1.vin.t1 VSS.t81 sg13_lv_nmos ad=0.34p pd=2.68u as=0.19p ps=1.38u w=1u l=0.13u
X583 VSS.t385 iqmod_mfb_lpf_pex_half_1.iqmod_mfb_lpf_pex_ota_core_hybrid_bm_half_0.iqmod_mfb_lpf_pex_ota_core_inv_NF6$1_1.vout.t26 iqmod_mfb_lpf_pex_half_1.iqmod_mfb_lpf_pex_ota_core_hybrid_bm_half_0.iqmod_mfb_lpf_pex_ota_core_tg$1_0.v_b.t3 VSS.t314 sg13_lv_nmos ad=0.19p pd=1.38u as=0.19p ps=1.38u w=1u l=1u
X584 voutn.t39 iqmod_mfb_lpf_pex_half_1.iqmod_mfb_lpf_pex_ota_core_hybrid_bm_half_0.iqmod_mfb_lpf_pex_ota_core_tg$1_0.v_b.t39 VDD.t193 VDD.t6 sg13_lv_pmos ad=1.14p pd=6.38u as=1.14p ps=6.38u w=6u l=1u
X585 VDD.t48 iqmod_mfb_lpf_pex_half_1.iqmod_mfb_lpf_pex_ota_core_hybrid_bm_half_0.iqmod_mfb_lpf_pex_ota_core_tg$1_0.v_a.t0 iqmod_mfb_lpf_pex_half_1.iqmod_mfb_lpf_pex_ota_core_hybrid_bm_half_0.iqmod_mfb_lpf_pex_ota_core_tg$1_0.v_b.t18 VDD.t0 sg13_lv_pmos ad=1.14p pd=6.38u as=1.14p ps=6.38u w=6u l=1u
X586 VSS.t160 iqmod_mfb_lpf_pex_half_1.iqmod_mfb_lpf_pex_ota_core_hybrid_bm_half_0.iqmod_mfb_lpf_pex_ota_core_tg$1_0.v_a.t0 iqmod_mfb_lpf_pex_half_1.iqmod_mfb_lpf_pex_ota_core_hybrid_bm_half_0.iqmod_mfb_lpf_pex_ota_core_tg$1_0.v_b.t17 VSS.t193 sg13_lv_nmos ad=0.19p pd=1.38u as=0.19p ps=1.38u w=1u l=1u
X587 VSS.t337 voutp.t43 iqmod_mfb_lpf_pex_half_1.iqmod_mfb_lpf_pex_ota_core_hybrid_bm_half_0.iqmod_mfb_lpf_pex_ota_core_inv_NF20$1_0.vout.t41 VSS.t294 sg13_lv_nmos ad=0.19p pd=1.38u as=0.19p ps=1.38u w=1u l=1u
X588 VSS.t145 di_filter_en.t3 iqmod_mfb_lpf_pex_half_1.iqmod_mfb_lpf_pex_ota_core_hybrid_bm_half_0.iqmod_mfb_lpf_pex_ota_core_tg$1_0.di_tg_ctrl_n.t0 VSS.t233 sg13_lv_nmos ad=0.19p pd=1.38u as=0.19p ps=1.38u w=1u l=0.13u
X589 iqmod_mfb_lpf_pex_half_0.iqmod_mfb_lpf_pex_ota_core_hybrid_bm_half_0.iqmod_mfb_lpf_pex_ota_core_spdt_switch$1_0.iqmod_mfb_lpf_pex_ota_core_spdt_switch_inv$2_0.vout.t1 iqmod_mfb_lpf_pex_half_0.iqmod_mfb_lpf_pex_ota_core_hybrid_bm_half_0.iqmod_mfb_lpf_pex_ota_core_tg$1_0.di_tg_ctrl_n.t3 VSS.t91 VSS.t77 sg13_lv_nmos ad=0.19p pd=1.38u as=0.19p ps=1.38u w=1u l=0.13u
X590 voutp.t36 iqmod_mfb_lpf_pex_half_1.iqmod_mfb_lpf_pex_ota_core_hybrid_bm_half_0.iqmod_mfb_lpf_pex_ota_core_inv_NF20$1_1.vin.t0 VSS.t162 VSS.t30 sg13_lv_nmos ad=0.19p pd=1.38u as=0.19p ps=1.38u w=1u l=1u
X591 iqmod_mfb_lpf_pex_half_1.iqmod_mfb_lpf_pex_ota_core_hybrid_bm_half_0.iqmod_mfb_lpf_pex_ota_core_inv_NF20$1_1.vin.t0 iqmod_mfb_lpf_pex_half_1.iqmod_mfb_lpf_pex_ota_core_hybrid_bm_half_0.iqmod_mfb_lpf_pex_ota_core_spdt_switch$1_0.iqmod_mfb_lpf_pex_ota_core_spdt_switch_inv$2_0.vout.t2 VDD.t290 VDD.t0 sg13_lv_pmos ad=1.14p pd=6.38u as=2.04p ps=12.68u w=6u l=0.13u
X592 VDD.t5 iqmod_mfb_lpf_pex_half_1.iqmod_mfb_lpf_pex_ota_core_hybrid_bm_half_0.iqmod_mfb_lpf_pex_ota_core_tg$1_0.di_tg_ctrl_n.t7 iqmod_mfb_lpf_pex_half_1.iqmod_mfb_lpf_pex_ota_core_hybrid_bm_half_0.iqmod_mfb_lpf_pex_ota_core_inv_NF20$1_1.vin.t0 VSS.t10 sg13_lv_nmos ad=0.19p pd=1.38u as=0.19p ps=1.38u w=1u l=0.13u
X593 iqmod_mfb_lpf_pex_half_1.iqmod_mfb_lpf_pex_ota_core_hybrid_bm_half_0.iqmod_mfb_lpf_pex_ota_core_inv_NF20$1_0.vout.t10 di_filter_en.t4 iqmod_mfb_lpf_pex_half_1.iqmod_mfb_lpf_pex_ota_core_hybrid_bm_half_0.iqmod_mfb_lpf_pex_ota_core_inv_NF6$1_1.vout.t4 VSS.t243 sg13_lv_nmos ad=0.19p pd=1.38u as=0.19p ps=1.38u w=1u l=0.13u
R0 vinn.n0 vinn.t0 17.2505
R1 vinn.n0 vinn 2.73089
R2 vinn vinn.n0 0.0163689
R3 voutp.n53 voutp.t0 17.2505
R4 voutp.n54 voutp.t18 10.2939
R5 voutp.n55 voutp.t20 10.2939
R6 voutp.n56 voutp.t14 10.2939
R7 voutp.n57 voutp.t13 10.2939
R8 voutp.n58 voutp.t15 10.2939
R9 voutp.n59 voutp.t17 10.2939
R10 voutp.n60 voutp.t16 10.2939
R11 voutp.n61 voutp.t19 10.2939
R12 voutp.n62 voutp.t12 10.2939
R13 voutp.n63 voutp.t11 10.2939
R14 voutp.n73 voutp.t35 10.2939
R15 voutp.n72 voutp.t34 10.2939
R16 voutp.n71 voutp.t30 10.2939
R17 voutp.n70 voutp.t28 10.2939
R18 voutp.n69 voutp.t27 10.2939
R19 voutp.n68 voutp.t29 10.2939
R20 voutp.n67 voutp.t38 10.2939
R21 voutp.n66 voutp.t26 10.2939
R22 voutp.n65 voutp.t25 10.2939
R23 voutp.n64 voutp.t36 10.2933
R24 voutp.n76 voutp.n53 6.6345
R25 voutp.n75 voutp.t41 5.59594
R26 voutp.n76 voutp.n75 5.52837
R27 voutp.n76 voutp.n52 3.32827
R28 voutp.n54 voutp.t8 2.08789
R29 voutp.n55 voutp.t4 2.08789
R30 voutp.n56 voutp.t3 2.08789
R31 voutp.n57 voutp.t6 2.08789
R32 voutp.n58 voutp.t5 2.08789
R33 voutp.n73 voutp.t31 2.08789
R34 voutp.n72 voutp.t40 2.08789
R35 voutp.n71 voutp.t22 2.08789
R36 voutp.n70 voutp.t21 2.08789
R37 voutp.n69 voutp.t33 2.08789
R38 voutp.n59 voutp.t9 2.0693
R39 voutp.n60 voutp.t7 2.0693
R40 voutp.n61 voutp.t2 2.0693
R41 voutp.n62 voutp.t1 2.0693
R42 voutp.n63 voutp.t10 2.0693
R43 voutp.n68 voutp.t32 2.0693
R44 voutp.n67 voutp.t39 2.0693
R45 voutp.n66 voutp.t24 2.0693
R46 voutp.n65 voutp.t23 2.0693
R47 voutp.n64 voutp.t37 2.0693
R48 voutp.n75 voutp.n74 1.11021
R49 voutp.n25 voutp.t42 0.994013
R50 voutp.n43 voutp.t43 0.994013
R51 voutp.n52 voutp.n0 0.83231
R52 voutp.n34 voutp.n33 0.83231
R53 voutp.n36 voutp.n35 0.754036
R54 voutp.n51 voutp.n50 0.754036
R55 voutp.n18 voutp.n0 0.578786
R56 voutp.n19 voutp.n18 0.578786
R57 voutp.n20 voutp.n19 0.578786
R58 voutp.n21 voutp.n20 0.578786
R59 voutp.n22 voutp.n21 0.578786
R60 voutp.n23 voutp.n22 0.578786
R61 voutp.n24 voutp.n23 0.578786
R62 voutp.n25 voutp.n24 0.578786
R63 voutp.n26 voutp.n25 0.578786
R64 voutp.n27 voutp.n26 0.578786
R65 voutp.n28 voutp.n27 0.578786
R66 voutp.n29 voutp.n28 0.578786
R67 voutp.n30 voutp.n29 0.578786
R68 voutp.n31 voutp.n30 0.578786
R69 voutp.n32 voutp.n31 0.578786
R70 voutp.n33 voutp.n32 0.578786
R71 voutp.n50 voutp.n49 0.578786
R72 voutp.n49 voutp.n48 0.578786
R73 voutp.n48 voutp.n47 0.578786
R74 voutp.n47 voutp.n46 0.578786
R75 voutp.n46 voutp.n45 0.578786
R76 voutp.n45 voutp.n44 0.578786
R77 voutp.n44 voutp.n43 0.578786
R78 voutp.n43 voutp.n42 0.578786
R79 voutp.n42 voutp.n41 0.578786
R80 voutp.n41 voutp.n40 0.578786
R81 voutp.n40 voutp.n39 0.578786
R82 voutp.n39 voutp.n38 0.578786
R83 voutp.n38 voutp.n37 0.578786
R84 voutp.n37 voutp.n36 0.578786
R85 voutp.n25 voutp.n9 0.254024
R86 voutp.n1 voutp.n0 0.254024
R87 voutp.n18 voutp.n2 0.254024
R88 voutp.n19 voutp.n3 0.254024
R89 voutp.n20 voutp.n4 0.254024
R90 voutp.n21 voutp.n5 0.254024
R91 voutp.n22 voutp.n6 0.254024
R92 voutp.n23 voutp.n7 0.254024
R93 voutp.n24 voutp.n8 0.254024
R94 voutp.n26 voutp.n10 0.254024
R95 voutp.n27 voutp.n11 0.254024
R96 voutp.n28 voutp.n12 0.254024
R97 voutp.n29 voutp.n13 0.254024
R98 voutp.n30 voutp.n14 0.254024
R99 voutp.n31 voutp.n15 0.254024
R100 voutp.n32 voutp.n16 0.254024
R101 voutp.n33 voutp.n17 0.254024
R102 voutp.n43 voutp.n9 0.254024
R103 voutp.n36 voutp.n16 0.254024
R104 voutp.n37 voutp.n15 0.254024
R105 voutp.n38 voutp.n14 0.254024
R106 voutp.n39 voutp.n13 0.254024
R107 voutp.n40 voutp.n12 0.254024
R108 voutp.n41 voutp.n11 0.254024
R109 voutp.n42 voutp.n10 0.254024
R110 voutp.n44 voutp.n8 0.254024
R111 voutp.n45 voutp.n7 0.254024
R112 voutp.n46 voutp.n6 0.254024
R113 voutp.n47 voutp.n5 0.254024
R114 voutp.n48 voutp.n4 0.254024
R115 voutp.n49 voutp.n3 0.254024
R116 voutp.n50 voutp.n2 0.254024
R117 voutp.n74 voutp.n63 0.22138
R118 voutp.n74 voutp 0.2073
R119 voutp.n55 voutp.n54 0.16242
R120 voutp.n56 voutp.n55 0.16242
R121 voutp.n57 voutp.n56 0.16242
R122 voutp.n58 voutp.n57 0.16242
R123 voutp.n59 voutp.n58 0.16242
R124 voutp.n60 voutp.n59 0.16242
R125 voutp.n61 voutp.n60 0.16242
R126 voutp.n62 voutp.n61 0.16242
R127 voutp.n63 voutp.n62 0.16242
R128 voutp.n73 voutp.n72 0.16242
R129 voutp.n72 voutp.n71 0.16242
R130 voutp.n71 voutp.n70 0.16242
R131 voutp.n70 voutp.n69 0.16242
R132 voutp.n69 voutp.n68 0.16242
R133 voutp.n68 voutp.n67 0.16242
R134 voutp.n67 voutp.n66 0.16242
R135 voutp.n66 voutp.n65 0.16242
R136 voutp.n65 voutp.n64 0.16242
R137 voutp.n2 voutp.n1 0.12194
R138 voutp.n3 voutp.n2 0.12194
R139 voutp.n4 voutp.n3 0.12194
R140 voutp.n5 voutp.n4 0.12194
R141 voutp.n6 voutp.n5 0.12194
R142 voutp.n7 voutp.n6 0.12194
R143 voutp.n8 voutp.n7 0.12194
R144 voutp.n9 voutp.n8 0.12194
R145 voutp.n10 voutp.n9 0.12194
R146 voutp.n11 voutp.n10 0.12194
R147 voutp.n12 voutp.n11 0.12194
R148 voutp.n13 voutp.n12 0.12194
R149 voutp.n14 voutp.n13 0.12194
R150 voutp.n15 voutp.n14 0.12194
R151 voutp.n16 voutp.n15 0.12194
R152 voutp.n17 voutp.n16 0.12194
R153 voutp.n52 voutp.n51 0.0847067
R154 voutp.n35 voutp.n34 0.0847067
R155 voutp.n51 voutp.n1 0.0265126
R156 voutp.n35 voutp.n17 0.0265126
R157 voutp voutp.n76 0.0227933
R158 voutp.n53 voutp 0.0161129
R159 voutp.n54 voutp 0.0151667
R160 voutp voutp.n73 0.0151667
R161 voutp.n34 voutp 0.00974
R162 di_filter_en.n2 di_filter_en.n0 49.1515
R163 di_filter_en.n9 di_filter_en.n7 49.1515
R164 di_filter_en.n6 di_filter_en.n2 23.0421
R165 di_filter_en.n12 di_filter_en.n9 23.0421
R166 di_filter_en.n3 di_filter_en.t6 12.3425
R167 di_filter_en.n3 di_filter_en.t7 12.3425
R168 di_filter_en.n10 di_filter_en.t0 12.3425
R169 di_filter_en.n10 di_filter_en.t3 12.3425
R170 di_filter_en.n12 di_filter_en.n11 6.08136
R171 di_filter_en.n6 di_filter_en.n5 6.0005
R172 di_filter_en.n1 di_filter_en.t5 3.12406
R173 di_filter_en.n0 di_filter_en.t4 3.12406
R174 di_filter_en.n8 di_filter_en.t2 3.12406
R175 di_filter_en.n7 di_filter_en.t1 3.12406
R176 di_filter_en.n2 di_filter_en.n1 1.1255
R177 di_filter_en.n9 di_filter_en.n8 1.1255
R178 di_filter_en di_filter_en.n6 0.296608
R179 di_filter_en di_filter_en.n12 0.237149
R180 di_filter_en.n13 di_filter_en 0.1765
R181 di_filter_en.n13 di_filter_en 0.0976171
R182 di_filter_en.n4 di_filter_en 0.06342
R183 di_filter_en.n11 di_filter_en 0.06342
R184 di_filter_en.n4 di_filter_en 0.0511
R185 di_filter_en.n11 di_filter_en 0.0511
R186 di_filter_en di_filter_en.n13 0.0381577
R187 di_filter_en.n1 di_filter_en 0.0335
R188 di_filter_en.n0 di_filter_en 0.0335
R189 di_filter_en.n8 di_filter_en 0.0335
R190 di_filter_en.n7 di_filter_en 0.0335
R191 di_filter_en di_filter_en.n3 0.03174
R192 di_filter_en di_filter_en.n10 0.03174
R193 di_filter_en.n5 di_filter_en.n4 0.0306481
R194 di_filter_en.n11 di_filter_en 0.0203198
R195 di_filter_en.n5 di_filter_en 0.00158642
R196 vinp.n0 vinp.t0 17.2505
R197 vinp.n0 vinp 2.73089
R198 vinp vinp.n0 0.0163689
R199 voutn.n0 voutn.t20 17.2505
R200 voutn.n54 voutn.t26 10.2939
R201 voutn.n55 voutn.t27 10.2939
R202 voutn.n56 voutn.t24 10.2939
R203 voutn.n57 voutn.t23 10.2939
R204 voutn.n58 voutn.t28 10.2939
R205 voutn.n59 voutn.t30 10.2939
R206 voutn.n60 voutn.t29 10.2939
R207 voutn.n61 voutn.t22 10.2939
R208 voutn.n62 voutn.t21 10.2939
R209 voutn.n63 voutn.t25 10.2939
R210 voutn.n73 voutn.t16 10.2939
R211 voutn.n72 voutn.t10 10.2939
R212 voutn.n71 voutn.t9 10.2939
R213 voutn.n70 voutn.t5 10.2939
R214 voutn.n69 voutn.t4 10.2939
R215 voutn.n68 voutn.t2 10.2939
R216 voutn.n67 voutn.t1 10.2939
R217 voutn.n66 voutn.t14 10.2939
R218 voutn.n65 voutn.t15 10.2939
R219 voutn.n64 voutn.t0 10.2939
R220 voutn.n76 voutn.n0 6.6345
R221 voutn.n75 voutn.t41 5.59594
R222 voutn.n76 voutn.n75 5.52837
R223 voutn.n76 voutn.n53 3.32827
R224 voutn.n54 voutn.t37 2.0884
R225 voutn.n55 voutn.t34 2.0884
R226 voutn.n56 voutn.t33 2.0884
R227 voutn.n57 voutn.t40 2.0884
R228 voutn.n58 voutn.t39 2.0884
R229 voutn.n73 voutn.t8 2.0884
R230 voutn.n72 voutn.t7 2.0884
R231 voutn.n71 voutn.t6 2.0884
R232 voutn.n70 voutn.t12 2.0884
R233 voutn.n69 voutn.t11 2.0884
R234 voutn.n59 voutn.t38 2.0693
R235 voutn.n60 voutn.t32 2.0693
R236 voutn.n61 voutn.t31 2.0693
R237 voutn.n62 voutn.t36 2.0693
R238 voutn.n63 voutn.t35 2.0693
R239 voutn.n68 voutn.t18 2.0693
R240 voutn.n67 voutn.t19 2.0693
R241 voutn.n66 voutn.t17 2.0693
R242 voutn.n65 voutn.t13 2.0693
R243 voutn.n64 voutn.t3 2.0693
R244 voutn.n75 voutn.n74 1.11021
R245 voutn.n26 voutn.t42 0.994013
R246 voutn.n44 voutn.t43 0.994013
R247 voutn.n53 voutn.n1 0.83231
R248 voutn.n35 voutn.n34 0.83231
R249 voutn.n37 voutn.n36 0.754036
R250 voutn.n52 voutn.n51 0.754036
R251 voutn.n19 voutn.n1 0.578786
R252 voutn.n20 voutn.n19 0.578786
R253 voutn.n21 voutn.n20 0.578786
R254 voutn.n22 voutn.n21 0.578786
R255 voutn.n23 voutn.n22 0.578786
R256 voutn.n24 voutn.n23 0.578786
R257 voutn.n25 voutn.n24 0.578786
R258 voutn.n26 voutn.n25 0.578786
R259 voutn.n27 voutn.n26 0.578786
R260 voutn.n28 voutn.n27 0.578786
R261 voutn.n29 voutn.n28 0.578786
R262 voutn.n30 voutn.n29 0.578786
R263 voutn.n31 voutn.n30 0.578786
R264 voutn.n32 voutn.n31 0.578786
R265 voutn.n33 voutn.n32 0.578786
R266 voutn.n34 voutn.n33 0.578786
R267 voutn.n51 voutn.n50 0.578786
R268 voutn.n50 voutn.n49 0.578786
R269 voutn.n49 voutn.n48 0.578786
R270 voutn.n48 voutn.n47 0.578786
R271 voutn.n47 voutn.n46 0.578786
R272 voutn.n46 voutn.n45 0.578786
R273 voutn.n45 voutn.n44 0.578786
R274 voutn.n44 voutn.n43 0.578786
R275 voutn.n43 voutn.n42 0.578786
R276 voutn.n42 voutn.n41 0.578786
R277 voutn.n41 voutn.n40 0.578786
R278 voutn.n40 voutn.n39 0.578786
R279 voutn.n39 voutn.n38 0.578786
R280 voutn.n38 voutn.n37 0.578786
R281 voutn.n26 voutn.n10 0.254024
R282 voutn.n2 voutn.n1 0.254024
R283 voutn.n19 voutn.n3 0.254024
R284 voutn.n20 voutn.n4 0.254024
R285 voutn.n21 voutn.n5 0.254024
R286 voutn.n22 voutn.n6 0.254024
R287 voutn.n23 voutn.n7 0.254024
R288 voutn.n24 voutn.n8 0.254024
R289 voutn.n25 voutn.n9 0.254024
R290 voutn.n27 voutn.n11 0.254024
R291 voutn.n28 voutn.n12 0.254024
R292 voutn.n29 voutn.n13 0.254024
R293 voutn.n30 voutn.n14 0.254024
R294 voutn.n31 voutn.n15 0.254024
R295 voutn.n32 voutn.n16 0.254024
R296 voutn.n33 voutn.n17 0.254024
R297 voutn.n34 voutn.n18 0.254024
R298 voutn.n44 voutn.n10 0.254024
R299 voutn.n37 voutn.n17 0.254024
R300 voutn.n38 voutn.n16 0.254024
R301 voutn.n39 voutn.n15 0.254024
R302 voutn.n40 voutn.n14 0.254024
R303 voutn.n41 voutn.n13 0.254024
R304 voutn.n42 voutn.n12 0.254024
R305 voutn.n43 voutn.n11 0.254024
R306 voutn.n45 voutn.n9 0.254024
R307 voutn.n46 voutn.n8 0.254024
R308 voutn.n47 voutn.n7 0.254024
R309 voutn.n48 voutn.n6 0.254024
R310 voutn.n49 voutn.n5 0.254024
R311 voutn.n50 voutn.n4 0.254024
R312 voutn.n51 voutn.n3 0.254024
R313 voutn.n74 voutn.n63 0.22138
R314 voutn.n74 voutn 0.2073
R315 voutn.n55 voutn.n54 0.16242
R316 voutn.n56 voutn.n55 0.16242
R317 voutn.n57 voutn.n56 0.16242
R318 voutn.n58 voutn.n57 0.16242
R319 voutn.n59 voutn.n58 0.16242
R320 voutn.n60 voutn.n59 0.16242
R321 voutn.n61 voutn.n60 0.16242
R322 voutn.n62 voutn.n61 0.16242
R323 voutn.n63 voutn.n62 0.16242
R324 voutn.n73 voutn.n72 0.16242
R325 voutn.n72 voutn.n71 0.16242
R326 voutn.n71 voutn.n70 0.16242
R327 voutn.n70 voutn.n69 0.16242
R328 voutn.n69 voutn.n68 0.16242
R329 voutn.n68 voutn.n67 0.16242
R330 voutn.n67 voutn.n66 0.16242
R331 voutn.n66 voutn.n65 0.16242
R332 voutn.n65 voutn.n64 0.16242
R333 voutn.n3 voutn.n2 0.12194
R334 voutn.n4 voutn.n3 0.12194
R335 voutn.n5 voutn.n4 0.12194
R336 voutn.n6 voutn.n5 0.12194
R337 voutn.n7 voutn.n6 0.12194
R338 voutn.n8 voutn.n7 0.12194
R339 voutn.n9 voutn.n8 0.12194
R340 voutn.n10 voutn.n9 0.12194
R341 voutn.n11 voutn.n10 0.12194
R342 voutn.n12 voutn.n11 0.12194
R343 voutn.n13 voutn.n12 0.12194
R344 voutn.n14 voutn.n13 0.12194
R345 voutn.n15 voutn.n14 0.12194
R346 voutn.n16 voutn.n15 0.12194
R347 voutn.n17 voutn.n16 0.12194
R348 voutn.n18 voutn.n17 0.12194
R349 voutn.n53 voutn.n52 0.0847067
R350 voutn.n36 voutn.n35 0.0847067
R351 voutn.n52 voutn.n2 0.0265126
R352 voutn.n36 voutn.n18 0.0265126
R353 voutn voutn.n76 0.0227933
R354 voutn.n0 voutn 0.0161129
R355 voutn.n54 voutn 0.0151667
R356 voutn voutn.n73 0.0151667
R357 voutn.n35 voutn 0.00974
R358 VDD.n1354 VDD.t53 24.0005
R359 VDD.n2 VDD.t56 24.0005
R360 VDD.n2 VDD.t58 24.0005
R361 VDD.n1294 VDD.t61 24.0005
R362 VDD.n896 VDD.t98 24.0005
R363 VDD.n885 VDD.t106 24.0005
R364 VDD.n888 VDD.t101 24.0005
R365 VDD.n888 VDD.t103 24.0005
R366 VDD.t70 VDD.n1311 17.0005
R367 VDD.t69 VDD.n1326 17.0005
R368 VDD.t69 VDD.n1325 17.0005
R369 VDD.t69 VDD.n1324 17.0005
R370 VDD.t69 VDD.n1323 17.0005
R371 VDD.t69 VDD.n1322 17.0005
R372 VDD.t69 VDD.n1321 17.0005
R373 VDD.t69 VDD.n1320 17.0005
R374 VDD.n1327 VDD.t69 17.0005
R375 VDD.t69 VDD.n1319 17.0005
R376 VDD.t69 VDD.n1318 17.0005
R377 VDD.t69 VDD.n1317 17.0005
R378 VDD.t69 VDD.n1316 17.0005
R379 VDD.t69 VDD.n1315 17.0005
R380 VDD.t69 VDD.n1314 17.0005
R381 VDD.t70 VDD.n1313 17.0005
R382 VDD.t70 VDD.n1314 17.0005
R383 VDD.t70 VDD.n1315 17.0005
R384 VDD.t70 VDD.n1316 17.0005
R385 VDD.t70 VDD.n1317 17.0005
R386 VDD.t70 VDD.n1318 17.0005
R387 VDD.t70 VDD.n1320 17.0005
R388 VDD.t70 VDD.n1321 17.0005
R389 VDD.t70 VDD.n1322 17.0005
R390 VDD.t70 VDD.n1323 17.0005
R391 VDD.t70 VDD.n1324 17.0005
R392 VDD.t70 VDD.n1325 17.0005
R393 VDD.n1326 VDD.t70 17.0005
R394 VDD.t70 VDD.n1312 17.0005
R395 VDD.t69 VDD.n1313 17.0005
R396 VDD.t69 VDD.n1312 17.0005
R397 VDD.t69 VDD.n1311 17.0005
R398 VDD.n1191 VDD.t75 17.0005
R399 VDD.n1190 VDD.t7 17.0005
R400 VDD.n1189 VDD.t7 17.0005
R401 VDD.n1188 VDD.t7 17.0005
R402 VDD.n1187 VDD.t7 17.0005
R403 VDD.n1186 VDD.t7 17.0005
R404 VDD.n1185 VDD.t7 17.0005
R405 VDD.n1184 VDD.t7 17.0005
R406 VDD.n1213 VDD.t7 17.0005
R407 VDD.n1199 VDD.t7 17.0005
R408 VDD.n1192 VDD.t7 17.0005
R409 VDD.n1193 VDD.t7 17.0005
R410 VDD.n1194 VDD.t7 17.0005
R411 VDD.n1195 VDD.t7 17.0005
R412 VDD.n1196 VDD.t7 17.0005
R413 VDD.n1197 VDD.t75 17.0005
R414 VDD.n1196 VDD.t75 17.0005
R415 VDD.n1195 VDD.t75 17.0005
R416 VDD.n1194 VDD.t75 17.0005
R417 VDD.n1193 VDD.t75 17.0005
R418 VDD.n1192 VDD.t75 17.0005
R419 VDD.n1199 VDD.t75 17.0005
R420 VDD.n1213 VDD.t75 17.0005
R421 VDD.n1184 VDD.t75 17.0005
R422 VDD.n1185 VDD.t75 17.0005
R423 VDD.n1186 VDD.t75 17.0005
R424 VDD.n1187 VDD.t75 17.0005
R425 VDD.n1188 VDD.t75 17.0005
R426 VDD.n1189 VDD.t75 17.0005
R427 VDD.n1190 VDD.t75 17.0005
R428 VDD.n1198 VDD.t75 17.0005
R429 VDD.n1197 VDD.t7 17.0005
R430 VDD.n1198 VDD.t7 17.0005
R431 VDD.n1191 VDD.t7 17.0005
R432 VDD.n1161 VDD.t80 17.0005
R433 VDD.n1160 VDD.t79 17.0005
R434 VDD.n1159 VDD.t79 17.0005
R435 VDD.n1158 VDD.t79 17.0005
R436 VDD.n1157 VDD.t79 17.0005
R437 VDD.n1156 VDD.t79 17.0005
R438 VDD.n1155 VDD.t79 17.0005
R439 VDD.n1154 VDD.t79 17.0005
R440 VDD.n1171 VDD.t79 17.0005
R441 VDD.n1169 VDD.t79 17.0005
R442 VDD.n1162 VDD.t79 17.0005
R443 VDD.n1163 VDD.t79 17.0005
R444 VDD.n1164 VDD.t79 17.0005
R445 VDD.n1165 VDD.t79 17.0005
R446 VDD.n1166 VDD.t79 17.0005
R447 VDD.n1167 VDD.t80 17.0005
R448 VDD.n1166 VDD.t80 17.0005
R449 VDD.n1165 VDD.t80 17.0005
R450 VDD.n1164 VDD.t80 17.0005
R451 VDD.n1163 VDD.t80 17.0005
R452 VDD.n1162 VDD.t80 17.0005
R453 VDD.n1169 VDD.t80 17.0005
R454 VDD.n1171 VDD.t80 17.0005
R455 VDD.n1154 VDD.t80 17.0005
R456 VDD.n1155 VDD.t80 17.0005
R457 VDD.n1156 VDD.t80 17.0005
R458 VDD.n1157 VDD.t80 17.0005
R459 VDD.n1158 VDD.t80 17.0005
R460 VDD.n1159 VDD.t80 17.0005
R461 VDD.n1160 VDD.t80 17.0005
R462 VDD.n1168 VDD.t80 17.0005
R463 VDD.n1167 VDD.t79 17.0005
R464 VDD.n1168 VDD.t79 17.0005
R465 VDD.n1161 VDD.t79 17.0005
R466 VDD.n303 VDD.t85 17.0005
R467 VDD.n302 VDD.t41 17.0005
R468 VDD.n301 VDD.t41 17.0005
R469 VDD.n300 VDD.t41 17.0005
R470 VDD.n299 VDD.t41 17.0005
R471 VDD.n298 VDD.t41 17.0005
R472 VDD.n297 VDD.t41 17.0005
R473 VDD.n296 VDD.t41 17.0005
R474 VDD.n1134 VDD.t41 17.0005
R475 VDD.n311 VDD.t41 17.0005
R476 VDD.n304 VDD.t41 17.0005
R477 VDD.n305 VDD.t41 17.0005
R478 VDD.n306 VDD.t41 17.0005
R479 VDD.n307 VDD.t41 17.0005
R480 VDD.n308 VDD.t41 17.0005
R481 VDD.n309 VDD.t85 17.0005
R482 VDD.n308 VDD.t85 17.0005
R483 VDD.n307 VDD.t85 17.0005
R484 VDD.n306 VDD.t85 17.0005
R485 VDD.n305 VDD.t85 17.0005
R486 VDD.n304 VDD.t85 17.0005
R487 VDD.n311 VDD.t85 17.0005
R488 VDD.n1134 VDD.t85 17.0005
R489 VDD.n296 VDD.t85 17.0005
R490 VDD.n297 VDD.t85 17.0005
R491 VDD.n298 VDD.t85 17.0005
R492 VDD.n299 VDD.t85 17.0005
R493 VDD.n300 VDD.t85 17.0005
R494 VDD.n301 VDD.t85 17.0005
R495 VDD.n302 VDD.t85 17.0005
R496 VDD.n310 VDD.t85 17.0005
R497 VDD.n309 VDD.t41 17.0005
R498 VDD.n310 VDD.t41 17.0005
R499 VDD.n303 VDD.t41 17.0005
R500 VDD.t90 VDD.n335 17.0005
R501 VDD.n320 VDD.t89 17.0005
R502 VDD.n334 VDD.t89 17.0005
R503 VDD.n321 VDD.t89 17.0005
R504 VDD.n333 VDD.t89 17.0005
R505 VDD.n322 VDD.t89 17.0005
R506 VDD.n332 VDD.t89 17.0005
R507 VDD.n323 VDD.t89 17.0005
R508 VDD.n1125 VDD.t89 17.0005
R509 VDD.n324 VDD.t89 17.0005
R510 VDD.n331 VDD.t89 17.0005
R511 VDD.n325 VDD.t89 17.0005
R512 VDD.n330 VDD.t89 17.0005
R513 VDD.n326 VDD.t89 17.0005
R514 VDD.n329 VDD.t89 17.0005
R515 VDD.t90 VDD.n327 17.0005
R516 VDD.t90 VDD.n329 17.0005
R517 VDD.t90 VDD.n326 17.0005
R518 VDD.t90 VDD.n330 17.0005
R519 VDD.t90 VDD.n325 17.0005
R520 VDD.t90 VDD.n331 17.0005
R521 VDD.t90 VDD.n324 17.0005
R522 VDD.n1125 VDD.t90 17.0005
R523 VDD.t90 VDD.n323 17.0005
R524 VDD.t90 VDD.n332 17.0005
R525 VDD.t90 VDD.n322 17.0005
R526 VDD.t90 VDD.n333 17.0005
R527 VDD.t90 VDD.n321 17.0005
R528 VDD.t90 VDD.n334 17.0005
R529 VDD.t90 VDD.n320 17.0005
R530 VDD.t90 VDD.n328 17.0005
R531 VDD.n327 VDD.t89 17.0005
R532 VDD.n328 VDD.t89 17.0005
R533 VDD.n335 VDD.t89 17.0005
R534 VDD.t95 VDD.n1042 17.0005
R535 VDD.n1028 VDD.t94 17.0005
R536 VDD.n1041 VDD.t94 17.0005
R537 VDD.n1029 VDD.t94 17.0005
R538 VDD.n1040 VDD.t94 17.0005
R539 VDD.n1030 VDD.t94 17.0005
R540 VDD.n1039 VDD.t94 17.0005
R541 VDD.n1031 VDD.t94 17.0005
R542 VDD.n1044 VDD.t94 17.0005
R543 VDD.n1027 VDD.t94 17.0005
R544 VDD.n1038 VDD.t94 17.0005
R545 VDD.n1032 VDD.t94 17.0005
R546 VDD.n1037 VDD.t94 17.0005
R547 VDD.n1033 VDD.t94 17.0005
R548 VDD.n1036 VDD.t94 17.0005
R549 VDD.t95 VDD.n1034 17.0005
R550 VDD.t95 VDD.n1036 17.0005
R551 VDD.t95 VDD.n1033 17.0005
R552 VDD.t95 VDD.n1037 17.0005
R553 VDD.t95 VDD.n1032 17.0005
R554 VDD.t95 VDD.n1038 17.0005
R555 VDD.t95 VDD.n1031 17.0005
R556 VDD.t95 VDD.n1039 17.0005
R557 VDD.t95 VDD.n1030 17.0005
R558 VDD.t95 VDD.n1040 17.0005
R559 VDD.t95 VDD.n1029 17.0005
R560 VDD.t95 VDD.n1041 17.0005
R561 VDD.t95 VDD.n1028 17.0005
R562 VDD.t95 VDD.n1035 17.0005
R563 VDD.n1034 VDD.t94 17.0005
R564 VDD.n1035 VDD.t94 17.0005
R565 VDD.n1042 VDD.t94 17.0005
R566 VDD.n1343 VDD.n61 17.0005
R567 VDD.n1343 VDD.n59 17.0005
R568 VDD.n1343 VDD.n58 17.0005
R569 VDD.n1343 VDD.n57 17.0005
R570 VDD.n1343 VDD.n56 17.0005
R571 VDD.n1343 VDD.n55 17.0005
R572 VDD.n1343 VDD.n54 17.0005
R573 VDD.n1343 VDD.n53 17.0005
R574 VDD.n1343 VDD.n52 17.0005
R575 VDD.n1343 VDD.n51 17.0005
R576 VDD.n1343 VDD.n50 17.0005
R577 VDD.n1343 VDD.n49 17.0005
R578 VDD.n1343 VDD.n48 17.0005
R579 VDD.n1343 VDD.n47 17.0005
R580 VDD.n1343 VDD.n65 17.0005
R581 VDD.n1343 VDD.n66 17.0005
R582 VDD.n1343 VDD.n67 17.0005
R583 VDD.n1343 VDD.n68 17.0005
R584 VDD.n1343 VDD.n69 17.0005
R585 VDD.n1343 VDD.n70 17.0005
R586 VDD.n1343 VDD.n71 17.0005
R587 VDD.n1343 VDD.n72 17.0005
R588 VDD.n1343 VDD.n73 17.0005
R589 VDD.n1343 VDD.n74 17.0005
R590 VDD.n1343 VDD.n75 17.0005
R591 VDD.n1343 VDD.n76 17.0005
R592 VDD.n1343 VDD.n77 17.0005
R593 VDD.n1343 VDD.n79 17.0005
R594 VDD.n1343 VDD.n84 17.0005
R595 VDD.n1343 VDD.n85 17.0005
R596 VDD.n1343 VDD.n86 17.0005
R597 VDD.n1343 VDD.n87 17.0005
R598 VDD.n1343 VDD.n88 17.0005
R599 VDD.n1343 VDD.n89 17.0005
R600 VDD.n1343 VDD.n90 17.0005
R601 VDD.n1343 VDD.n91 17.0005
R602 VDD.n1343 VDD.n92 17.0005
R603 VDD.n1343 VDD.n93 17.0005
R604 VDD.n1343 VDD.n94 17.0005
R605 VDD.n1343 VDD.n95 17.0005
R606 VDD.n1343 VDD.n96 17.0005
R607 VDD.n1343 VDD.n98 17.0005
R608 VDD.n1343 VDD.n103 17.0005
R609 VDD.n1343 VDD.n104 17.0005
R610 VDD.n1343 VDD.n105 17.0005
R611 VDD.n1343 VDD.n106 17.0005
R612 VDD.n1343 VDD.n107 17.0005
R613 VDD.n1343 VDD.n108 17.0005
R614 VDD.n1343 VDD.n109 17.0005
R615 VDD.n1343 VDD.n110 17.0005
R616 VDD.n1343 VDD.n111 17.0005
R617 VDD.n1343 VDD.n112 17.0005
R618 VDD.n1343 VDD.n113 17.0005
R619 VDD.n1343 VDD.n114 17.0005
R620 VDD.n1343 VDD.n115 17.0005
R621 VDD.n1343 VDD.n117 17.0005
R622 VDD.n1343 VDD.n122 17.0005
R623 VDD.n1343 VDD.n123 17.0005
R624 VDD.n1343 VDD.n124 17.0005
R625 VDD.n1343 VDD.n125 17.0005
R626 VDD.n1343 VDD.n126 17.0005
R627 VDD.n1343 VDD.n127 17.0005
R628 VDD.n1343 VDD.n128 17.0005
R629 VDD.n1343 VDD.n129 17.0005
R630 VDD.n1343 VDD.n130 17.0005
R631 VDD.n1343 VDD.n131 17.0005
R632 VDD.n1343 VDD.n132 17.0005
R633 VDD.n1343 VDD.n133 17.0005
R634 VDD.n1343 VDD.n134 17.0005
R635 VDD.n1343 VDD.n136 17.0005
R636 VDD.n1343 VDD.n189 17.0005
R637 VDD.n1343 VDD.n188 17.0005
R638 VDD.n1343 VDD.n187 17.0005
R639 VDD.n1343 VDD.n186 17.0005
R640 VDD.n1343 VDD.n185 17.0005
R641 VDD.n1343 VDD.n184 17.0005
R642 VDD.n1343 VDD.n183 17.0005
R643 VDD.n1343 VDD.n182 17.0005
R644 VDD.n1343 VDD.n181 17.0005
R645 VDD.n1343 VDD.n180 17.0005
R646 VDD.n1343 VDD.n179 17.0005
R647 VDD.n1343 VDD.n178 17.0005
R648 VDD.n1343 VDD.n177 17.0005
R649 VDD.n1343 VDD.n175 17.0005
R650 VDD.n1343 VDD.n198 17.0005
R651 VDD.n1343 VDD.n199 17.0005
R652 VDD.n1343 VDD.n200 17.0005
R653 VDD.n1343 VDD.n201 17.0005
R654 VDD.n1343 VDD.n202 17.0005
R655 VDD.n1343 VDD.n203 17.0005
R656 VDD.n1343 VDD.n204 17.0005
R657 VDD.n1343 VDD.n205 17.0005
R658 VDD.n1343 VDD.n206 17.0005
R659 VDD.n1343 VDD.n207 17.0005
R660 VDD.n1343 VDD.n208 17.0005
R661 VDD.n1343 VDD.n209 17.0005
R662 VDD.n1343 VDD.n210 17.0005
R663 VDD.n1343 VDD.n212 17.0005
R664 VDD.n1343 VDD.n217 17.0005
R665 VDD.n1343 VDD.n218 17.0005
R666 VDD.n1343 VDD.n219 17.0005
R667 VDD.n1343 VDD.n220 17.0005
R668 VDD.n1343 VDD.n221 17.0005
R669 VDD.n1343 VDD.n222 17.0005
R670 VDD.n1343 VDD.n223 17.0005
R671 VDD.n1343 VDD.n224 17.0005
R672 VDD.n1343 VDD.n225 17.0005
R673 VDD.n1343 VDD.n226 17.0005
R674 VDD.n1343 VDD.n227 17.0005
R675 VDD.n1343 VDD.n228 17.0005
R676 VDD.n1343 VDD.n229 17.0005
R677 VDD.n1343 VDD.n231 17.0005
R678 VDD.n1343 VDD.n237 17.0005
R679 VDD.n1343 VDD.n238 17.0005
R680 VDD.n1343 VDD.n239 17.0005
R681 VDD.n1343 VDD.n240 17.0005
R682 VDD.n1343 VDD.n241 17.0005
R683 VDD.n1343 VDD.n242 17.0005
R684 VDD.n1343 VDD.n243 17.0005
R685 VDD.n1343 VDD.n244 17.0005
R686 VDD.n1343 VDD.n245 17.0005
R687 VDD.n1343 VDD.n246 17.0005
R688 VDD.n1343 VDD.n247 17.0005
R689 VDD.n1343 VDD.n248 17.0005
R690 VDD.n1343 VDD.n249 17.0005
R691 VDD.n1343 VDD.n251 17.0005
R692 VDD.t65 VDD.n1251 17.0005
R693 VDD.t8 VDD.n1287 17.0005
R694 VDD.t8 VDD.n1282 17.0005
R695 VDD.t8 VDD.n1281 17.0005
R696 VDD.t8 VDD.n1277 17.0005
R697 VDD.t8 VDD.n1276 17.0005
R698 VDD.t8 VDD.n1272 17.0005
R699 VDD.t8 VDD.n1271 17.0005
R700 VDD.n1288 VDD.t8 17.0005
R701 VDD.t8 VDD.n1270 17.0005
R702 VDD.t8 VDD.n1267 17.0005
R703 VDD.t8 VDD.n1263 17.0005
R704 VDD.t8 VDD.n1262 17.0005
R705 VDD.t8 VDD.n1258 17.0005
R706 VDD.t8 VDD.n1257 17.0005
R707 VDD.t65 VDD.n1253 17.0005
R708 VDD.t65 VDD.n1257 17.0005
R709 VDD.t65 VDD.n1258 17.0005
R710 VDD.t65 VDD.n1262 17.0005
R711 VDD.t65 VDD.n1263 17.0005
R712 VDD.t65 VDD.n1267 17.0005
R713 VDD.t65 VDD.n1271 17.0005
R714 VDD.t65 VDD.n1272 17.0005
R715 VDD.t65 VDD.n1276 17.0005
R716 VDD.t65 VDD.n1277 17.0005
R717 VDD.t65 VDD.n1281 17.0005
R718 VDD.t65 VDD.n1282 17.0005
R719 VDD.n1287 VDD.t65 17.0005
R720 VDD.t65 VDD.n1252 17.0005
R721 VDD.t8 VDD.n1253 17.0005
R722 VDD.t8 VDD.n1252 17.0005
R723 VDD.t8 VDD.n1251 17.0005
R724 VDD.n1343 VDD.n33 17.0005
R725 VDD.n1255 VDD.n1254 17.0005
R726 VDD.n1256 VDD.n1255 17.0005
R727 VDD.n1260 VDD.n1259 17.0005
R728 VDD.n1261 VDD.n1260 17.0005
R729 VDD.n1265 VDD.n1264 17.0005
R730 VDD.n1266 VDD.n1265 17.0005
R731 VDD.n1269 VDD.n1268 17.0005
R732 VDD.n1268 VDD.n1249 17.0005
R733 VDD.n1274 VDD.n1273 17.0005
R734 VDD.n1275 VDD.n1274 17.0005
R735 VDD.n1279 VDD.n1278 17.0005
R736 VDD.n1280 VDD.n1279 17.0005
R737 VDD.n1285 VDD.n1284 17.0005
R738 VDD.n1286 VDD.n1285 17.0005
R739 VDD.n1343 VDD.n32 17.0005
R740 VDD.n818 VDD.t120 17.0005
R741 VDD.n816 VDD.t119 17.0005
R742 VDD.n814 VDD.t119 17.0005
R743 VDD.n812 VDD.t119 17.0005
R744 VDD.n810 VDD.t119 17.0005
R745 VDD.n808 VDD.t119 17.0005
R746 VDD.n806 VDD.t119 17.0005
R747 VDD.n804 VDD.t119 17.0005
R748 VDD.n837 VDD.t119 17.0005
R749 VDD.n819 VDD.t119 17.0005
R750 VDD.n821 VDD.t119 17.0005
R751 VDD.n823 VDD.t119 17.0005
R752 VDD.n825 VDD.t119 17.0005
R753 VDD.n827 VDD.t119 17.0005
R754 VDD.n829 VDD.t119 17.0005
R755 VDD.n831 VDD.t120 17.0005
R756 VDD.n829 VDD.t120 17.0005
R757 VDD.n827 VDD.t120 17.0005
R758 VDD.n825 VDD.t120 17.0005
R759 VDD.n823 VDD.t120 17.0005
R760 VDD.n821 VDD.t120 17.0005
R761 VDD.n819 VDD.t120 17.0005
R762 VDD.n837 VDD.t120 17.0005
R763 VDD.n804 VDD.t120 17.0005
R764 VDD.n806 VDD.t120 17.0005
R765 VDD.n808 VDD.t120 17.0005
R766 VDD.n810 VDD.t120 17.0005
R767 VDD.n812 VDD.t120 17.0005
R768 VDD.n814 VDD.t120 17.0005
R769 VDD.n816 VDD.t120 17.0005
R770 VDD.n832 VDD.t120 17.0005
R771 VDD.n831 VDD.t119 17.0005
R772 VDD.n832 VDD.t119 17.0005
R773 VDD.n818 VDD.t119 17.0005
R774 VDD.n752 VDD.t125 17.0005
R775 VDD.n750 VDD.t124 17.0005
R776 VDD.n748 VDD.t124 17.0005
R777 VDD.n746 VDD.t124 17.0005
R778 VDD.n744 VDD.t124 17.0005
R779 VDD.n742 VDD.t124 17.0005
R780 VDD.n740 VDD.t124 17.0005
R781 VDD.n738 VDD.t124 17.0005
R782 VDD.n771 VDD.t124 17.0005
R783 VDD.n753 VDD.t124 17.0005
R784 VDD.n755 VDD.t124 17.0005
R785 VDD.n757 VDD.t124 17.0005
R786 VDD.n759 VDD.t124 17.0005
R787 VDD.n761 VDD.t124 17.0005
R788 VDD.n763 VDD.t124 17.0005
R789 VDD.n765 VDD.t125 17.0005
R790 VDD.n763 VDD.t125 17.0005
R791 VDD.n761 VDD.t125 17.0005
R792 VDD.n759 VDD.t125 17.0005
R793 VDD.n757 VDD.t125 17.0005
R794 VDD.n755 VDD.t125 17.0005
R795 VDD.n753 VDD.t125 17.0005
R796 VDD.n771 VDD.t125 17.0005
R797 VDD.n738 VDD.t125 17.0005
R798 VDD.n740 VDD.t125 17.0005
R799 VDD.n742 VDD.t125 17.0005
R800 VDD.n744 VDD.t125 17.0005
R801 VDD.n746 VDD.t125 17.0005
R802 VDD.n748 VDD.t125 17.0005
R803 VDD.n750 VDD.t125 17.0005
R804 VDD.n766 VDD.t125 17.0005
R805 VDD.n765 VDD.t124 17.0005
R806 VDD.n766 VDD.t124 17.0005
R807 VDD.n752 VDD.t124 17.0005
R808 VDD.n673 VDD.t130 17.0005
R809 VDD.n671 VDD.t129 17.0005
R810 VDD.n669 VDD.t129 17.0005
R811 VDD.n667 VDD.t129 17.0005
R812 VDD.n665 VDD.t129 17.0005
R813 VDD.n663 VDD.t129 17.0005
R814 VDD.n661 VDD.t129 17.0005
R815 VDD.n659 VDD.t129 17.0005
R816 VDD.n720 VDD.t129 17.0005
R817 VDD.n674 VDD.t129 17.0005
R818 VDD.n676 VDD.t129 17.0005
R819 VDD.n678 VDD.t129 17.0005
R820 VDD.n680 VDD.t129 17.0005
R821 VDD.n682 VDD.t129 17.0005
R822 VDD.n684 VDD.t129 17.0005
R823 VDD.n686 VDD.t130 17.0005
R824 VDD.n684 VDD.t130 17.0005
R825 VDD.n682 VDD.t130 17.0005
R826 VDD.n680 VDD.t130 17.0005
R827 VDD.n678 VDD.t130 17.0005
R828 VDD.n676 VDD.t130 17.0005
R829 VDD.n674 VDD.t130 17.0005
R830 VDD.n720 VDD.t130 17.0005
R831 VDD.n659 VDD.t130 17.0005
R832 VDD.n661 VDD.t130 17.0005
R833 VDD.n663 VDD.t130 17.0005
R834 VDD.n665 VDD.t130 17.0005
R835 VDD.n667 VDD.t130 17.0005
R836 VDD.n669 VDD.t130 17.0005
R837 VDD.n671 VDD.t130 17.0005
R838 VDD.n687 VDD.t130 17.0005
R839 VDD.n686 VDD.t129 17.0005
R840 VDD.n687 VDD.t129 17.0005
R841 VDD.n673 VDD.t129 17.0005
R842 VDD.n621 VDD.t135 17.0005
R843 VDD.n619 VDD.t134 17.0005
R844 VDD.n617 VDD.t134 17.0005
R845 VDD.n615 VDD.t134 17.0005
R846 VDD.n613 VDD.t134 17.0005
R847 VDD.n611 VDD.t134 17.0005
R848 VDD.n609 VDD.t134 17.0005
R849 VDD.n607 VDD.t134 17.0005
R850 VDD.n640 VDD.t134 17.0005
R851 VDD.n622 VDD.t134 17.0005
R852 VDD.n624 VDD.t134 17.0005
R853 VDD.n626 VDD.t134 17.0005
R854 VDD.n628 VDD.t134 17.0005
R855 VDD.n630 VDD.t134 17.0005
R856 VDD.n632 VDD.t134 17.0005
R857 VDD.n634 VDD.t135 17.0005
R858 VDD.n632 VDD.t135 17.0005
R859 VDD.n630 VDD.t135 17.0005
R860 VDD.n628 VDD.t135 17.0005
R861 VDD.n626 VDD.t135 17.0005
R862 VDD.n624 VDD.t135 17.0005
R863 VDD.n622 VDD.t135 17.0005
R864 VDD.n640 VDD.t135 17.0005
R865 VDD.n607 VDD.t135 17.0005
R866 VDD.n609 VDD.t135 17.0005
R867 VDD.n611 VDD.t135 17.0005
R868 VDD.n613 VDD.t135 17.0005
R869 VDD.n615 VDD.t135 17.0005
R870 VDD.n617 VDD.t135 17.0005
R871 VDD.n619 VDD.t135 17.0005
R872 VDD.n635 VDD.t135 17.0005
R873 VDD.n634 VDD.t134 17.0005
R874 VDD.n635 VDD.t134 17.0005
R875 VDD.n621 VDD.t134 17.0005
R876 VDD.t140 VDD.n982 17.0005
R877 VDD.t139 VDD.n1011 17.0005
R878 VDD.t139 VDD.n1008 17.0005
R879 VDD.t139 VDD.n1006 17.0005
R880 VDD.t139 VDD.n1004 17.0005
R881 VDD.t139 VDD.n1002 17.0005
R882 VDD.t139 VDD.n1000 17.0005
R883 VDD.t139 VDD.n998 17.0005
R884 VDD.n1012 VDD.t139 17.0005
R885 VDD.t139 VDD.n997 17.0005
R886 VDD.t139 VDD.n995 17.0005
R887 VDD.t139 VDD.n993 17.0005
R888 VDD.t139 VDD.n991 17.0005
R889 VDD.t139 VDD.n989 17.0005
R890 VDD.t139 VDD.n987 17.0005
R891 VDD.t140 VDD.n985 17.0005
R892 VDD.t140 VDD.n987 17.0005
R893 VDD.t140 VDD.n989 17.0005
R894 VDD.t140 VDD.n991 17.0005
R895 VDD.t140 VDD.n993 17.0005
R896 VDD.t140 VDD.n995 17.0005
R897 VDD.t140 VDD.n997 17.0005
R898 VDD.t140 VDD.n1000 17.0005
R899 VDD.t140 VDD.n1002 17.0005
R900 VDD.t140 VDD.n1004 17.0005
R901 VDD.t140 VDD.n1006 17.0005
R902 VDD.t140 VDD.n1008 17.0005
R903 VDD.n1011 VDD.t140 17.0005
R904 VDD.t140 VDD.n983 17.0005
R905 VDD.t139 VDD.n985 17.0005
R906 VDD.t139 VDD.n983 17.0005
R907 VDD.t139 VDD.n982 17.0005
R908 VDD.n359 VDD.n350 17.0005
R909 VDD.n361 VDD.n350 17.0005
R910 VDD.n363 VDD.n350 17.0005
R911 VDD.n365 VDD.n350 17.0005
R912 VDD.n367 VDD.n350 17.0005
R913 VDD.n368 VDD.n350 17.0005
R914 VDD.n381 VDD.n350 17.0005
R915 VDD.n371 VDD.n350 17.0005
R916 VDD.n373 VDD.n350 17.0005
R917 VDD.n375 VDD.n350 17.0005
R918 VDD.n377 VDD.n350 17.0005
R919 VDD.n379 VDD.n350 17.0005
R920 VDD.n411 VDD.n350 17.0005
R921 VDD.n407 VDD.n350 17.0005
R922 VDD.n352 VDD.n350 17.0005
R923 VDD.n986 VDD.n350 17.0005
R924 VDD.n988 VDD.n350 17.0005
R925 VDD.n990 VDD.n350 17.0005
R926 VDD.n992 VDD.n350 17.0005
R927 VDD.n994 VDD.n350 17.0005
R928 VDD.n996 VDD.n350 17.0005
R929 VDD.n354 VDD.n350 17.0005
R930 VDD.n999 VDD.n350 17.0005
R931 VDD.n1001 VDD.n350 17.0005
R932 VDD.n1003 VDD.n350 17.0005
R933 VDD.n1005 VDD.n350 17.0005
R934 VDD.n1007 VDD.n350 17.0005
R935 VDD.n1010 VDD.n350 17.0005
R936 VDD.n593 VDD.n350 17.0005
R937 VDD.n589 VDD.n350 17.0005
R938 VDD.n587 VDD.n350 17.0005
R939 VDD.n585 VDD.n350 17.0005
R940 VDD.n583 VDD.n350 17.0005
R941 VDD.n581 VDD.n350 17.0005
R942 VDD.n579 VDD.n350 17.0005
R943 VDD.n577 VDD.n350 17.0005
R944 VDD.n574 VDD.n350 17.0005
R945 VDD.n572 VDD.n350 17.0005
R946 VDD.n570 VDD.n350 17.0005
R947 VDD.n568 VDD.n350 17.0005
R948 VDD.n566 VDD.n350 17.0005
R949 VDD.n564 VDD.n350 17.0005
R950 VDD.n636 VDD.n350 17.0005
R951 VDD.n633 VDD.n350 17.0005
R952 VDD.n631 VDD.n350 17.0005
R953 VDD.n629 VDD.n350 17.0005
R954 VDD.n627 VDD.n350 17.0005
R955 VDD.n625 VDD.n350 17.0005
R956 VDD.n623 VDD.n350 17.0005
R957 VDD.n605 VDD.n350 17.0005
R958 VDD.n608 VDD.n350 17.0005
R959 VDD.n610 VDD.n350 17.0005
R960 VDD.n612 VDD.n350 17.0005
R961 VDD.n614 VDD.n350 17.0005
R962 VDD.n616 VDD.n350 17.0005
R963 VDD.n618 VDD.n350 17.0005
R964 VDD.n688 VDD.n350 17.0005
R965 VDD.n685 VDD.n350 17.0005
R966 VDD.n683 VDD.n350 17.0005
R967 VDD.n681 VDD.n350 17.0005
R968 VDD.n679 VDD.n350 17.0005
R969 VDD.n677 VDD.n350 17.0005
R970 VDD.n675 VDD.n350 17.0005
R971 VDD.n657 VDD.n350 17.0005
R972 VDD.n660 VDD.n350 17.0005
R973 VDD.n662 VDD.n350 17.0005
R974 VDD.n664 VDD.n350 17.0005
R975 VDD.n666 VDD.n350 17.0005
R976 VDD.n668 VDD.n350 17.0005
R977 VDD.n670 VDD.n350 17.0005
R978 VDD.n767 VDD.n350 17.0005
R979 VDD.n764 VDD.n350 17.0005
R980 VDD.n762 VDD.n350 17.0005
R981 VDD.n760 VDD.n350 17.0005
R982 VDD.n758 VDD.n350 17.0005
R983 VDD.n756 VDD.n350 17.0005
R984 VDD.n754 VDD.n350 17.0005
R985 VDD.n736 VDD.n350 17.0005
R986 VDD.n739 VDD.n350 17.0005
R987 VDD.n741 VDD.n350 17.0005
R988 VDD.n743 VDD.n350 17.0005
R989 VDD.n745 VDD.n350 17.0005
R990 VDD.n747 VDD.n350 17.0005
R991 VDD.n749 VDD.n350 17.0005
R992 VDD.n833 VDD.n350 17.0005
R993 VDD.n830 VDD.n350 17.0005
R994 VDD.n828 VDD.n350 17.0005
R995 VDD.n826 VDD.n350 17.0005
R996 VDD.n824 VDD.n350 17.0005
R997 VDD.n822 VDD.n350 17.0005
R998 VDD.n820 VDD.n350 17.0005
R999 VDD.n802 VDD.n350 17.0005
R1000 VDD.n805 VDD.n350 17.0005
R1001 VDD.n807 VDD.n350 17.0005
R1002 VDD.n809 VDD.n350 17.0005
R1003 VDD.n811 VDD.n350 17.0005
R1004 VDD.n813 VDD.n350 17.0005
R1005 VDD.n815 VDD.n350 17.0005
R1006 VDD.n956 VDD.n479 17.0005
R1007 VDD.n956 VDD.n481 17.0005
R1008 VDD.n956 VDD.n482 17.0005
R1009 VDD.n956 VDD.n483 17.0005
R1010 VDD.n956 VDD.n484 17.0005
R1011 VDD.n956 VDD.n485 17.0005
R1012 VDD.n956 VDD.n486 17.0005
R1013 VDD.n956 VDD.n487 17.0005
R1014 VDD.n956 VDD.n488 17.0005
R1015 VDD.n956 VDD.n489 17.0005
R1016 VDD.n956 VDD.n490 17.0005
R1017 VDD.n956 VDD.n491 17.0005
R1018 VDD.n956 VDD.n492 17.0005
R1019 VDD.n956 VDD.n493 17.0005
R1020 VDD.t110 VDD.n860 17.0005
R1021 VDD.t109 VDD.n875 17.0005
R1022 VDD.t109 VDD.n874 17.0005
R1023 VDD.t109 VDD.n873 17.0005
R1024 VDD.t109 VDD.n872 17.0005
R1025 VDD.t109 VDD.n871 17.0005
R1026 VDD.t109 VDD.n870 17.0005
R1027 VDD.t109 VDD.n869 17.0005
R1028 VDD.n876 VDD.t109 17.0005
R1029 VDD.t109 VDD.n868 17.0005
R1030 VDD.t109 VDD.n867 17.0005
R1031 VDD.t109 VDD.n866 17.0005
R1032 VDD.t109 VDD.n865 17.0005
R1033 VDD.t109 VDD.n864 17.0005
R1034 VDD.t109 VDD.n863 17.0005
R1035 VDD.t110 VDD.n862 17.0005
R1036 VDD.t110 VDD.n863 17.0005
R1037 VDD.t110 VDD.n864 17.0005
R1038 VDD.t110 VDD.n865 17.0005
R1039 VDD.t110 VDD.n866 17.0005
R1040 VDD.t110 VDD.n867 17.0005
R1041 VDD.t110 VDD.n868 17.0005
R1042 VDD.t110 VDD.n870 17.0005
R1043 VDD.t110 VDD.n871 17.0005
R1044 VDD.t110 VDD.n872 17.0005
R1045 VDD.t110 VDD.n873 17.0005
R1046 VDD.t110 VDD.n874 17.0005
R1047 VDD.n875 VDD.t110 17.0005
R1048 VDD.t110 VDD.n861 17.0005
R1049 VDD.t109 VDD.n862 17.0005
R1050 VDD.t109 VDD.n861 17.0005
R1051 VDD.t109 VDD.n860 17.0005
R1052 VDD.n956 VDD.n503 17.0005
R1053 VDD.n956 VDD.n505 17.0005
R1054 VDD.n956 VDD.n506 17.0005
R1055 VDD.n956 VDD.n507 17.0005
R1056 VDD.n956 VDD.n508 17.0005
R1057 VDD.n956 VDD.n509 17.0005
R1058 VDD.n956 VDD.n510 17.0005
R1059 VDD.n956 VDD.n511 17.0005
R1060 VDD.n956 VDD.n512 17.0005
R1061 VDD.n956 VDD.n513 17.0005
R1062 VDD.n956 VDD.n514 17.0005
R1063 VDD.n956 VDD.n515 17.0005
R1064 VDD.n956 VDD.n516 17.0005
R1065 VDD.n956 VDD.n517 17.0005
R1066 VDD.n420 VDD.n350 17.0005
R1067 VDD.n966 VDD.t115 17.0005
R1068 VDD.t47 VDD.n965 17.0005
R1069 VDD.t47 VDD.n437 17.0005
R1070 VDD.t47 VDD.n436 17.0005
R1071 VDD.t47 VDD.n435 17.0005
R1072 VDD.t47 VDD.n434 17.0005
R1073 VDD.t47 VDD.n433 17.0005
R1074 VDD.t47 VDD.n432 17.0005
R1075 VDD.t47 VDD.n430 17.0005
R1076 VDD.t47 VDD.n429 17.0005
R1077 VDD.t47 VDD.n428 17.0005
R1078 VDD.t47 VDD.n427 17.0005
R1079 VDD.t47 VDD.n426 17.0005
R1080 VDD.t47 VDD.n425 17.0005
R1081 VDD.t47 VDD.n424 17.0005
R1082 VDD.n423 VDD.t115 17.0005
R1083 VDD.n424 VDD.t115 17.0005
R1084 VDD.n425 VDD.t115 17.0005
R1085 VDD.n426 VDD.t115 17.0005
R1086 VDD.n427 VDD.t115 17.0005
R1087 VDD.n428 VDD.t115 17.0005
R1088 VDD.n429 VDD.t115 17.0005
R1089 VDD.n433 VDD.t115 17.0005
R1090 VDD.n434 VDD.t115 17.0005
R1091 VDD.n435 VDD.t115 17.0005
R1092 VDD.n436 VDD.t115 17.0005
R1093 VDD.n437 VDD.t115 17.0005
R1094 VDD.n965 VDD.t115 17.0005
R1095 VDD.n422 VDD.t115 17.0005
R1096 VDD.t47 VDD.n423 17.0005
R1097 VDD.t47 VDD.n422 17.0005
R1098 VDD.n966 VDD.t47 17.0005
R1099 VDD.n474 VDD.n473 17.0005
R1100 VDD.n473 VDD.n472 17.0005
R1101 VDD.n471 VDD.n470 17.0005
R1102 VDD.n470 VDD.n469 17.0005
R1103 VDD.n462 VDD.n460 17.0005
R1104 VDD.n462 VDD.n461 17.0005
R1105 VDD.n458 VDD.n456 17.0005
R1106 VDD.n458 VDD.n457 17.0005
R1107 VDD.n454 VDD.n452 17.0005
R1108 VDD.n454 VDD.n453 17.0005
R1109 VDD.n450 VDD.n448 17.0005
R1110 VDD.n450 VDD.n449 17.0005
R1111 VDD.n446 VDD.n444 17.0005
R1112 VDD.n446 VDD.n445 17.0005
R1113 VDD.n963 VDD.n438 17.0005
R1114 VDD.n964 VDD.n963 17.0005
R1115 VDD.n1351 VDD.t289 10.8541
R1116 VDD.n1350 VDD.t288 10.8541
R1117 VDD.n1349 VDD.t287 10.8541
R1118 VDD.n1348 VDD.t286 10.8541
R1119 VDD.n893 VDD.t46 10.8541
R1120 VDD.n892 VDD.t3 10.8541
R1121 VDD.n891 VDD.t5 10.8541
R1122 VDD.n890 VDD.t4 10.8541
R1123 VDD.n1233 VDD.n1232 8.50175
R1124 VDD.n1063 VDD.n1062 8.50175
R1125 VDD.n1098 VDD.n1097 8.50175
R1126 VDD.n951 VDD.n950 8.50175
R1127 VDD.n410 VDD.n357 8.50175
R1128 VDD.n591 VDD.n590 8.50175
R1129 VDD.n1098 VDD.n1096 8.501
R1130 VDD.n1063 VDD.n1061 8.501
R1131 VDD.n1233 VDD.n1231 8.501
R1132 VDD.t6 VDD.n29 8.501
R1133 VDD.t6 VDD.n28 8.501
R1134 VDD.t6 VDD.n27 8.501
R1135 VDD.t6 VDD.n26 8.501
R1136 VDD.t6 VDD.n25 8.501
R1137 VDD.t6 VDD.n24 8.501
R1138 VDD.t6 VDD.n23 8.501
R1139 VDD.n592 VDD.n591 8.501
R1140 VDD.n408 VDD.n357 8.501
R1141 VDD.n952 VDD.n951 8.501
R1142 VDD.t0 VDD.n443 8.501
R1143 VDD.t0 VDD.n465 8.501
R1144 VDD.t0 VDD.n464 8.501
R1145 VDD.t0 VDD.n463 8.501
R1146 VDD.t0 VDD.n459 8.501
R1147 VDD.t0 VDD.n455 8.501
R1148 VDD.t0 VDD.n451 8.501
R1149 VDD.t0 VDD.n447 8.501
R1150 VDD.t0 VDD.n439 8.501
R1151 VDD.n962 VDD.t0 8.501
R1152 VDD.t0 VDD.n442 8.501
R1153 VDD.t0 VDD.n441 8.501
R1154 VDD.t72 VDD.n1191 8.5005
R1155 VDD.t72 VDD.n1197 8.5005
R1156 VDD.t72 VDD.n1196 8.5005
R1157 VDD.t72 VDD.n1195 8.5005
R1158 VDD.t72 VDD.n1194 8.5005
R1159 VDD.t72 VDD.n1193 8.5005
R1160 VDD.t72 VDD.n1192 8.5005
R1161 VDD.t72 VDD.n1190 8.5005
R1162 VDD.t72 VDD.n1189 8.5005
R1163 VDD.t72 VDD.n1188 8.5005
R1164 VDD.t72 VDD.n1187 8.5005
R1165 VDD.t72 VDD.n1186 8.5005
R1166 VDD.t72 VDD.n1185 8.5005
R1167 VDD.t72 VDD.n1184 8.5005
R1168 VDD.t72 VDD.n1198 8.5005
R1169 VDD.t36 VDD.n1161 8.5005
R1170 VDD.t36 VDD.n1167 8.5005
R1171 VDD.t36 VDD.n1166 8.5005
R1172 VDD.t36 VDD.n1165 8.5005
R1173 VDD.t36 VDD.n1164 8.5005
R1174 VDD.t36 VDD.n1163 8.5005
R1175 VDD.t36 VDD.n1162 8.5005
R1176 VDD.t36 VDD.n1160 8.5005
R1177 VDD.t36 VDD.n1159 8.5005
R1178 VDD.t36 VDD.n1158 8.5005
R1179 VDD.t36 VDD.n1157 8.5005
R1180 VDD.t36 VDD.n1156 8.5005
R1181 VDD.t36 VDD.n1155 8.5005
R1182 VDD.t36 VDD.n1154 8.5005
R1183 VDD.t36 VDD.n1168 8.5005
R1184 VDD.t82 VDD.n303 8.5005
R1185 VDD.t82 VDD.n309 8.5005
R1186 VDD.t82 VDD.n308 8.5005
R1187 VDD.t82 VDD.n307 8.5005
R1188 VDD.t82 VDD.n306 8.5005
R1189 VDD.t82 VDD.n305 8.5005
R1190 VDD.t82 VDD.n304 8.5005
R1191 VDD.t82 VDD.n302 8.5005
R1192 VDD.t82 VDD.n301 8.5005
R1193 VDD.t82 VDD.n300 8.5005
R1194 VDD.t82 VDD.n299 8.5005
R1195 VDD.t82 VDD.n298 8.5005
R1196 VDD.t82 VDD.n297 8.5005
R1197 VDD.t82 VDD.n296 8.5005
R1198 VDD.t82 VDD.n310 8.5005
R1199 VDD.n335 VDD.t45 8.5005
R1200 VDD.t45 VDD.n327 8.5005
R1201 VDD.t45 VDD.n329 8.5005
R1202 VDD.t45 VDD.n326 8.5005
R1203 VDD.t45 VDD.n330 8.5005
R1204 VDD.t45 VDD.n325 8.5005
R1205 VDD.t45 VDD.n331 8.5005
R1206 VDD.t45 VDD.n320 8.5005
R1207 VDD.t45 VDD.n334 8.5005
R1208 VDD.t45 VDD.n321 8.5005
R1209 VDD.t45 VDD.n333 8.5005
R1210 VDD.t45 VDD.n322 8.5005
R1211 VDD.t45 VDD.n332 8.5005
R1212 VDD.t45 VDD.n323 8.5005
R1213 VDD.t45 VDD.n328 8.5005
R1214 VDD.t92 VDD.n1110 8.5005
R1215 VDD.t92 VDD.n1109 8.5005
R1216 VDD.t92 VDD.n1108 8.5005
R1217 VDD.t92 VDD.n1107 8.5005
R1218 VDD.t92 VDD.n1106 8.5005
R1219 VDD.t92 VDD.n1105 8.5005
R1220 VDD.t92 VDD.n1104 8.5005
R1221 VDD.t92 VDD.n1103 8.5005
R1222 VDD.t92 VDD.n1102 8.5005
R1223 VDD.t92 VDD.n1101 8.5005
R1224 VDD.t92 VDD.n1100 8.5005
R1225 VDD.t92 VDD.n1099 8.5005
R1226 VDD.t92 VDD.n1111 8.5005
R1227 VDD.t97 VDD.n1075 8.5005
R1228 VDD.t97 VDD.n1074 8.5005
R1229 VDD.t97 VDD.n1073 8.5005
R1230 VDD.t97 VDD.n1072 8.5005
R1231 VDD.t97 VDD.n1071 8.5005
R1232 VDD.t97 VDD.n1070 8.5005
R1233 VDD.t97 VDD.n1069 8.5005
R1234 VDD.t97 VDD.n1068 8.5005
R1235 VDD.t97 VDD.n1067 8.5005
R1236 VDD.t97 VDD.n1066 8.5005
R1237 VDD.t97 VDD.n1065 8.5005
R1238 VDD.t97 VDD.n1064 8.5005
R1239 VDD.t97 VDD.n1076 8.5005
R1240 VDD.t17 VDD.n1230 8.5005
R1241 VDD.t17 VDD.n1229 8.5005
R1242 VDD.t17 VDD.n1228 8.5005
R1243 VDD.t17 VDD.n1227 8.5005
R1244 VDD.t17 VDD.n1226 8.5005
R1245 VDD.t17 VDD.n1225 8.5005
R1246 VDD.t17 VDD.n1224 8.5005
R1247 VDD.t17 VDD.n1223 8.5005
R1248 VDD.t17 VDD.n1222 8.5005
R1249 VDD.t17 VDD.n1221 8.5005
R1250 VDD.t17 VDD.n1220 8.5005
R1251 VDD.t17 VDD.n1219 8.5005
R1252 VDD.t17 VDD.n1234 8.5005
R1253 VDD.t52 VDD.n818 8.5005
R1254 VDD.t52 VDD.n831 8.5005
R1255 VDD.t52 VDD.n829 8.5005
R1256 VDD.t52 VDD.n827 8.5005
R1257 VDD.t52 VDD.n825 8.5005
R1258 VDD.t52 VDD.n823 8.5005
R1259 VDD.t52 VDD.n821 8.5005
R1260 VDD.t52 VDD.n819 8.5005
R1261 VDD.t52 VDD.n816 8.5005
R1262 VDD.t52 VDD.n814 8.5005
R1263 VDD.t52 VDD.n812 8.5005
R1264 VDD.t52 VDD.n810 8.5005
R1265 VDD.t52 VDD.n808 8.5005
R1266 VDD.t52 VDD.n806 8.5005
R1267 VDD.n832 VDD.t52 8.5005
R1268 VDD.t122 VDD.n752 8.5005
R1269 VDD.t122 VDD.n765 8.5005
R1270 VDD.t122 VDD.n763 8.5005
R1271 VDD.t122 VDD.n761 8.5005
R1272 VDD.t122 VDD.n759 8.5005
R1273 VDD.t122 VDD.n757 8.5005
R1274 VDD.t122 VDD.n755 8.5005
R1275 VDD.t122 VDD.n753 8.5005
R1276 VDD.t122 VDD.n750 8.5005
R1277 VDD.t122 VDD.n748 8.5005
R1278 VDD.t122 VDD.n746 8.5005
R1279 VDD.t122 VDD.n744 8.5005
R1280 VDD.t122 VDD.n742 8.5005
R1281 VDD.t122 VDD.n740 8.5005
R1282 VDD.n766 VDD.t122 8.5005
R1283 VDD.t127 VDD.n673 8.5005
R1284 VDD.t127 VDD.n686 8.5005
R1285 VDD.t127 VDD.n684 8.5005
R1286 VDD.t127 VDD.n682 8.5005
R1287 VDD.t127 VDD.n680 8.5005
R1288 VDD.t127 VDD.n678 8.5005
R1289 VDD.t127 VDD.n676 8.5005
R1290 VDD.t127 VDD.n674 8.5005
R1291 VDD.t127 VDD.n671 8.5005
R1292 VDD.t127 VDD.n669 8.5005
R1293 VDD.t127 VDD.n667 8.5005
R1294 VDD.t127 VDD.n665 8.5005
R1295 VDD.t127 VDD.n663 8.5005
R1296 VDD.t127 VDD.n661 8.5005
R1297 VDD.n687 VDD.t127 8.5005
R1298 VDD.t132 VDD.n621 8.5005
R1299 VDD.t132 VDD.n634 8.5005
R1300 VDD.t132 VDD.n632 8.5005
R1301 VDD.t132 VDD.n630 8.5005
R1302 VDD.t132 VDD.n628 8.5005
R1303 VDD.t132 VDD.n626 8.5005
R1304 VDD.t132 VDD.n624 8.5005
R1305 VDD.t132 VDD.n622 8.5005
R1306 VDD.t132 VDD.n619 8.5005
R1307 VDD.t132 VDD.n617 8.5005
R1308 VDD.t132 VDD.n615 8.5005
R1309 VDD.t132 VDD.n613 8.5005
R1310 VDD.t132 VDD.n611 8.5005
R1311 VDD.t132 VDD.n609 8.5005
R1312 VDD.n635 VDD.t132 8.5005
R1313 VDD.n588 VDD.t137 8.5005
R1314 VDD.n586 VDD.t137 8.5005
R1315 VDD.n584 VDD.t137 8.5005
R1316 VDD.n582 VDD.t137 8.5005
R1317 VDD.n580 VDD.t137 8.5005
R1318 VDD.n578 VDD.t137 8.5005
R1319 VDD.n573 VDD.t137 8.5005
R1320 VDD.n571 VDD.t137 8.5005
R1321 VDD.n569 VDD.t137 8.5005
R1322 VDD.n567 VDD.t137 8.5005
R1323 VDD.n565 VDD.t137 8.5005
R1324 VDD.n563 VDD.t137 8.5005
R1325 VDD.n561 VDD.t137 8.5005
R1326 VDD.t142 VDD.n412 8.5005
R1327 VDD.t142 VDD.n378 8.5005
R1328 VDD.t142 VDD.n376 8.5005
R1329 VDD.t142 VDD.n374 8.5005
R1330 VDD.t142 VDD.n372 8.5005
R1331 VDD.t142 VDD.n370 8.5005
R1332 VDD.t142 VDD.n369 8.5005
R1333 VDD.t142 VDD.n366 8.5005
R1334 VDD.t142 VDD.n364 8.5005
R1335 VDD.t142 VDD.n362 8.5005
R1336 VDD.t142 VDD.n360 8.5005
R1337 VDD.t142 VDD.n358 8.5005
R1338 VDD.n413 VDD.t142 8.5005
R1339 VDD.t112 VDD.n948 8.5005
R1340 VDD.t112 VDD.n947 8.5005
R1341 VDD.t112 VDD.n946 8.5005
R1342 VDD.t112 VDD.n945 8.5005
R1343 VDD.t112 VDD.n944 8.5005
R1344 VDD.t112 VDD.n943 8.5005
R1345 VDD.t112 VDD.n942 8.5005
R1346 VDD.t112 VDD.n941 8.5005
R1347 VDD.t112 VDD.n940 8.5005
R1348 VDD.t112 VDD.n939 8.5005
R1349 VDD.t112 VDD.n938 8.5005
R1350 VDD.t112 VDD.n937 8.5005
R1351 VDD.t112 VDD.n949 8.5005
R1352 VDD.n959 VDD.n958 8.5005
R1353 VDD.n960 VDD.n959 8.5005
R1354 VDD.n959 VDD.n350 8.5005
R1355 VDD.n1343 VDD.n102 8.49913
R1356 VDD.n1343 VDD.n116 8.49913
R1357 VDD.n1343 VDD.n121 8.49913
R1358 VDD.n1343 VDD.n135 8.49913
R1359 VDD.n1343 VDD.n190 8.49913
R1360 VDD.n1343 VDD.n176 8.49913
R1361 VDD.n1343 VDD.n197 8.49913
R1362 VDD.n1343 VDD.n211 8.49913
R1363 VDD.n606 VDD.n350 8.49913
R1364 VDD.n620 VDD.n350 8.49913
R1365 VDD.n658 VDD.n350 8.49913
R1366 VDD.n672 VDD.n350 8.49913
R1367 VDD.n737 VDD.n350 8.49913
R1368 VDD.n751 VDD.n350 8.49913
R1369 VDD.n803 VDD.n350 8.49913
R1370 VDD.n817 VDD.n350 8.49913
R1371 VDD.n1343 VDD.n60 8.49747
R1372 VDD.n1343 VDD.n46 8.49747
R1373 VDD.n1343 VDD.n64 8.49747
R1374 VDD.n1343 VDD.n78 8.49747
R1375 VDD.n1343 VDD.n83 8.49747
R1376 VDD.n1343 VDD.n97 8.49747
R1377 VDD.n1343 VDD.n216 8.49747
R1378 VDD.n1343 VDD.n230 8.49747
R1379 VDD.n1343 VDD.n236 8.49747
R1380 VDD.n1343 VDD.n250 8.49747
R1381 VDD.n1283 VDD.n31 8.49747
R1382 VDD.n355 VDD.n350 8.49747
R1383 VDD.n409 VDD.n350 8.49747
R1384 VDD.n984 VDD.n350 8.49747
R1385 VDD.n1009 VDD.n350 8.49747
R1386 VDD.n560 VDD.n350 8.49747
R1387 VDD.n562 VDD.n350 8.49747
R1388 VDD.n956 VDD.n480 8.49747
R1389 VDD.n956 VDD.n494 8.49747
R1390 VDD.n956 VDD.n504 8.49747
R1391 VDD.n956 VDD.n518 8.49747
R1392 VDD.n440 VDD.n421 8.49747
R1393 VDD.t70 VDD.n1310 8.49726
R1394 VDD.n1043 VDD.t95 8.49726
R1395 VDD.t65 VDD.n1250 8.49726
R1396 VDD.t140 VDD.n353 8.49726
R1397 VDD.t110 VDD.n859 8.49726
R1398 VDD.n431 VDD.t115 8.49726
R1399 VDD.n967 VDD.n350 8.46995
R1400 VDD.n1026 VDD.n1025 7.19433
R1401 VDD.n1352 VDD.n1351 6.32824
R1402 VDD.n894 VDD.n893 6.32824
R1403 VDD.t6 VDD.n30 5.66767
R1404 VDD.n957 VDD.n956 5.66453
R1405 VDD.n1343 VDD.n40 5.65856
R1406 VDD.n1343 VDD.n258 5.65856
R1407 VDD.n1343 VDD.n139 5.65856
R1408 VDD.n1343 VDD.n145 5.65856
R1409 VDD.n848 VDD.n350 5.65856
R1410 VDD.n712 VDD.n350 5.65856
R1411 VDD.n645 VDD.n350 5.65856
R1412 VDD.n956 VDD.n499 5.65856
R1413 VDD.n1343 VDD.n235 5.62487
R1414 VDD.n1343 VDD.n215 5.62487
R1415 VDD.n1343 VDD.n196 5.62487
R1416 VDD.n1343 VDD.n191 5.62487
R1417 VDD.n1343 VDD.n120 5.62487
R1418 VDD.n1343 VDD.n101 5.62487
R1419 VDD.n1343 VDD.n82 5.62487
R1420 VDD.n1343 VDD.n63 5.62487
R1421 VDD.n956 VDD.n953 5.62487
R1422 VDD.n981 VDD.n350 5.62486
R1423 VDD.n415 VDD.n350 5.62486
R1424 VDD.n416 VDD.n350 5.62486
R1425 VDD.n417 VDD.n350 5.62486
R1426 VDD.n418 VDD.n350 5.62486
R1427 VDD.n419 VDD.n350 5.62486
R1428 VDD.n1328 VDD.t68 5.0005
R1429 VDD.n1210 VDD.t73 5.0005
R1430 VDD.n1210 VDD.t71 5.0005
R1431 VDD.n1151 VDD.t78 5.0005
R1432 VDD.n1151 VDD.t76 5.0005
R1433 VDD.n1131 VDD.t83 5.0005
R1434 VDD.n1131 VDD.t81 5.0005
R1435 VDD.n1122 VDD.t88 5.0005
R1436 VDD.n1122 VDD.t86 5.0005
R1437 VDD.n1114 VDD.t91 5.0005
R1438 VDD.n1045 VDD.t93 5.0005
R1439 VDD.n1079 VDD.t96 5.0005
R1440 VDD.n1237 VDD.t66 5.0005
R1441 VDD.n1289 VDD.t63 5.0005
R1442 VDD.n834 VDD.t118 5.0005
R1443 VDD.n834 VDD.t116 5.0005
R1444 VDD.n768 VDD.t123 5.0005
R1445 VDD.n768 VDD.t121 5.0005
R1446 VDD.n717 VDD.t128 5.0005
R1447 VDD.n717 VDD.t126 5.0005
R1448 VDD.n637 VDD.t133 5.0005
R1449 VDD.n637 VDD.t131 5.0005
R1450 VDD.n594 VDD.t136 5.0005
R1451 VDD.n1014 VDD.t138 5.0005
R1452 VDD.n406 VDD.t141 5.0005
R1453 VDD.n933 VDD.t111 5.0005
R1454 VDD.n877 VDD.t108 5.0005
R1455 VDD.n475 VDD.t113 5.0005
R1456 VDD.n1353 VDD.n1352 4.62073
R1457 VDD.n895 VDD.n894 4.62073
R1458 VDD.n1200 VDD.t72 4.24914
R1459 VDD.n1170 VDD.t36 4.24914
R1460 VDD.n312 VDD.t82 4.24914
R1461 VDD.t45 VDD.n319 4.24914
R1462 VDD.t52 VDD.n800 4.24914
R1463 VDD.t122 VDD.n731 4.24914
R1464 VDD.t127 VDD.n655 4.24914
R1465 VDD.t132 VDD.n603 4.24914
R1466 VDD.n1112 VDD.t92 4.24739
R1467 VDD.n1077 VDD.t97 4.24739
R1468 VDD.n1235 VDD.t17 4.24739
R1469 VDD.n575 VDD.t137 4.24739
R1470 VDD.t142 VDD.n356 4.24739
R1471 VDD.t112 VDD.n936 4.24739
R1472 VDD.n1343 VDD.n41 4.23817
R1473 VDD.n846 VDD.n350 4.23817
R1474 VDD.n956 VDD.n498 4.23817
R1475 VDD.n1343 VDD.n259 4.23805
R1476 VDD.n1343 VDD.n140 4.23805
R1477 VDD.n1343 VDD.n146 4.23805
R1478 VDD.n651 VDD.n350 4.23805
R1479 VDD.n555 VDD.n350 4.23805
R1480 VDD.n1350 VDD.t146 3.59112
R1481 VDD.n1349 VDD.t144 3.59112
R1482 VDD.n892 VDD.t293 3.59112
R1483 VDD.n891 VDD.t291 3.59112
R1484 VDD.n1351 VDD.t37 3.59068
R1485 VDD.n1348 VDD.t143 3.59068
R1486 VDD.n893 VDD.t295 3.59068
R1487 VDD.n890 VDD.t290 3.59068
R1488 VDD.n902 VDD.n466 3.38434
R1489 VDD.n1345 VDD.n20 3.38434
R1490 VDD.n1345 VDD.n22 3.38434
R1491 VDD.n1345 VDD.n4 3.38434
R1492 VDD.n897 VDD.n466 3.38434
R1493 VDD.n898 VDD.n466 3.38434
R1494 VDD.n1329 VDD.n1328 3.0005
R1495 VDD.n1210 VDD.n1182 3.0005
R1496 VDD.n1211 VDD.n1210 3.0005
R1497 VDD.n1152 VDD.n1151 3.0005
R1498 VDD.n1151 VDD.n1150 3.0005
R1499 VDD.n1131 VDD.n294 3.0005
R1500 VDD.n1132 VDD.n1131 3.0005
R1501 VDD.n1122 VDD.n317 3.0005
R1502 VDD.n1123 VDD.n1122 3.0005
R1503 VDD.n1115 VDD.n1114 3.0005
R1504 VDD.n1046 VDD.n1045 3.0005
R1505 VDD.n1080 VDD.n1079 3.0005
R1506 VDD.n1238 VDD.n1237 3.0005
R1507 VDD.n1290 VDD.n1289 3.0005
R1508 VDD.n834 VDD.n799 3.0005
R1509 VDD.n835 VDD.n834 3.0005
R1510 VDD.n768 VDD.n730 3.0005
R1511 VDD.n769 VDD.n768 3.0005
R1512 VDD.n717 VDD.n654 3.0005
R1513 VDD.n718 VDD.n717 3.0005
R1514 VDD.n637 VDD.n602 3.0005
R1515 VDD.n638 VDD.n637 3.0005
R1516 VDD.n594 VDD.n557 3.0005
R1517 VDD.n1014 VDD.n1013 3.0005
R1518 VDD.n406 VDD.n405 3.0005
R1519 VDD.n934 VDD.n933 3.0005
R1520 VDD.n878 VDD.n877 3.0005
R1521 VDD.n852 VDD.n475 3.0005
R1522 VDD.n1343 VDD.n253 2.81408
R1523 VDD.n1343 VDD.n150 2.81408
R1524 VDD.n901 VDD.n466 2.81408
R1525 VDD.n905 VDD.n466 2.81408
R1526 VDD.n956 VDD.n477 2.81408
R1527 VDD.n597 VDD.n350 2.81408
R1528 VDD.n1345 VDD.n12 2.81408
R1529 VDD.n1345 VDD.n8 2.81408
R1530 VDD.n1343 VDD.n254 2.40596
R1531 VDD.n1343 VDD.n151 2.40596
R1532 VDD.n1345 VDD.n9 2.40574
R1533 VDD.n906 VDD.n466 2.40562
R1534 VDD.n910 VDD.n466 2.40562
R1535 VDD.n956 VDD.n476 2.40562
R1536 VDD.n351 VDD.n350 2.40562
R1537 VDD.n1343 VDD.n42 2.09887
R1538 VDD.n1343 VDD.n43 2.09887
R1539 VDD.n1343 VDD.n257 2.09887
R1540 VDD.n1343 VDD.n263 2.09887
R1541 VDD.n1343 VDD.n264 2.09887
R1542 VDD.n1343 VDD.n265 2.09887
R1543 VDD.n1343 VDD.n266 2.09887
R1544 VDD.n1343 VDD.n267 2.09887
R1545 VDD.n1343 VDD.n268 2.09887
R1546 VDD.n1343 VDD.n269 2.09887
R1547 VDD.n1343 VDD.n270 2.09887
R1548 VDD.n1343 VDD.n271 2.09887
R1549 VDD.n1343 VDD.n1342 2.09887
R1550 VDD.n1343 VDD.n138 2.09887
R1551 VDD.n1343 VDD.n144 2.09887
R1552 VDD.n1343 VDD.n154 2.09887
R1553 VDD.n1343 VDD.n155 2.09887
R1554 VDD.n1343 VDD.n156 2.09887
R1555 VDD.n1343 VDD.n157 2.09887
R1556 VDD.n1343 VDD.n158 2.09887
R1557 VDD.n1343 VDD.n159 2.09887
R1558 VDD.n1343 VDD.n160 2.09887
R1559 VDD.n1343 VDD.n161 2.09887
R1560 VDD.n1343 VDD.n162 2.09887
R1561 VDD.n776 VDD.n350 2.09887
R1562 VDD.n544 VDD.n350 2.09887
R1563 VDD.n697 VDD.n350 2.09887
R1564 VDD.n699 VDD.n350 2.09887
R1565 VDD.n701 VDD.n350 2.09887
R1566 VDD.n703 VDD.n350 2.09887
R1567 VDD.n705 VDD.n350 2.09887
R1568 VDD.n707 VDD.n350 2.09887
R1569 VDD.n709 VDD.n350 2.09887
R1570 VDD.n711 VDD.n350 2.09887
R1571 VDD.n1345 VDD.n13 2.09868
R1572 VDD.n1343 VDD.n38 2.09868
R1573 VDD.n1343 VDD.n39 2.09868
R1574 VDD.n1343 VDD.n260 2.09868
R1575 VDD.n1343 VDD.n141 2.09868
R1576 VDD.n1343 VDD.n147 2.09868
R1577 VDD.n849 VDD.n350 2.09868
R1578 VDD.n649 VDD.n350 2.09868
R1579 VDD.n559 VDD.n350 2.09868
R1580 VDD.n956 VDD.n501 2.09868
R1581 VDD.n956 VDD.n500 2.09868
R1582 VDD.n1343 VDD.n173 2.09849
R1583 VDD.n1343 VDD.n172 2.09849
R1584 VDD.n1343 VDD.n171 2.09849
R1585 VDD.n1343 VDD.n170 2.09849
R1586 VDD.n1343 VDD.n169 2.09849
R1587 VDD.n1343 VDD.n168 2.09849
R1588 VDD.n1343 VDD.n167 2.09849
R1589 VDD.n1343 VDD.n166 2.09849
R1590 VDD.n1343 VDD.n165 2.09849
R1591 VDD.n1343 VDD.n164 2.09849
R1592 VDD.n844 VDD.n350 2.09849
R1593 VDD.n842 VDD.n350 2.09849
R1594 VDD.n534 VDD.n350 2.09849
R1595 VDD.n788 VDD.n350 2.09849
R1596 VDD.n790 VDD.n350 2.09849
R1597 VDD.n792 VDD.n350 2.09849
R1598 VDD.n786 VDD.n350 2.09849
R1599 VDD.n784 VDD.n350 2.09849
R1600 VDD.n782 VDD.n350 2.09849
R1601 VDD.n780 VDD.n350 2.09849
R1602 VDD.n778 VDD.n350 2.09849
R1603 VDD.n714 VDD.n350 2.09849
R1604 VDD.n647 VDD.n350 2.09849
R1605 VDD.n1017 VDD.n350 2.09849
R1606 VDD.n350 VDD.n349 2.09849
R1607 VDD.n391 VDD.n350 2.09849
R1608 VDD.n393 VDD.n350 2.09849
R1609 VDD.n395 VDD.n350 2.09849
R1610 VDD.n397 VDD.n350 2.09849
R1611 VDD.n399 VDD.n350 2.09849
R1612 VDD.n388 VDD.n350 2.09849
R1613 VDD.n386 VDD.n350 2.09849
R1614 VDD.n956 VDD.n497 2.09849
R1615 VDD.n956 VDD.n496 2.09849
R1616 VDD.n725 VDD.n530 1.90013
R1617 VDD.n1334 VDD.n1178 1.90013
R1618 VDD.n1353 VDD.t54 1.89817
R1619 VDD.n1 VDD.t38 1.89817
R1620 VDD.n895 VDD.t99 1.89817
R1621 VDD.n887 VDD.t1 1.89817
R1622 VDD.n1353 VDD.t55 1.89773
R1623 VDD.n1 VDD.t60 1.89773
R1624 VDD.n895 VDD.t100 1.89773
R1625 VDD.n887 VDD.t105 1.89773
R1626 VDD.n1343 VDD.n255 1.88884
R1627 VDD.n1343 VDD.n152 1.88884
R1628 VDD.n1015 VDD.n350 1.88884
R1629 VDD.n956 VDD.n502 1.88884
R1630 VDD.n1343 VDD.n35 1.88871
R1631 VDD.n1343 VDD.n148 1.88844
R1632 VDD.n595 VDD.n350 1.88844
R1633 VDD.n956 VDD.n478 1.88844
R1634 VDD.n1343 VDD.n44 1.88843
R1635 VDD.n80 VDD.n45 1.5629
R1636 VDD.n980 VDD.n414 1.56223
R1637 VDD.n194 VDD.n193 1.56211
R1638 VDD.n213 VDD.n195 1.56211
R1639 VDD.n973 VDD.n972 1.56211
R1640 VDD.n971 VDD.n970 1.56211
R1641 VDD.n195 VDD.n194 1.52234
R1642 VDD.n193 VDD.n192 1.52234
R1643 VDD.n974 VDD.n973 1.52234
R1644 VDD.n972 VDD.n971 1.52234
R1645 VDD.n234 VDD.n34 1.50193
R1646 VDD.n954 VDD.n519 1.5007
R1647 VDD.n1345 VDD.n7 1.48726
R1648 VDD.n916 VDD.n466 1.48726
R1649 VDD.n1346 VDD.n5 1.45604
R1650 VDD.n918 VDD.n917 1.45534
R1651 VDD.n913 VDD.n912 1.4411
R1652 VDD.n15 VDD.n14 1.43808
R1653 VDD.n414 VDD.n413 1.43207
R1654 VDD.n1061 VDD.n45 1.43162
R1655 VDD.n860 VDD.n519 1.43018
R1656 VDD.n1252 VDD.n34 1.42331
R1657 VDD.n977 VDD.n976 1.42275
R1658 VDD.n975 VDD.n974 1.42275
R1659 VDD.n118 VDD.n100 1.42222
R1660 VDD.n192 VDD.n119 1.42222
R1661 VDD.n232 VDD.n214 1.42222
R1662 VDD.n970 VDD.n969 1.41922
R1663 VDD.n100 VDD.n99 1.41053
R1664 VDD.n119 VDD.n118 1.41053
R1665 VDD.n214 VDD.n213 1.41053
R1666 VDD.n978 VDD.n977 1.41009
R1667 VDD.n976 VDD.n975 1.41009
R1668 VDD.n36 VDD.n14 1.34736
R1669 VDD.n725 VDD.n724 1.33341
R1670 VDD.n856 VDD.n530 1.33341
R1671 VDD.n1178 VDD.n285 1.33341
R1672 VDD.n1334 VDD.n1333 1.33341
R1673 VDD.n969 VDD.n968 1.30726
R1674 VDD.n1088 VDD.t220 1.2889
R1675 VDD.n1141 VDD.t193 1.2889
R1676 VDD.n281 VDD.t26 1.2889
R1677 VDD.n344 VDD.t239 1.2889
R1678 VDD.n549 VDD.t173 1.2889
R1679 VDD.n794 VDD.t275 1.2889
R1680 VDD.n912 VDD.n911 1.24682
R1681 VDD.n956 VDD.n955 1.17495
R1682 VDD.n1294 VDD.t39 1.11515
R1683 VDD.n885 VDD.t2 1.11515
R1684 VDD.n913 VDD.n908 1.10572
R1685 VDD.n1025 VDD.n342 1.09933
R1686 VDD.n1118 VDD.n1026 1.09933
R1687 VDD.n1343 VDD.n261 1.06347
R1688 VDD.n1343 VDD.n142 1.06347
R1689 VDD.n553 VDD.n350 1.06347
R1690 VDD.n1343 VDD.n174 1.06306
R1691 VDD.n1343 VDD.n137 1.06306
R1692 VDD.n533 VDD.n350 1.06306
R1693 VDD.n543 VDD.n350 1.06306
R1694 VDD.n716 VDD.n350 1.06306
R1695 VDD.n979 VDD.n350 1.05325
R1696 VDD.n1345 VDD.n16 1.05282
R1697 VDD.n1343 VDD.n233 1.05282
R1698 VDD.n1343 VDD.n81 1.05282
R1699 VDD.n1331 VDD.n1218 1.02406
R1700 VDD.n1215 VDD.n1181 1.02406
R1701 VDD.n1209 VDD.n1202 1.02406
R1702 VDD.n1208 VDD.n1204 1.02406
R1703 VDD.n1207 VDD.n1206 1.02406
R1704 VDD.n284 VDD.n283 1.02406
R1705 VDD.n1336 VDD.n279 1.02406
R1706 VDD.n1337 VDD.n277 1.02406
R1707 VDD.n1338 VDD.n275 1.02406
R1708 VDD.n1340 VDD.n1339 1.02406
R1709 VDD.n1173 VDD.n1149 1.02406
R1710 VDD.n1174 VDD.n1147 1.02406
R1711 VDD.n1175 VDD.n1145 1.02406
R1712 VDD.n1176 VDD.n1143 1.02406
R1713 VDD.n1139 VDD.n287 1.02406
R1714 VDD.n1138 VDD.n289 1.02406
R1715 VDD.n1137 VDD.n291 1.02406
R1716 VDD.n1136 VDD.n293 1.02406
R1717 VDD.n1130 VDD.n314 1.02406
R1718 VDD.n1127 VDD.n316 1.02406
R1719 VDD.n1121 VDD.n337 1.02406
R1720 VDD.n340 VDD.n339 1.02406
R1721 VDD.n1093 VDD.n1048 1.02406
R1722 VDD.n1092 VDD.n1050 1.02406
R1723 VDD.n1091 VDD.n1052 1.02406
R1724 VDD.n1090 VDD.n1054 1.02406
R1725 VDD.n1086 VDD.n1056 1.02406
R1726 VDD.n1085 VDD.n1058 1.02406
R1727 VDD.n1084 VDD.n1060 1.02406
R1728 VDD.n1083 VDD.n1082 1.02406
R1729 VDD.n1248 VDD.n1247 1.02406
R1730 VDD.n1244 VDD.n1243 1.02406
R1731 VDD.n1303 VDD.n1240 1.02406
R1732 VDD.n1306 VDD.n1305 1.02406
R1733 VDD.n532 VDD.n531 1.02406
R1734 VDD.n854 VDD.n851 1.02406
R1735 VDD.n734 VDD.n542 1.02406
R1736 VDD.n733 VDD.n541 1.02406
R1737 VDD.n732 VDD.n540 1.02406
R1738 VDD.n539 VDD.n538 1.02406
R1739 VDD.n796 VDD.n537 1.02406
R1740 VDD.n797 VDD.n536 1.02406
R1741 VDD.n798 VDD.n535 1.02406
R1742 VDD.n840 VDD.n839 1.02406
R1743 VDD.n691 VDD.n689 1.02406
R1744 VDD.n692 VDD.n690 1.02406
R1745 VDD.n694 VDD.n693 1.02406
R1746 VDD.n695 VDD.n548 1.02406
R1747 VDD.n727 VDD.n547 1.02406
R1748 VDD.n728 VDD.n546 1.02406
R1749 VDD.n729 VDD.n545 1.02406
R1750 VDD.n774 VDD.n773 1.02406
R1751 VDD.n552 VDD.n551 1.02406
R1752 VDD.n722 VDD.n653 1.02406
R1753 VDD.n601 VDD.n556 1.02406
R1754 VDD.n642 VDD.n554 1.02406
R1755 VDD.n404 VDD.n383 1.02406
R1756 VDD.n403 VDD.n384 1.02406
R1757 VDD.n402 VDD.n401 1.02406
R1758 VDD.n389 VDD.n343 1.02406
R1759 VDD.n1023 VDD.n345 1.02406
R1760 VDD.n1022 VDD.n346 1.02406
R1761 VDD.n1021 VDD.n347 1.02406
R1762 VDD.n1020 VDD.n1019 1.02406
R1763 VDD.n931 VDD.n523 1.02406
R1764 VDD.n930 VDD.n525 1.02406
R1765 VDD.n529 VDD.n528 1.02406
R1766 VDD.n881 VDD.n880 1.02406
R1767 VDD.n15 VDD.n10 1.01997
R1768 VDD.n6 VDD.n5 1.01997
R1769 VDD.n18 VDD.n17 1.01997
R1770 VDD.n900 VDD.n899 1.01786
R1771 VDD.n904 VDD.n903 1.01786
R1772 VDD.n917 VDD.n900 1.01427
R1773 VDD.n915 VDD.n904 1.01427
R1774 VDD.n21 VDD.n6 1.01216
R1775 VDD.n19 VDD.n18 1.01216
R1776 VDD.n11 VDD.n10 1.01216
R1777 VDD.n908 VDD.n907 0.991305
R1778 VDD.n380 VDD.n350 0.965965
R1779 VDD.n1343 VDD.n62 0.965505
R1780 VDD.n1218 VDD.t251 0.958035
R1781 VDD.n1181 VDD.t253 0.958035
R1782 VDD.n1202 VDD.t18 0.958035
R1783 VDD.n1204 VDD.t20 0.958035
R1784 VDD.n1206 VDD.t22 0.958035
R1785 VDD.n283 VDD.t24 0.958035
R1786 VDD.n279 VDD.t28 0.958035
R1787 VDD.n277 VDD.t30 0.958035
R1788 VDD.n275 VDD.t32 0.958035
R1789 VDD.n1340 VDD.t34 0.958035
R1790 VDD.n1149 VDD.t185 0.958035
R1791 VDD.n1147 VDD.t187 0.958035
R1792 VDD.n1145 VDD.t189 0.958035
R1793 VDD.n1143 VDD.t191 0.958035
R1794 VDD.n287 VDD.t195 0.958035
R1795 VDD.n289 VDD.t197 0.958035
R1796 VDD.n291 VDD.t199 0.958035
R1797 VDD.n293 VDD.t201 0.958035
R1798 VDD.n314 VDD.t40 0.958035
R1799 VDD.n316 VDD.t43 0.958035
R1800 VDD.n337 VDD.t155 0.958035
R1801 VDD.n339 VDD.t157 0.958035
R1802 VDD.n1048 VDD.t211 0.958035
R1803 VDD.n1050 VDD.t212 0.958035
R1804 VDD.n1052 VDD.t215 0.958035
R1805 VDD.n1054 VDD.t218 0.958035
R1806 VDD.n1056 VDD.t217 0.958035
R1807 VDD.n1058 VDD.t223 0.958035
R1808 VDD.n1060 VDD.t225 0.958035
R1809 VDD.n1082 VDD.t227 0.958035
R1810 VDD.n1247 VDD.t9 0.958035
R1811 VDD.n1243 VDD.t11 0.958035
R1812 VDD.n1240 VDD.t13 0.958035
R1813 VDD.n1305 VDD.t15 0.958035
R1814 VDD.n532 VDD.t50 0.958035
R1815 VDD.n851 VDD.t48 0.958035
R1816 VDD.n542 VDD.t283 0.958035
R1817 VDD.n541 VDD.t281 0.958035
R1818 VDD.n540 VDD.t279 0.958035
R1819 VDD.n539 VDD.t277 0.958035
R1820 VDD.n537 VDD.t273 0.958035
R1821 VDD.n536 VDD.t271 0.958035
R1822 VDD.n535 VDD.t269 0.958035
R1823 VDD.n840 VDD.t267 0.958035
R1824 VDD.n689 VDD.t181 0.958035
R1825 VDD.n690 VDD.t179 0.958035
R1826 VDD.n694 VDD.t177 0.958035
R1827 VDD.n695 VDD.t175 0.958035
R1828 VDD.n547 VDD.t171 0.958035
R1829 VDD.n546 VDD.t169 0.958035
R1830 VDD.n545 VDD.t167 0.958035
R1831 VDD.n774 VDD.t165 0.958035
R1832 VDD.n552 VDD.t207 0.958035
R1833 VDD.n653 VDD.t205 0.958035
R1834 VDD.n556 VDD.t148 0.958035
R1835 VDD.n554 VDD.t150 0.958035
R1836 VDD.n383 VDD.t243 0.958035
R1837 VDD.n384 VDD.t246 0.958035
R1838 VDD.n401 VDD.t244 0.958035
R1839 VDD.n389 VDD.t241 0.958035
R1840 VDD.n345 VDD.t234 0.958035
R1841 VDD.n346 VDD.t236 0.958035
R1842 VDD.n347 VDD.t233 0.958035
R1843 VDD.n1019 VDD.t230 0.958035
R1844 VDD.n523 VDD.t263 0.958035
R1845 VDD.n525 VDD.t261 0.958035
R1846 VDD.n528 VDD.t259 0.958035
R1847 VDD.n880 VDD.t257 0.958035
R1848 VDD VDD.n918 0.95141
R1849 VDD.n1 VDD.t57 0.950057
R1850 VDD.n887 VDD.t102 0.950057
R1851 VDD VDD.n1346 0.948715
R1852 VDD.n914 VDD.n466 0.947759
R1853 VDD.n915 VDD.n914 0.899143
R1854 VDD.n979 VDD.n978 0.852245
R1855 VDD.n17 VDD.n16 0.851769
R1856 VDD.n99 VDD.n81 0.851769
R1857 VDD.n234 VDD.n233 0.851769
R1858 VDD.n16 VDD.n15 0.842667
R1859 VDD.n81 VDD.n80 0.842667
R1860 VDD.n233 VDD.n232 0.842667
R1861 VDD.n980 VDD.n979 0.842245
R1862 VDD.n955 VDD.n954 0.80224
R1863 VDD.n955 VDD.n420 0.800297
R1864 VDD.n928 VDD.n927 0.795433
R1865 VDD.n1301 VDD.n1300 0.795433
R1866 VDD.n724 VDD.n550 0.766687
R1867 VDD.n1119 VDD.n285 0.766687
R1868 VDD.n914 VDD.n913 0.758814
R1869 VDD.n7 VDD.n5 0.704151
R1870 VDD.n917 VDD.n916 0.704151
R1871 VDD.n17 VDD.n7 0.702785
R1872 VDD.n916 VDD.n915 0.702785
R1873 VDD.n928 VDD.n857 0.694527
R1874 VDD.n1301 VDD.n1179 0.694527
R1875 VDD.n1214 VDD.n1213 0.643357
R1876 VDD.n1213 VDD.n1212 0.643357
R1877 VDD.n1171 VDD.n273 0.643357
R1878 VDD.n1172 VDD.n1171 0.643357
R1879 VDD.n1135 VDD.n1134 0.643357
R1880 VDD.n1134 VDD.n1133 0.643357
R1881 VDD.n1126 VDD.n1125 0.643357
R1882 VDD.n1125 VDD.n1124 0.643357
R1883 VDD.n837 VDD.n801 0.643357
R1884 VDD.n838 VDD.n837 0.643357
R1885 VDD.n771 VDD.n735 0.643357
R1886 VDD.n772 VDD.n771 0.643357
R1887 VDD.n720 VDD.n656 0.643357
R1888 VDD.n721 VDD.n720 0.643357
R1889 VDD.n640 VDD.n639 0.643357
R1890 VDD.n641 VDD.n640 0.643357
R1891 VDD.n550 VDD.n342 0.532607
R1892 VDD.n857 VDD.n856 0.532607
R1893 VDD.n1119 VDD.n1118 0.532607
R1894 VDD.n1333 VDD.n1179 0.532607
R1895 VDD.t0 VDD.n961 0.516125
R1896 VDD.n1218 VDD.n1217 0.506645
R1897 VDD.n1181 VDD.n1180 0.506645
R1898 VDD.n1202 VDD.n1201 0.506645
R1899 VDD.n1204 VDD.n1203 0.506645
R1900 VDD.n1206 VDD.n1205 0.506645
R1901 VDD.n283 VDD.n282 0.506645
R1902 VDD.n279 VDD.n278 0.506645
R1903 VDD.n277 VDD.n276 0.506645
R1904 VDD.n275 VDD.n274 0.506645
R1905 VDD.n1341 VDD.n1340 0.506645
R1906 VDD.n1149 VDD.n1148 0.506645
R1907 VDD.n1147 VDD.n1146 0.506645
R1908 VDD.n1145 VDD.n1144 0.506645
R1909 VDD.n1143 VDD.n1142 0.506645
R1910 VDD.n287 VDD.n286 0.506645
R1911 VDD.n289 VDD.n288 0.506645
R1912 VDD.n291 VDD.n290 0.506645
R1913 VDD.n293 VDD.n292 0.506645
R1914 VDD.n314 VDD.n313 0.506645
R1915 VDD.n316 VDD.n315 0.506645
R1916 VDD.n337 VDD.n336 0.506645
R1917 VDD.n339 VDD.n338 0.506645
R1918 VDD.n1048 VDD.n1047 0.506645
R1919 VDD.n1050 VDD.n1049 0.506645
R1920 VDD.n1052 VDD.n1051 0.506645
R1921 VDD.n1054 VDD.n1053 0.506645
R1922 VDD.n1056 VDD.n1055 0.506645
R1923 VDD.n1058 VDD.n1057 0.506645
R1924 VDD.n1060 VDD.n1059 0.506645
R1925 VDD.n1082 VDD.n1081 0.506645
R1926 VDD.n1247 VDD.n1246 0.506645
R1927 VDD.n1243 VDD.n1242 0.506645
R1928 VDD.n1240 VDD.n1239 0.506645
R1929 VDD.n1305 VDD.n1304 0.506645
R1930 VDD.n845 VDD.n532 0.506645
R1931 VDD.n851 VDD.n850 0.506645
R1932 VDD.n779 VDD.n542 0.506645
R1933 VDD.n781 VDD.n541 0.506645
R1934 VDD.n783 VDD.n540 0.506645
R1935 VDD.n785 VDD.n539 0.506645
R1936 VDD.n791 VDD.n537 0.506645
R1937 VDD.n789 VDD.n536 0.506645
R1938 VDD.n787 VDD.n535 0.506645
R1939 VDD.n841 VDD.n840 0.506645
R1940 VDD.n710 VDD.n689 0.506645
R1941 VDD.n708 VDD.n690 0.506645
R1942 VDD.n706 VDD.n694 0.506645
R1943 VDD.n704 VDD.n695 0.506645
R1944 VDD.n700 VDD.n547 0.506645
R1945 VDD.n698 VDD.n546 0.506645
R1946 VDD.n696 VDD.n545 0.506645
R1947 VDD.n775 VDD.n774 0.506645
R1948 VDD.n650 VDD.n552 0.506645
R1949 VDD.n713 VDD.n653 0.506645
R1950 VDD.n558 VDD.n556 0.506645
R1951 VDD.n646 VDD.n554 0.506645
R1952 VDD.n385 VDD.n383 0.506645
R1953 VDD.n387 VDD.n384 0.506645
R1954 VDD.n401 VDD.n400 0.506645
R1955 VDD.n398 VDD.n389 0.506645
R1956 VDD.n394 VDD.n345 0.506645
R1957 VDD.n392 VDD.n346 0.506645
R1958 VDD.n390 VDD.n347 0.506645
R1959 VDD.n1019 VDD.n1018 0.506645
R1960 VDD.n523 VDD.n522 0.506645
R1961 VDD.n525 VDD.n524 0.506645
R1962 VDD.n528 VDD.n527 0.506645
R1963 VDD.n880 VDD.n879 0.506645
R1964 VDD.n1296 VDD.n1295 0.5005
R1965 VDD.n1355 VDD.n1347 0.5005
R1966 VDD.n920 VDD.n919 0.5005
R1967 VDD.n923 VDD.n886 0.5005
R1968 VDD.n921 VDD.n920 0.5005
R1969 VDD.n923 VDD.n922 0.5005
R1970 VDD.n1296 VDD.n0 0.5005
R1971 VDD.n1356 VDD.n1355 0.5005
R1972 VDD.n908 VDD.n466 0.446652
R1973 VDD.n1345 VDD.n10 0.409392
R1974 VDD.n1345 VDD.n18 0.409392
R1975 VDD.n1345 VDD.n6 0.409392
R1976 VDD.n904 VDD.n466 0.40939
R1977 VDD.n900 VDD.n466 0.40939
R1978 VDD.n1309 VDD.n1308 0.3755
R1979 VDD.n1117 VDD.n1095 0.3755
R1980 VDD.n1299 VDD.n1292 0.3755
R1981 VDD.n1298 VDD.n1293 0.3755
R1982 VDD.n925 VDD.n884 0.3755
R1983 VDD.n926 VDD.n883 0.3755
R1984 VDD.n599 VDD.n598 0.3755
R1985 VDD.n521 VDD.n520 0.3755
R1986 VDD.n857 VDD.n521 0.3755
R1987 VDD.n599 VDD.n342 0.3755
R1988 VDD.n925 VDD.n858 0.3755
R1989 VDD.n927 VDD.n926 0.3755
R1990 VDD.n1300 VDD.n1299 0.3755
R1991 VDD.n1298 VDD.n1245 0.3755
R1992 VDD.n1118 VDD.n1117 0.3755
R1993 VDD.n1309 VDD.n1179 0.3755
R1994 VDD.n1329 VDD.n1327 0.325576
R1995 VDD.n1115 VDD.n1113 0.325576
R1996 VDD.n1046 VDD.n1044 0.325576
R1997 VDD.n1080 VDD.n1078 0.325576
R1998 VDD.n1238 VDD.n1236 0.325576
R1999 VDD.n1290 VDD.n1288 0.325576
R2000 VDD.n878 VDD.n876 0.325576
R2001 VDD.n576 VDD.n557 0.325576
R2002 VDD.n1013 VDD.n1012 0.325576
R2003 VDD.n405 VDD.n382 0.325576
R2004 VDD.n935 VDD.n934 0.325576
R2005 VDD.n852 VDD.n430 0.325576
R2006 VDD.n1299 VDD.n1298 0.298527
R2007 VDD.n926 VDD.n925 0.298527
R2008 VDD.n927 VDD.n858 0.298527
R2009 VDD.n1300 VDD.n1245 0.298527
R2010 VDD.n922 VDD.n858 0.268607
R2011 VDD.n1245 VDD.n0 0.268607
R2012 VDD.n1299 VDD.n1291 0.24162
R2013 VDD.n926 VDD.n882 0.24162
R2014 VDD.n922 VDD.n921 0.238687
R2015 VDD.n1356 VDD.n0 0.238687
R2016 VDD.n1083 VDD.n1080 0.203837
R2017 VDD.n405 VDD.n404 0.203837
R2018 VDD.n1035 VDD.n63 0.179602
R2019 VDD.n1096 VDD.n82 0.179602
R2020 VDD.n1312 VDD.n215 0.179602
R2021 VDD.n1231 VDD.n235 0.179602
R2022 VDD.n953 VDD.n952 0.179602
R2023 VDD.n561 VDD.n415 0.179263
R2024 VDD.n982 VDD.n981 0.179263
R2025 VDD.n328 VDD.n101 0.17667
R2026 VDD.n310 VDD.n120 0.17667
R2027 VDD.n1168 VDD.n191 0.17667
R2028 VDD.n1198 VDD.n196 0.17667
R2029 VDD.n818 VDD.n419 0.176331
R2030 VDD.n752 VDD.n418 0.176331
R2031 VDD.n673 VDD.n417 0.176331
R2032 VDD.n621 VDD.n416 0.176331
R2033 VDD.n1354 VDD.n1353 0.165593
R2034 VDD.n896 VDD.n895 0.165593
R2035 VDD.n1339 VDD.n1338 0.16242
R2036 VDD.n1338 VDD.n1337 0.16242
R2037 VDD.n1337 VDD.n1336 0.16242
R2038 VDD.n1336 VDD.n1335 0.16242
R2039 VDD.n1335 VDD.n284 0.16242
R2040 VDD.n1207 VDD.n284 0.16242
R2041 VDD.n1208 VDD.n1207 0.16242
R2042 VDD.n1209 VDD.n1208 0.16242
R2043 VDD.n1137 VDD.n1136 0.16242
R2044 VDD.n1138 VDD.n1137 0.16242
R2045 VDD.n1139 VDD.n1138 0.16242
R2046 VDD.n1177 VDD.n1139 0.16242
R2047 VDD.n1177 VDD.n1176 0.16242
R2048 VDD.n1176 VDD.n1175 0.16242
R2049 VDD.n1175 VDD.n1174 0.16242
R2050 VDD.n1174 VDD.n1173 0.16242
R2051 VDD.n1084 VDD.n1083 0.16242
R2052 VDD.n1085 VDD.n1084 0.16242
R2053 VDD.n1086 VDD.n1085 0.16242
R2054 VDD.n1089 VDD.n1086 0.16242
R2055 VDD.n1090 VDD.n1089 0.16242
R2056 VDD.n1091 VDD.n1090 0.16242
R2057 VDD.n1092 VDD.n1091 0.16242
R2058 VDD.n1093 VDD.n1092 0.16242
R2059 VDD.n1306 VDD.n1303 0.16242
R2060 VDD.n1248 VDD.n1244 0.16242
R2061 VDD.n734 VDD.n733 0.16242
R2062 VDD.n733 VDD.n732 0.16242
R2063 VDD.n732 VDD.n538 0.16242
R2064 VDD.n795 VDD.n538 0.16242
R2065 VDD.n796 VDD.n795 0.16242
R2066 VDD.n797 VDD.n796 0.16242
R2067 VDD.n798 VDD.n797 0.16242
R2068 VDD.n839 VDD.n798 0.16242
R2069 VDD.n692 VDD.n691 0.16242
R2070 VDD.n693 VDD.n692 0.16242
R2071 VDD.n693 VDD.n548 0.16242
R2072 VDD.n726 VDD.n548 0.16242
R2073 VDD.n727 VDD.n726 0.16242
R2074 VDD.n728 VDD.n727 0.16242
R2075 VDD.n729 VDD.n728 0.16242
R2076 VDD.n773 VDD.n729 0.16242
R2077 VDD.n404 VDD.n403 0.16242
R2078 VDD.n403 VDD.n402 0.16242
R2079 VDD.n402 VDD.n343 0.16242
R2080 VDD.n1024 VDD.n343 0.16242
R2081 VDD.n1024 VDD.n1023 0.16242
R2082 VDD.n1023 VDD.n1022 0.16242
R2083 VDD.n1022 VDD.n1021 0.16242
R2084 VDD.n1021 VDD.n1020 0.16242
R2085 VDD.n931 VDD.n930 0.16242
R2086 VDD.n881 VDD.n529 0.16242
R2087 VDD.n1215 VDD.n1214 0.157346
R2088 VDD.n1212 VDD.n1209 0.157346
R2089 VDD.n1339 VDD.n273 0.157346
R2090 VDD.n1173 VDD.n1172 0.157346
R2091 VDD.n1136 VDD.n1135 0.157346
R2092 VDD.n1133 VDD.n1130 0.157346
R2093 VDD.n1127 VDD.n1126 0.157346
R2094 VDD.n1124 VDD.n1121 0.157346
R2095 VDD.n801 VDD.n531 0.157346
R2096 VDD.n839 VDD.n838 0.157346
R2097 VDD.n735 VDD.n734 0.157346
R2098 VDD.n773 VDD.n772 0.157346
R2099 VDD.n691 VDD.n656 0.157346
R2100 VDD.n722 VDD.n721 0.157346
R2101 VDD.n639 VDD.n551 0.157346
R2102 VDD.n642 VDD.n641 0.157346
R2103 VDD.n1213 VDD.n1183 0.156657
R2104 VDD.n1171 VDD.n1153 0.156657
R2105 VDD.n1134 VDD.n295 0.156657
R2106 VDD.n1125 VDD.n318 0.156657
R2107 VDD.n837 VDD.n836 0.156657
R2108 VDD.n771 VDD.n770 0.156657
R2109 VDD.n720 VDD.n719 0.156657
R2110 VDD.n640 VDD.n604 0.156657
R2111 VDD.n1331 VDD.n1330 0.15626
R2112 VDD.n1116 VDD.n340 0.15626
R2113 VDD.n1094 VDD.n1093 0.15626
R2114 VDD.n1307 VDD.n1306 0.15626
R2115 VDD.n1291 VDD.n1248 0.15626
R2116 VDD.n854 VDD.n853 0.15626
R2117 VDD.n601 VDD.n600 0.15626
R2118 VDD.n1020 VDD.n348 0.15626
R2119 VDD.n932 VDD.n931 0.15626
R2120 VDD.n882 VDD.n881 0.15626
R2121 VDD.n1345 VDD.n14 0.143404
R2122 VDD.n385 VDD.n380 0.143068
R2123 VDD.n1081 VDD.n62 0.142594
R2124 VDD.n1330 VDD.n1309 0.140713
R2125 VDD.n1309 VDD.n1307 0.140713
R2126 VDD.n1117 VDD.n1094 0.140713
R2127 VDD.n1117 VDD.n1116 0.140713
R2128 VDD.n1298 VDD.n1297 0.140713
R2129 VDD.n925 VDD.n924 0.140713
R2130 VDD.n599 VDD.n348 0.140713
R2131 VDD.n600 VDD.n599 0.140713
R2132 VDD.n853 VDD.n521 0.140713
R2133 VDD.n932 VDD.n521 0.140713
R2134 VDD.n967 VDD.n966 0.135344
R2135 VDD.n968 VDD.n967 0.132772
R2136 VDD.n912 VDD.n466 0.130659
R2137 VDD.n968 VDD.n420 0.125167
R2138 VDD.n975 VDD.n350 0.123612
R2139 VDD.n977 VDD.n350 0.123612
R2140 VDD.n1343 VDD.n214 0.123154
R2141 VDD.n1343 VDD.n119 0.123154
R2142 VDD.n1343 VDD.n100 0.123154
R2143 VDD.n1346 VDD.n1345 0.120955
R2144 VDD.n37 VDD.n36 0.120038
R2145 VDD.n911 VDD.n909 0.120038
R2146 VDD.n918 VDD.n466 0.119956
R2147 VDD.n969 VDD.n350 0.113707
R2148 VDD.n921 VDD 0.107567
R2149 VDD VDD.n1356 0.107567
R2150 VDD.n1332 VDD.n1216 0.0972742
R2151 VDD.n1129 VDD.n1128 0.0972742
R2152 VDD.n1120 VDD.n341 0.0972742
R2153 VDD.n855 VDD.n847 0.0972742
R2154 VDD.n723 VDD.n652 0.0972742
R2155 VDD.n644 VDD.n643 0.0972742
R2156 VDD.n643 VDD.n550 0.0972742
R2157 VDD.n724 VDD.n723 0.0972742
R2158 VDD.n856 VDD.n855 0.0972742
R2159 VDD.n1120 VDD.n1119 0.0972742
R2160 VDD.n1129 VDD.n285 0.0972742
R2161 VDD.n1333 VDD.n1332 0.0972742
R2162 VDD.n1355 VDD.n1354 0.0951558
R2163 VDD.n920 VDD.n896 0.0951558
R2164 VDD.n1201 VDD.n264 0.0944516
R2165 VDD.n1047 VDD.n155 0.0944516
R2166 VDD.n775 VDD.n544 0.0944516
R2167 VDD.n1246 VDD.n39 0.0942639
R2168 VDD.n879 VDD.n500 0.0942639
R2169 VDD.n1148 VDD.n172 0.0940701
R2170 VDD.n841 VDD.n534 0.0940701
R2171 VDD.n1018 VDD.n349 0.0940701
R2172 VDD.n292 VDD.n165 0.0936876
R2173 VDD.n780 VDD.n779 0.0936876
R2174 VDD.n386 VDD.n385 0.0936876
R2175 VDD.n522 VDD.n497 0.0936876
R2176 VDD.n1341 VDD.n271 0.0933112
R2177 VDD.n1081 VDD.n162 0.0933112
R2178 VDD.n1304 VDD.n42 0.0933112
R2179 VDD.n710 VDD.n709 0.0933112
R2180 VDD.n1203 VDD.n265 0.0920071
R2181 VDD.n1049 VDD.n156 0.0920071
R2182 VDD.n697 VDD.n696 0.0920071
R2183 VDD.n1146 VDD.n171 0.0916257
R2184 VDD.n788 VDD.n787 0.0916257
R2185 VDD.n391 VDD.n390 0.0916257
R2186 VDD.n290 VDD.n166 0.0912432
R2187 VDD.n782 VDD.n781 0.0912432
R2188 VDD.n388 VDD.n387 0.0912432
R2189 VDD.n274 VDD.n270 0.0908667
R2190 VDD.n1059 VDD.n161 0.0908667
R2191 VDD.n708 VDD.n707 0.0908667
R2192 VDD.n2 VDD.n1 0.0906662
R2193 VDD.n888 VDD.n887 0.0906662
R2194 VDD.n257 VDD.n256 0.0904794
R2195 VDD.n263 VDD.n262 0.0904794
R2196 VDD.n163 VDD.n138 0.0904794
R2197 VDD.n144 VDD.n143 0.0904794
R2198 VDD.n154 VDD.n153 0.0904794
R2199 VDD.n777 VDD.n776 0.0904794
R2200 VDD.n38 VDD.n37 0.0902916
R2201 VDD.n849 VDD.n468 0.0902916
R2202 VDD.n909 VDD.n501 0.0902916
R2203 VDD.n1351 VDD.n1350 0.09026
R2204 VDD.n1350 VDD.n1349 0.09026
R2205 VDD.n1349 VDD.n1348 0.09026
R2206 VDD.n893 VDD.n892 0.09026
R2207 VDD.n892 VDD.n891 0.09026
R2208 VDD.n891 VDD.n890 0.09026
R2209 VDD.n272 VDD.n173 0.0900979
R2210 VDD.n843 VDD.n842 0.0900979
R2211 VDD.n715 VDD.n714 0.0900979
R2212 VDD.n648 VDD.n647 0.0900979
R2213 VDD.n1017 VDD.n1016 0.0900979
R2214 VDD.n164 VDD.n163 0.0897154
R2215 VDD.n844 VDD.n843 0.0897154
R2216 VDD.n778 VDD.n777 0.0897154
R2217 VDD.n496 VDD.n495 0.0897154
R2218 VDD.n280 VDD.n268 0.0895627
R2219 VDD.n1205 VDD.n266 0.0895627
R2220 VDD.n1087 VDD.n159 0.0895627
R2221 VDD.n1051 VDD.n157 0.0895627
R2222 VDD.n703 VDD.n702 0.0895627
R2223 VDD.n699 VDD.n698 0.0895627
R2224 VDD.n262 VDD.n260 0.0895285
R2225 VDD.n143 VDD.n141 0.0895285
R2226 VDD.n149 VDD.n147 0.0895285
R2227 VDD.n649 VDD.n648 0.0895285
R2228 VDD.n596 VDD.n559 0.0895285
R2229 VDD.n1342 VDD.n272 0.0893389
R2230 VDD.n252 VDD.n43 0.0893389
R2231 VDD.n715 VDD.n711 0.0893389
R2232 VDD.n1140 VDD.n168 0.0891812
R2233 VDD.n1144 VDD.n170 0.0891812
R2234 VDD.n793 VDD.n786 0.0891812
R2235 VDD.n790 VDD.n789 0.0891812
R2236 VDD.n397 VDD.n396 0.0891812
R2237 VDD.n393 VDD.n392 0.0891812
R2238 VDD.n970 VDD.n419 0.089169
R2239 VDD.n972 VDD.n418 0.089169
R2240 VDD.n974 VDD.n417 0.089169
R2241 VDD.n976 VDD.n416 0.089169
R2242 VDD.n978 VDD.n415 0.089169
R2243 VDD.n981 VDD.n980 0.089169
R2244 VDD.n232 VDD.n215 0.0888312
R2245 VDD.n213 VDD.n196 0.0888312
R2246 VDD.n194 VDD.n191 0.0888312
R2247 VDD.n192 VDD.n120 0.0888312
R2248 VDD.n118 VDD.n101 0.0888312
R2249 VDD.n99 VDD.n82 0.0888312
R2250 VDD.n80 VDD.n63 0.0888312
R2251 VDD.n235 VDD.n234 0.0888312
R2252 VDD.n954 VDD.n953 0.0888312
R2253 VDD.n288 VDD.n167 0.0887988
R2254 VDD.n784 VDD.n783 0.0887988
R2255 VDD.n400 VDD.n399 0.0887988
R2256 VDD.n276 VDD.n269 0.0884223
R2257 VDD.n1057 VDD.n160 0.0884223
R2258 VDD.n706 VDD.n705 0.0884223
R2259 VDD.n278 VDD.n269 0.0871182
R2260 VDD.n282 VDD.n267 0.0871182
R2261 VDD.n1055 VDD.n160 0.0871182
R2262 VDD.n1053 VDD.n158 0.0871182
R2263 VDD.n705 VDD.n704 0.0871182
R2264 VDD.n701 VDD.n700 0.0871182
R2265 VDD.n286 VDD.n167 0.0867368
R2266 VDD.n1142 VDD.n169 0.0867368
R2267 VDD.n785 VDD.n784 0.0867368
R2268 VDD.n792 VDD.n791 0.0867368
R2269 VDD.n399 VDD.n398 0.0867368
R2270 VDD.n395 VDD.n394 0.0867368
R2271 VDD.n11 VDD.n9 0.086454
R2272 VDD.n286 VDD.n168 0.0863543
R2273 VDD.n1142 VDD.n170 0.0863543
R2274 VDD.n786 VDD.n785 0.0863543
R2275 VDD.n791 VDD.n790 0.0863543
R2276 VDD.n398 VDD.n397 0.0863543
R2277 VDD.n394 VDD.n393 0.0863543
R2278 VDD.n911 VDD.n910 0.0860905
R2279 VDD.n907 VDD.n906 0.0860905
R2280 VDD.n278 VDD.n268 0.0859778
R2281 VDD.n282 VDD.n266 0.0859778
R2282 VDD.n1055 VDD.n159 0.0859778
R2283 VDD.n1053 VDD.n157 0.0859778
R2284 VDD.n704 VDD.n703 0.0859778
R2285 VDD.n700 VDD.n699 0.0859778
R2286 VDD.n1292 VDD.n13 0.0855563
R2287 VDD.n276 VDD.n270 0.0846738
R2288 VDD.n1057 VDD.n161 0.0846738
R2289 VDD.n707 VDD.n706 0.0846738
R2290 VDD.n288 VDD.n166 0.0842923
R2291 VDD.n783 VDD.n782 0.0842923
R2292 VDD.n400 VDD.n388 0.0842923
R2293 VDD.n1144 VDD.n171 0.0839099
R2294 VDD.n789 VDD.n788 0.0839099
R2295 VDD.n392 VDD.n391 0.0839099
R2296 VDD.n1345 VDD.t6 0.0836256
R2297 VDD.n1205 VDD.n265 0.0835334
R2298 VDD.n1051 VDD.n156 0.0835334
R2299 VDD.n698 VDD.n697 0.0835334
R2300 VDD.t0 VDD.n466 0.0826256
R2301 VDD.n274 VDD.n271 0.0822293
R2302 VDD.n1059 VDD.n162 0.0822293
R2303 VDD.n1239 VDD.n42 0.0822293
R2304 VDD.n709 VDD.n708 0.0822293
R2305 VDD.n290 VDD.n165 0.0818479
R2306 VDD.n781 VDD.n780 0.0818479
R2307 VDD.n387 VDD.n386 0.0818479
R2308 VDD.n524 VDD.n497 0.0818479
R2309 VDD.n1146 VDD.n172 0.0814654
R2310 VDD.n787 VDD.n534 0.0814654
R2311 VDD.n390 VDD.n349 0.0814654
R2312 VDD.n1332 VDD.n1215 0.08146
R2313 VDD.n1332 VDD.n1331 0.08146
R2314 VDD.n1129 VDD.n1127 0.08146
R2315 VDD.n1130 VDD.n1129 0.08146
R2316 VDD.n1120 VDD.n340 0.08146
R2317 VDD.n1121 VDD.n1120 0.08146
R2318 VDD.n1303 VDD.n1302 0.08146
R2319 VDD.n1302 VDD.n1244 0.08146
R2320 VDD.n855 VDD.n531 0.08146
R2321 VDD.n855 VDD.n854 0.08146
R2322 VDD.n723 VDD.n551 0.08146
R2323 VDD.n723 VDD.n722 0.08146
R2324 VDD.n643 VDD.n601 0.08146
R2325 VDD.n643 VDD.n642 0.08146
R2326 VDD.n930 VDD.n929 0.08146
R2327 VDD.n929 VDD.n529 0.08146
R2328 VDD.n1242 VDD.n39 0.0812785
R2329 VDD.n527 VDD.n500 0.0812785
R2330 VDD VDD.n169 0.0811599
R2331 VDD VDD.n792 0.0811599
R2332 VDD VDD.n395 0.0811599
R2333 VDD.n1203 VDD.n264 0.0810889
R2334 VDD.n1049 VDD.n155 0.0810889
R2335 VDD.n696 VDD.n544 0.0810889
R2336 VDD VDD.n267 0.0807834
R2337 VDD VDD.n158 0.0807834
R2338 VDD VDD.n701 0.0807834
R2339 VDD.n1342 VDD.n1341 0.0797849
R2340 VDD.n1304 VDD.n43 0.0797849
R2341 VDD.n711 VDD.n710 0.0797849
R2342 VDD.n1180 VDD.n260 0.0795972
R2343 VDD.n315 VDD.n141 0.0795972
R2344 VDD.n338 VDD.n147 0.0795972
R2345 VDD.n650 VDD.n649 0.0795972
R2346 VDD.n559 VDD.n558 0.0795972
R2347 VDD.n292 VDD.n164 0.0794034
R2348 VDD.n845 VDD.n844 0.0794034
R2349 VDD.n779 VDD.n778 0.0794034
R2350 VDD.n522 VDD.n496 0.0794034
R2351 VDD.n1079 VDD.n62 0.0791298
R2352 VDD.n1148 VDD.n173 0.079021
R2353 VDD.n842 VDD.n841 0.079021
R2354 VDD.n714 VDD.n713 0.079021
R2355 VDD.n647 VDD.n646 0.079021
R2356 VDD.n1018 VDD.n1017 0.079021
R2357 VDD.n1246 VDD.n38 0.0788341
R2358 VDD.n850 VDD.n849 0.0788341
R2359 VDD.n879 VDD.n501 0.0788341
R2360 VDD.n406 VDD.n380 0.0786588
R2361 VDD.n1217 VDD.n257 0.0786445
R2362 VDD.n1201 VDD.n263 0.0786445
R2363 VDD.n313 VDD.n138 0.0786445
R2364 VDD.n336 VDD.n144 0.0786445
R2365 VDD.n1047 VDD.n154 0.0786445
R2366 VDD.n776 VDD.n775 0.0786445
R2367 VDD.n1016 VDD.n351 0.0769239
R2368 VDD.n476 VDD.n468 0.0769239
R2369 VDD.n256 VDD.n254 0.0765648
R2370 VDD.n153 VDD.n151 0.0765648
R2371 VDD.n36 VDD.n13 0.0765417
R2372 VDD.n1308 VDD.n254 0.0757423
R2373 VDD.n1095 VDD.n151 0.0757423
R2374 VDD.n907 VDD.n905 0.0756576
R2375 VDD.n903 VDD.n901 0.0756576
R2376 VDD.n910 VDD.n883 0.0753795
R2377 VDD.n906 VDD.n884 0.0753795
R2378 VDD.n598 VDD.n351 0.0753795
R2379 VDD.n520 VDD.n476 0.0753795
R2380 VDD.n12 VDD.n11 0.0753198
R2381 VDD.n19 VDD.n8 0.0753198
R2382 VDD.n1293 VDD.n9 0.0750173
R2383 VDD.n1297 VDD.n1294 0.0713958
R2384 VDD.n924 VDD.n885 0.0713958
R2385 VDD VDD.n12 0.0674076
R2386 VDD VDD.n8 0.0674076
R2387 VDD.n1302 VDD.n1241 0.0671667
R2388 VDD.n929 VDD.n526 0.0671667
R2389 VDD.n929 VDD.n928 0.0671667
R2390 VDD.n1302 VDD.n1301 0.0671667
R2391 VDD VDD.n253 0.0670698
R2392 VDD VDD.n150 0.0670698
R2393 VDD.n905 VDD 0.0670698
R2394 VDD.n901 VDD 0.0670698
R2395 VDD VDD.n597 0.0670698
R2396 VDD VDD.n477 0.0670698
R2397 VDD.n253 VDD.n252 0.066491
R2398 VDD.n150 VDD.n149 0.066491
R2399 VDD.n597 VDD.n596 0.066491
R2400 VDD.n495 VDD.n477 0.066491
R2401 VDD.n22 VDD.n21 0.0647009
R2402 VDD.n21 VDD.n4 0.0647009
R2403 VDD.n899 VDD.n897 0.0647009
R2404 VDD.n20 VDD.n19 0.0646991
R2405 VDD.n903 VDD.n902 0.0646991
R2406 VDD.n899 VDD.n898 0.0646991
R2407 VDD.n1295 VDD.n20 0.0640898
R2408 VDD.n902 VDD.n886 0.0640898
R2409 VDD.n1347 VDD.n4 0.064088
R2410 VDD.n919 VDD.n897 0.064088
R2411 VDD.n898 VDD 0.0564509
R2412 VDD VDD.n22 0.0564491
R2413 VDD.n846 VDD.n845 0.0509488
R2414 VDD.n1180 VDD.n259 0.0508231
R2415 VDD.n315 VDD.n140 0.0508231
R2416 VDD.n338 VDD.n146 0.0508231
R2417 VDD.n651 VDD.n650 0.0508231
R2418 VDD.n558 VDD.n555 0.0508231
R2419 VDD.n524 VDD.n498 0.0485043
R2420 VDD.n1239 VDD.n41 0.0482523
R2421 VDD.n1330 VDD.n1329 0.0480766
R2422 VDD.n1116 VDD.n1115 0.0480766
R2423 VDD.n1094 VDD.n1046 0.0480766
R2424 VDD.n1307 VDD.n1238 0.0480766
R2425 VDD.n1291 VDD.n1290 0.0480766
R2426 VDD.n882 VDD.n878 0.0480766
R2427 VDD.n600 VDD.n557 0.0480766
R2428 VDD.n1013 VDD.n348 0.0480766
R2429 VDD.n934 VDD.n932 0.0480766
R2430 VDD.n853 VDD.n852 0.0480766
R2431 VDD.n1352 VDD 0.0445
R2432 VDD.n894 VDD 0.0445
R2433 VDD.n850 VDD.n848 0.0401412
R2434 VDD.n1241 VDD.n41 0.0399488
R2435 VDD.n1217 VDD.n258 0.0398068
R2436 VDD.n313 VDD.n139 0.0398068
R2437 VDD.n336 VDD.n145 0.0398068
R2438 VDD.n713 VDD.n712 0.0398068
R2439 VDD.n646 VDD.n645 0.0398068
R2440 VDD.n526 VDD.n498 0.0396967
R2441 VDD.n3 VDD.n2 0.03922
R2442 VDD.n889 VDD.n888 0.03922
R2443 VDD.n1025 VDD.n1024 0.0389615
R2444 VDD.n726 VDD.n725 0.0389615
R2445 VDD.n795 VDD.n530 0.0389615
R2446 VDD.n1178 VDD.n1177 0.0389615
R2447 VDD.n1335 VDD.n1334 0.0389615
R2448 VDD.n1089 VDD.n1026 0.0389615
R2449 VDD.n1242 VDD.n40 0.0376968
R2450 VDD.n527 VDD.n499 0.0376968
R2451 VDD.n1216 VDD.n259 0.0373786
R2452 VDD.n1128 VDD.n140 0.0373786
R2453 VDD.n341 VDD.n146 0.0373786
R2454 VDD.n652 VDD.n651 0.0373786
R2455 VDD.n644 VDD.n555 0.0373786
R2456 VDD.n847 VDD.n846 0.0372523
R2457 VDD.n256 VDD.n255 0.0342052
R2458 VDD.n153 VDD.n152 0.0342052
R2459 VDD.n1016 VDD.n1015 0.0342052
R2460 VDD.n909 VDD.n502 0.0342052
R2461 VDD.n37 VDD.n35 0.0341496
R2462 VDD.n149 VDD.n148 0.0339273
R2463 VDD.n596 VDD.n595 0.0339273
R2464 VDD.n495 VDD.n478 0.0339273
R2465 VDD.n252 VDD.n44 0.0338718
R2466 VDD.n959 VDD.n468 0.0316909
R2467 VDD VDD.n40 0.0315568
R2468 VDD VDD.n499 0.0315568
R2469 VDD VDD.n258 0.0294468
R2470 VDD VDD.n139 0.0294468
R2471 VDD VDD.n145 0.0294468
R2472 VDD.n712 VDD 0.0294468
R2473 VDD.n645 VDD 0.0294468
R2474 VDD.n848 VDD 0.0291124
R2475 VDD.n1343 VDD.n34 0.0274656
R2476 VDD.n956 VDD.n519 0.0271145
R2477 VDD.n1335 VDD.n281 0.0261043
R2478 VDD.n1177 VDD.n1141 0.0261043
R2479 VDD.n1089 VDD.n1088 0.0261043
R2480 VDD.n795 VDD.n794 0.0261043
R2481 VDD.n726 VDD.n549 0.0261043
R2482 VDD.n1024 VDD.n344 0.0261043
R2483 VDD.n1355 VDD.n3 0.02426
R2484 VDD.n1297 VDD.n1296 0.02426
R2485 VDD.n1296 VDD.n3 0.02426
R2486 VDD.n924 VDD.n923 0.02426
R2487 VDD.n923 VDD.n889 0.02426
R2488 VDD.n920 VDD.n889 0.02426
R2489 VDD.n1237 VDD.n44 0.0223496
R2490 VDD.n1114 VDD.n148 0.0222942
R2491 VDD.n595 VDD.n594 0.0222942
R2492 VDD.n933 VDD.n478 0.0222942
R2493 VDD.n1289 VDD.n35 0.0220723
R2494 VDD.n1328 VDD.n255 0.0220168
R2495 VDD.n1045 VDD.n152 0.0220168
R2496 VDD.n1015 VDD.n1014 0.0220168
R2497 VDD.n877 VDD.n502 0.0220168
R2498 VDD.n1292 VDD 0.0185278
R2499 VDD.n1293 VDD 0.0185278
R2500 VDD.n1308 VDD 0.0185278
R2501 VDD.n1216 VDD 0.0185278
R2502 VDD.n1128 VDD 0.0185278
R2503 VDD.n341 VDD 0.0185278
R2504 VDD.n1095 VDD 0.0185278
R2505 VDD.n1241 VDD 0.0185278
R2506 VDD VDD.n883 0.0185278
R2507 VDD VDD.n884 0.0185278
R2508 VDD VDD.n847 0.0185278
R2509 VDD VDD.n652 0.0185278
R2510 VDD VDD.n644 0.0185278
R2511 VDD.n598 VDD 0.0185278
R2512 VDD.n520 VDD 0.0185278
R2513 VDD.n526 VDD 0.0185278
R2514 VDD.n262 VDD.n261 0.01847
R2515 VDD.n143 VDD.n142 0.01847
R2516 VDD.n648 VDD.n553 0.01847
R2517 VDD.n957 VDD.n475 0.0183231
R2518 VDD.n272 VDD.n174 0.0182511
R2519 VDD.n163 VDD.n137 0.0182511
R2520 VDD.n843 VDD.n533 0.0182511
R2521 VDD.n777 VDD.n543 0.0182511
R2522 VDD.n716 VDD.n715 0.0182511
R2523 VDD.n1211 VDD.n1183 0.0182506
R2524 VDD.n1183 VDD.n1182 0.0182506
R2525 VDD.n1153 VDD.n1150 0.0182506
R2526 VDD.n1153 VDD.n1152 0.0182506
R2527 VDD.n1132 VDD.n295 0.0182506
R2528 VDD.n295 VDD.n294 0.0182506
R2529 VDD.n1123 VDD.n318 0.0182506
R2530 VDD.n318 VDD.n317 0.0182506
R2531 VDD.n836 VDD.n799 0.0182506
R2532 VDD.n836 VDD.n835 0.0182506
R2533 VDD.n770 VDD.n730 0.0182506
R2534 VDD.n770 VDD.n769 0.0182506
R2535 VDD.n719 VDD.n654 0.0182506
R2536 VDD.n719 VDD.n718 0.0182506
R2537 VDD.n604 VDD.n602 0.0182506
R2538 VDD.n638 VDD.n604 0.0182506
R2539 VDD.t0 VDD.n467 0.0162193
R2540 VDD.t6 VDD.n1344 0.0156923
R2541 VDD.n1254 VDD.n33 0.0146399
R2542 VDD.n472 VDD.n471 0.0146399
R2543 VDD.n1313 VDD.n217 0.0144319
R2544 VDD.n1097 VDD.n84 0.0144319
R2545 VDD.n1034 VDD.n65 0.0144319
R2546 VDD.n1062 VDD.n47 0.0144319
R2547 VDD.n1232 VDD.n237 0.0144319
R2548 VDD.n1256 VDD.n1253 0.0144319
R2549 VDD.n564 VDD.n563 0.0144319
R2550 VDD.n1011 VDD.n1010 0.0144319
R2551 VDD.n359 VDD.n358 0.0144319
R2552 VDD.n950 VDD.n493 0.0144319
R2553 VDD.n875 VDD.n517 0.0144319
R2554 VDD.n965 VDD.n964 0.0144319
R2555 VDD.n1311 VDD.n231 0.014224
R2556 VDD.n1326 VDD.n229 0.014224
R2557 VDD.n1111 VDD.n98 0.014224
R2558 VDD.n1099 VDD.n96 0.014224
R2559 VDD.n1042 VDD.n79 0.014224
R2560 VDD.n1028 VDD.n77 0.014224
R2561 VDD.n1076 VDD.n61 0.014224
R2562 VDD.n1064 VDD.n59 0.014224
R2563 VDD.n1234 VDD.n251 0.014224
R2564 VDD.n1230 VDD.n249 0.014224
R2565 VDD.n1251 VDD.n32 0.014224
R2566 VDD.n1287 VDD.n1286 0.014224
R2567 VDD.n590 VDD.n589 0.014224
R2568 VDD.n593 VDD.n592 0.014224
R2569 VDD.n986 VDD.n985 0.014224
R2570 VDD.n983 VDD.n352 0.014224
R2571 VDD.n411 VDD.n410 0.014224
R2572 VDD.n408 VDD.n407 0.014224
R2573 VDD.n937 VDD.n481 0.014224
R2574 VDD.n949 VDD.n479 0.014224
R2575 VDD.n862 VDD.n505 0.014224
R2576 VDD.n861 VDD.n503 0.014224
R2577 VDD.n469 VDD.n423 0.014224
R2578 VDD.n474 VDD.n422 0.014224
R2579 VDD.n1314 VDD.n218 0.0138081
R2580 VDD.n1110 VDD.n85 0.0138081
R2581 VDD.n1036 VDD.n66 0.0138081
R2582 VDD.n1075 VDD.n48 0.0138081
R2583 VDD.n1219 VDD.n238 0.0138081
R2584 VDD.n1259 VDD.n1257 0.0138081
R2585 VDD.n566 VDD.n565 0.0138081
R2586 VDD.n1008 VDD.n1007 0.0138081
R2587 VDD.n361 VDD.n360 0.0138081
R2588 VDD.n948 VDD.n492 0.0138081
R2589 VDD.n874 VDD.n516 0.0138081
R2590 VDD.n438 VDD.n437 0.0138081
R2591 VDD.n1077 VDD.n52 0.0137626
R2592 VDD.n575 VDD.n574 0.0137626
R2593 VDD.n368 VDD.n356 0.0137626
R2594 VDD.n1112 VDD.n89 0.0137626
R2595 VDD.n1235 VDD.n242 0.0137626
R2596 VDD.n936 VDD.n488 0.0137626
R2597 VDD.n1325 VDD.n228 0.0136002
R2598 VDD.n1100 VDD.n95 0.0136002
R2599 VDD.n1041 VDD.n76 0.0136002
R2600 VDD.n1065 VDD.n58 0.0136002
R2601 VDD.n1229 VDD.n248 0.0136002
R2602 VDD.n1284 VDD.n1282 0.0136002
R2603 VDD.n588 VDD.n587 0.0136002
R2604 VDD.n988 VDD.n987 0.0136002
R2605 VDD.n412 VDD.n379 0.0136002
R2606 VDD.n938 VDD.n482 0.0136002
R2607 VDD.n863 VDD.n506 0.0136002
R2608 VDD.n460 VDD.n424 0.0136002
R2609 VDD.n1088 VDD.n1087 0.0134139
R2610 VDD.n1141 VDD.n1140 0.0134139
R2611 VDD.n281 VDD.n280 0.0134139
R2612 VDD.n396 VDD.n344 0.0134139
R2613 VDD.n702 VDD.n549 0.0134139
R2614 VDD.n794 VDD.n793 0.0134139
R2615 VDD.n1315 VDD.n219 0.0131843
R2616 VDD.n1109 VDD.n86 0.0131843
R2617 VDD.n1033 VDD.n67 0.0131843
R2618 VDD.n1074 VDD.n49 0.0131843
R2619 VDD.n1220 VDD.n239 0.0131843
R2620 VDD.n1261 VDD.n1258 0.0131843
R2621 VDD.n568 VDD.n567 0.0131843
R2622 VDD.n1006 VDD.n1005 0.0131843
R2623 VDD.n363 VDD.n362 0.0131843
R2624 VDD.n947 VDD.n491 0.0131843
R2625 VDD.n873 VDD.n515 0.0131843
R2626 VDD.n445 VDD.n436 0.0131843
R2627 VDD.n1324 VDD.n227 0.0129764
R2628 VDD.n1101 VDD.n94 0.0129764
R2629 VDD.n1029 VDD.n75 0.0129764
R2630 VDD.n1066 VDD.n57 0.0129764
R2631 VDD.n1228 VDD.n247 0.0129764
R2632 VDD.n1281 VDD.n1280 0.0129764
R2633 VDD.n586 VDD.n585 0.0129764
R2634 VDD.n990 VDD.n989 0.0129764
R2635 VDD.n378 VDD.n377 0.0129764
R2636 VDD.n939 VDD.n483 0.0129764
R2637 VDD.n864 VDD.n507 0.0129764
R2638 VDD.n461 VDD.n425 0.0129764
R2639 VDD.n1151 VDD.n174 0.0129619
R2640 VDD.n1131 VDD.n137 0.0129619
R2641 VDD.n834 VDD.n533 0.0129619
R2642 VDD.n768 VDD.n543 0.0129619
R2643 VDD.n717 VDD.n716 0.0129619
R2644 VDD.n1210 VDD.n261 0.0127433
R2645 VDD.n1122 VDD.n142 0.0127433
R2646 VDD.n637 VDD.n553 0.0127433
R2647 VDD.n1323 VDD.n226 0.0123526
R2648 VDD.n1316 VDD.n220 0.0123526
R2649 VDD.n1102 VDD.n93 0.0123526
R2650 VDD.n1108 VDD.n87 0.0123526
R2651 VDD.n1040 VDD.n74 0.0123526
R2652 VDD.n1037 VDD.n68 0.0123526
R2653 VDD.n1067 VDD.n56 0.0123526
R2654 VDD.n1073 VDD.n50 0.0123526
R2655 VDD.n1227 VDD.n246 0.0123526
R2656 VDD.n1221 VDD.n240 0.0123526
R2657 VDD.n1278 VDD.n1277 0.0123526
R2658 VDD.n1264 VDD.n1262 0.0123526
R2659 VDD.n570 VDD.n569 0.0123526
R2660 VDD.n584 VDD.n583 0.0123526
R2661 VDD.n1004 VDD.n1003 0.0123526
R2662 VDD.n992 VDD.n991 0.0123526
R2663 VDD.n365 VDD.n364 0.0123526
R2664 VDD.n376 VDD.n375 0.0123526
R2665 VDD.n946 VDD.n490 0.0123526
R2666 VDD.n940 VDD.n484 0.0123526
R2667 VDD.n872 VDD.n514 0.0123526
R2668 VDD.n865 VDD.n508 0.0123526
R2669 VDD.n444 VDD.n435 0.0123526
R2670 VDD.n456 VDD.n426 0.0123526
R2671 VDD.n1317 VDD.n221 0.0117287
R2672 VDD.n1107 VDD.n88 0.0117287
R2673 VDD.n1032 VDD.n69 0.0117287
R2674 VDD.n1072 VDD.n51 0.0117287
R2675 VDD.n1222 VDD.n241 0.0117287
R2676 VDD.n1266 VDD.n1263 0.0117287
R2677 VDD.n572 VDD.n571 0.0117287
R2678 VDD.n1002 VDD.n1001 0.0117287
R2679 VDD.n367 VDD.n366 0.0117287
R2680 VDD.n945 VDD.n489 0.0117287
R2681 VDD.n871 VDD.n513 0.0117287
R2682 VDD.n449 VDD.n434 0.0117287
R2683 VDD.n1322 VDD.n225 0.0115208
R2684 VDD.n1103 VDD.n92 0.0115208
R2685 VDD.n1030 VDD.n73 0.0115208
R2686 VDD.n1068 VDD.n55 0.0115208
R2687 VDD.n1226 VDD.n245 0.0115208
R2688 VDD.n1276 VDD.n1275 0.0115208
R2689 VDD.n582 VDD.n581 0.0115208
R2690 VDD.n994 VDD.n993 0.0115208
R2691 VDD.n374 VDD.n373 0.0115208
R2692 VDD.n941 VDD.n485 0.0115208
R2693 VDD.n866 VDD.n509 0.0115208
R2694 VDD.n457 VDD.n427 0.0115208
R2695 VDD.n1318 VDD.n222 0.0111049
R2696 VDD.n1106 VDD.n89 0.0111049
R2697 VDD.n1038 VDD.n70 0.0111049
R2698 VDD.n1071 VDD.n52 0.0111049
R2699 VDD.n1223 VDD.n242 0.0111049
R2700 VDD.n1269 VDD.n1267 0.0111049
R2701 VDD.n574 VDD.n573 0.0111049
R2702 VDD.n1000 VDD.n999 0.0111049
R2703 VDD.n369 VDD.n368 0.0111049
R2704 VDD.n944 VDD.n488 0.0111049
R2705 VDD.n870 VDD.n512 0.0111049
R2706 VDD.n448 VDD.n433 0.0111049
R2707 VDD.n1321 VDD.n224 0.010897
R2708 VDD.n1104 VDD.n91 0.010897
R2709 VDD.n1039 VDD.n72 0.010897
R2710 VDD.n1069 VDD.n54 0.010897
R2711 VDD.n1225 VDD.n244 0.010897
R2712 VDD.n1273 VDD.n1272 0.010897
R2713 VDD.n580 VDD.n579 0.010897
R2714 VDD.n996 VDD.n995 0.010897
R2715 VDD.n372 VDD.n371 0.010897
R2716 VDD.n942 VDD.n486 0.010897
R2717 VDD.n867 VDD.n510 0.010897
R2718 VDD.n452 VDD.n428 0.010897
R2719 VDD.n1320 VDD.n223 0.0102732
R2720 VDD.n1105 VDD.n90 0.0102732
R2721 VDD.n1031 VDD.n71 0.0102732
R2722 VDD.n1070 VDD.n53 0.0102732
R2723 VDD.n1224 VDD.n243 0.0102732
R2724 VDD.n1271 VDD.n1249 0.0102732
R2725 VDD.n578 VDD.n577 0.0102732
R2726 VDD.n997 VDD.n354 0.0102732
R2727 VDD.n381 VDD.n370 0.0102732
R2728 VDD.n943 VDD.n487 0.0102732
R2729 VDD.n868 VDD.n511 0.0102732
R2730 VDD.n453 VDD.n429 0.0102732
R2731 VDD.n1348 VDD 0.00974
R2732 VDD.n890 VDD 0.00974
R2733 VDD.n1078 VDD.n1077 0.00935329
R2734 VDD.n576 VDD.n575 0.00935329
R2735 VDD.n382 VDD.n356 0.00935329
R2736 VDD.n1113 VDD.n1112 0.00935329
R2737 VDD.n1236 VDD.n1235 0.00935329
R2738 VDD.n936 VDD.n935 0.00935329
R2739 VDD.n1311 VDD.n230 0.00848288
R2740 VDD.n1326 VDD.n230 0.00848288
R2741 VDD.n1312 VDD.n216 0.00848288
R2742 VDD.n1111 VDD.n97 0.00848288
R2743 VDD.n1099 VDD.n97 0.00848288
R2744 VDD.n1096 VDD.n83 0.00848288
R2745 VDD.n1042 VDD.n78 0.00848288
R2746 VDD.n1028 VDD.n78 0.00848288
R2747 VDD.n1035 VDD.n64 0.00848288
R2748 VDD.n1076 VDD.n60 0.00848288
R2749 VDD.n1064 VDD.n60 0.00848288
R2750 VDD.n1061 VDD.n46 0.00848288
R2751 VDD.n1234 VDD.n250 0.00848288
R2752 VDD.n1230 VDD.n250 0.00848288
R2753 VDD.n1231 VDD.n236 0.00848288
R2754 VDD.n1283 VDD.n1251 0.00848288
R2755 VDD.n1287 VDD.n1283 0.00848288
R2756 VDD.n562 VDD.n561 0.00848288
R2757 VDD.n590 VDD.n560 0.00848288
R2758 VDD.n592 VDD.n560 0.00848288
R2759 VDD.n1009 VDD.n982 0.00848288
R2760 VDD.n985 VDD.n984 0.00848288
R2761 VDD.n984 VDD.n983 0.00848288
R2762 VDD.n413 VDD.n355 0.00848288
R2763 VDD.n410 VDD.n409 0.00848288
R2764 VDD.n409 VDD.n408 0.00848288
R2765 VDD.n952 VDD.n494 0.00848288
R2766 VDD.n937 VDD.n480 0.00848288
R2767 VDD.n949 VDD.n480 0.00848288
R2768 VDD.n860 VDD.n518 0.00848288
R2769 VDD.n862 VDD.n504 0.00848288
R2770 VDD.n861 VDD.n504 0.00848288
R2771 VDD.n966 VDD.n421 0.00848288
R2772 VDD.n1319 VDD.n1310 0.00848253
R2773 VDD.n1327 VDD.n1310 0.00848253
R2774 VDD.n1043 VDD.n1027 0.00848253
R2775 VDD.n1044 VDD.n1043 0.00848253
R2776 VDD.n1270 VDD.n1250 0.00848253
R2777 VDD.n1288 VDD.n1250 0.00848253
R2778 VDD.n998 VDD.n353 0.00848253
R2779 VDD.n1012 VDD.n353 0.00848253
R2780 VDD.n869 VDD.n859 0.00848253
R2781 VDD.n876 VDD.n859 0.00848253
R2782 VDD.n432 VDD.n431 0.00848253
R2783 VDD.n431 VDD.n430 0.00848253
R2784 VDD.n1313 VDD.n216 0.00827494
R2785 VDD.n1097 VDD.n83 0.00827494
R2786 VDD.n1034 VDD.n64 0.00827494
R2787 VDD.n1062 VDD.n46 0.00827494
R2788 VDD.n1232 VDD.n236 0.00827494
R2789 VDD.n563 VDD.n562 0.00827494
R2790 VDD.n1011 VDD.n1009 0.00827494
R2791 VDD.n358 VDD.n355 0.00827494
R2792 VDD.n950 VDD.n494 0.00827494
R2793 VDD.n875 VDD.n518 0.00827494
R2794 VDD.n965 VDD.n421 0.00827494
R2795 VDD.n1295 VDD 0.00813889
R2796 VDD.n1347 VDD 0.00813889
R2797 VDD.n280 VDD 0.00813889
R2798 VDD.n1140 VDD 0.00813889
R2799 VDD.n1087 VDD 0.00813889
R2800 VDD VDD.n886 0.00813889
R2801 VDD.n919 VDD 0.00813889
R2802 VDD.n793 VDD 0.00813889
R2803 VDD.n702 VDD 0.00813889
R2804 VDD.n396 VDD 0.00813889
R2805 VDD.n1197 VDD.n198 0.00788477
R2806 VDD.n1167 VDD.n189 0.00788477
R2807 VDD.n309 VDD.n122 0.00788477
R2808 VDD.n327 VDD.n103 0.00788477
R2809 VDD.n816 VDD.n815 0.00788477
R2810 VDD.n750 VDD.n749 0.00788477
R2811 VDD.n671 VDD.n670 0.00788477
R2812 VDD.n619 VDD.n618 0.00788477
R2813 VDD.n1191 VDD.n212 0.00777455
R2814 VDD.n1190 VDD.n210 0.00777455
R2815 VDD.n1161 VDD.n175 0.00777455
R2816 VDD.n1160 VDD.n177 0.00777455
R2817 VDD.n303 VDD.n136 0.00777455
R2818 VDD.n302 VDD.n134 0.00777455
R2819 VDD.n335 VDD.n117 0.00777455
R2820 VDD.n320 VDD.n115 0.00777455
R2821 VDD.n831 VDD.n830 0.00777455
R2822 VDD.n833 VDD.n832 0.00777455
R2823 VDD.n765 VDD.n764 0.00777455
R2824 VDD.n767 VDD.n766 0.00777455
R2825 VDD.n686 VDD.n685 0.00777455
R2826 VDD.n688 VDD.n687 0.00777455
R2827 VDD.n634 VDD.n633 0.00777455
R2828 VDD.n636 VDD.n635 0.00777455
R2829 VDD.n1212 VDD.n1211 0.00763514
R2830 VDD.n1214 VDD.n1182 0.00763514
R2831 VDD.n1172 VDD.n1150 0.00763514
R2832 VDD.n1152 VDD.n273 0.00763514
R2833 VDD.n1133 VDD.n1132 0.00763514
R2834 VDD.n1135 VDD.n294 0.00763514
R2835 VDD.n1124 VDD.n1123 0.00763514
R2836 VDD.n1126 VDD.n317 0.00763514
R2837 VDD.n838 VDD.n799 0.00763514
R2838 VDD.n835 VDD.n801 0.00763514
R2839 VDD.n772 VDD.n730 0.00763514
R2840 VDD.n769 VDD.n735 0.00763514
R2841 VDD.n721 VDD.n654 0.00763514
R2842 VDD.n718 VDD.n656 0.00763514
R2843 VDD.n641 VDD.n602 0.00763514
R2844 VDD.n639 VDD.n638 0.00763514
R2845 VDD.n1196 VDD.n199 0.00755411
R2846 VDD.n1166 VDD.n188 0.00755411
R2847 VDD.n308 VDD.n123 0.00755411
R2848 VDD.n329 VDD.n104 0.00755411
R2849 VDD.n814 VDD.n813 0.00755411
R2850 VDD.n748 VDD.n747 0.00755411
R2851 VDD.n669 VDD.n668 0.00755411
R2852 VDD.n617 VDD.n616 0.00755411
R2853 VDD.n1189 VDD.n209 0.00744389
R2854 VDD.n1159 VDD.n178 0.00744389
R2855 VDD.n301 VDD.n133 0.00744389
R2856 VDD.n334 VDD.n114 0.00744389
R2857 VDD.n829 VDD.n828 0.00744389
R2858 VDD.n763 VDD.n762 0.00744389
R2859 VDD.n684 VDD.n683 0.00744389
R2860 VDD.n632 VDD.n631 0.00744389
R2861 VDD.n1195 VDD.n200 0.00722345
R2862 VDD.n1165 VDD.n187 0.00722345
R2863 VDD.n307 VDD.n124 0.00722345
R2864 VDD.n326 VDD.n105 0.00722345
R2865 VDD.n812 VDD.n811 0.00722345
R2866 VDD.n746 VDD.n745 0.00722345
R2867 VDD.n667 VDD.n666 0.00722345
R2868 VDD.n615 VDD.n614 0.00722345
R2869 VDD.n1188 VDD.n208 0.00711323
R2870 VDD.n1158 VDD.n179 0.00711323
R2871 VDD.n300 VDD.n132 0.00711323
R2872 VDD.n321 VDD.n113 0.00711323
R2873 VDD.n827 VDD.n826 0.00711323
R2874 VDD.n761 VDD.n760 0.00711323
R2875 VDD.n682 VDD.n681 0.00711323
R2876 VDD.n630 VDD.n629 0.00711323
R2877 VDD.n1187 VDD.n207 0.00678257
R2878 VDD.n1194 VDD.n201 0.00678257
R2879 VDD.n1157 VDD.n180 0.00678257
R2880 VDD.n1164 VDD.n186 0.00678257
R2881 VDD.n299 VDD.n131 0.00678257
R2882 VDD.n306 VDD.n125 0.00678257
R2883 VDD.n333 VDD.n112 0.00678257
R2884 VDD.n330 VDD.n106 0.00678257
R2885 VDD.n810 VDD.n809 0.00678257
R2886 VDD.n825 VDD.n824 0.00678257
R2887 VDD.n744 VDD.n743 0.00678257
R2888 VDD.n759 VDD.n758 0.00678257
R2889 VDD.n665 VDD.n664 0.00678257
R2890 VDD.n680 VDD.n679 0.00678257
R2891 VDD.n613 VDD.n612 0.00678257
R2892 VDD.n628 VDD.n627 0.00678257
R2893 VDD.n1328 VDD.n231 0.00673819
R2894 VDD.n1114 VDD.n98 0.00673819
R2895 VDD.n1045 VDD.n79 0.00673819
R2896 VDD.n1079 VDD.n61 0.00673819
R2897 VDD.n1237 VDD.n251 0.00673819
R2898 VDD.n1289 VDD.n32 0.00673819
R2899 VDD.n594 VDD.n593 0.00673819
R2900 VDD.n1014 VDD.n352 0.00673819
R2901 VDD.n407 VDD.n406 0.00673819
R2902 VDD.n933 VDD.n479 0.00673819
R2903 VDD.n877 VDD.n503 0.00673819
R2904 VDD.n475 VDD.n474 0.00673819
R2905 VDD.n1193 VDD.n202 0.0064519
R2906 VDD.n1163 VDD.n185 0.0064519
R2907 VDD.n305 VDD.n126 0.0064519
R2908 VDD.n325 VDD.n107 0.0064519
R2909 VDD.n808 VDD.n807 0.0064519
R2910 VDD.n742 VDD.n741 0.0064519
R2911 VDD.n663 VDD.n662 0.0064519
R2912 VDD.n611 VDD.n610 0.0064519
R2913 VDD.n1186 VDD.n206 0.00634168
R2914 VDD.n1156 VDD.n181 0.00634168
R2915 VDD.n298 VDD.n130 0.00634168
R2916 VDD.n322 VDD.n111 0.00634168
R2917 VDD.n823 VDD.n822 0.00634168
R2918 VDD.n757 VDD.n756 0.00634168
R2919 VDD.n678 VDD.n677 0.00634168
R2920 VDD.n626 VDD.n625 0.00634168
R2921 VDD.n1192 VDD.n203 0.00612124
R2922 VDD.n1162 VDD.n184 0.00612124
R2923 VDD.n304 VDD.n127 0.00612124
R2924 VDD.n331 VDD.n108 0.00612124
R2925 VDD.n806 VDD.n805 0.00612124
R2926 VDD.n740 VDD.n739 0.00612124
R2927 VDD.n661 VDD.n660 0.00612124
R2928 VDD.n609 VDD.n608 0.00612124
R2929 VDD.n1213 VDD.n1200 0.00609085
R2930 VDD.n1171 VDD.n1170 0.00609085
R2931 VDD.n1134 VDD.n312 0.00609085
R2932 VDD.n1125 VDD.n319 0.00609085
R2933 VDD.n804 VDD.n800 0.00609085
R2934 VDD.n738 VDD.n731 0.00609085
R2935 VDD.n659 VDD.n655 0.00609085
R2936 VDD.n607 VDD.n603 0.00609085
R2937 VDD.n1185 VDD.n205 0.00601102
R2938 VDD.n1155 VDD.n182 0.00601102
R2939 VDD.n297 VDD.n129 0.00601102
R2940 VDD.n332 VDD.n110 0.00601102
R2941 VDD.n821 VDD.n820 0.00601102
R2942 VDD.n755 VDD.n754 0.00601102
R2943 VDD.n676 VDD.n675 0.00601102
R2944 VDD.n624 VDD.n623 0.00601102
R2945 VDD.n1200 VDD.n1199 0.00584055
R2946 VDD.n1170 VDD.n1169 0.00584055
R2947 VDD.n312 VDD.n311 0.00584055
R2948 VDD.n324 VDD.n319 0.00584055
R2949 VDD.n837 VDD.n800 0.00584055
R2950 VDD.n771 VDD.n731 0.00584055
R2951 VDD.n720 VDD.n655 0.00584055
R2952 VDD.n640 VDD.n603 0.00584055
R2953 VDD.n959 VDD.n957 0.00571068
R2954 VDD.n1184 VDD.n204 0.00568036
R2955 VDD.n1154 VDD.n183 0.00568036
R2956 VDD.n296 VDD.n128 0.00568036
R2957 VDD.n323 VDD.n109 0.00568036
R2958 VDD.n819 VDD.n802 0.00568036
R2959 VDD.n753 VDD.n736 0.00568036
R2960 VDD.n674 VDD.n657 0.00568036
R2961 VDD.n622 VDD.n605 0.00568036
R2962 VDD.n1327 VDD.n223 0.00549055
R2963 VDD.n1113 VDD.n90 0.00549055
R2964 VDD.n1044 VDD.n71 0.00549055
R2965 VDD.n1078 VDD.n53 0.00549055
R2966 VDD.n1236 VDD.n243 0.00549055
R2967 VDD.n1288 VDD.n1249 0.00549055
R2968 VDD.n577 VDD.n576 0.00549055
R2969 VDD.n1012 VDD.n354 0.00549055
R2970 VDD.n382 VDD.n381 0.00549055
R2971 VDD.n935 VDD.n487 0.00549055
R2972 VDD.n876 VDD.n511 0.00549055
R2973 VDD.n453 VDD.n430 0.00549055
R2974 VDD.n1198 VDD.n197 0.00496711
R2975 VDD.n1168 VDD.n190 0.00496711
R2976 VDD.n310 VDD.n121 0.00496711
R2977 VDD.n328 VDD.n102 0.00496711
R2978 VDD.n831 VDD.n803 0.00496711
R2979 VDD.n832 VDD.n803 0.00496711
R2980 VDD.n765 VDD.n737 0.00496711
R2981 VDD.n766 VDD.n737 0.00496711
R2982 VDD.n686 VDD.n658 0.00496711
R2983 VDD.n687 VDD.n658 0.00496711
R2984 VDD.n634 VDD.n606 0.00496711
R2985 VDD.n635 VDD.n606 0.00496711
R2986 VDD.n1191 VDD.n211 0.00496711
R2987 VDD.n1190 VDD.n211 0.00496711
R2988 VDD.n1161 VDD.n176 0.00496711
R2989 VDD.n1160 VDD.n176 0.00496711
R2990 VDD.n303 VDD.n135 0.00496711
R2991 VDD.n302 VDD.n135 0.00496711
R2992 VDD.n335 VDD.n116 0.00496711
R2993 VDD.n320 VDD.n116 0.00496711
R2994 VDD.n818 VDD.n817 0.00496711
R2995 VDD.n752 VDD.n751 0.00496711
R2996 VDD.n673 VDD.n672 0.00496711
R2997 VDD.n621 VDD.n620 0.00496711
R2998 VDD.n1320 VDD.n224 0.00486673
R2999 VDD.n1105 VDD.n91 0.00486673
R3000 VDD.n1031 VDD.n72 0.00486673
R3001 VDD.n1070 VDD.n54 0.00486673
R3002 VDD.n1224 VDD.n244 0.00486673
R3003 VDD.n1273 VDD.n1271 0.00486673
R3004 VDD.n579 VDD.n578 0.00486673
R3005 VDD.n997 VDD.n996 0.00486673
R3006 VDD.n371 VDD.n370 0.00486673
R3007 VDD.n943 VDD.n486 0.00486673
R3008 VDD.n868 VDD.n510 0.00486673
R3009 VDD.n452 VDD.n429 0.00486673
R3010 VDD.n1197 VDD.n197 0.00485689
R3011 VDD.n1167 VDD.n190 0.00485689
R3012 VDD.n309 VDD.n121 0.00485689
R3013 VDD.n327 VDD.n102 0.00485689
R3014 VDD.n817 VDD.n816 0.00485689
R3015 VDD.n751 VDD.n750 0.00485689
R3016 VDD.n672 VDD.n671 0.00485689
R3017 VDD.n620 VDD.n619 0.00485689
R3018 VDD.n1319 VDD.n222 0.00465879
R3019 VDD.n1027 VDD.n70 0.00465879
R3020 VDD.n1270 VDD.n1269 0.00465879
R3021 VDD.n999 VDD.n998 0.00465879
R3022 VDD.n869 VDD.n512 0.00465879
R3023 VDD.n448 VDD.n432 0.00465879
R3024 VDD.n1343 VDD.n195 0.00456101
R3025 VDD.n1343 VDD.n193 0.00456101
R3026 VDD.n971 VDD.n350 0.00456101
R3027 VDD.n973 VDD.n350 0.00456101
R3028 VDD.n1321 VDD.n225 0.00424291
R3029 VDD.n1104 VDD.n92 0.00424291
R3030 VDD.n1039 VDD.n73 0.00424291
R3031 VDD.n1069 VDD.n55 0.00424291
R3032 VDD.n1225 VDD.n245 0.00424291
R3033 VDD.n1275 VDD.n1272 0.00424291
R3034 VDD.n581 VDD.n580 0.00424291
R3035 VDD.n995 VDD.n994 0.00424291
R3036 VDD.n373 VDD.n372 0.00424291
R3037 VDD.n942 VDD.n485 0.00424291
R3038 VDD.n867 VDD.n509 0.00424291
R3039 VDD.n457 VDD.n428 0.00424291
R3040 VDD.n1318 VDD.n221 0.00403497
R3041 VDD.n1106 VDD.n88 0.00403497
R3042 VDD.n1038 VDD.n69 0.00403497
R3043 VDD.n1071 VDD.n51 0.00403497
R3044 VDD.n1223 VDD.n241 0.00403497
R3045 VDD.n1267 VDD.n1266 0.00403497
R3046 VDD.n573 VDD.n572 0.00403497
R3047 VDD.n1001 VDD.n1000 0.00403497
R3048 VDD.n369 VDD.n367 0.00403497
R3049 VDD.n944 VDD.n489 0.00403497
R3050 VDD.n870 VDD.n513 0.00403497
R3051 VDD.n449 VDD.n433 0.00403497
R3052 VDD.n1210 VDD.n212 0.00380661
R3053 VDD.n1151 VDD.n175 0.00380661
R3054 VDD.n1131 VDD.n136 0.00380661
R3055 VDD.n1122 VDD.n117 0.00380661
R3056 VDD.n834 VDD.n833 0.00380661
R3057 VDD.n768 VDD.n767 0.00380661
R3058 VDD.n717 VDD.n688 0.00380661
R3059 VDD.n637 VDD.n636 0.00380661
R3060 VDD.n1343 VDD.n45 0.00376702
R3061 VDD.n1322 VDD.n226 0.00361909
R3062 VDD.n1103 VDD.n93 0.00361909
R3063 VDD.n1030 VDD.n74 0.00361909
R3064 VDD.n1068 VDD.n56 0.00361909
R3065 VDD.n1226 VDD.n246 0.00361909
R3066 VDD.n1278 VDD.n1276 0.00361909
R3067 VDD.n583 VDD.n582 0.00361909
R3068 VDD.n993 VDD.n992 0.00361909
R3069 VDD.n375 VDD.n374 0.00361909
R3070 VDD.n941 VDD.n484 0.00361909
R3071 VDD.n866 VDD.n508 0.00361909
R3072 VDD.n456 VDD.n427 0.00361909
R3073 VDD.n414 VDD.n350 0.00344016
R3074 VDD.n1317 VDD.n220 0.00341115
R3075 VDD.n1107 VDD.n87 0.00341115
R3076 VDD.n1032 VDD.n68 0.00341115
R3077 VDD.n1072 VDD.n50 0.00341115
R3078 VDD.n1222 VDD.n240 0.00341115
R3079 VDD.n1264 VDD.n1263 0.00341115
R3080 VDD.n571 VDD.n570 0.00341115
R3081 VDD.n1003 VDD.n1002 0.00341115
R3082 VDD.n366 VDD.n365 0.00341115
R3083 VDD.n945 VDD.n490 0.00341115
R3084 VDD.n871 VDD.n514 0.00341115
R3085 VDD.n444 VDD.n434 0.00341115
R3086 VDD.n1213 VDD.n204 0.00314529
R3087 VDD.n1171 VDD.n183 0.00314529
R3088 VDD.n1134 VDD.n128 0.00314529
R3089 VDD.n1125 VDD.n109 0.00314529
R3090 VDD.n837 VDD.n802 0.00314529
R3091 VDD.n771 VDD.n736 0.00314529
R3092 VDD.n720 VDD.n657 0.00314529
R3093 VDD.n640 VDD.n605 0.00314529
R3094 VDD.n1184 VDD.n205 0.00281463
R3095 VDD.n1154 VDD.n182 0.00281463
R3096 VDD.n296 VDD.n129 0.00281463
R3097 VDD.n323 VDD.n110 0.00281463
R3098 VDD.n820 VDD.n819 0.00281463
R3099 VDD.n754 VDD.n753 0.00281463
R3100 VDD.n675 VDD.n674 0.00281463
R3101 VDD.n623 VDD.n622 0.00281463
R3102 VDD.n1323 VDD.n227 0.00278733
R3103 VDD.n1316 VDD.n219 0.00278733
R3104 VDD.n1102 VDD.n94 0.00278733
R3105 VDD.n1108 VDD.n86 0.00278733
R3106 VDD.n1040 VDD.n75 0.00278733
R3107 VDD.n1037 VDD.n67 0.00278733
R3108 VDD.n1067 VDD.n57 0.00278733
R3109 VDD.n1073 VDD.n49 0.00278733
R3110 VDD.n1227 VDD.n247 0.00278733
R3111 VDD.n1221 VDD.n239 0.00278733
R3112 VDD.n1280 VDD.n1277 0.00278733
R3113 VDD.n1262 VDD.n1261 0.00278733
R3114 VDD.n569 VDD.n568 0.00278733
R3115 VDD.n585 VDD.n584 0.00278733
R3116 VDD.n1005 VDD.n1004 0.00278733
R3117 VDD.n991 VDD.n990 0.00278733
R3118 VDD.n364 VDD.n363 0.00278733
R3119 VDD.n377 VDD.n376 0.00278733
R3120 VDD.n946 VDD.n491 0.00278733
R3121 VDD.n940 VDD.n483 0.00278733
R3122 VDD.n872 VDD.n515 0.00278733
R3123 VDD.n865 VDD.n507 0.00278733
R3124 VDD.n445 VDD.n435 0.00278733
R3125 VDD.n461 VDD.n426 0.00278733
R3126 VDD.n1199 VDD.n203 0.00270441
R3127 VDD.n1169 VDD.n184 0.00270441
R3128 VDD.n311 VDD.n127 0.00270441
R3129 VDD.n324 VDD.n108 0.00270441
R3130 VDD.n805 VDD.n804 0.00270441
R3131 VDD.n739 VDD.n738 0.00270441
R3132 VDD.n660 VDD.n659 0.00270441
R3133 VDD.n608 VDD.n607 0.00270441
R3134 VDD.n1185 VDD.n206 0.00248397
R3135 VDD.n1155 VDD.n181 0.00248397
R3136 VDD.n297 VDD.n130 0.00248397
R3137 VDD.n332 VDD.n111 0.00248397
R3138 VDD.n822 VDD.n821 0.00248397
R3139 VDD.n756 VDD.n755 0.00248397
R3140 VDD.n677 VDD.n676 0.00248397
R3141 VDD.n625 VDD.n624 0.00248397
R3142 VDD.n1192 VDD.n202 0.00237375
R3143 VDD.n1162 VDD.n185 0.00237375
R3144 VDD.n304 VDD.n126 0.00237375
R3145 VDD.n331 VDD.n107 0.00237375
R3146 VDD.n807 VDD.n806 0.00237375
R3147 VDD.n741 VDD.n740 0.00237375
R3148 VDD.n662 VDD.n661 0.00237375
R3149 VDD.n610 VDD.n609 0.00237375
R3150 VDD.n1324 VDD.n228 0.00216352
R3151 VDD.n1101 VDD.n95 0.00216352
R3152 VDD.n1029 VDD.n76 0.00216352
R3153 VDD.n1066 VDD.n58 0.00216352
R3154 VDD.n1228 VDD.n248 0.00216352
R3155 VDD.n1284 VDD.n1281 0.00216352
R3156 VDD.n587 VDD.n586 0.00216352
R3157 VDD.n989 VDD.n988 0.00216352
R3158 VDD.n379 VDD.n378 0.00216352
R3159 VDD.n939 VDD.n482 0.00216352
R3160 VDD.n864 VDD.n506 0.00216352
R3161 VDD.n460 VDD.n425 0.00216352
R3162 VDD.n1186 VDD.n207 0.00215331
R3163 VDD.n1156 VDD.n180 0.00215331
R3164 VDD.n298 VDD.n131 0.00215331
R3165 VDD.n322 VDD.n112 0.00215331
R3166 VDD.n824 VDD.n823 0.00215331
R3167 VDD.n758 VDD.n757 0.00215331
R3168 VDD.n679 VDD.n678 0.00215331
R3169 VDD.n627 VDD.n626 0.00215331
R3170 VDD.n1193 VDD.n201 0.00204309
R3171 VDD.n1163 VDD.n186 0.00204309
R3172 VDD.n305 VDD.n125 0.00204309
R3173 VDD.n325 VDD.n106 0.00204309
R3174 VDD.n809 VDD.n808 0.00204309
R3175 VDD.n743 VDD.n742 0.00204309
R3176 VDD.n664 VDD.n663 0.00204309
R3177 VDD.n612 VDD.n611 0.00204309
R3178 VDD.n1344 VDD.n31 0.00199911
R3179 VDD.n961 VDD.n960 0.00196967
R3180 VDD.n1315 VDD.n218 0.00195558
R3181 VDD.n1109 VDD.n85 0.00195558
R3182 VDD.n1033 VDD.n66 0.00195558
R3183 VDD.n1074 VDD.n48 0.00195558
R3184 VDD.n1220 VDD.n238 0.00195558
R3185 VDD.n1259 VDD.n1258 0.00195558
R3186 VDD.n567 VDD.n566 0.00195558
R3187 VDD.n1007 VDD.n1006 0.00195558
R3188 VDD.n362 VDD.n361 0.00195558
R3189 VDD.n947 VDD.n492 0.00195558
R3190 VDD.n873 VDD.n516 0.00195558
R3191 VDD.n438 VDD.n436 0.00195558
R3192 VDD.n1187 VDD.n208 0.00171242
R3193 VDD.n1194 VDD.n200 0.00171242
R3194 VDD.n1157 VDD.n179 0.00171242
R3195 VDD.n1164 VDD.n187 0.00171242
R3196 VDD.n299 VDD.n132 0.00171242
R3197 VDD.n306 VDD.n124 0.00171242
R3198 VDD.n333 VDD.n113 0.00171242
R3199 VDD.n330 VDD.n105 0.00171242
R3200 VDD.n811 VDD.n810 0.00171242
R3201 VDD.n826 VDD.n825 0.00171242
R3202 VDD.n745 VDD.n744 0.00171242
R3203 VDD.n760 VDD.n759 0.00171242
R3204 VDD.n666 VDD.n665 0.00171242
R3205 VDD.n681 VDD.n680 0.00171242
R3206 VDD.n614 VDD.n613 0.00171242
R3207 VDD.n629 VDD.n628 0.00171242
R3208 VDD.n1325 VDD.n229 0.0015397
R3209 VDD.n1100 VDD.n96 0.0015397
R3210 VDD.n1041 VDD.n77 0.0015397
R3211 VDD.n1065 VDD.n59 0.0015397
R3212 VDD.n1229 VDD.n249 0.0015397
R3213 VDD.n1286 VDD.n1282 0.0015397
R3214 VDD.n589 VDD.n588 0.0015397
R3215 VDD.n987 VDD.n986 0.0015397
R3216 VDD.n412 VDD.n411 0.0015397
R3217 VDD.n938 VDD.n481 0.0015397
R3218 VDD.n863 VDD.n505 0.0015397
R3219 VDD.n469 VDD.n424 0.0015397
R3220 VDD.n1188 VDD.n209 0.00138176
R3221 VDD.n1158 VDD.n178 0.00138176
R3222 VDD.n300 VDD.n133 0.00138176
R3223 VDD.n321 VDD.n114 0.00138176
R3224 VDD.n828 VDD.n827 0.00138176
R3225 VDD.n762 VDD.n761 0.00138176
R3226 VDD.n683 VDD.n682 0.00138176
R3227 VDD.n631 VDD.n630 0.00138176
R3228 VDD.n1314 VDD.n217 0.00133176
R3229 VDD.n1110 VDD.n84 0.00133176
R3230 VDD.n1036 VDD.n65 0.00133176
R3231 VDD.n1075 VDD.n47 0.00133176
R3232 VDD.n1219 VDD.n237 0.00133176
R3233 VDD.n1257 VDD.n1256 0.00133176
R3234 VDD.n565 VDD.n564 0.00133176
R3235 VDD.n1010 VDD.n1008 0.00133176
R3236 VDD.n360 VDD.n359 0.00133176
R3237 VDD.n948 VDD.n493 0.00133176
R3238 VDD.n874 VDD.n517 0.00133176
R3239 VDD.n964 VDD.n437 0.00133176
R3240 VDD.n1195 VDD.n199 0.00127154
R3241 VDD.n1165 VDD.n188 0.00127154
R3242 VDD.n307 VDD.n123 0.00127154
R3243 VDD.n326 VDD.n104 0.00127154
R3244 VDD.n813 VDD.n812 0.00127154
R3245 VDD.n747 VDD.n746 0.00127154
R3246 VDD.n668 VDD.n667 0.00127154
R3247 VDD.n616 VDD.n615 0.00127154
R3248 VDD.t92 VDD.n1098 0.00124999
R3249 VDD.t97 VDD.n1063 0.00124999
R3250 VDD.t17 VDD.n1233 0.00124999
R3251 VDD.n591 VDD.t137 0.00124999
R3252 VDD.t142 VDD.n357 0.00124999
R3253 VDD.n951 VDD.t112 0.00124999
R3254 VDD.n1189 VDD.n210 0.0010511
R3255 VDD.n1159 VDD.n177 0.0010511
R3256 VDD.n301 VDD.n134 0.0010511
R3257 VDD.n334 VDD.n115 0.0010511
R3258 VDD.n830 VDD.n829 0.0010511
R3259 VDD.n764 VDD.n763 0.0010511
R3260 VDD.n685 VDD.n684 0.0010511
R3261 VDD.n633 VDD.n632 0.0010511
R3262 VDD.n961 VDD.n350 0.0010303
R3263 VDD.n1344 VDD.n1343 0.00100086
R3264 VDD.n31 VDD.n23 0.001
R3265 VDD.n1285 VDD.n24 0.001
R3266 VDD.n1279 VDD.n25 0.001
R3267 VDD.n1274 VDD.n26 0.001
R3268 VDD.n1268 VDD.n27 0.001
R3269 VDD.n1265 VDD.n28 0.001
R3270 VDD.n1260 VDD.n29 0.001
R3271 VDD.n1255 VDD.n30 0.001
R3272 VDD.n1343 VDD.n30 0.001
R3273 VDD.n1255 VDD.n29 0.001
R3274 VDD.n1260 VDD.n28 0.001
R3275 VDD.n1265 VDD.n27 0.001
R3276 VDD.n1268 VDD.n26 0.001
R3277 VDD.n1274 VDD.n25 0.001
R3278 VDD.n1279 VDD.n24 0.001
R3279 VDD.n1285 VDD.n23 0.001
R3280 VDD.n443 VDD.n350 0.001
R3281 VDD.n962 VDD.n440 0.001
R3282 VDD.n963 VDD.n439 0.001
R3283 VDD.n447 VDD.n446 0.001
R3284 VDD.n451 VDD.n450 0.001
R3285 VDD.n455 VDD.n454 0.001
R3286 VDD.n459 VDD.n458 0.001
R3287 VDD.n463 VDD.n462 0.001
R3288 VDD.n470 VDD.n464 0.001
R3289 VDD.n473 VDD.n465 0.001
R3290 VDD.n956 VDD.n467 0.001
R3291 VDD.n960 VDD.n441 0.001
R3292 VDD.n958 VDD.n442 0.001
R3293 VDD.n467 VDD.n350 0.001
R3294 VDD.n956 VDD.n465 0.001
R3295 VDD.n473 VDD.n464 0.001
R3296 VDD.n470 VDD.n463 0.001
R3297 VDD.n462 VDD.n459 0.001
R3298 VDD.n458 VDD.n455 0.001
R3299 VDD.n454 VDD.n451 0.001
R3300 VDD.n450 VDD.n447 0.001
R3301 VDD.n446 VDD.n439 0.001
R3302 VDD.n963 VDD.n962 0.001
R3303 VDD.n443 VDD.n440 0.001
R3304 VDD.n956 VDD.n442 0.001
R3305 VDD.n958 VDD.n441 0.001
R3306 VDD.n1196 VDD.n198 0.000940882
R3307 VDD.n1166 VDD.n189 0.000940882
R3308 VDD.n308 VDD.n122 0.000940882
R3309 VDD.n329 VDD.n103 0.000940882
R3310 VDD.n815 VDD.n814 0.000940882
R3311 VDD.n749 VDD.n748 0.000940882
R3312 VDD.n670 VDD.n669 0.000940882
R3313 VDD.n618 VDD.n617 0.000940882
R3314 VDD.n1252 VDD.n33 0.000915879
R3315 VDD.n471 VDD.n423 0.000915879
R3316 VDD.n472 VDD.n422 0.000915879
R3317 VDD.n1254 VDD.n1253 0.00070794
R3318 VSS.n1487 VSS.n1486 11665.2
R3319 VSS.n1486 VSS.n220 11665.2
R3320 VSS.n2075 VSS.n203 5637.93
R3321 VSS.n2075 VSS.n2074 5637.93
R3322 VSS.n2076 VSS.n2075 781.885
R3323 VSS.n1777 VSS.n32 476.896
R3324 VSS.n1486 VSS.n888 454.714
R3325 VSS.t77 VSS.t79 141.405
R3326 VSS.t232 VSS.t233 141.405
R3327 VSS.t242 VSS.n933 115.066
R3328 VSS.n444 VSS.t236 115.066
R3329 VSS.t11 VSS.n46 115.066
R3330 VSS.t5 VSS.n71 115.066
R3331 VSS.n988 VSS.n987 94.2704
R3332 VSS.n1871 VSS.n464 94.2704
R3333 VSS.n1777 VSS.n1768 94.2704
R3334 VSS.n891 VSS.t302 88.7251
R3335 VSS.t278 VSS.n928 88.7251
R3336 VSS.t202 VSS.n1096 88.7251
R3337 VSS.t197 VSS.n947 88.7251
R3338 VSS.n967 VSS.t320 88.7251
R3339 VSS.t313 VSS.n985 88.7251
R3340 VSS.t231 VSS.n728 88.7251
R3341 VSS.n654 VSS.t203 88.7251
R3342 VSS.t69 VSS.n506 88.7251
R3343 VSS.n469 VSS.t30 88.7251
R3344 VSS.n263 VSS.t193 88.7251
R3345 VSS.n1336 VSS.t186 88.7251
R3346 VSS.n325 VSS.t42 88.7251
R3347 VSS.n421 VSS.t26 88.7251
R3348 VSS.n893 VSS.t282 83.1798
R3349 VSS.t279 VSS.n926 83.1798
R3350 VSS.t201 VSS.n1087 83.1798
R3351 VSS.t198 VSS.n945 83.1798
R3352 VSS.n974 VSS.t319 83.1798
R3353 VSS.t314 VSS.n983 83.1798
R3354 VSS.t230 VSS.n724 83.1798
R3355 VSS.n658 VSS.t204 83.1798
R3356 VSS.t68 VSS.n504 83.1798
R3357 VSS.n471 VSS.t44 83.1798
R3358 VSS.n268 VSS.t192 83.1798
R3359 VSS.n1343 VSS.t187 83.1798
R3360 VSS.n334 VSS.t41 83.1798
R3361 VSS.n425 VSS.t28 83.1798
R3362 VSS.n895 VSS.t301 77.6345
R3363 VSS.t276 VSS.n924 77.6345
R3364 VSS.t199 VSS.n1077 77.6345
R3365 VSS.t195 VSS.n943 77.6345
R3366 VSS.n1022 VSS.t317 77.6345
R3367 VSS.t316 VSS.n981 77.6345
R3368 VSS.t228 VSS.n720 77.6345
R3369 VSS.n662 VSS.t206 77.6345
R3370 VSS.t66 VSS.n502 77.6345
R3371 VSS.n473 VSS.t46 77.6345
R3372 VSS.n273 VSS.t190 77.6345
R3373 VSS.n1348 VSS.t189 77.6345
R3374 VSS.n342 VSS.t39 77.6345
R3375 VSS.n429 VSS.t32 77.6345
R3376 VSS.t20 VSS.n224 75.7222
R3377 VSS.t74 VSS.n1485 75.6333
R3378 VSS.t244 VSS.n932 73.4755
R3379 VSS.t241 VSS.n934 73.4755
R3380 VSS.n446 VSS.t238 73.4755
R3381 VSS.n443 VSS.t235 73.4755
R3382 VSS.n45 VSS.t13 73.4755
R3383 VSS.t10 VSS.n48 73.4755
R3384 VSS.n70 VSS.t7 73.4755
R3385 VSS.t4 VSS.n73 73.4755
R3386 VSS.n897 VSS.t300 72.0892
R3387 VSS.t280 VSS.n922 72.0892
R3388 VSS.t227 VSS.n716 72.0892
R3389 VSS.n666 VSS.t207 72.0892
R3390 VSS.t65 VSS.n500 72.0892
R3391 VSS.n475 VSS.t47 72.0892
R3392 VSS.n351 VSS.t38 72.0892
R3393 VSS.n433 VSS.t33 72.0892
R3394 VSS.n2065 VSS.n221 71.944
R3395 VSS.n2025 VSS.n227 71.942
R3396 VSS.t14 VSS.n1483 71.9364
R3397 VSS.n239 VSS.t194 71.8738
R3398 VSS.t194 VSS.n204 71.8567
R3399 VSS.n1985 VSS.n239 71.856
R3400 VSS.n2025 VSS.n240 71.856
R3401 VSS.n1484 VSS.t14 71.8538
R3402 VSS.n1135 VSS.t245 67.9303
R3403 VSS.t243 VSS.n932 67.9303
R3404 VSS.n934 VSS.t242 67.9303
R3405 VSS.n938 VSS.t240 67.9303
R3406 VSS.t239 VSS.n291 67.9303
R3407 VSS.n446 VSS.t237 67.9303
R3408 VSS.t236 VSS.n443 67.9303
R3409 VSS.t234 VSS.n439 67.9303
R3410 VSS.n192 VSS.t81 67.9303
R3411 VSS.t12 VSS.n45 67.9303
R3412 VSS.n48 VSS.t11 67.9303
R3413 VSS.n55 VSS.t9 67.9303
R3414 VSS.n164 VSS.t8 67.9303
R3415 VSS.t6 VSS.n70 67.9303
R3416 VSS.n73 VSS.t5 67.9303
R3417 VSS.n80 VSS.t3 67.9303
R3418 VSS.n152 VSS.t94 67.9303
R3419 VSS.n103 VSS.t90 67.9303
R3420 VSS.n114 VSS.t87 67.9303
R3421 VSS.t83 VSS.n106 67.9303
R3422 VSS.n899 VSS.t298 66.5439
R3423 VSS.t287 VSS.n920 66.5439
R3424 VSS.t225 VSS.n712 66.5439
R3425 VSS.n670 VSS.t209 66.5439
R3426 VSS.t63 VSS.n498 66.5439
R3427 VSS.n477 VSS.t49 66.5439
R3428 VSS.n359 VSS.t36 66.5439
R3429 VSS.n437 VSS.t35 66.5439
R3430 VSS.t17 VSS.n1484 64.5013
R3431 VSS.n240 VSS.t23 64.3187
R3432 VSS.t23 VSS.n234 64.2968
R3433 VSS.n1488 VSS.t17 64.2947
R3434 VSS.n901 VSS.t297 60.9987
R3435 VSS.t288 VSS.n918 60.9987
R3436 VSS.t224 VSS.n708 60.9987
R3437 VSS.n674 VSS.t210 60.9987
R3438 VSS.t24 VSS.n496 60.9987
R3439 VSS.n479 VSS.t50 60.9987
R3440 VSS.n903 VSS.t295 55.4534
R3441 VSS.t293 VSS.n908 55.4534
R3442 VSS.n911 VSS.t291 55.4534
R3443 VSS.t290 VSS.n916 55.4534
R3444 VSS.t222 VSS.n704 55.4534
R3445 VSS.n694 VSS.t218 55.4534
R3446 VSS.t216 VSS.n688 55.4534
R3447 VSS.n678 VSS.t212 55.4534
R3448 VSS.t62 VSS.n494 55.4534
R3449 VSS.n489 VSS.t58 55.4534
R3450 VSS.t56 VSS.n486 55.4534
R3451 VSS.n481 VSS.t52 55.4534
R3452 VSS.n905 VSS.t285 49.9081
R3453 VSS.t294 VSS.n906 49.9081
R3454 VSS.n913 VSS.t274 49.9081
R3455 VSS.t284 VSS.n914 49.9081
R3456 VSS.t221 VSS.n700 49.9081
R3457 VSS.n698 VSS.t219 49.9081
R3458 VSS.t215 VSS.n684 49.9081
R3459 VSS.n682 VSS.t213 49.9081
R3460 VSS.t61 VSS.n492 49.9081
R3461 VSS.n491 VSS.t59 49.9081
R3462 VSS.t55 VSS.n484 49.9081
R3463 VSS.n483 VSS.t53 49.9081
R3464 VSS.t285 VSS.n904 44.3628
R3465 VSS.n907 VSS.t294 44.3628
R3466 VSS.t274 VSS.n912 44.3628
R3467 VSS.n915 VSS.t284 44.3628
R3468 VSS.n702 VSS.t221 44.3628
R3469 VSS.t219 VSS.n696 44.3628
R3470 VSS.n686 VSS.t215 44.3628
R3471 VSS.t213 VSS.n680 44.3628
R3472 VSS.n493 VSS.t61 44.3628
R3473 VSS.t59 VSS.n490 44.3628
R3474 VSS.n485 VSS.t55 44.3628
R3475 VSS.t53 VSS.n482 44.3628
R3476 VSS.t0 VSS.n1485 41.7978
R3477 VSS.t71 VSS.n220 41.7078
R3478 VSS.n1487 VSS.t0 41.6628
R3479 VSS.n221 VSS.t71 41.6188
R3480 VSS.n2074 VSS.n204 39.7481
R3481 VSS.n1483 VSS.n203 39.7278
R3482 VSS.t295 VSS.n902 38.8175
R3483 VSS.n909 VSS.t293 38.8175
R3484 VSS.t291 VSS.n910 38.8175
R3485 VSS.n917 VSS.t290 38.8175
R3486 VSS.n706 VSS.t222 38.8175
R3487 VSS.t218 VSS.n692 38.8175
R3488 VSS.n690 VSS.t216 38.8175
R3489 VSS.t212 VSS.n676 38.8175
R3490 VSS.n495 VSS.t62 38.8175
R3491 VSS.t58 VSS.n488 38.8175
R3492 VSS.n487 VSS.t56 38.8175
R3493 VSS.t52 VSS.n480 38.8175
R3494 VSS.t297 VSS.n900 33.2722
R3495 VSS.n919 VSS.t288 33.2722
R3496 VSS.n710 VSS.t224 33.2722
R3497 VSS.t210 VSS.n672 33.2722
R3498 VSS.n497 VSS.t24 33.2722
R3499 VSS.t50 VSS.n478 33.2722
R3500 VSS.n2074 VSS.n2073 32.1265
R3501 VSS.n1544 VSS.n203 32.1265
R3502 VSS.t298 VSS.n898 27.7269
R3503 VSS.n921 VSS.t287 27.7269
R3504 VSS.n714 VSS.t225 27.7269
R3505 VSS.t209 VSS.n668 27.7269
R3506 VSS.n499 VSS.t63 27.7269
R3507 VSS.t49 VSS.n476 27.7269
R3508 VSS.t36 VSS.n358 27.7269
R3509 VSS.t35 VSS.n435 27.7269
R3510 VSS.t245 VSS.n1134 26.3406
R3511 VSS.n933 VSS.t243 26.3406
R3512 VSS.t240 VSS.n937 26.3406
R3513 VSS.n292 VSS.t239 26.3406
R3514 VSS.t237 VSS.n444 26.3406
R3515 VSS.n440 VSS.t234 26.3406
R3516 VSS.t81 VSS.n41 26.3406
R3517 VSS.n46 VSS.t12 26.3406
R3518 VSS.t9 VSS.n52 26.3406
R3519 VSS.t8 VSS.n66 26.3406
R3520 VSS.n71 VSS.t6 26.3406
R3521 VSS.t3 VSS.n77 26.3406
R3522 VSS.t94 VSS.n95 26.3406
R3523 VSS.t90 VSS.n102 26.3406
R3524 VSS.t87 VSS.n20 26.3406
R3525 VSS.n107 VSS.t83 26.3406
R3526 VSS.t300 VSS.n896 22.1816
R3527 VSS.n923 VSS.t280 22.1816
R3528 VSS.n718 VSS.t227 22.1816
R3529 VSS.t207 VSS.n664 22.1816
R3530 VSS.n501 VSS.t65 22.1816
R3531 VSS.t47 VSS.n474 22.1816
R3532 VSS.t38 VSS.n350 22.1816
R3533 VSS.t33 VSS.n431 22.1816
R3534 VSS.n1130 VSS.t244 20.7953
R3535 VSS.n935 VSS.t241 20.7953
R3536 VSS.t238 VSS.n445 20.7953
R3537 VSS.t235 VSS.n442 20.7953
R3538 VSS.t13 VSS.n42 20.7953
R3539 VSS.n51 VSS.t10 20.7953
R3540 VSS.t7 VSS.n67 20.7953
R3541 VSS.n76 VSS.t4 20.7953
R3542 VSS.t79 VSS.n96 20.7953
R3543 VSS.n98 VSS.t77 20.7953
R3544 VSS.t233 VSS.n19 20.7953
R3545 VSS.n2087 VSS.t232 20.7953
R3546 VSS.t130 VSS.n1610 17.0005
R3547 VSS.n1611 VSS.t129 17.0005
R3548 VSS.t130 VSS.n1609 17.0005
R3549 VSS.n1611 VSS.t130 17.0005
R3550 VSS.n1609 VSS.t129 17.0005
R3551 VSS.n1610 VSS.t129 17.0005
R3552 VSS.n1619 VSS.t178 17.0005
R3553 VSS.n1620 VSS.t178 17.0005
R3554 VSS.t178 VSS.n1614 17.0005
R3555 VSS.t177 VSS.n1614 17.0005
R3556 VSS.n1620 VSS.t177 17.0005
R3557 VSS.t177 VSS.n1619 17.0005
R3558 VSS.t123 VSS.n1638 17.0005
R3559 VSS.n1639 VSS.t122 17.0005
R3560 VSS.t123 VSS.n1637 17.0005
R3561 VSS.n1639 VSS.t123 17.0005
R3562 VSS.n1637 VSS.t122 17.0005
R3563 VSS.n1638 VSS.t122 17.0005
R3564 VSS.n1647 VSS.t173 17.0005
R3565 VSS.n1648 VSS.t173 17.0005
R3566 VSS.t173 VSS.n1642 17.0005
R3567 VSS.t172 VSS.n1642 17.0005
R3568 VSS.n1648 VSS.t172 17.0005
R3569 VSS.t172 VSS.n1647 17.0005
R3570 VSS.t116 VSS.n1663 17.0005
R3571 VSS.n1664 VSS.t115 17.0005
R3572 VSS.t116 VSS.n1662 17.0005
R3573 VSS.n1664 VSS.t116 17.0005
R3574 VSS.n1662 VSS.t115 17.0005
R3575 VSS.n1663 VSS.t115 17.0005
R3576 VSS.n1672 VSS.t168 17.0005
R3577 VSS.n1673 VSS.t168 17.0005
R3578 VSS.t168 VSS.n1667 17.0005
R3579 VSS.t167 VSS.n1667 17.0005
R3580 VSS.n1673 VSS.t167 17.0005
R3581 VSS.t167 VSS.n1672 17.0005
R3582 VSS.n2085 VSS.n192 17.0005
R3583 VSS.n2085 VSS.n45 17.0005
R3584 VSS.n2085 VSS.n46 17.0005
R3585 VSS.n2085 VSS.n48 17.0005
R3586 VSS.n2085 VSS.n185 17.0005
R3587 VSS.n2085 VSS.n164 17.0005
R3588 VSS.n2085 VSS.n70 17.0005
R3589 VSS.n2085 VSS.n71 17.0005
R3590 VSS.n2085 VSS.n73 17.0005
R3591 VSS.n2085 VSS.n159 17.0005
R3592 VSS.n2085 VSS.n152 17.0005
R3593 VSS.n2085 VSS.n148 17.0005
R3594 VSS.n2085 VSS.n114 17.0005
R3595 VSS.n2085 VSS.n110 17.0005
R3596 VSS.n2088 VSS.n86 17.0005
R3597 VSS.n2088 VSS.n85 17.0005
R3598 VSS.n2088 VSS.n84 17.0005
R3599 VSS.n258 VSS.n247 17.0005
R3600 VSS.n1692 VSS.n247 17.0005
R3601 VSS.n1408 VSS.n247 17.0005
R3602 VSS.n1618 VSS.n247 17.0005
R3603 VSS.n1617 VSS.n247 17.0005
R3604 VSS.n1621 VSS.n247 17.0005
R3605 VSS.n1646 VSS.n247 17.0005
R3606 VSS.n1645 VSS.n247 17.0005
R3607 VSS.n1649 VSS.n247 17.0005
R3608 VSS.n1671 VSS.n247 17.0005
R3609 VSS.n1670 VSS.n247 17.0005
R3610 VSS.n1674 VSS.n247 17.0005
R3611 VSS.n1889 VSS.n1045 17.0005
R3612 VSS.n1889 VSS.n1044 17.0005
R3613 VSS.n1889 VSS.n1043 17.0005
R3614 VSS.n1889 VSS.n993 17.0005
R3615 VSS.n1889 VSS.n992 17.0005
R3616 VSS.n1889 VSS.n991 17.0005
R3617 VSS.n1889 VSS.n631 17.0005
R3618 VSS.n1889 VSS.n632 17.0005
R3619 VSS.n1889 VSS.n633 17.0005
R3620 VSS.n1889 VSS.n942 17.0005
R3621 VSS.n1628 VSS.n247 17.0005
R3622 VSS.n1449 VSS.n247 17.0005
R3623 VSS.n1590 VSS.n247 17.0005
R3624 VSS.n1586 VSS.n247 17.0005
R3625 VSS.n1587 VSS.n247 17.0005
R3626 VSS.n1889 VSS.n1318 17.0005
R3627 VSS.n1889 VSS.n1319 17.0005
R3628 VSS.n1889 VSS.n1320 17.0005
R3629 VSS.n1541 VSS.n1510 17.0005
R3630 VSS.n1541 VSS.n1540 17.0005
R3631 VSS.n1517 VSS.n1516 17.0005
R3632 VSS.n1516 VSS.n1515 17.0005
R3633 VSS.n200 VSS.t85 17.0005
R3634 VSS.n2083 VSS.t84 17.0005
R3635 VSS.t85 VSS.n198 17.0005
R3636 VSS.n2083 VSS.t85 17.0005
R3637 VSS.t84 VSS.n198 17.0005
R3638 VSS.n200 VSS.t84 17.0005
R3639 VSS.n110 VSS.n4 17.0005
R3640 VSS.n111 VSS.n4 17.0005
R3641 VSS.n106 VSS.n4 17.0005
R3642 VSS.n107 VSS.n4 17.0005
R3643 VSS.n2079 VSS.n2078 17.0005
R3644 VSS.n2078 VSS.n201 17.0005
R3645 VSS.n2085 VSS.n108 17.0005
R3646 VSS.n2085 VSS.n2084 17.0005
R3647 VSS.t143 VSS.n1923 17.0005
R3648 VSS.t143 VSS.n1921 17.0005
R3649 VSS.n1924 VSS.t143 17.0005
R3650 VSS.n1924 VSS.t142 17.0005
R3651 VSS.n1921 VSS.t142 17.0005
R3652 VSS.n1923 VSS.t142 17.0005
R3653 VSS.n2088 VSS.n28 17.0005
R3654 VSS.n2088 VSS.n27 17.0005
R3655 VSS.n2088 VSS.n26 17.0005
R3656 VSS.n1939 VSS.n1938 17.0005
R3657 VSS.n1940 VSS.n1939 17.0005
R3658 VSS.n1949 VSS.n216 17.0005
R3659 VSS.n1918 VSS.n216 17.0005
R3660 VSS.n1864 VSS.t110 17.0005
R3661 VSS.t31 VSS.n1863 17.0005
R3662 VSS.n1861 VSS.t110 17.0005
R3663 VSS.n1863 VSS.t110 17.0005
R3664 VSS.t31 VSS.n1861 17.0005
R3665 VSS.n1864 VSS.t31 17.0005
R3666 VSS.n1898 VSS.t163 17.0005
R3667 VSS.n255 VSS.t163 17.0005
R3668 VSS.n1897 VSS.t163 17.0005
R3669 VSS.t162 VSS.n1897 17.0005
R3670 VSS.t162 VSS.n255 17.0005
R3671 VSS.n1898 VSS.t162 17.0005
R3672 VSS.n254 VSS.n247 17.0005
R3673 VSS.n256 VSS.n247 17.0005
R3674 VSS.n1894 VSS.n247 17.0005
R3675 VSS.n1867 VSS.n1866 17.0005
R3676 VSS.n1866 VSS.n1865 17.0005
R3677 VSS.n1889 VSS.n510 17.0005
R3678 VSS.n1889 VSS.n513 17.0005
R3679 VSS.n1887 VSS.t106 17.0005
R3680 VSS.n1887 VSS.n1886 17.0005
R3681 VSS.n1884 VSS.n1883 17.0005
R3682 VSS.n1883 VSS.n1882 17.0005
R3683 VSS.n1880 VSS.n1879 17.0005
R3684 VSS.n1879 VSS.n1878 17.0005
R3685 VSS.n1876 VSS.n1875 17.0005
R3686 VSS.n1875 VSS.n1874 17.0005
R3687 VSS.t109 VSS.n1872 17.0005
R3688 VSS.n1872 VSS.n1871 17.0005
R3689 VSS.n1889 VSS.n816 17.0005
R3690 VSS.n1889 VSS.n798 17.0005
R3691 VSS.n1889 VSS.n824 17.0005
R3692 VSS.n1889 VSS.n791 17.0005
R3693 VSS.n1889 VSS.n832 17.0005
R3694 VSS.n1889 VSS.n784 17.0005
R3695 VSS.n1889 VSS.n840 17.0005
R3696 VSS.n1889 VSS.n777 17.0005
R3697 VSS.n1889 VSS.n848 17.0005
R3698 VSS.n1889 VSS.n770 17.0005
R3699 VSS.n1889 VSS.n856 17.0005
R3700 VSS.n1889 VSS.n763 17.0005
R3701 VSS.n1889 VSS.n864 17.0005
R3702 VSS.n1889 VSS.n756 17.0005
R3703 VSS.n1889 VSS.n872 17.0005
R3704 VSS.n1889 VSS.n749 17.0005
R3705 VSS.n1889 VSS.n880 17.0005
R3706 VSS.n1889 VSS.n742 17.0005
R3707 VSS.n1889 VSS.n629 17.0005
R3708 VSS.n1889 VSS.n619 17.0005
R3709 VSS.n1889 VSS.n618 17.0005
R3710 VSS.n1889 VSS.n608 17.0005
R3711 VSS.n1889 VSS.n607 17.0005
R3712 VSS.n1889 VSS.n597 17.0005
R3713 VSS.n1889 VSS.n596 17.0005
R3714 VSS.n1889 VSS.n586 17.0005
R3715 VSS.n1889 VSS.n585 17.0005
R3716 VSS.n1889 VSS.n575 17.0005
R3717 VSS.n1889 VSS.n574 17.0005
R3718 VSS.n1889 VSS.n564 17.0005
R3719 VSS.n1889 VSS.n563 17.0005
R3720 VSS.n1889 VSS.n553 17.0005
R3721 VSS.n1889 VSS.n552 17.0005
R3722 VSS.n1889 VSS.n542 17.0005
R3723 VSS.n1889 VSS.n541 17.0005
R3724 VSS.n1889 VSS.n531 17.0005
R3725 VSS.n1889 VSS.n530 17.0005
R3726 VSS.n1889 VSS.n519 17.0005
R3727 VSS.n1889 VSS.n1004 17.0005
R3728 VSS.n1889 VSS.n1018 17.0005
R3729 VSS.n1889 VSS.n1019 17.0005
R3730 VSS.n1889 VSS.n1025 17.0005
R3731 VSS.n1889 VSS.n1029 17.0005
R3732 VSS.n1889 VSS.n1030 17.0005
R3733 VSS.n1889 VSS.n1038 17.0005
R3734 VSS.n1889 VSS.n1054 17.0005
R3735 VSS.n1889 VSS.n1068 17.0005
R3736 VSS.n1889 VSS.n1069 17.0005
R3737 VSS.n1889 VSS.n1074 17.0005
R3738 VSS.n1889 VSS.n1081 17.0005
R3739 VSS.n1889 VSS.n1084 17.0005
R3740 VSS.n1889 VSS.n1108 17.0005
R3741 VSS.n1889 VSS.n1111 17.0005
R3742 VSS.n1889 VSS.n1126 17.0005
R3743 VSS.n1889 VSS.n1127 17.0005
R3744 VSS.n1889 VSS.n1152 17.0005
R3745 VSS.n1889 VSS.n1175 17.0005
R3746 VSS.n1889 VSS.n1176 17.0005
R3747 VSS.n1889 VSS.n1190 17.0005
R3748 VSS.n1889 VSS.n1191 17.0005
R3749 VSS.n1889 VSS.n1205 17.0005
R3750 VSS.n1889 VSS.n1206 17.0005
R3751 VSS.n1889 VSS.n1220 17.0005
R3752 VSS.n1889 VSS.n1221 17.0005
R3753 VSS.n1889 VSS.n1235 17.0005
R3754 VSS.n1889 VSS.n1236 17.0005
R3755 VSS.n1889 VSS.n1250 17.0005
R3756 VSS.n1889 VSS.n1251 17.0005
R3757 VSS.n1889 VSS.n1265 17.0005
R3758 VSS.n1889 VSS.n1266 17.0005
R3759 VSS.n1889 VSS.n1280 17.0005
R3760 VSS.n1889 VSS.n1281 17.0005
R3761 VSS.n1889 VSS.n1295 17.0005
R3762 VSS.n1889 VSS.n1296 17.0005
R3763 VSS.n1889 VSS.n1309 17.0005
R3764 VSS.n1781 VSS.n247 17.0005
R3765 VSS.n1716 VSS.n247 17.0005
R3766 VSS.n1715 VSS.n247 17.0005
R3767 VSS.n1712 VSS.n247 17.0005
R3768 VSS.n1711 VSS.n247 17.0005
R3769 VSS.n1707 VSS.n247 17.0005
R3770 VSS.n1706 VSS.n247 17.0005
R3771 VSS.n1738 VSS.n247 17.0005
R3772 VSS.n1737 VSS.n247 17.0005
R3773 VSS.n1837 VSS.n247 17.0005
R3774 VSS.n1836 VSS.n247 17.0005
R3775 VSS.n1358 VSS.n247 17.0005
R3776 VSS.n1357 VSS.n247 17.0005
R3777 VSS.n1845 VSS.n247 17.0005
R3778 VSS.n1847 VSS.n247 17.0005
R3779 VSS.n1891 VSS.n247 17.0005
R3780 VSS.n1889 VSS.n409 17.0005
R3781 VSS.n1889 VSS.n411 17.0005
R3782 VSS.n1889 VSS.n392 17.0005
R3783 VSS.n1889 VSS.n413 17.0005
R3784 VSS.n1889 VSS.n375 17.0005
R3785 VSS.n1889 VSS.n415 17.0005
R3786 VSS.n1889 VSS.n366 17.0005
R3787 VSS.n1889 VSS.n283 17.0005
R3788 VSS.n1889 VSS.n1328 17.0005
R3789 VSS.n1889 VSS.n276 17.0005
R3790 VSS.n1889 VSS.n1344 17.0005
R3791 VSS.n2089 VSS.n4 17.0005
R3792 VSS.n2087 VSS.n4 17.0005
R3793 VSS.n4 VSS.n3 17.0005
R3794 VSS.n19 VSS.n4 17.0005
R3795 VSS.n20 VSS.n4 17.0005
R3796 VSS.n114 VSS.n4 17.0005
R3797 VSS.n115 VSS.n4 17.0005
R3798 VSS.n129 VSS.n4 17.0005
R3799 VSS.n103 VSS.n4 17.0005
R3800 VSS.n102 VSS.n4 17.0005
R3801 VSS.n98 VSS.n4 17.0005
R3802 VSS.n1817 VSS.n4 17.0005
R3803 VSS.n96 VSS.n4 17.0005
R3804 VSS.n95 VSS.n4 17.0005
R3805 VSS.n152 VSS.n4 17.0005
R3806 VSS.n1793 VSS.n4 17.0005
R3807 VSS.n154 VSS.n4 17.0005
R3808 VSS.n153 VSS.n4 17.0005
R3809 VSS.n160 VSS.n4 17.0005
R3810 VSS.n80 VSS.n4 17.0005
R3811 VSS.n77 VSS.n4 17.0005
R3812 VSS.n76 VSS.n4 17.0005
R3813 VSS.n73 VSS.n4 17.0005
R3814 VSS.n1821 VSS.n4 17.0005
R3815 VSS.n71 VSS.n4 17.0005
R3816 VSS.n70 VSS.n4 17.0005
R3817 VSS.n67 VSS.n4 17.0005
R3818 VSS.n66 VSS.n4 17.0005
R3819 VSS.n164 VSS.n4 17.0005
R3820 VSS.n166 VSS.n4 17.0005
R3821 VSS.n165 VSS.n4 17.0005
R3822 VSS.n188 VSS.n4 17.0005
R3823 VSS.n55 VSS.n4 17.0005
R3824 VSS.n52 VSS.n4 17.0005
R3825 VSS.n51 VSS.n4 17.0005
R3826 VSS.n48 VSS.n4 17.0005
R3827 VSS.n1824 VSS.n4 17.0005
R3828 VSS.n46 VSS.n4 17.0005
R3829 VSS.n45 VSS.n4 17.0005
R3830 VSS.n42 VSS.n4 17.0005
R3831 VSS.n41 VSS.n4 17.0005
R3832 VSS.n192 VSS.n4 17.0005
R3833 VSS.n193 VSS.n4 17.0005
R3834 VSS.n2088 VSS.n33 17.0005
R3835 VSS.n2088 VSS.n47 17.0005
R3836 VSS.n2088 VSS.n58 17.0005
R3837 VSS.n2088 VSS.n60 17.0005
R3838 VSS.n2088 VSS.n72 17.0005
R3839 VSS.n2088 VSS.n92 17.0005
R3840 VSS.n2088 VSS.n97 17.0005
R3841 VSS.n2088 VSS.n10 17.0005
R3842 VSS.n2089 VSS.n2088 17.0005
R3843 VSS.n1804 VSS.n1799 17.0005
R3844 VSS.n1804 VSS.n1803 17.0005
R3845 VSS.n1808 VSS.n1792 17.0005
R3846 VSS.n1809 VSS.n1808 17.0005
R3847 VSS.n1795 VSS.n4 17.0005
R3848 VSS.t301 VSS.n894 16.6364
R3849 VSS.n925 VSS.t276 16.6364
R3850 VSS.n1078 VSS.t199 16.6364
R3851 VSS.n944 VSS.t195 16.6364
R3852 VSS.t317 VSS.n980 16.6364
R3853 VSS.n982 VSS.t316 16.6364
R3854 VSS.n722 VSS.t228 16.6364
R3855 VSS.t206 VSS.n660 16.6364
R3856 VSS.n503 VSS.t66 16.6364
R3857 VSS.t46 VSS.n472 16.6364
R3858 VSS.t190 VSS.n272 16.6364
R3859 VSS.t189 VSS.n454 16.6364
R3860 VSS.t39 VSS.n341 16.6364
R3861 VSS.t32 VSS.n427 16.6364
R3862 VSS.n2069 VSS.t248 15.0583
R3863 VSS.n1950 VSS.t306 15.0583
R3864 VSS.n1539 VSS.t310 15.0583
R3865 VSS.n1574 VSS.t303 15.0583
R3866 VSS.n1736 VSS.t99 15.0005
R3867 VSS.t101 VSS.n1747 15.0005
R3868 VSS.t134 VSS.n1442 15.0005
R3869 VSS.n1743 VSS.t154 15.0005
R3870 VSS.n1756 VSS.t156 15.0005
R3871 VSS.t179 VSS.n1416 15.0005
R3872 VSS.n1451 VSS.t181 15.0005
R3873 VSS.n1815 VSS.t149 15.0005
R3874 VSS.n120 VSS.t144 15.0005
R3875 VSS.n123 VSS.t146 15.0005
R3876 VSS.n137 VSS.t86 15.0005
R3877 VSS.n139 VSS.t89 15.0005
R3878 VSS.n2030 VSS.t21 15.0005
R3879 VSS.n2067 VSS.t249 15.0005
R3880 VSS.n1990 VSS.t323 15.0005
R3881 VSS.n2027 VSS.t22 15.0005
R3882 VSS.n1916 VSS.t305 15.0005
R3883 VSS.n1987 VSS.t324 15.0005
R3884 VSS.n1536 VSS.t309 15.0005
R3885 VSS.n1532 VSS.t19 15.0005
R3886 VSS.n1529 VSS.t18 15.0005
R3887 VSS.n1525 VSS.t312 15.0005
R3888 VSS.n1522 VSS.t311 15.0005
R3889 VSS.n1570 VSS.t304 15.0005
R3890 VSS.t131 VSS.n1430 15.0005
R3891 VSS.n1492 VSS.t1 15.0005
R3892 VSS.n1564 VSS.t75 15.0005
R3893 VSS.n1494 VSS.t2 15.0005
R3894 VSS.n1558 VSS.t321 15.0005
R3895 VSS.n1562 VSS.t76 15.0005
R3896 VSS.n1552 VSS.t15 15.0005
R3897 VSS.n1556 VSS.t322 15.0005
R3898 VSS.n1549 VSS.t16 15.0005
R3899 VSS.n2080 VSS.t82 15.0005
R3900 VSS.n1919 VSS.t141 15.0005
R3901 VSS.n1929 VSS.t253 15.0005
R3902 VSS.n237 VSS.t252 15.0005
R3903 VSS.n232 VSS.t308 15.0005
R3904 VSS.n230 VSS.t307 15.0005
R3905 VSS.n241 VSS.t251 15.0005
R3906 VSS.n225 VSS.t250 15.0005
R3907 VSS.n243 VSS.t73 15.0005
R3908 VSS.n218 VSS.t72 15.0005
R3909 VSS.n1788 VSS.t96 15.0005
R3910 VSS.t151 VSS.n1729 15.0005
R3911 VSS.n1810 VSS.t93 15.0005
R3912 VSS.n995 VSS.n994 14.8739
R3913 VSS.n286 VSS.n285 14.8738
R3914 VSS.n1421 VSS.n1120 14.8738
R3915 VSS.n1316 VSS.n1315 14.8738
R3916 VSS.n288 VSS.n287 14.8732
R3917 VSS.n309 VSS.n308 14.8732
R3918 VSS.n307 VSS.n301 14.8731
R3919 VSS.n436 VSS.n360 14.8643
R3920 VSS.n1047 VSS.n1046 14.86
R3921 VSS.n1024 VSS.n1023 14.7418
R3922 VSS.n1347 VSS.n274 14.741
R3923 VSS.n1073 VSS.n1072 14.741
R3924 VSS.n776 VSS.n775 14.6218
R3925 VSS.n689 VSS.n576 14.6218
R3926 VSS.n1233 VSS.n1231 14.6209
R3927 VSS.n776 VSS.n774 14.6205
R3928 VSS.n691 VSS.n576 14.6205
R3929 VSS.n1233 VSS.n1232 14.6203
R3930 VSS.n810 VSS.n809 14.406
R3931 VSS.n804 VSS.n803 14.406
R3932 VSS.n801 VSS.n800 14.406
R3933 VSS.n797 VSS.n796 14.406
R3934 VSS.n794 VSS.n793 14.406
R3935 VSS.n790 VSS.n789 14.406
R3936 VSS.n787 VSS.n786 14.406
R3937 VSS.n783 VSS.n782 14.406
R3938 VSS.n780 VSS.n779 14.406
R3939 VSS.n773 VSS.n772 14.406
R3940 VSS.n769 VSS.n768 14.406
R3941 VSS.n766 VSS.n765 14.406
R3942 VSS.n762 VSS.n761 14.406
R3943 VSS.n759 VSS.n758 14.406
R3944 VSS.n755 VSS.n754 14.406
R3945 VSS.n752 VSS.n751 14.406
R3946 VSS.n748 VSS.n747 14.406
R3947 VSS.n745 VSS.n744 14.406
R3948 VSS.n741 VSS.n740 14.406
R3949 VSS.n736 VSS.n735 14.406
R3950 VSS.n653 VSS.n625 14.406
R3951 VSS.n657 VSS.n620 14.406
R3952 VSS.n661 VSS.n614 14.406
R3953 VSS.n665 VSS.n609 14.406
R3954 VSS.n669 VSS.n603 14.406
R3955 VSS.n673 VSS.n598 14.406
R3956 VSS.n677 VSS.n592 14.406
R3957 VSS.n681 VSS.n587 14.406
R3958 VSS.n685 VSS.n581 14.406
R3959 VSS.n693 VSS.n570 14.406
R3960 VSS.n697 VSS.n565 14.406
R3961 VSS.n701 VSS.n559 14.406
R3962 VSS.n705 VSS.n554 14.406
R3963 VSS.n709 VSS.n548 14.406
R3964 VSS.n713 VSS.n543 14.406
R3965 VSS.n717 VSS.n537 14.406
R3966 VSS.n721 VSS.n532 14.406
R3967 VSS.n725 VSS.n526 14.406
R3968 VSS.n729 VSS.n521 14.406
R3969 VSS.n520 VSS.n518 14.406
R3970 VSS.n517 VSS.n516 14.406
R3971 VSS.n515 VSS.n514 14.406
R3972 VSS.n997 VSS.n996 14.406
R3973 VSS.n1003 VSS.n1001 14.406
R3974 VSS.n1009 VSS.n1007 14.406
R3975 VSS.n1016 VSS.n1014 14.406
R3976 VSS.n1049 VSS.n1048 14.406
R3977 VSS.n265 VSS.n264 14.4051
R3978 VSS.n270 VSS.n269 14.4051
R3979 VSS.n1342 VSS.n275 14.4051
R3980 VSS.n1335 VSS.n277 14.4051
R3981 VSS.n279 VSS.n278 14.4051
R3982 VSS.n284 VSS.n282 14.4051
R3983 VSS.n1853 VSS.n456 14.4051
R3984 VSS.n1059 VSS.n1057 14.4051
R3985 VSS.n1066 VSS.n1064 14.4051
R3986 VSS.n1083 VSS.n1082 14.4051
R3987 VSS.n1093 VSS.n1092 14.4051
R3988 VSS.n1102 VSS.n1101 14.4051
R3989 VSS.n1110 VSS.n1109 14.4051
R3990 VSS.n1151 VSS.n1150 14.4051
R3991 VSS.n1159 VSS.n1157 14.4051
R3992 VSS.n1166 VSS.n1164 14.4051
R3993 VSS.n1173 VSS.n1171 14.4051
R3994 VSS.n1181 VSS.n1179 14.4051
R3995 VSS.n1188 VSS.n1186 14.4051
R3996 VSS.n1196 VSS.n1194 14.4051
R3997 VSS.n1203 VSS.n1201 14.4051
R3998 VSS.n1211 VSS.n1209 14.4051
R3999 VSS.n1218 VSS.n1216 14.4051
R4000 VSS.n1226 VSS.n1224 14.4051
R4001 VSS.n1241 VSS.n1239 14.4051
R4002 VSS.n1248 VSS.n1246 14.4051
R4003 VSS.n1256 VSS.n1254 14.4051
R4004 VSS.n1263 VSS.n1261 14.4051
R4005 VSS.n1271 VSS.n1269 14.4051
R4006 VSS.n1278 VSS.n1276 14.4051
R4007 VSS.n1286 VSS.n1284 14.4051
R4008 VSS.n1293 VSS.n1291 14.4051
R4009 VSS.n1301 VSS.n1299 14.4051
R4010 VSS.n1307 VSS.n1306 14.4051
R4011 VSS.n1311 VSS.n1310 14.4051
R4012 VSS.n1313 VSS.n1312 14.4051
R4013 VSS.n1316 VSS.n1314 14.4051
R4014 VSS.n394 VSS.n393 14.4051
R4015 VSS.n390 VSS.n389 14.4051
R4016 VSS.n386 VSS.n385 14.4051
R4017 VSS.n418 VSS.n382 14.4051
R4018 VSS.n422 VSS.n377 14.4051
R4019 VSS.n426 VSS.n373 14.4051
R4020 VSS.n430 VSS.n368 14.4051
R4021 VSS.n434 VSS.n364 14.4051
R4022 VSS.n356 VSS.n355 14.4051
R4023 VSS.n347 VSS.n346 14.4051
R4024 VSS.n339 VSS.n338 14.4051
R4025 VSS.n330 VSS.n329 14.4051
R4026 VSS.n321 VSS.n320 14.4051
R4027 VSS.n317 VSS.n316 14.4051
R4028 VSS.n314 VSS.n313 14.4051
R4029 VSS.n310 VSS.n309 14.4051
R4030 VSS.n438 VSS.n301 14.4051
R4031 VSS.n289 VSS.n288 14.4051
R4032 VSS.n810 VSS.n808 14.4046
R4033 VSS.n804 VSS.n802 14.4046
R4034 VSS.n801 VSS.n799 14.4046
R4035 VSS.n797 VSS.n795 14.4046
R4036 VSS.n794 VSS.n792 14.4046
R4037 VSS.n790 VSS.n788 14.4046
R4038 VSS.n787 VSS.n785 14.4046
R4039 VSS.n783 VSS.n781 14.4046
R4040 VSS.n780 VSS.n778 14.4046
R4041 VSS.n773 VSS.n771 14.4046
R4042 VSS.n769 VSS.n767 14.4046
R4043 VSS.n766 VSS.n764 14.4046
R4044 VSS.n762 VSS.n760 14.4046
R4045 VSS.n759 VSS.n757 14.4046
R4046 VSS.n755 VSS.n753 14.4046
R4047 VSS.n752 VSS.n750 14.4046
R4048 VSS.n748 VSS.n746 14.4046
R4049 VSS.n745 VSS.n743 14.4046
R4050 VSS.n741 VSS.n739 14.4046
R4051 VSS.n740 VSS.n738 14.4046
R4052 VSS.n737 VSS.n736 14.4046
R4053 VSS.n735 VSS.n734 14.4046
R4054 VSS.n655 VSS.n625 14.4046
R4055 VSS.n659 VSS.n620 14.4046
R4056 VSS.n663 VSS.n614 14.4046
R4057 VSS.n667 VSS.n609 14.4046
R4058 VSS.n671 VSS.n603 14.4046
R4059 VSS.n675 VSS.n598 14.4046
R4060 VSS.n679 VSS.n592 14.4046
R4061 VSS.n683 VSS.n587 14.4046
R4062 VSS.n687 VSS.n581 14.4046
R4063 VSS.n695 VSS.n570 14.4046
R4064 VSS.n699 VSS.n565 14.4046
R4065 VSS.n703 VSS.n559 14.4046
R4066 VSS.n707 VSS.n554 14.4046
R4067 VSS.n711 VSS.n548 14.4046
R4068 VSS.n715 VSS.n543 14.4046
R4069 VSS.n719 VSS.n537 14.4046
R4070 VSS.n723 VSS.n532 14.4046
R4071 VSS.n727 VSS.n526 14.4046
R4072 VSS.n521 VSS.n520 14.4046
R4073 VSS.n516 VSS.n515 14.4046
R4074 VSS.n996 VSS.n995 14.4046
R4075 VSS.n998 VSS.n997 14.4046
R4076 VSS.n1001 VSS.n999 14.4046
R4077 VSS.n1003 VSS.n1002 14.4046
R4078 VSS.n1009 VSS.n1008 14.4046
R4079 VSS.n1016 VSS.n1015 14.4046
R4080 VSS.n1048 VSS.n1047 14.4046
R4081 VSS.n1050 VSS.n1049 14.4046
R4082 VSS.n1314 VSS.n1313 14.4044
R4083 VSS.n1310 VSS.n1307 14.4044
R4084 VSS.n1301 VSS.n1300 14.4044
R4085 VSS.n1293 VSS.n1292 14.4044
R4086 VSS.n1286 VSS.n1285 14.4044
R4087 VSS.n1278 VSS.n1277 14.4044
R4088 VSS.n1271 VSS.n1270 14.4044
R4089 VSS.n1263 VSS.n1262 14.4044
R4090 VSS.n1256 VSS.n1255 14.4044
R4091 VSS.n1248 VSS.n1247 14.4044
R4092 VSS.n1241 VSS.n1240 14.4044
R4093 VSS.n1226 VSS.n1225 14.4044
R4094 VSS.n1218 VSS.n1217 14.4044
R4095 VSS.n1211 VSS.n1210 14.4044
R4096 VSS.n1203 VSS.n1202 14.4044
R4097 VSS.n1196 VSS.n1195 14.4044
R4098 VSS.n1188 VSS.n1187 14.4044
R4099 VSS.n1181 VSS.n1180 14.4044
R4100 VSS.n1173 VSS.n1172 14.4044
R4101 VSS.n1166 VSS.n1165 14.4044
R4102 VSS.n1159 VSS.n1158 14.4044
R4103 VSS.n1157 VSS.n1154 14.4044
R4104 VSS.n1153 VSS.n1151 14.4044
R4105 VSS.n1139 VSS.n1136 14.4044
R4106 VSS.n1120 VSS.n1119 14.4044
R4107 VSS.n1114 VSS.n1110 14.4044
R4108 VSS.n1109 VSS.n1106 14.4044
R4109 VSS.n1105 VSS.n1102 14.4044
R4110 VSS.n1101 VSS.n1098 14.4044
R4111 VSS.n1092 VSS.n1089 14.4044
R4112 VSS.n1082 VSS.n1079 14.4044
R4113 VSS.n1066 VSS.n1065 14.4044
R4114 VSS.n1059 VSS.n1058 14.4044
R4115 VSS.n456 VSS.n455 14.4044
R4116 VSS.n393 VSS.n390 14.4044
R4117 VSS.n385 VSS.n382 14.4044
R4118 VSS.n420 VSS.n377 14.4044
R4119 VSS.n424 VSS.n373 14.4044
R4120 VSS.n428 VSS.n368 14.4044
R4121 VSS.n432 VSS.n364 14.4044
R4122 VSS.n355 VSS.n352 14.4044
R4123 VSS.n346 VSS.n343 14.4044
R4124 VSS.n338 VSS.n335 14.4044
R4125 VSS.n329 VSS.n326 14.4044
R4126 VSS.n320 VSS.n317 14.4044
R4127 VSS.n313 VSS.n310 14.4044
R4128 VSS.n285 VSS.n284 14.4044
R4129 VSS.n282 VSS.n281 14.4044
R4130 VSS.n280 VSS.n279 14.4044
R4131 VSS.n449 VSS.n278 14.4044
R4132 VSS.n451 VSS.n277 14.4044
R4133 VSS.n453 VSS.n275 14.4044
R4134 VSS.n271 VSS.n270 14.4044
R4135 VSS.n266 VSS.n265 14.4044
R4136 VSS.n455 VSS.n261 14.4044
R4137 VSS.n110 VSS.n18 14.1878
R4138 VSS.n637 VSS.n636 14.1633
R4139 VSS.n1145 VSS.n1143 14.1633
R4140 VSS.n1880 VSS.n512 13.9782
R4141 VSS.n734 VSS.n733 13.8941
R4142 VSS.n954 VSS.n953 13.8939
R4143 VSS.n950 VSS.n949 13.8939
R4144 VSS.n1052 VSS.n1051 13.8933
R4145 VSS.n1041 VSS.n953 13.8932
R4146 VSS.n1150 VSS.n930 13.8932
R4147 VSS.n1140 VSS.n1139 13.8932
R4148 VSS.n1115 VSS.n1114 13.8932
R4149 VSS.n1985 VSS.n234 13.7723
R4150 VSS.n2065 VSS.n224 13.7493
R4151 VSS.n466 VSS.n465 13.3823
R4152 VSS.n979 VSS.n978 13.3823
R4153 VSS.n976 VSS.n975 13.3823
R4154 VSS.n972 VSS.n971 13.3823
R4155 VSS.n969 VSS.n968 13.3823
R4156 VSS.n965 VSS.n964 13.3823
R4157 VSS.n955 VSS.n954 13.3823
R4158 VSS.n951 VSS.n950 13.3823
R4159 VSS.n1042 VSS.n1041 13.3823
R4160 VSS.n733 VSS.n635 13.3823
R4161 VSS.n1422 VSS.n1115 13.3823
R4162 VSS.n1144 VSS.n1140 13.3823
R4163 VSS.n1143 VSS.n930 13.3823
R4164 VSS.n1051 VSS.n951 13.3816
R4165 VSS.n651 VSS.n650 13.3816
R4166 VSS.n467 VSS.n466 13.3816
R4167 VSS.n110 VSS.n105 13.3816
R4168 VSS.n956 VSS.n955 12.4949
R4169 VSS.t125 VSS.n958 12.4949
R4170 VSS.n959 VSS.t125 12.4949
R4171 VSS.n962 VSS.n961 12.4949
R4172 VSS.n963 VSS.n962 12.4949
R4173 VSS.n970 VSS.n969 12.4949
R4174 VSS.n977 VSS.n976 12.4949
R4175 VSS.n649 VSS.n648 12.4949
R4176 VSS.n648 VSS.n647 12.4949
R4177 VSS.n645 VSS.t114 12.4949
R4178 VSS.t114 VSS.n644 12.4949
R4179 VSS.n642 VSS.n641 12.4949
R4180 VSS.n641 VSS.n640 12.4949
R4181 VSS.n638 VSS.n637 12.4949
R4182 VSS.t109 VSS.n463 12.4949
R4183 VSS.n1876 VSS.n462 12.4949
R4184 VSS.n1856 VSS.n461 12.4949
R4185 VSS.n1857 VSS.n1856 12.4949
R4186 VSS.n1884 VSS.n459 12.4949
R4187 VSS.t106 VSS.n457 12.4949
R4188 VSS.n35 VSS.n34 12.4949
R4189 VSS.n194 VSS.n193 12.4949
R4190 VSS.n191 VSS.n42 12.4949
R4191 VSS.n190 VSS.n52 12.4949
R4192 VSS.n189 VSS.n188 12.4949
R4193 VSS.n184 VSS.n183 12.4949
R4194 VSS.n167 VSS.n166 12.4949
R4195 VSS.n163 VSS.n67 12.4949
R4196 VSS.n162 VSS.n77 12.4949
R4197 VSS.n161 VSS.n160 12.4949
R4198 VSS.n1806 VSS.n1797 12.4949
R4199 VSS.n155 VSS.n154 12.4949
R4200 VSS.n151 VSS.n96 12.4949
R4201 VSS.n150 VSS.n102 12.4949
R4202 VSS.n149 VSS.n104 12.4949
R4203 VSS.n148 VSS.n147 12.4949
R4204 VSS.n133 VSS.n22 12.4949
R4205 VSS.n116 VSS.n115 12.4949
R4206 VSS.n113 VSS.n19 12.4949
R4207 VSS.n2086 VSS.n107 12.4949
R4208 VSS.n112 VSS.n111 12.4949
R4209 VSS.n194 VSS.n35 12.4949
R4210 VSS.n191 VSS.n41 12.4949
R4211 VSS.n190 VSS.n51 12.4949
R4212 VSS.n189 VSS.n55 12.4949
R4213 VSS.n167 VSS.n165 12.4949
R4214 VSS.n163 VSS.n66 12.4949
R4215 VSS.n162 VSS.n76 12.4949
R4216 VSS.n161 VSS.n80 12.4949
R4217 VSS.n155 VSS.n153 12.4949
R4218 VSS.n151 VSS.n95 12.4949
R4219 VSS.n150 VSS.n98 12.4949
R4220 VSS.n149 VSS.n103 12.4949
R4221 VSS.n116 VSS.n22 12.4949
R4222 VSS.n113 VSS.n20 12.4949
R4223 VSS.n2087 VSS.n2086 12.4949
R4224 VSS.n112 VSS.n106 12.4949
R4225 VSS.n639 VSS.n638 12.4949
R4226 VSS.n643 VSS.n642 12.4949
R4227 VSS.n646 VSS.n645 12.4949
R4228 VSS.n650 VSS.n649 12.4949
R4229 VSS.n961 VSS.n960 12.4949
R4230 VSS.n958 VSS.n957 12.4949
R4231 VSS.n1886 VSS.n457 12.4949
R4232 VSS.n1882 VSS.n459 12.4949
R4233 VSS.n1878 VSS.n461 12.4949
R4234 VSS.n1874 VSS.n462 12.4949
R4235 VSS.n1871 VSS.n463 12.4949
R4236 VSS.n640 VSS.n639 12.4949
R4237 VSS.n644 VSS.n643 12.4949
R4238 VSS.n647 VSS.n646 12.4949
R4239 VSS.n978 VSS.n977 12.4949
R4240 VSS.n971 VSS.n970 12.4949
R4241 VSS.n964 VSS.n963 12.4949
R4242 VSS.n960 VSS.n959 12.4949
R4243 VSS.n957 VSS.n956 12.4949
R4244 VSS.n1858 VSS.n1857 12.4949
R4245 VSS.n134 VSS.n133 12.4949
R4246 VSS.n147 VSS.n104 12.4949
R4247 VSS.n1797 VSS.n159 12.4949
R4248 VSS.n185 VSS.n184 12.4949
R4249 VSS.n34 VSS.n32 12.4949
R4250 VSS.n1488 VSS.t74 11.6839
R4251 VSS.n227 VSS.t20 11.3824
R4252 VSS.t282 VSS.n892 11.0911
R4253 VSS.n927 VSS.t279 11.0911
R4254 VSS.n1088 VSS.t201 11.0911
R4255 VSS.n946 VSS.t198 11.0911
R4256 VSS.t319 VSS.n973 11.0911
R4257 VSS.n984 VSS.t314 11.0911
R4258 VSS.n726 VSS.t230 11.0911
R4259 VSS.t204 VSS.n656 11.0911
R4260 VSS.n505 VSS.t68 11.0911
R4261 VSS.t44 VSS.n470 11.0911
R4262 VSS.t192 VSS.n267 11.0911
R4263 VSS.t187 VSS.n452 11.0911
R4264 VSS.t41 VSS.n333 11.0911
R4265 VSS.t28 VSS.n423 11.0911
R4266 VSS.n123 VSS.n121 9.0005
R4267 VSS.n121 VSS.n120 9.0005
R4268 VSS.n140 VSS.n137 9.0005
R4269 VSS.n140 VSS.n139 9.0005
R4270 VSS.n2081 VSS.n2080 9.0005
R4271 VSS.n1920 VSS.n1919 9.0005
R4272 VSS.n1811 VSS.n1810 9.0005
R4273 VSS.n1816 VSS.n1815 9.0005
R4274 VSS.n1802 VSS.t95 8.5015
R4275 VSS.t185 VSS.n246 8.5015
R4276 VSS.t140 VSS.n1482 8.5015
R4277 VSS.t80 VSS.n1812 8.5015
R4278 VSS.n2065 VSS.n2042 8.501
R4279 VSS.n2065 VSS.n2041 8.501
R4280 VSS.n2065 VSS.n2040 8.501
R4281 VSS.n2065 VSS.n2039 8.501
R4282 VSS.n2065 VSS.n2038 8.501
R4283 VSS.n2065 VSS.n2037 8.501
R4284 VSS.n2065 VSS.n2036 8.501
R4285 VSS.n2065 VSS.n2035 8.501
R4286 VSS.n2065 VSS.n2034 8.501
R4287 VSS.n2066 VSS.n2065 8.501
R4288 VSS.n2025 VSS.n2002 8.501
R4289 VSS.n2025 VSS.n2001 8.501
R4290 VSS.n2025 VSS.n2000 8.501
R4291 VSS.n2025 VSS.n1999 8.501
R4292 VSS.n2025 VSS.n1998 8.501
R4293 VSS.n2025 VSS.n1997 8.501
R4294 VSS.n2025 VSS.n1996 8.501
R4295 VSS.n2025 VSS.n1995 8.501
R4296 VSS.n2025 VSS.n1994 8.501
R4297 VSS.n1985 VSS.n1962 8.501
R4298 VSS.n1985 VSS.n1961 8.501
R4299 VSS.n1985 VSS.n1960 8.501
R4300 VSS.n1985 VSS.n1959 8.501
R4301 VSS.n1985 VSS.n1958 8.501
R4302 VSS.n1985 VSS.n1957 8.501
R4303 VSS.n1985 VSS.n1956 8.501
R4304 VSS.n1985 VSS.n1955 8.501
R4305 VSS.n1985 VSS.n1954 8.501
R4306 VSS.n134 VSS.n131 8.501
R4307 VSS.n135 VSS.n134 8.501
R4308 VSS.n144 VSS.n130 8.501
R4309 VSS.n134 VSS.n132 8.501
R4310 VSS.n1806 VSS.n1805 8.501
R4311 VSS.n183 VSS.n172 8.501
R4312 VSS.n183 VSS.n173 8.501
R4313 VSS.n183 VSS.n182 8.501
R4314 VSS.n401 VSS.n32 8.501
R4315 VSS.n403 VSS.n32 8.501
R4316 VSS.n404 VSS.n32 8.501
R4317 VSS.n1423 VSS.n1422 8.501
R4318 VSS.n1422 VSS.n940 8.501
R4319 VSS.n1422 VSS.n1419 8.501
R4320 VSS.n1544 VSS.n1542 8.501
R4321 VSS.n1544 VSS.n1507 8.501
R4322 VSS.n1544 VSS.n1506 8.501
R4323 VSS.n1544 VSS.n1505 8.501
R4324 VSS.n1544 VSS.n1504 8.501
R4325 VSS.n1544 VSS.n1503 8.501
R4326 VSS.n1544 VSS.n1502 8.501
R4327 VSS.n1544 VSS.n1500 8.501
R4328 VSS.n2073 VSS.n213 8.501
R4329 VSS.n2073 VSS.n212 8.501
R4330 VSS.n2073 VSS.n211 8.501
R4331 VSS.n2073 VSS.n210 8.501
R4332 VSS.n2073 VSS.n209 8.501
R4333 VSS.n2073 VSS.n208 8.501
R4334 VSS.n2073 VSS.n207 8.501
R4335 VSS.n2073 VSS.n206 8.501
R4336 VSS.n2073 VSS.n205 8.501
R4337 VSS.n2073 VSS.n214 8.501
R4338 VSS.n1985 VSS.n235 8.501
R4339 VSS.n1985 VSS.n1984 8.501
R4340 VSS.n2025 VSS.n2024 8.501
R4341 VSS.n2065 VSS.n2064 8.501
R4342 VSS.n1859 VSS.n1858 8.501
R4343 VSS.n1858 VSS.n511 8.501
R4344 VSS.n1854 VSS.n259 8.501
R4345 VSS.n1869 VSS.n259 8.501
R4346 VSS.n1870 VSS.n259 8.501
R4347 VSS.n815 VSS.n259 8.501
R4348 VSS.n1777 VSS.n1769 8.501
R4349 VSS.n1777 VSS.n1775 8.501
R4350 VSS.n1778 VSS.n1777 8.501
R4351 VSS.n144 VSS.n128 8.501
R4352 VSS.n1806 VSS.n1796 8.501
R4353 VSS.n1807 VSS.n1806 8.501
R4354 VSS.n1610 VSS.t126 8.5005
R4355 VSS.n1609 VSS.t126 8.5005
R4356 VSS.n1611 VSS.t126 8.5005
R4357 VSS.n1619 VSS.t175 8.5005
R4358 VSS.n1620 VSS.t175 8.5005
R4359 VSS.t175 VSS.n1614 8.5005
R4360 VSS.n1638 VSS.t119 8.5005
R4361 VSS.n1637 VSS.t119 8.5005
R4362 VSS.n1639 VSS.t119 8.5005
R4363 VSS.n1647 VSS.t170 8.5005
R4364 VSS.n1648 VSS.t170 8.5005
R4365 VSS.t170 VSS.n1642 8.5005
R4366 VSS.n1663 VSS.t70 8.5005
R4367 VSS.n1662 VSS.t70 8.5005
R4368 VSS.n1664 VSS.t70 8.5005
R4369 VSS.n1672 VSS.t165 8.5005
R4370 VSS.n1673 VSS.t165 8.5005
R4371 VSS.t165 VSS.n1667 8.5005
R4372 VSS.n1814 VSS.t80 8.5005
R4373 VSS.t80 VSS.n1813 8.5005
R4374 VSS.n2051 VSS.n2033 8.5005
R4375 VSS.n2011 VSS.n1993 8.5005
R4376 VSS.n1971 VSS.n1953 8.5005
R4377 VSS.n144 VSS.n136 8.5005
R4378 VSS.n2088 VSS.n19 8.5005
R4379 VSS.n2088 VSS.n20 8.5005
R4380 VSS.n2088 VSS.n22 8.5005
R4381 VSS.n987 VSS.n247 8.5005
R4382 VSS.n1022 VSS.n247 8.5005
R4383 VSS.n1889 VSS.n419 8.5005
R4384 VSS.n1889 VSS.n421 8.5005
R4385 VSS.n1889 VSS.n423 8.5005
R4386 VSS.n1889 VSS.n425 8.5005
R4387 VSS.n1889 VSS.n427 8.5005
R4388 VSS.n1889 VSS.n429 8.5005
R4389 VSS.n1889 VSS.n431 8.5005
R4390 VSS.n1889 VSS.n433 8.5005
R4391 VSS.n1889 VSS.n435 8.5005
R4392 VSS.n1889 VSS.n437 8.5005
R4393 VSS.n1889 VSS.n439 8.5005
R4394 VSS.n1889 VSS.n440 8.5005
R4395 VSS.n1889 VSS.n442 8.5005
R4396 VSS.n1889 VSS.n443 8.5005
R4397 VSS.n1889 VSS.n444 8.5005
R4398 VSS.n1889 VSS.n446 8.5005
R4399 VSS.n1889 VSS.n450 8.5005
R4400 VSS.n1889 VSS.n452 8.5005
R4401 VSS.n1889 VSS.n454 8.5005
R4402 VSS.n1889 VSS.n464 8.5005
R4403 VSS.n1889 VSS.n466 8.5005
R4404 VSS.n1889 VSS.n468 8.5005
R4405 VSS.n1889 VSS.n469 8.5005
R4406 VSS.n1889 VSS.n470 8.5005
R4407 VSS.n1889 VSS.n471 8.5005
R4408 VSS.n1889 VSS.n472 8.5005
R4409 VSS.n1889 VSS.n473 8.5005
R4410 VSS.n1889 VSS.n474 8.5005
R4411 VSS.n1889 VSS.n475 8.5005
R4412 VSS.n1889 VSS.n476 8.5005
R4413 VSS.n1889 VSS.n477 8.5005
R4414 VSS.n1889 VSS.n478 8.5005
R4415 VSS.n1889 VSS.n479 8.5005
R4416 VSS.n1889 VSS.n480 8.5005
R4417 VSS.n1889 VSS.n481 8.5005
R4418 VSS.n1889 VSS.n482 8.5005
R4419 VSS.n1889 VSS.n483 8.5005
R4420 VSS.n1889 VSS.n484 8.5005
R4421 VSS.n1889 VSS.n485 8.5005
R4422 VSS.n1889 VSS.n486 8.5005
R4423 VSS.n1889 VSS.n487 8.5005
R4424 VSS.n1889 VSS.n488 8.5005
R4425 VSS.n1889 VSS.n489 8.5005
R4426 VSS.n1889 VSS.n490 8.5005
R4427 VSS.n1889 VSS.n491 8.5005
R4428 VSS.n1889 VSS.n492 8.5005
R4429 VSS.n1889 VSS.n493 8.5005
R4430 VSS.n1889 VSS.n494 8.5005
R4431 VSS.n1889 VSS.n495 8.5005
R4432 VSS.n1889 VSS.n496 8.5005
R4433 VSS.n1889 VSS.n497 8.5005
R4434 VSS.n1889 VSS.n498 8.5005
R4435 VSS.n1889 VSS.n499 8.5005
R4436 VSS.n1889 VSS.n500 8.5005
R4437 VSS.n1889 VSS.n501 8.5005
R4438 VSS.n1889 VSS.n502 8.5005
R4439 VSS.n1889 VSS.n503 8.5005
R4440 VSS.n1889 VSS.n504 8.5005
R4441 VSS.n1889 VSS.n505 8.5005
R4442 VSS.n1889 VSS.n506 8.5005
R4443 VSS.n1889 VSS.n507 8.5005
R4444 VSS.n1889 VSS.n637 8.5005
R4445 VSS.n1889 VSS.n639 8.5005
R4446 VSS.n1889 VSS.n641 8.5005
R4447 VSS.n1889 VSS.n643 8.5005
R4448 VSS.n1889 VSS.t114 8.5005
R4449 VSS.n1889 VSS.n646 8.5005
R4450 VSS.n1889 VSS.n648 8.5005
R4451 VSS.n1889 VSS.n650 8.5005
R4452 VSS.n1889 VSS.n652 8.5005
R4453 VSS.n1889 VSS.n654 8.5005
R4454 VSS.n1889 VSS.n656 8.5005
R4455 VSS.n1889 VSS.n658 8.5005
R4456 VSS.n1889 VSS.n660 8.5005
R4457 VSS.n1889 VSS.n662 8.5005
R4458 VSS.n1889 VSS.n664 8.5005
R4459 VSS.n1889 VSS.n666 8.5005
R4460 VSS.n1889 VSS.n668 8.5005
R4461 VSS.n1889 VSS.n670 8.5005
R4462 VSS.n1889 VSS.n672 8.5005
R4463 VSS.n1889 VSS.n674 8.5005
R4464 VSS.n1889 VSS.n676 8.5005
R4465 VSS.n1889 VSS.n678 8.5005
R4466 VSS.n1889 VSS.n680 8.5005
R4467 VSS.n1889 VSS.n682 8.5005
R4468 VSS.n1889 VSS.n684 8.5005
R4469 VSS.n1889 VSS.n686 8.5005
R4470 VSS.n1889 VSS.n688 8.5005
R4471 VSS.n1889 VSS.n690 8.5005
R4472 VSS.n1889 VSS.n692 8.5005
R4473 VSS.n1889 VSS.n694 8.5005
R4474 VSS.n1889 VSS.n696 8.5005
R4475 VSS.n1889 VSS.n698 8.5005
R4476 VSS.n1889 VSS.n700 8.5005
R4477 VSS.n1889 VSS.n702 8.5005
R4478 VSS.n1889 VSS.n704 8.5005
R4479 VSS.n1889 VSS.n706 8.5005
R4480 VSS.n1889 VSS.n708 8.5005
R4481 VSS.n1889 VSS.n710 8.5005
R4482 VSS.n1889 VSS.n712 8.5005
R4483 VSS.n1889 VSS.n714 8.5005
R4484 VSS.n1889 VSS.n716 8.5005
R4485 VSS.n1889 VSS.n718 8.5005
R4486 VSS.n1889 VSS.n720 8.5005
R4487 VSS.n1889 VSS.n722 8.5005
R4488 VSS.n1889 VSS.n724 8.5005
R4489 VSS.n1889 VSS.n726 8.5005
R4490 VSS.n1889 VSS.n728 8.5005
R4491 VSS.n1889 VSS.n730 8.5005
R4492 VSS.n1889 VSS.n986 8.5005
R4493 VSS.n1889 VSS.n985 8.5005
R4494 VSS.n1889 VSS.n984 8.5005
R4495 VSS.n1889 VSS.n983 8.5005
R4496 VSS.n1889 VSS.n982 8.5005
R4497 VSS.n1889 VSS.n981 8.5005
R4498 VSS.n1889 VSS.n980 8.5005
R4499 VSS.n1889 VSS.n978 8.5005
R4500 VSS.n1889 VSS.n976 8.5005
R4501 VSS.n1889 VSS.n974 8.5005
R4502 VSS.n1889 VSS.n973 8.5005
R4503 VSS.n1889 VSS.n971 8.5005
R4504 VSS.n1889 VSS.n969 8.5005
R4505 VSS.n1889 VSS.n967 8.5005
R4506 VSS.n1889 VSS.n966 8.5005
R4507 VSS.n1889 VSS.n964 8.5005
R4508 VSS.n1889 VSS.n962 8.5005
R4509 VSS.n1889 VSS.n960 8.5005
R4510 VSS.n1889 VSS.t125 8.5005
R4511 VSS.n1889 VSS.n957 8.5005
R4512 VSS.n1889 VSS.n955 8.5005
R4513 VSS.n1889 VSS.n951 8.5005
R4514 VSS.n1889 VSS.n947 8.5005
R4515 VSS.n1889 VSS.n946 8.5005
R4516 VSS.n1889 VSS.n945 8.5005
R4517 VSS.n1889 VSS.n944 8.5005
R4518 VSS.n1889 VSS.n943 8.5005
R4519 VSS.n1889 VSS.n938 8.5005
R4520 VSS.n1889 VSS.n937 8.5005
R4521 VSS.n1889 VSS.n935 8.5005
R4522 VSS.n1889 VSS.n934 8.5005
R4523 VSS.n1889 VSS.n933 8.5005
R4524 VSS.n1889 VSS.n932 8.5005
R4525 VSS.n1889 VSS.n929 8.5005
R4526 VSS.n1889 VSS.n928 8.5005
R4527 VSS.n1889 VSS.n927 8.5005
R4528 VSS.n1889 VSS.n926 8.5005
R4529 VSS.n1889 VSS.n925 8.5005
R4530 VSS.n1889 VSS.n924 8.5005
R4531 VSS.n1889 VSS.n923 8.5005
R4532 VSS.n1889 VSS.n922 8.5005
R4533 VSS.n1889 VSS.n921 8.5005
R4534 VSS.n1889 VSS.n920 8.5005
R4535 VSS.n1889 VSS.n919 8.5005
R4536 VSS.n1889 VSS.n918 8.5005
R4537 VSS.n1889 VSS.n917 8.5005
R4538 VSS.n1889 VSS.n916 8.5005
R4539 VSS.n1889 VSS.n915 8.5005
R4540 VSS.n1889 VSS.n914 8.5005
R4541 VSS.n1889 VSS.n913 8.5005
R4542 VSS.n1889 VSS.n912 8.5005
R4543 VSS.n1889 VSS.n911 8.5005
R4544 VSS.n1889 VSS.n910 8.5005
R4545 VSS.n1889 VSS.n909 8.5005
R4546 VSS.n1889 VSS.n908 8.5005
R4547 VSS.n1889 VSS.n907 8.5005
R4548 VSS.n1889 VSS.n906 8.5005
R4549 VSS.n1889 VSS.n905 8.5005
R4550 VSS.n1889 VSS.n904 8.5005
R4551 VSS.n1889 VSS.n903 8.5005
R4552 VSS.n1889 VSS.n902 8.5005
R4553 VSS.n1889 VSS.n901 8.5005
R4554 VSS.n1889 VSS.n900 8.5005
R4555 VSS.n1889 VSS.n899 8.5005
R4556 VSS.n1889 VSS.n898 8.5005
R4557 VSS.n1889 VSS.n897 8.5005
R4558 VSS.n1889 VSS.n896 8.5005
R4559 VSS.n1889 VSS.n895 8.5005
R4560 VSS.n1889 VSS.n894 8.5005
R4561 VSS.n1889 VSS.n893 8.5005
R4562 VSS.n1889 VSS.n892 8.5005
R4563 VSS.n1889 VSS.n891 8.5005
R4564 VSS.n1889 VSS.n890 8.5005
R4565 VSS.n1425 VSS.n1424 8.5005
R4566 VSS.n948 VSS.n247 8.5005
R4567 VSS.n1077 VSS.n247 8.5005
R4568 VSS.n1078 VSS.n247 8.5005
R4569 VSS.n1087 VSS.n247 8.5005
R4570 VSS.n1088 VSS.n247 8.5005
R4571 VSS.n1096 VSS.n247 8.5005
R4572 VSS.n1097 VSS.n247 8.5005
R4573 VSS.n934 VSS.n247 8.5005
R4574 VSS.n933 VSS.n247 8.5005
R4575 VSS.n932 VSS.n247 8.5005
R4576 VSS.n1130 VSS.n247 8.5005
R4577 VSS.n1134 VSS.n247 8.5005
R4578 VSS.n1135 VSS.n247 8.5005
R4579 VSS.n1143 VSS.n247 8.5005
R4580 VSS.n1578 VSS.t140 8.5005
R4581 VSS.t185 VSS.n1588 8.5005
R4582 VSS.n1589 VSS.t185 8.5005
R4583 VSS.t140 VSS.n1577 8.5005
R4584 VSS.n2088 VSS.n107 8.5005
R4585 VSS.n2088 VSS.n106 8.5005
R4586 VSS.n1983 VSS.n1982 8.5005
R4587 VSS.n2023 VSS.n2022 8.5005
R4588 VSS.n2063 VSS.n2062 8.5005
R4589 VSS.n1768 VSS.n247 8.5005
R4590 VSS.n359 VSS.n247 8.5005
R4591 VSS.n358 VSS.n247 8.5005
R4592 VSS.n351 VSS.n247 8.5005
R4593 VSS.n350 VSS.n247 8.5005
R4594 VSS.n342 VSS.n247 8.5005
R4595 VSS.n341 VSS.n247 8.5005
R4596 VSS.n334 VSS.n247 8.5005
R4597 VSS.n333 VSS.n247 8.5005
R4598 VSS.n325 VSS.n247 8.5005
R4599 VSS.n324 VSS.n247 8.5005
R4600 VSS.n443 VSS.n247 8.5005
R4601 VSS.n444 VSS.n247 8.5005
R4602 VSS.n446 VSS.n247 8.5005
R4603 VSS.n445 VSS.n247 8.5005
R4604 VSS.n292 VSS.n247 8.5005
R4605 VSS.n291 VSS.n247 8.5005
R4606 VSS.n273 VSS.n247 8.5005
R4607 VSS.n272 VSS.n247 8.5005
R4608 VSS.n268 VSS.n247 8.5005
R4609 VSS.n267 VSS.n247 8.5005
R4610 VSS.n263 VSS.n247 8.5005
R4611 VSS.n262 VSS.n247 8.5005
R4612 VSS.n1864 VSS.t107 8.5005
R4613 VSS.n1861 VSS.t107 8.5005
R4614 VSS.n1863 VSS.t107 8.5005
R4615 VSS.n1898 VSS.t160 8.5005
R4616 VSS.n255 VSS.t160 8.5005
R4617 VSS.n1897 VSS.t160 8.5005
R4618 VSS.n1856 VSS.n247 8.5005
R4619 VSS.n1871 VSS.n247 8.5005
R4620 VSS.n1773 VSS.n1770 8.5005
R4621 VSS.n1781 VSS.n1730 8.5005
R4622 VSS.n1889 VSS.n1336 8.5005
R4623 VSS.n1889 VSS.n1343 8.5005
R4624 VSS.n1889 VSS.n1348 8.5005
R4625 VSS.n2088 VSS.n35 8.5005
R4626 VSS.n2088 VSS.n41 8.5005
R4627 VSS.n2088 VSS.n42 8.5005
R4628 VSS.n2088 VSS.n45 8.5005
R4629 VSS.n2088 VSS.n46 8.5005
R4630 VSS.n2088 VSS.n48 8.5005
R4631 VSS.n2088 VSS.n51 8.5005
R4632 VSS.n2088 VSS.n52 8.5005
R4633 VSS.n2088 VSS.n55 8.5005
R4634 VSS.n2088 VSS.n66 8.5005
R4635 VSS.n2088 VSS.n67 8.5005
R4636 VSS.n2088 VSS.n70 8.5005
R4637 VSS.n2088 VSS.n71 8.5005
R4638 VSS.n2088 VSS.n73 8.5005
R4639 VSS.n2088 VSS.n76 8.5005
R4640 VSS.n2088 VSS.n77 8.5005
R4641 VSS.n2088 VSS.n80 8.5005
R4642 VSS.n2088 VSS.n95 8.5005
R4643 VSS.n2088 VSS.n96 8.5005
R4644 VSS.n2088 VSS.n98 8.5005
R4645 VSS.n2088 VSS.n102 8.5005
R4646 VSS.n2088 VSS.n103 8.5005
R4647 VSS.n2088 VSS.n104 8.5005
R4648 VSS.n2088 VSS.n2087 8.5005
R4649 VSS.t95 VSS.n1791 8.5005
R4650 VSS.t95 VSS.n1801 8.5005
R4651 VSS.n1879 VSS.n1868 8.49913
R4652 VSS.n813 VSS.n247 8.4984
R4653 VSS.n811 VSS.n247 8.4984
R4654 VSS.n806 VSS.n247 8.4984
R4655 VSS.n817 VSS.n247 8.4984
R4656 VSS.n819 VSS.n247 8.4984
R4657 VSS.n821 VSS.n247 8.4984
R4658 VSS.n822 VSS.n247 8.4984
R4659 VSS.n825 VSS.n247 8.4984
R4660 VSS.n827 VSS.n247 8.4984
R4661 VSS.n829 VSS.n247 8.4984
R4662 VSS.n830 VSS.n247 8.4984
R4663 VSS.n833 VSS.n247 8.4984
R4664 VSS.n835 VSS.n247 8.4984
R4665 VSS.n837 VSS.n247 8.4984
R4666 VSS.n838 VSS.n247 8.4984
R4667 VSS.n841 VSS.n247 8.4984
R4668 VSS.n843 VSS.n247 8.4984
R4669 VSS.n845 VSS.n247 8.4984
R4670 VSS.n846 VSS.n247 8.4984
R4671 VSS.n849 VSS.n247 8.4984
R4672 VSS.n851 VSS.n247 8.4984
R4673 VSS.n853 VSS.n247 8.4984
R4674 VSS.n854 VSS.n247 8.4984
R4675 VSS.n857 VSS.n247 8.4984
R4676 VSS.n859 VSS.n247 8.4984
R4677 VSS.n861 VSS.n247 8.4984
R4678 VSS.n862 VSS.n247 8.4984
R4679 VSS.n865 VSS.n247 8.4984
R4680 VSS.n867 VSS.n247 8.4984
R4681 VSS.n869 VSS.n247 8.4984
R4682 VSS.n870 VSS.n247 8.4984
R4683 VSS.n873 VSS.n247 8.4984
R4684 VSS.n875 VSS.n247 8.4984
R4685 VSS.n877 VSS.n247 8.4984
R4686 VSS.n878 VSS.n247 8.4984
R4687 VSS.n881 VSS.n247 8.4984
R4688 VSS.n883 VSS.n247 8.4984
R4689 VSS.n885 VSS.n247 8.4984
R4690 VSS.n886 VSS.n247 8.4984
R4691 VSS.n628 VSS.n247 8.4984
R4692 VSS.n626 VSS.n247 8.4984
R4693 VSS.n623 VSS.n247 8.4984
R4694 VSS.n621 VSS.n247 8.4984
R4695 VSS.n617 VSS.n247 8.4984
R4696 VSS.n615 VSS.n247 8.4984
R4697 VSS.n612 VSS.n247 8.4984
R4698 VSS.n610 VSS.n247 8.4984
R4699 VSS.n606 VSS.n247 8.4984
R4700 VSS.n604 VSS.n247 8.4984
R4701 VSS.n601 VSS.n247 8.4984
R4702 VSS.n599 VSS.n247 8.4984
R4703 VSS.n595 VSS.n247 8.4984
R4704 VSS.n593 VSS.n247 8.4984
R4705 VSS.n590 VSS.n247 8.4984
R4706 VSS.n588 VSS.n247 8.4984
R4707 VSS.n584 VSS.n247 8.4984
R4708 VSS.n582 VSS.n247 8.4984
R4709 VSS.n579 VSS.n247 8.4984
R4710 VSS.n577 VSS.n247 8.4984
R4711 VSS.n573 VSS.n247 8.4984
R4712 VSS.n571 VSS.n247 8.4984
R4713 VSS.n568 VSS.n247 8.4984
R4714 VSS.n566 VSS.n247 8.4984
R4715 VSS.n562 VSS.n247 8.4984
R4716 VSS.n560 VSS.n247 8.4984
R4717 VSS.n557 VSS.n247 8.4984
R4718 VSS.n555 VSS.n247 8.4984
R4719 VSS.n551 VSS.n247 8.4984
R4720 VSS.n549 VSS.n247 8.4984
R4721 VSS.n546 VSS.n247 8.4984
R4722 VSS.n544 VSS.n247 8.4984
R4723 VSS.n540 VSS.n247 8.4984
R4724 VSS.n538 VSS.n247 8.4984
R4725 VSS.n535 VSS.n247 8.4984
R4726 VSS.n533 VSS.n247 8.4984
R4727 VSS.n529 VSS.n247 8.4984
R4728 VSS.n527 VSS.n247 8.4984
R4729 VSS.n524 VSS.n247 8.4984
R4730 VSS.n522 VSS.n247 8.4984
R4731 VSS.n1005 VSS.n247 8.4984
R4732 VSS.n1010 VSS.n247 8.4984
R4733 VSS.n1012 VSS.n247 8.4984
R4734 VSS.n1017 VSS.n247 8.4984
R4735 VSS.n1020 VSS.n247 8.4984
R4736 VSS.n1026 VSS.n247 8.4984
R4737 VSS.n1028 VSS.n247 8.4984
R4738 VSS.n1031 VSS.n247 8.4984
R4739 VSS.n1033 VSS.n247 8.4984
R4740 VSS.n1035 VSS.n247 8.4984
R4741 VSS.n1037 VSS.n247 8.4984
R4742 VSS.n1055 VSS.n247 8.4984
R4743 VSS.n1060 VSS.n247 8.4984
R4744 VSS.n1062 VSS.n247 8.4984
R4745 VSS.n1067 VSS.n247 8.4984
R4746 VSS.n1070 VSS.n247 8.4984
R4747 VSS.n1075 VSS.n247 8.4984
R4748 VSS.n1080 VSS.n247 8.4984
R4749 VSS.n1085 VSS.n247 8.4984
R4750 VSS.n1090 VSS.n247 8.4984
R4751 VSS.n1094 VSS.n247 8.4984
R4752 VSS.n1099 VSS.n247 8.4984
R4753 VSS.n1103 VSS.n247 8.4984
R4754 VSS.n1107 VSS.n247 8.4984
R4755 VSS.n1112 VSS.n247 8.4984
R4756 VSS.n1117 VSS.n247 8.4984
R4757 VSS.n1121 VSS.n247 8.4984
R4758 VSS.n1123 VSS.n247 8.4984
R4759 VSS.n1125 VSS.n247 8.4984
R4760 VSS.n1128 VSS.n247 8.4984
R4761 VSS.n1132 VSS.n247 8.4984
R4762 VSS.n1137 VSS.n247 8.4984
R4763 VSS.n1146 VSS.n247 8.4984
R4764 VSS.n1148 VSS.n247 8.4984
R4765 VSS.n1155 VSS.n247 8.4984
R4766 VSS.n1160 VSS.n247 8.4984
R4767 VSS.n1162 VSS.n247 8.4984
R4768 VSS.n1167 VSS.n247 8.4984
R4769 VSS.n1169 VSS.n247 8.4984
R4770 VSS.n1174 VSS.n247 8.4984
R4771 VSS.n1177 VSS.n247 8.4984
R4772 VSS.n1182 VSS.n247 8.4984
R4773 VSS.n1184 VSS.n247 8.4984
R4774 VSS.n1189 VSS.n247 8.4984
R4775 VSS.n1192 VSS.n247 8.4984
R4776 VSS.n1197 VSS.n247 8.4984
R4777 VSS.n1199 VSS.n247 8.4984
R4778 VSS.n1204 VSS.n247 8.4984
R4779 VSS.n1207 VSS.n247 8.4984
R4780 VSS.n1212 VSS.n247 8.4984
R4781 VSS.n1214 VSS.n247 8.4984
R4782 VSS.n1219 VSS.n247 8.4984
R4783 VSS.n1222 VSS.n247 8.4984
R4784 VSS.n1227 VSS.n247 8.4984
R4785 VSS.n1229 VSS.n247 8.4984
R4786 VSS.n1234 VSS.n247 8.4984
R4787 VSS.n1237 VSS.n247 8.4984
R4788 VSS.n1242 VSS.n247 8.4984
R4789 VSS.n1244 VSS.n247 8.4984
R4790 VSS.n1249 VSS.n247 8.4984
R4791 VSS.n1252 VSS.n247 8.4984
R4792 VSS.n1257 VSS.n247 8.4984
R4793 VSS.n1259 VSS.n247 8.4984
R4794 VSS.n1264 VSS.n247 8.4984
R4795 VSS.n1267 VSS.n247 8.4984
R4796 VSS.n1272 VSS.n247 8.4984
R4797 VSS.n1274 VSS.n247 8.4984
R4798 VSS.n1279 VSS.n247 8.4984
R4799 VSS.n1282 VSS.n247 8.4984
R4800 VSS.n1287 VSS.n247 8.4984
R4801 VSS.n1289 VSS.n247 8.4984
R4802 VSS.n1294 VSS.n247 8.4984
R4803 VSS.n1297 VSS.n247 8.4984
R4804 VSS.n1302 VSS.n247 8.4984
R4805 VSS.n1304 VSS.n247 8.4984
R4806 VSS.n1308 VSS.n247 8.4984
R4807 VSS.n1889 VSS.n814 8.4984
R4808 VSS.n1889 VSS.n812 8.4984
R4809 VSS.n1889 VSS.n807 8.4984
R4810 VSS.n1889 VSS.n805 8.4984
R4811 VSS.n1889 VSS.n818 8.4984
R4812 VSS.n1889 VSS.n820 8.4984
R4813 VSS.n1889 VSS.n823 8.4984
R4814 VSS.n1889 VSS.n826 8.4984
R4815 VSS.n1889 VSS.n828 8.4984
R4816 VSS.n1889 VSS.n831 8.4984
R4817 VSS.n1889 VSS.n834 8.4984
R4818 VSS.n1889 VSS.n836 8.4984
R4819 VSS.n1889 VSS.n839 8.4984
R4820 VSS.n1889 VSS.n842 8.4984
R4821 VSS.n1889 VSS.n844 8.4984
R4822 VSS.n1889 VSS.n847 8.4984
R4823 VSS.n1889 VSS.n850 8.4984
R4824 VSS.n1889 VSS.n852 8.4984
R4825 VSS.n1889 VSS.n855 8.4984
R4826 VSS.n1889 VSS.n858 8.4984
R4827 VSS.n1889 VSS.n860 8.4984
R4828 VSS.n1889 VSS.n863 8.4984
R4829 VSS.n1889 VSS.n866 8.4984
R4830 VSS.n1889 VSS.n868 8.4984
R4831 VSS.n1889 VSS.n871 8.4984
R4832 VSS.n1889 VSS.n874 8.4984
R4833 VSS.n1889 VSS.n876 8.4984
R4834 VSS.n1889 VSS.n879 8.4984
R4835 VSS.n1889 VSS.n882 8.4984
R4836 VSS.n1889 VSS.n884 8.4984
R4837 VSS.n1889 VSS.n887 8.4984
R4838 VSS.n1889 VSS.n627 8.4984
R4839 VSS.n1889 VSS.n624 8.4984
R4840 VSS.n1889 VSS.n622 8.4984
R4841 VSS.n1889 VSS.n616 8.4984
R4842 VSS.n1889 VSS.n613 8.4984
R4843 VSS.n1889 VSS.n611 8.4984
R4844 VSS.n1889 VSS.n605 8.4984
R4845 VSS.n1889 VSS.n602 8.4984
R4846 VSS.n1889 VSS.n600 8.4984
R4847 VSS.n1889 VSS.n594 8.4984
R4848 VSS.n1889 VSS.n591 8.4984
R4849 VSS.n1889 VSS.n589 8.4984
R4850 VSS.n1889 VSS.n583 8.4984
R4851 VSS.n1889 VSS.n580 8.4984
R4852 VSS.n1889 VSS.n578 8.4984
R4853 VSS.n1889 VSS.n572 8.4984
R4854 VSS.n1889 VSS.n569 8.4984
R4855 VSS.n1889 VSS.n567 8.4984
R4856 VSS.n1889 VSS.n561 8.4984
R4857 VSS.n1889 VSS.n558 8.4984
R4858 VSS.n1889 VSS.n556 8.4984
R4859 VSS.n1889 VSS.n550 8.4984
R4860 VSS.n1889 VSS.n547 8.4984
R4861 VSS.n1889 VSS.n545 8.4984
R4862 VSS.n1889 VSS.n539 8.4984
R4863 VSS.n1889 VSS.n536 8.4984
R4864 VSS.n1889 VSS.n534 8.4984
R4865 VSS.n1889 VSS.n528 8.4984
R4866 VSS.n1889 VSS.n525 8.4984
R4867 VSS.n1889 VSS.n523 8.4984
R4868 VSS.n1889 VSS.n1006 8.4984
R4869 VSS.n1889 VSS.n1011 8.4984
R4870 VSS.n1889 VSS.n1013 8.4984
R4871 VSS.n1889 VSS.n1021 8.4984
R4872 VSS.n1889 VSS.n1027 8.4984
R4873 VSS.n1889 VSS.n1032 8.4984
R4874 VSS.n1889 VSS.n1034 8.4984
R4875 VSS.n1889 VSS.n1036 8.4984
R4876 VSS.n1889 VSS.n1056 8.4984
R4877 VSS.n1889 VSS.n1061 8.4984
R4878 VSS.n1889 VSS.n1063 8.4984
R4879 VSS.n1889 VSS.n1071 8.4984
R4880 VSS.n1889 VSS.n1076 8.4984
R4881 VSS.n1889 VSS.n1086 8.4984
R4882 VSS.n1889 VSS.n1091 8.4984
R4883 VSS.n1889 VSS.n1095 8.4984
R4884 VSS.n1889 VSS.n1100 8.4984
R4885 VSS.n1889 VSS.n1104 8.4984
R4886 VSS.n1889 VSS.n1113 8.4984
R4887 VSS.n1889 VSS.n1118 8.4984
R4888 VSS.n1889 VSS.n1122 8.4984
R4889 VSS.n1889 VSS.n1124 8.4984
R4890 VSS.n1889 VSS.n1129 8.4984
R4891 VSS.n1889 VSS.n1133 8.4984
R4892 VSS.n1889 VSS.n1138 8.4984
R4893 VSS.n1889 VSS.n1147 8.4984
R4894 VSS.n1889 VSS.n1149 8.4984
R4895 VSS.n1889 VSS.n1156 8.4984
R4896 VSS.n1889 VSS.n1161 8.4984
R4897 VSS.n1889 VSS.n1163 8.4984
R4898 VSS.n1889 VSS.n1168 8.4984
R4899 VSS.n1889 VSS.n1170 8.4984
R4900 VSS.n1889 VSS.n1178 8.4984
R4901 VSS.n1889 VSS.n1183 8.4984
R4902 VSS.n1889 VSS.n1185 8.4984
R4903 VSS.n1889 VSS.n1193 8.4984
R4904 VSS.n1889 VSS.n1198 8.4984
R4905 VSS.n1889 VSS.n1200 8.4984
R4906 VSS.n1889 VSS.n1208 8.4984
R4907 VSS.n1889 VSS.n1213 8.4984
R4908 VSS.n1889 VSS.n1215 8.4984
R4909 VSS.n1889 VSS.n1223 8.4984
R4910 VSS.n1889 VSS.n1228 8.4984
R4911 VSS.n1889 VSS.n1230 8.4984
R4912 VSS.n1889 VSS.n1238 8.4984
R4913 VSS.n1889 VSS.n1243 8.4984
R4914 VSS.n1889 VSS.n1245 8.4984
R4915 VSS.n1889 VSS.n1253 8.4984
R4916 VSS.n1889 VSS.n1258 8.4984
R4917 VSS.n1889 VSS.n1260 8.4984
R4918 VSS.n1889 VSS.n1268 8.4984
R4919 VSS.n1889 VSS.n1273 8.4984
R4920 VSS.n1889 VSS.n1275 8.4984
R4921 VSS.n1889 VSS.n1283 8.4984
R4922 VSS.n1889 VSS.n1288 8.4984
R4923 VSS.n1889 VSS.n1290 8.4984
R4924 VSS.n1889 VSS.n1298 8.4984
R4925 VSS.n1889 VSS.n1303 8.4984
R4926 VSS.n1889 VSS.n1305 8.4984
R4927 VSS.n397 VSS.n247 8.4984
R4928 VSS.n410 VSS.n247 8.4984
R4929 VSS.n391 VSS.n247 8.4984
R4930 VSS.n387 VSS.n247 8.4984
R4931 VSS.n383 VSS.n247 8.4984
R4932 VSS.n380 VSS.n247 8.4984
R4933 VSS.n378 VSS.n247 8.4984
R4934 VSS.n412 VSS.n247 8.4984
R4935 VSS.n374 VSS.n247 8.4984
R4936 VSS.n371 VSS.n247 8.4984
R4937 VSS.n369 VSS.n247 8.4984
R4938 VSS.n414 VSS.n247 8.4984
R4939 VSS.n365 VSS.n247 8.4984
R4940 VSS.n361 VSS.n247 8.4984
R4941 VSS.n353 VSS.n247 8.4984
R4942 VSS.n348 VSS.n247 8.4984
R4943 VSS.n344 VSS.n247 8.4984
R4944 VSS.n336 VSS.n247 8.4984
R4945 VSS.n331 VSS.n247 8.4984
R4946 VSS.n327 VSS.n247 8.4984
R4947 VSS.n322 VSS.n247 8.4984
R4948 VSS.n318 VSS.n247 8.4984
R4949 VSS.n311 VSS.n247 8.4984
R4950 VSS.n304 VSS.n247 8.4984
R4951 VSS.n302 VSS.n247 8.4984
R4952 VSS.n299 VSS.n247 8.4984
R4953 VSS.n296 VSS.n247 8.4984
R4954 VSS.n294 VSS.n247 8.4984
R4955 VSS.n1323 VSS.n247 8.4984
R4956 VSS.n1325 VSS.n247 8.4984
R4957 VSS.n1326 VSS.n247 8.4984
R4958 VSS.n1329 VSS.n247 8.4984
R4959 VSS.n1331 VSS.n247 8.4984
R4960 VSS.n1333 VSS.n247 8.4984
R4961 VSS.n1337 VSS.n247 8.4984
R4962 VSS.n1339 VSS.n247 8.4984
R4963 VSS.n1340 VSS.n247 8.4984
R4964 VSS.n1345 VSS.n247 8.4984
R4965 VSS.n1350 VSS.n247 8.4984
R4966 VSS.n1849 VSS.n247 8.4984
R4967 VSS.n1851 VSS.n247 8.4984
R4968 VSS.n260 VSS.n247 8.4984
R4969 VSS.n1889 VSS.n395 8.4984
R4970 VSS.n1889 VSS.n388 8.4984
R4971 VSS.n1889 VSS.n384 8.4984
R4972 VSS.n1889 VSS.n381 8.4984
R4973 VSS.n1889 VSS.n379 8.4984
R4974 VSS.n1889 VSS.n376 8.4984
R4975 VSS.n1889 VSS.n372 8.4984
R4976 VSS.n1889 VSS.n370 8.4984
R4977 VSS.n1889 VSS.n367 8.4984
R4978 VSS.n1889 VSS.n363 8.4984
R4979 VSS.n1889 VSS.n362 8.4984
R4980 VSS.n1889 VSS.n357 8.4984
R4981 VSS.n1889 VSS.n354 8.4984
R4982 VSS.n1889 VSS.n349 8.4984
R4983 VSS.n1889 VSS.n345 8.4984
R4984 VSS.n1889 VSS.n340 8.4984
R4985 VSS.n1889 VSS.n337 8.4984
R4986 VSS.n1889 VSS.n332 8.4984
R4987 VSS.n1889 VSS.n328 8.4984
R4988 VSS.n1889 VSS.n323 8.4984
R4989 VSS.n1889 VSS.n319 8.4984
R4990 VSS.n1889 VSS.n315 8.4984
R4991 VSS.n1889 VSS.n312 8.4984
R4992 VSS.n1889 VSS.n305 8.4984
R4993 VSS.n1889 VSS.n303 8.4984
R4994 VSS.n1889 VSS.n300 8.4984
R4995 VSS.n1889 VSS.n298 8.4984
R4996 VSS.n1889 VSS.n297 8.4984
R4997 VSS.n1889 VSS.n295 8.4984
R4998 VSS.n1889 VSS.n290 8.4984
R4999 VSS.n1889 VSS.n1324 8.4984
R5000 VSS.n1889 VSS.n1327 8.4984
R5001 VSS.n1889 VSS.n1330 8.4984
R5002 VSS.n1889 VSS.n1332 8.4984
R5003 VSS.n1889 VSS.n1334 8.4984
R5004 VSS.n1889 VSS.n1338 8.4984
R5005 VSS.n1889 VSS.n1341 8.4984
R5006 VSS.n1889 VSS.n1346 8.4984
R5007 VSS.n1889 VSS.n1349 8.4984
R5008 VSS.n1889 VSS.n1351 8.4984
R5009 VSS.n1889 VSS.n1848 8.4984
R5010 VSS.n1889 VSS.n1850 8.4984
R5011 VSS.n1889 VSS.n1852 8.4984
R5012 VSS.n1890 VSS.n1889 8.4984
R5013 VSS.n7 VSS.n4 8.4984
R5014 VSS.n9 VSS.n4 8.4984
R5015 VSS.n100 VSS.n4 8.4984
R5016 VSS.n99 VSS.n4 8.4984
R5017 VSS.n93 VSS.n4 8.4984
R5018 VSS.n89 VSS.n4 8.4984
R5019 VSS.n82 VSS.n4 8.4984
R5020 VSS.n78 VSS.n4 8.4984
R5021 VSS.n74 VSS.n4 8.4984
R5022 VSS.n68 VSS.n4 8.4984
R5023 VSS.n64 VSS.n4 8.4984
R5024 VSS.n61 VSS.n4 8.4984
R5025 VSS.n57 VSS.n4 8.4984
R5026 VSS.n53 VSS.n4 8.4984
R5027 VSS.n49 VSS.n4 8.4984
R5028 VSS.n43 VSS.n4 8.4984
R5029 VSS.n39 VSS.n4 8.4984
R5030 VSS.n36 VSS.n4 8.4984
R5031 VSS.n2088 VSS.n37 8.4984
R5032 VSS.n2088 VSS.n40 8.4984
R5033 VSS.n2088 VSS.n44 8.4984
R5034 VSS.n2088 VSS.n50 8.4984
R5035 VSS.n2088 VSS.n54 8.4984
R5036 VSS.n2088 VSS.n62 8.4984
R5037 VSS.n2088 VSS.n65 8.4984
R5038 VSS.n2088 VSS.n69 8.4984
R5039 VSS.n2088 VSS.n75 8.4984
R5040 VSS.n2088 VSS.n79 8.4984
R5041 VSS.n2088 VSS.n83 8.4984
R5042 VSS.n2088 VSS.n90 8.4984
R5043 VSS.n2088 VSS.n94 8.4984
R5044 VSS.n2088 VSS.n101 8.4984
R5045 VSS.n2088 VSS.n11 8.4984
R5046 VSS.n2088 VSS.n8 8.4984
R5047 VSS.n2088 VSS.n6 8.4984
R5048 VSS.n1928 VSS.n1927 8.4983
R5049 VSS.n1931 VSS.n1930 8.49762
R5050 VSS.n1521 VSS.n1511 8.49694
R5051 VSS.n1520 VSS.n1512 8.49694
R5052 VSS.n1519 VSS.n1513 8.49694
R5053 VSS.n1518 VSS.n1514 8.49694
R5054 VSS.n1501 VSS.n1499 8.49694
R5055 VSS.n1547 VSS.n1546 8.49694
R5056 VSS.n1509 VSS.n1489 8.49694
R5057 VSS.n1933 VSS.n1932 8.49694
R5058 VSS.n1935 VSS.n1934 8.49694
R5059 VSS.n1937 VSS.n1936 8.49694
R5060 VSS.n1942 VSS.n1941 8.49694
R5061 VSS.n1944 VSS.n1943 8.49694
R5062 VSS.n1946 VSS.n1945 8.49694
R5063 VSS.n1948 VSS.n1947 8.49694
R5064 VSS.n2071 VSS.n1914 8.49694
R5065 VSS.n2088 VSS.n87 8.49574
R5066 VSS.n2053 VSS.n2052 8.48545
R5067 VSS.n2013 VSS.n2012 8.48545
R5068 VSS.n1973 VSS.n1972 8.48545
R5069 VSS.n2061 VSS.n2043 8.48544
R5070 VSS.n2021 VSS.n2003 8.48544
R5071 VSS.n1981 VSS.n1963 8.48544
R5072 VSS.n2085 VSS.n146 8.48362
R5073 VSS.n2085 VSS.n158 8.48362
R5074 VSS.n2085 VSS.n171 8.48362
R5075 VSS.n179 VSS.n4 8.48362
R5076 VSS.n407 VSS.n4 8.48362
R5077 VSS.n2060 VSS.n2044 8.46995
R5078 VSS.n2059 VSS.n2045 8.46995
R5079 VSS.n2058 VSS.n2046 8.46995
R5080 VSS.n2056 VSS.n2048 8.46995
R5081 VSS.n2055 VSS.n2049 8.46995
R5082 VSS.n2054 VSS.n2050 8.46995
R5083 VSS.n2020 VSS.n2004 8.46995
R5084 VSS.n2019 VSS.n2005 8.46995
R5085 VSS.n2018 VSS.n2006 8.46995
R5086 VSS.n2016 VSS.n2008 8.46995
R5087 VSS.n2015 VSS.n2009 8.46995
R5088 VSS.n2014 VSS.n2010 8.46995
R5089 VSS.n1980 VSS.n1964 8.46995
R5090 VSS.n1979 VSS.n1965 8.46995
R5091 VSS.n1978 VSS.n1966 8.46995
R5092 VSS.n1976 VSS.n1968 8.46995
R5093 VSS.n1975 VSS.n1969 8.46995
R5094 VSS.n1974 VSS.n1970 8.46995
R5095 VSS.n145 VSS.n118 8.46995
R5096 VSS.n1800 VSS.n1798 8.46995
R5097 VSS.n175 VSS.n174 8.46995
R5098 VSS.n181 VSS.n180 8.46995
R5099 VSS.n400 VSS.n399 8.46995
R5100 VSS.n406 VSS.n405 8.46995
R5101 VSS.n1420 VSS.n1417 8.46995
R5102 VSS.n1772 VSS.n1771 8.46995
R5103 VSS.n177 VSS.n176 8.46813
R5104 VSS.n402 VSS.n398 8.46813
R5105 VSS.n2057 VSS.n2047 8.46086
R5106 VSS.n2017 VSS.n2007 8.46086
R5107 VSS.n1977 VSS.n1967 8.46086
R5108 VSS.n148 VSS.n13 7.6711
R5109 VSS.n165 VSS.n59 7.6711
R5110 VSS.n153 VSS.n88 7.6711
R5111 VSS.n437 VSS.n436 7.66219
R5112 VSS.n1023 VSS.n981 7.53841
R5113 VSS.n1072 VSS.n943 7.53822
R5114 VSS.n1348 VSS.n1347 7.53822
R5115 VSS.t99 VSS.n1735 7.49606
R5116 VSS.n1749 VSS.t101 7.49606
R5117 VSS.n1444 VSS.t134 7.49606
R5118 VSS.t154 VSS.n1742 7.49606
R5119 VSS.n1758 VSS.t156 7.49606
R5120 VSS.n1435 VSS.t179 7.49606
R5121 VSS.t181 VSS.n1441 7.49606
R5122 VSS.n1431 VSS.t131 7.49606
R5123 VSS.t96 VSS.n1727 7.49606
R5124 VSS.n1783 VSS.t151 7.49606
R5125 VSS.t112 VSS.n737 7.20324
R5126 VSS.n739 VSS.n507 7.20324
R5127 VSS.n743 VSS.n505 7.20324
R5128 VSS.n746 VSS.n503 7.20324
R5129 VSS.n750 VSS.n501 7.20324
R5130 VSS.n753 VSS.n499 7.20324
R5131 VSS.n757 VSS.n497 7.20324
R5132 VSS.n760 VSS.n495 7.20324
R5133 VSS.n764 VSS.n493 7.20324
R5134 VSS.n767 VSS.n491 7.20324
R5135 VSS.n771 VSS.n489 7.20324
R5136 VSS.n774 VSS.n487 7.20324
R5137 VSS.n778 VSS.n485 7.20324
R5138 VSS.n781 VSS.n483 7.20324
R5139 VSS.n785 VSS.n481 7.20324
R5140 VSS.n788 VSS.n479 7.20324
R5141 VSS.n792 VSS.n477 7.20324
R5142 VSS.n795 VSS.n475 7.20324
R5143 VSS.n799 VSS.n473 7.20324
R5144 VSS.n802 VSS.n471 7.20324
R5145 VSS.n808 VSS.n469 7.20324
R5146 VSS.n262 VSS.n261 7.20324
R5147 VSS.n267 VSS.n266 7.20324
R5148 VSS.n272 VSS.n271 7.20324
R5149 VSS.t102 VSS.n280 7.20324
R5150 VSS.n656 VSS.n655 7.20324
R5151 VSS.n660 VSS.n659 7.20324
R5152 VSS.n664 VSS.n663 7.20324
R5153 VSS.n668 VSS.n667 7.20324
R5154 VSS.n672 VSS.n671 7.20324
R5155 VSS.n676 VSS.n675 7.20324
R5156 VSS.n680 VSS.n679 7.20324
R5157 VSS.n684 VSS.n683 7.20324
R5158 VSS.n688 VSS.n687 7.20324
R5159 VSS.n692 VSS.n691 7.20324
R5160 VSS.n696 VSS.n695 7.20324
R5161 VSS.n700 VSS.n699 7.20324
R5162 VSS.n704 VSS.n703 7.20324
R5163 VSS.n708 VSS.n707 7.20324
R5164 VSS.n712 VSS.n711 7.20324
R5165 VSS.n716 VSS.n715 7.20324
R5166 VSS.n720 VSS.n719 7.20324
R5167 VSS.n724 VSS.n723 7.20324
R5168 VSS.n728 VSS.n727 7.20324
R5169 VSS.t121 VSS.n998 7.20324
R5170 VSS.n1002 VSS.n986 7.20324
R5171 VSS.n1008 VSS.n984 7.20324
R5172 VSS.n1015 VSS.n982 7.20324
R5173 VSS.t128 VSS.n1050 7.20324
R5174 VSS.n360 VSS.n359 7.20324
R5175 VSS.n352 VSS.n351 7.20324
R5176 VSS.n343 VSS.n342 7.20324
R5177 VSS.n335 VSS.n334 7.20324
R5178 VSS.n326 VSS.n325 7.20324
R5179 VSS.n293 VSS.n292 7.20324
R5180 VSS.n738 VSS.t112 7.20324
R5181 VSS.n999 VSS.t121 7.20324
R5182 VSS.n1052 VSS.t128 7.20324
R5183 VSS.n1079 VSS.n1078 7.20324
R5184 VSS.n1089 VSS.n1088 7.20324
R5185 VSS.n1098 VSS.n1097 7.20324
R5186 VSS.n1106 VSS.t132 7.20324
R5187 VSS.n1131 VSS.n1130 7.20324
R5188 VSS.n1136 VSS.n1135 7.20324
R5189 VSS.n1154 VSS.t135 7.20324
R5190 VSS.n1881 VSS.n1880 7.20307
R5191 VSS.n809 VSS.n470 7.20256
R5192 VSS.n803 VSS.n472 7.20256
R5193 VSS.n800 VSS.n474 7.20256
R5194 VSS.n796 VSS.n476 7.20256
R5195 VSS.n793 VSS.n478 7.20256
R5196 VSS.n789 VSS.n480 7.20256
R5197 VSS.n786 VSS.n482 7.20256
R5198 VSS.n782 VSS.n484 7.20256
R5199 VSS.n779 VSS.n486 7.20256
R5200 VSS.n775 VSS.n488 7.20256
R5201 VSS.n772 VSS.n490 7.20256
R5202 VSS.n768 VSS.n492 7.20256
R5203 VSS.n765 VSS.n494 7.20256
R5204 VSS.n761 VSS.n496 7.20256
R5205 VSS.n758 VSS.n498 7.20256
R5206 VSS.n754 VSS.n500 7.20256
R5207 VSS.n751 VSS.n502 7.20256
R5208 VSS.n747 VSS.n504 7.20256
R5209 VSS.n744 VSS.n506 7.20256
R5210 VSS.n654 VSS.n653 7.20256
R5211 VSS.n658 VSS.n657 7.20256
R5212 VSS.n662 VSS.n661 7.20256
R5213 VSS.n666 VSS.n665 7.20256
R5214 VSS.n670 VSS.n669 7.20256
R5215 VSS.n674 VSS.n673 7.20256
R5216 VSS.n678 VSS.n677 7.20256
R5217 VSS.n682 VSS.n681 7.20256
R5218 VSS.n686 VSS.n685 7.20256
R5219 VSS.n690 VSS.n689 7.20256
R5220 VSS.n694 VSS.n693 7.20256
R5221 VSS.n698 VSS.n697 7.20256
R5222 VSS.n702 VSS.n701 7.20256
R5223 VSS.n706 VSS.n705 7.20256
R5224 VSS.n710 VSS.n709 7.20256
R5225 VSS.n714 VSS.n713 7.20256
R5226 VSS.n718 VSS.n717 7.20256
R5227 VSS.n722 VSS.n721 7.20256
R5228 VSS.n726 VSS.n725 7.20256
R5229 VSS.n730 VSS.n729 7.20256
R5230 VSS.t118 VSS.n517 7.20256
R5231 VSS.n1007 VSS.n985 7.20256
R5232 VSS.n1014 VSS.n983 7.20256
R5233 VSS.n518 VSS.t118 7.20256
R5234 VSS.n987 VSS.n514 7.20256
R5235 VSS.n1024 VSS.n1022 7.20256
R5236 VSS.n1077 VSS.n1073 7.20256
R5237 VSS.n1087 VSS.n1083 7.20256
R5238 VSS.n1096 VSS.n1093 7.20256
R5239 VSS.n1134 VSS.n1131 7.20256
R5240 VSS.t139 VSS.n1311 7.20256
R5241 VSS.n1768 VSS.n394 7.20256
R5242 VSS.t97 VSS.n386 7.20256
R5243 VSS.n358 VSS.n356 7.20256
R5244 VSS.n350 VSS.n347 7.20256
R5245 VSS.n341 VSS.n339 7.20256
R5246 VSS.n333 VSS.n330 7.20256
R5247 VSS.n324 VSS.n321 7.20256
R5248 VSS.t100 VSS.n314 7.20256
R5249 VSS.n445 VSS.n293 7.20256
R5250 VSS.n291 VSS.n289 7.20256
R5251 VSS.n274 VSS.n273 7.20256
R5252 VSS.n269 VSS.n268 7.20256
R5253 VSS.n264 VSS.n263 7.20256
R5254 VSS.n949 VSS.n948 7.2024
R5255 VSS.n1882 VSS.n1881 7.2024
R5256 VSS.n1312 VSS.t139 7.20236
R5257 VSS.n1306 VSS.n890 7.20236
R5258 VSS.n1299 VSS.n892 7.20236
R5259 VSS.n1291 VSS.n894 7.20236
R5260 VSS.n1284 VSS.n896 7.20236
R5261 VSS.n1276 VSS.n898 7.20236
R5262 VSS.n1269 VSS.n900 7.20236
R5263 VSS.n1261 VSS.n902 7.20236
R5264 VSS.n1254 VSS.n904 7.20236
R5265 VSS.n1246 VSS.n906 7.20236
R5266 VSS.n1239 VSS.n908 7.20236
R5267 VSS.n1231 VSS.n910 7.20236
R5268 VSS.n1224 VSS.n912 7.20236
R5269 VSS.n1216 VSS.n914 7.20236
R5270 VSS.n1209 VSS.n916 7.20236
R5271 VSS.n1201 VSS.n918 7.20236
R5272 VSS.n1194 VSS.n920 7.20236
R5273 VSS.n1186 VSS.n922 7.20236
R5274 VSS.n1179 VSS.n924 7.20236
R5275 VSS.n1171 VSS.n926 7.20236
R5276 VSS.n1164 VSS.n928 7.20236
R5277 VSS.n937 VSS.n936 7.20236
R5278 VSS.n1064 VSS.n945 7.20236
R5279 VSS.n1057 VSS.n947 7.20236
R5280 VSS.n1873 VSS.t109 7.20236
R5281 VSS.n1877 VSS.n1876 7.20236
R5282 VSS.n1885 VSS.n1884 7.20236
R5283 VSS.t106 VSS.n1853 7.20236
R5284 VSS.n454 VSS.n453 7.20236
R5285 VSS.n452 VSS.n451 7.20236
R5286 VSS.n450 VSS.n449 7.20236
R5287 VSS.n281 VSS.t102 7.20236
R5288 VSS.n442 VSS.n441 7.20236
R5289 VSS.n439 VSS.n438 7.20236
R5290 VSS.n316 VSS.t100 7.20236
R5291 VSS.n435 VSS.n434 7.20236
R5292 VSS.n431 VSS.n430 7.20236
R5293 VSS.n427 VSS.n426 7.20236
R5294 VSS.n423 VSS.n422 7.20236
R5295 VSS.n419 VSS.n418 7.20236
R5296 VSS.n389 VSS.t97 7.20236
R5297 VSS.n193 VSS.n38 7.20236
R5298 VSS.n188 VSS.n56 7.20236
R5299 VSS.n166 VSS.n63 7.20236
R5300 VSS.n160 VSS.n81 7.20236
R5301 VSS.n154 VSS.n91 7.20236
R5302 VSS.n114 VSS.n21 7.20236
R5303 VSS.n115 VSS.n21 7.20236
R5304 VSS.n1058 VSS.n946 7.20236
R5305 VSS.n1065 VSS.n944 7.20236
R5306 VSS.t132 VSS.n1105 7.20236
R5307 VSS.n1119 VSS.n938 7.20236
R5308 VSS.n936 VSS.n935 7.20236
R5309 VSS.t135 VSS.n1153 7.20236
R5310 VSS.n1158 VSS.n929 7.20236
R5311 VSS.n1165 VSS.n927 7.20236
R5312 VSS.n1172 VSS.n925 7.20236
R5313 VSS.n1180 VSS.n923 7.20236
R5314 VSS.n1187 VSS.n921 7.20236
R5315 VSS.n1195 VSS.n919 7.20236
R5316 VSS.n1202 VSS.n917 7.20236
R5317 VSS.n1210 VSS.n915 7.20236
R5318 VSS.n1217 VSS.n913 7.20236
R5319 VSS.n1225 VSS.n911 7.20236
R5320 VSS.n1232 VSS.n909 7.20236
R5321 VSS.n1240 VSS.n907 7.20236
R5322 VSS.n1247 VSS.n905 7.20236
R5323 VSS.n1255 VSS.n903 7.20236
R5324 VSS.n1262 VSS.n901 7.20236
R5325 VSS.n1270 VSS.n899 7.20236
R5326 VSS.n1277 VSS.n897 7.20236
R5327 VSS.n1285 VSS.n895 7.20236
R5328 VSS.n1292 VSS.n893 7.20236
R5329 VSS.n1300 VSS.n891 7.20236
R5330 VSS.n421 VSS.n420 7.20236
R5331 VSS.n425 VSS.n424 7.20236
R5332 VSS.n429 VSS.n428 7.20236
R5333 VSS.n433 VSS.n432 7.20236
R5334 VSS.n441 VSS.n440 7.20236
R5335 VSS.n1336 VSS.n1335 7.20236
R5336 VSS.n1343 VSS.n1342 7.20236
R5337 VSS.n1886 VSS.n1885 7.20236
R5338 VSS.n1878 VSS.n1877 7.20236
R5339 VSS.n1874 VSS.n1873 7.20236
R5340 VSS.n192 VSS.n38 7.20236
R5341 VSS.n185 VSS.n56 7.20236
R5342 VSS.n164 VSS.n63 7.20236
R5343 VSS.n159 VSS.n81 7.20236
R5344 VSS.n152 VSS.n91 7.20236
R5345 VSS.n966 VSS.n965 6.69134
R5346 VSS.n973 VSS.n972 6.69134
R5347 VSS.n980 VSS.n979 6.69134
R5348 VSS.n465 VSS.n464 6.69134
R5349 VSS.n975 VSS.n974 6.69134
R5350 VSS.n968 VSS.n967 6.69134
R5351 VSS.n468 VSS.n467 6.69128
R5352 VSS.n652 VSS.n651 6.69128
R5353 VSS.n111 VSS.n105 6.69128
R5354 VSS.n1468 VSS.t292 5.84693
R5355 VSS.n1363 VSS.t57 5.84693
R5356 VSS.n1390 VSS.t217 5.84693
R5357 VSS.n1545 VSS.n1544 5.66778
R5358 VSS.n2077 VSS.n2076 5.66778
R5359 VSS.n2073 VSS.n215 5.66778
R5360 VSS.n2025 VSS.n228 5.66778
R5361 VSS.n2065 VSS.n222 5.66778
R5362 VSS.n1888 VSS.n259 5.66778
R5363 VSS.n1855 VSS.n259 5.66778
R5364 VSS.n1777 VSS.n417 5.66778
R5365 VSS.n1777 VSS.n1776 5.66778
R5366 VSS.n2026 VSS.n2025 5.66767
R5367 VSS.n1986 VSS.n1985 5.66767
R5368 VSS.n134 VSS.n117 5.66767
R5369 VSS.n1806 VSS.n157 5.66767
R5370 VSS.n183 VSS.n170 5.66767
R5371 VSS.n195 VSS.n32 5.66767
R5372 VSS.n2073 VSS.n2072 5.66767
R5373 VSS.n1422 VSS.n1116 5.66767
R5374 VSS.n1777 VSS.n396 5.66767
R5375 VSS.n1734 VSS.t43 5.66717
R5376 VSS.t43 VSS.n1731 5.66717
R5377 VSS.n1753 VSS.t104 5.66717
R5378 VSS.n1748 VSS.t103 5.66717
R5379 VSS.n1447 VSS.t137 5.66717
R5380 VSS.n1445 VSS.t136 5.66717
R5381 VSS.t155 VSS.n1744 5.66717
R5382 VSS.n1745 VSS.t155 5.66717
R5383 VSS.n1761 VSS.t158 5.66717
R5384 VSS.n1759 VSS.t157 5.66717
R5385 VSS.n1434 VSS.t180 5.66717
R5386 VSS.t180 VSS.n1433 5.66717
R5387 VSS.n1448 VSS.t183 5.66717
R5388 VSS.n1440 VSS.t182 5.66717
R5389 VSS.n122 VSS.t145 5.66717
R5390 VSS.n119 VSS.t148 5.66717
R5391 VSS.n126 VSS.t145 5.66717
R5392 VSS.n124 VSS.t78 5.66717
R5393 VSS.n141 VSS.t88 5.66717
R5394 VSS.n127 VSS.t92 5.66717
R5395 VSS.n138 VSS.t91 5.66717
R5396 VSS.n143 VSS.t88 5.66717
R5397 VSS.n1429 VSS.t133 5.66717
R5398 VSS.t133 VSS.n1426 5.66717
R5399 VSS.n1425 VSS.n1418 5.66717
R5400 VSS.n1728 VSS.t98 5.66717
R5401 VSS.n1726 VSS.t27 5.66717
R5402 VSS.n1774 VSS.n1773 5.66717
R5403 VSS.n1786 VSS.t153 5.66717
R5404 VSS.n1784 VSS.t152 5.66717
R5405 VSS.n1780 VSS.n1779 5.66615
R5406 VSS.n1565 VSS.n1489 5.66326
R5407 VSS.n1561 VSS.n1489 5.66326
R5408 VSS.n1559 VSS.n1489 5.66326
R5409 VSS.n1555 VSS.n1489 5.66326
R5410 VSS.n1553 VSS.n1489 5.66326
R5411 VSS.n2071 VSS.n238 5.66326
R5412 VSS.n2071 VSS.n242 5.66326
R5413 VSS.n2071 VSS.n244 5.66326
R5414 VSS.n1352 VSS.t348 5.66167
R5415 VSS.n1844 VSS.t191 5.66167
R5416 VSS.n1355 VSS.t346 5.66167
R5417 VSS.n1353 VSS.t188 5.66167
R5418 VSS.n1709 VSS.t40 5.66167
R5419 VSS.n1705 VSS.t358 5.66167
R5420 VSS.n1714 VSS.t37 5.66167
R5421 VSS.n1710 VSS.t356 5.66167
R5422 VSS.n1720 VSS.t34 5.66167
R5423 VSS.n1718 VSS.t354 5.66167
R5424 VSS.n1723 VSS.t29 5.66167
R5425 VSS.n1721 VSS.t352 5.66167
R5426 VSS.n1466 VSS.t334 5.66167
R5427 VSS.n1480 VSS.t342 5.66167
R5428 VSS.n1477 VSS.t327 5.66167
R5429 VSS.n1474 VSS.t339 5.66167
R5430 VSS.n1471 VSS.t337 5.66167
R5431 VSS.n1465 VSS.t333 5.66167
R5432 VSS.n1462 VSS.t330 5.66167
R5433 VSS.n1459 VSS.t329 5.66167
R5434 VSS.n1456 VSS.t326 5.66167
R5435 VSS.n1361 VSS.t370 5.66167
R5436 VSS.n1388 VSS.t263 5.66167
R5437 VSS.n1378 VSS.t255 5.66167
R5438 VSS.n1406 VSS.t318 5.66167
R5439 VSS.n1635 VSS.t385 5.66167
R5440 VSS.n1403 VSS.t315 5.66167
R5441 VSS.n1402 VSS.t229 5.66167
R5442 VSS.n1400 VSS.t271 5.66167
R5443 VSS.n1399 VSS.t226 5.66167
R5444 VSS.n1397 VSS.t269 5.66167
R5445 VSS.n1396 VSS.t223 5.66167
R5446 VSS.n1394 VSS.t267 5.66167
R5447 VSS.n1393 VSS.t220 5.66167
R5448 VSS.n1391 VSS.t265 5.66167
R5449 VSS.n1387 VSS.t214 5.66167
R5450 VSS.n1385 VSS.t261 5.66167
R5451 VSS.n1384 VSS.t211 5.66167
R5452 VSS.n1382 VSS.t259 5.66167
R5453 VSS.n1381 VSS.t208 5.66167
R5454 VSS.n1379 VSS.t257 5.66167
R5455 VSS.n1375 VSS.t378 5.66167
R5456 VSS.n1372 VSS.t376 5.66167
R5457 VSS.n1369 VSS.t374 5.66167
R5458 VSS.n1366 VSS.t372 5.66167
R5459 VSS.n1684 VSS.t368 5.66167
R5460 VSS.n1687 VSS.t366 5.66167
R5461 VSS.n1690 VSS.t364 5.66167
R5462 VSS.n1694 VSS.t45 5.66167
R5463 VSS.n1691 VSS.t362 5.66167
R5464 VSS.n1413 VSS.t200 5.66167
R5465 VSS.n1626 VSS.t390 5.66167
R5466 VSS.n1608 VSS.t196 5.66167
R5467 VSS.n1478 VSS.t283 5.66167
R5468 VSS.n1475 VSS.t299 5.66167
R5469 VSS.n1472 VSS.t296 5.66167
R5470 VSS.n1469 VSS.t286 5.66167
R5471 VSS.n1463 VSS.t275 5.66167
R5472 VSS.n1460 VSS.t289 5.66167
R5473 VSS.n1457 VSS.t281 5.66167
R5474 VSS.n1454 VSS.t277 5.66167
R5475 VSS.n1404 VSS.t384 5.66167
R5476 VSS.n1376 VSS.t205 5.66167
R5477 VSS.n1373 VSS.t67 5.66167
R5478 VSS.n1370 VSS.t64 5.66167
R5479 VSS.n1367 VSS.t25 5.66167
R5480 VSS.n1364 VSS.t60 5.66167
R5481 VSS.n1682 VSS.t54 5.66167
R5482 VSS.n1685 VSS.t51 5.66167
R5483 VSS.n1688 VSS.t48 5.66167
R5484 VSS.n1411 VSS.t392 5.66167
R5485 VSS.n1575 VSS.n1489 5.66056
R5486 VSS.n2071 VSS.n1913 5.66056
R5487 VSS.n2071 VSS.n1915 5.6579
R5488 VSS.n2071 VSS.n1991 5.6579
R5489 VSS.n2071 VSS.n2031 5.6579
R5490 VSS.n1535 VSS.n1489 5.6579
R5491 VSS.n1533 VSS.n1489 5.6579
R5492 VSS.n1528 VSS.n1489 5.6579
R5493 VSS.n1526 VSS.n1489 5.6579
R5494 VSS.n1490 VSS.n1489 5.6579
R5495 VSS.n1889 VSS.n1040 5.61281
R5496 VSS.n1899 VSS.n247 5.61281
R5497 VSS.t302 VSS.n890 5.54579
R5498 VSS.n929 VSS.t278 5.54579
R5499 VSS.n1097 VSS.t202 5.54579
R5500 VSS.n948 VSS.t197 5.54579
R5501 VSS.t320 VSS.n966 5.54579
R5502 VSS.n986 VSS.t313 5.54579
R5503 VSS.n730 VSS.t231 5.54579
R5504 VSS.t203 VSS.n652 5.54579
R5505 VSS.n507 VSS.t69 5.54579
R5506 VSS.t30 VSS.n468 5.54579
R5507 VSS.t193 VSS.n262 5.54579
R5508 VSS.t186 VSS.n450 5.54579
R5509 VSS.t42 VSS.n324 5.54579
R5510 VSS.t26 VSS.n419 5.54579
R5511 VSS.n1612 VSS.t124 5.0005
R5512 VSS.n1612 VSS.t127 5.0005
R5513 VSS.n1622 VSS.t174 5.0005
R5514 VSS.n1622 VSS.t176 5.0005
R5515 VSS.n1640 VSS.t117 5.0005
R5516 VSS.n1640 VSS.t120 5.0005
R5517 VSS.n1650 VSS.t169 5.0005
R5518 VSS.n1650 VSS.t171 5.0005
R5519 VSS.n1665 VSS.t111 5.0005
R5520 VSS.n1665 VSS.t113 5.0005
R5521 VSS.n1675 VSS.t164 5.0005
R5522 VSS.n1675 VSS.t166 5.0005
R5523 VSS.n1591 VSS.t184 5.0005
R5524 VSS.n1580 VSS.t138 5.0005
R5525 VSS.n1860 VSS.t105 5.0005
R5526 VSS.n1860 VSS.t108 5.0005
R5527 VSS.n1895 VSS.t159 5.0005
R5528 VSS.n1895 VSS.t161 5.0005
R5529 VSS.n1734 VSS.n1733 4.5005
R5530 VSS.n1752 VSS.n1748 4.5005
R5531 VSS.n1446 VSS.n1445 4.5005
R5532 VSS.n1744 VSS.n1740 4.5005
R5533 VSS.n1760 VSS.n1759 4.5005
R5534 VSS.n1440 VSS.n1439 4.5005
R5535 VSS.n125 VSS.n122 4.5005
R5536 VSS.n126 VSS.n125 4.5005
R5537 VSS.n125 VSS.n119 4.5005
R5538 VSS.n125 VSS.n124 4.5005
R5539 VSS.n142 VSS.n141 4.5005
R5540 VSS.n143 VSS.n142 4.5005
R5541 VSS.n142 VSS.n127 4.5005
R5542 VSS.n142 VSS.n138 4.5005
R5543 VSS.n1429 VSS.n1428 4.5005
R5544 VSS.n1434 VSS.n1415 4.5005
R5545 VSS.n1726 VSS.n1725 4.5005
R5546 VSS.n1785 VSS.n1784 4.5005
R5547 VSS.n1495 VSS.n1489 4.24484
R5548 VSS.n1550 VSS.n1498 4.24438
R5549 VSS.n1548 VSS.n1498 4.24137
R5550 VSS.n1569 VSS.n1489 4.23712
R5551 VSS.n1889 VSS.n990 4.18435
R5552 VSS.n1889 VSS.n634 4.18435
R5553 VSS.n252 VSS.n247 4.18435
R5554 VSS.n251 VSS.n247 4.18435
R5555 VSS.n250 VSS.n247 4.18435
R5556 VSS.n2088 VSS.n17 4.18423
R5557 VSS.n1889 VSS.n460 4.18423
R5558 VSS.n1777 VSS.n1767 3.401
R5559 VSS.n2071 VSS.n233 3.39481
R5560 VSS.n2071 VSS.n229 3.39453
R5561 VSS.n2071 VSS.n223 3.39453
R5562 VSS.n2071 VSS.n2032 3.38692
R5563 VSS.n2071 VSS.n1992 3.38692
R5564 VSS.n2071 VSS.n1952 3.38692
R5565 VSS.n308 VSS.n307 3.07092
R5566 VSS.n287 VSS.n286 3.07092
R5567 VSS.n1732 VSS.n1703 3.0005
R5568 VSS.n1751 VSS.n1750 3.0005
R5569 VSS.n1443 VSS.n1438 3.0005
R5570 VSS.n1741 VSS.n1704 3.0005
R5571 VSS.n1757 VSS.n1755 3.0005
R5572 VSS.n1453 VSS.n1452 3.0005
R5573 VSS.n1427 VSS.n1414 3.0005
R5574 VSS.n1437 VSS.n1436 3.0005
R5575 VSS.n1592 VSS.n1591 3.0005
R5576 VSS.n1581 VSS.n1580 3.0005
R5577 VSS.n1790 VSS.n1789 3.0005
R5578 VSS.n1782 VSS.n1724 3.0005
R5579 VSS.n202 VSS.n4 2.83368
R5580 VSS.n1858 VSS.n512 2.7961
R5581 VSS.n1843 VSS.n1352 2.4821
R5582 VSS.n1844 VSS.n1843 2.4821
R5583 VSS.n1356 VSS.n1355 2.4821
R5584 VSS.n1356 VSS.n1353 2.4821
R5585 VSS.n1834 VSS.n1709 2.4821
R5586 VSS.n1834 VSS.n1705 2.4821
R5587 VSS.n1833 VSS.n1714 2.4821
R5588 VSS.n1833 VSS.n1710 2.4821
R5589 VSS.n1831 VSS.n1720 2.4821
R5590 VSS.n1831 VSS.n1718 2.4821
R5591 VSS.n1830 VSS.n1723 2.4821
R5592 VSS.n1830 VSS.n1721 2.4821
R5593 VSS.n1598 VSS.n1466 2.4821
R5594 VSS.n1594 VSS.n1480 2.4821
R5595 VSS.n1594 VSS.n1478 2.4821
R5596 VSS.n1595 VSS.n1477 2.4821
R5597 VSS.n1595 VSS.n1475 2.4821
R5598 VSS.n1596 VSS.n1474 2.4821
R5599 VSS.n1596 VSS.n1472 2.4821
R5600 VSS.n1597 VSS.n1471 2.4821
R5601 VSS.n1597 VSS.n1469 2.4821
R5602 VSS.n1599 VSS.n1465 2.4821
R5603 VSS.n1599 VSS.n1463 2.4821
R5604 VSS.n1600 VSS.n1462 2.4821
R5605 VSS.n1600 VSS.n1460 2.4821
R5606 VSS.n1601 VSS.n1459 2.4821
R5607 VSS.n1601 VSS.n1457 2.4821
R5608 VSS.n1602 VSS.n1456 2.4821
R5609 VSS.n1602 VSS.n1454 2.4821
R5610 VSS.n1699 VSS.n1361 2.4821
R5611 VSS.n1657 VSS.n1388 2.4821
R5612 VSS.n1661 VSS.n1378 2.4821
R5613 VSS.n1407 VSS.n1406 2.4821
R5614 VSS.n1407 VSS.n1404 2.4821
R5615 VSS.n1636 VSS.n1635 2.4821
R5616 VSS.n1636 VSS.n1403 2.4821
R5617 VSS.n1653 VSS.n1402 2.4821
R5618 VSS.n1653 VSS.n1400 2.4821
R5619 VSS.n1654 VSS.n1399 2.4821
R5620 VSS.n1654 VSS.n1397 2.4821
R5621 VSS.n1655 VSS.n1396 2.4821
R5622 VSS.n1655 VSS.n1394 2.4821
R5623 VSS.n1656 VSS.n1393 2.4821
R5624 VSS.n1656 VSS.n1391 2.4821
R5625 VSS.n1658 VSS.n1387 2.4821
R5626 VSS.n1658 VSS.n1385 2.4821
R5627 VSS.n1659 VSS.n1384 2.4821
R5628 VSS.n1659 VSS.n1382 2.4821
R5629 VSS.n1660 VSS.n1381 2.4821
R5630 VSS.n1660 VSS.n1379 2.4821
R5631 VSS.n1661 VSS.n1376 2.4821
R5632 VSS.n1678 VSS.n1375 2.4821
R5633 VSS.n1678 VSS.n1373 2.4821
R5634 VSS.n1679 VSS.n1372 2.4821
R5635 VSS.n1679 VSS.n1370 2.4821
R5636 VSS.n1680 VSS.n1369 2.4821
R5637 VSS.n1680 VSS.n1367 2.4821
R5638 VSS.n1681 VSS.n1366 2.4821
R5639 VSS.n1681 VSS.n1364 2.4821
R5640 VSS.n1698 VSS.n1684 2.4821
R5641 VSS.n1698 VSS.n1682 2.4821
R5642 VSS.n1697 VSS.n1687 2.4821
R5643 VSS.n1697 VSS.n1685 2.4821
R5644 VSS.n1696 VSS.n1690 2.4821
R5645 VSS.n1696 VSS.n1688 2.4821
R5646 VSS.n1695 VSS.n1694 2.4821
R5647 VSS.n1695 VSS.n1691 2.4821
R5648 VSS.n1607 VSS.n1413 2.4821
R5649 VSS.n1607 VSS.n1411 2.4821
R5650 VSS.n1627 VSS.n1626 2.4821
R5651 VSS.n1627 VSS.n1608 2.4821
R5652 VSS.n1544 VSS.n1543 2.42957
R5653 VSS.n2076 VSS.n109 2.42951
R5654 VSS.n2088 VSS.n25 2.42759
R5655 VSS.n1811 VSS.n1791 2.29165
R5656 VSS.n1816 VSS.n1814 2.29165
R5657 VSS.n2085 VSS.n194 2.25406
R5658 VSS.n2085 VSS.n191 2.25406
R5659 VSS.n2085 VSS.n190 2.25406
R5660 VSS.n2085 VSS.n189 2.25406
R5661 VSS.n2085 VSS.n167 2.25406
R5662 VSS.n2085 VSS.n163 2.25406
R5663 VSS.n2085 VSS.n162 2.25406
R5664 VSS.n2085 VSS.n161 2.25406
R5665 VSS.n2085 VSS.n155 2.25406
R5666 VSS.n2085 VSS.n151 2.25406
R5667 VSS.n2085 VSS.n150 2.25406
R5668 VSS.n2085 VSS.n149 2.25406
R5669 VSS.n2085 VSS.n116 2.25406
R5670 VSS.n2085 VSS.n113 2.25406
R5671 VSS.n2086 VSS.n2085 2.25406
R5672 VSS.n2085 VSS.n112 2.25406
R5673 VSS.n638 VSS.n247 2.25406
R5674 VSS.n642 VSS.n247 2.25406
R5675 VSS.n645 VSS.n247 2.25406
R5676 VSS.n649 VSS.n247 2.25406
R5677 VSS.n961 VSS.n247 2.25406
R5678 VSS.n958 VSS.n247 2.25406
R5679 VSS.n1889 VSS.n457 2.25406
R5680 VSS.n1889 VSS.n459 2.25406
R5681 VSS.n1889 VSS.n461 2.25406
R5682 VSS.n1889 VSS.n462 2.25406
R5683 VSS.n1889 VSS.n463 2.25406
R5684 VSS.n640 VSS.n247 2.25406
R5685 VSS.n644 VSS.n247 2.25406
R5686 VSS.n647 VSS.n247 2.25406
R5687 VSS.n977 VSS.n247 2.25406
R5688 VSS.n970 VSS.n247 2.25406
R5689 VSS.n963 VSS.n247 2.25406
R5690 VSS.n959 VSS.n247 2.25406
R5691 VSS.n956 VSS.n247 2.25406
R5692 VSS.n1879 VSS.n1857 2.25406
R5693 VSS.n133 VSS.n4 2.25406
R5694 VSS.n147 VSS.n4 2.25406
R5695 VSS.n1797 VSS.n4 2.25406
R5696 VSS.n184 VSS.n4 2.25406
R5697 VSS.n34 VSS.n4 2.25406
R5698 VSS.n1733 VSS.n1731 2.2505
R5699 VSS.n1753 VSS.n1752 2.2505
R5700 VSS.n1447 VSS.n1446 2.2505
R5701 VSS.n1745 VSS.n1740 2.2505
R5702 VSS.n1761 VSS.n1760 2.2505
R5703 VSS.n1448 VSS.n1439 2.2505
R5704 VSS.n1428 VSS.n1426 2.2505
R5705 VSS.n1433 VSS.n1415 2.2505
R5706 VSS.n2083 VSS.n2082 2.2505
R5707 VSS.n1925 VSS.n1924 2.2505
R5708 VSS.n1728 VSS.n1725 2.2505
R5709 VSS.n1786 VSS.n1785 2.2505
R5710 VSS.n1889 VSS.n1142 2.08781
R5711 VSS.n1889 VSS.n1322 2.08781
R5712 VSS.n1889 VSS.n306 2.08781
R5713 VSS.n1491 VSS.n1489 1.86685
R5714 VSS.n2071 VSS.n217 1.86591
R5715 VSS.n1746 VSS.n247 1.83321
R5716 VSS.n1762 VSS.n247 1.83321
R5717 VSS.n249 VSS.n247 1.83321
R5718 VSS.n248 VSS.n247 1.83321
R5719 VSS.n2088 VSS.n29 1.7212
R5720 VSS.n1046 VSS.n1042 1.70312
R5721 VSS.n1889 VSS.n1042 1.70125
R5722 VSS.n1144 VSS.n247 1.70125
R5723 VSS.n1889 VSS.n635 1.7005
R5724 VSS.n1889 VSS.n988 1.7005
R5725 VSS.n1858 VSS.n247 1.7005
R5726 VSS.n2088 VSS.n32 1.7005
R5727 VSS.n1889 VSS.n888 1.7005
R5728 VSS.n1585 VSS.n247 1.69904
R5729 VSS.n1889 VSS.n1317 1.69904
R5730 VSS.n1573 VSS.n1489 1.67405
R5731 VSS.n2071 VSS.n245 1.67405
R5732 VSS.n2088 VSS.n12 1.64828
R5733 VSS.n1145 VSS.n1144 1.57459
R5734 VSS.n636 VSS.n635 1.57459
R5735 VSS.n1141 VSS.n889 1.56425
R5736 VSS.n1911 VSS.n1910 1.56234
R5737 VSS.n732 VSS.n731 1.56211
R5738 VSS.n509 VSS.n508 1.56211
R5739 VSS.n1903 VSS.n1902 1.56178
R5740 VSS.n1572 VSS 1.54763
R5741 VSS.n2070 VSS 1.54739
R5742 VSS.n994 VSS.n988 1.53575
R5743 VSS.n1422 VSS.n1421 1.53569
R5744 VSS.n1315 VSS.n888 1.5353
R5745 VSS.n183 VSS.n59 1.53502
R5746 VSS.n1806 VSS.n88 1.53502
R5747 VSS.n134 VSS.n13 1.53502
R5748 VSS.n1772 VSS.n416 1.53424
R5749 VSS.n1904 VSS.n1903 1.52253
R5750 VSS.n1902 VSS.n1901 1.52241
R5751 VSS.n731 VSS.n509 1.52234
R5752 VSS.n989 VSS.n732 1.52234
R5753 VSS.n1989 VSS 1.51564
R5754 VSS VSS.n1530 1.51564
R5755 VSS.n1780 VSS.n1766 1.50769
R5756 VSS.n1613 VSS.n1612 1.5005
R5757 VSS.n1623 VSS.n1622 1.5005
R5758 VSS.n1641 VSS.n1640 1.5005
R5759 VSS.n1651 VSS.n1650 1.5005
R5760 VSS.n1666 VSS.n1665 1.5005
R5761 VSS.n1676 VSS.n1675 1.5005
R5762 VSS.n1588 VSS.n1583 1.5005
R5763 VSS.n1579 VSS.n1578 1.5005
R5764 VSS.n1862 VSS.n1860 1.5005
R5765 VSS.n1896 VSS.n1895 1.5005
R5766 VSS.n1766 VSS.n1765 1.49803
R5767 VSS.n2029 VSS 1.492
R5768 VSS VSS.n1523 1.492
R5769 VSS.n2088 VSS.n14 1.48726
R5770 VSS.n2085 VSS.n156 1.48726
R5771 VSS VSS.n1917 1.48364
R5772 VSS VSS.n1537 1.48364
R5773 VSS VSS.n2028 1.47574
R5774 VSS.n1524 VSS 1.47574
R5775 VSS.n2068 VSS.n2067 1.46124
R5776 VSS.n1571 VSS.n1570 1.461
R5777 VSS.n2028 VSS.n2027 1.45998
R5778 VSS.n1525 VSS.n1524 1.45998
R5779 VSS.n1901 VSS.n1900 1.43796
R5780 VSS.n1763 VSS.n253 1.43286
R5781 VSS.n1039 VSS.n939 1.43208
R5782 VSS.n989 VSS.n952 1.43208
R5783 VSS.n2030 VSS.n2029 1.42389
R5784 VSS.n1523 VSS.n1522 1.42389
R5785 VSS.n1321 VSS.n458 1.42275
R5786 VSS.n1907 VSS.n1906 1.42222
R5787 VSS.n1905 VSS.n1904 1.42222
R5788 VSS.n2076 VSS.n18 1.41957
R5789 VSS VSS.n1571 1.41752
R5790 VSS VSS.n2068 1.41733
R5791 VSS.n1951 VSS 1.4116
R5792 VSS.n1538 VSS 1.4116
R5793 VSS.n1908 VSS.n1907 1.41053
R5794 VSS.n1906 VSS.n1905 1.41053
R5795 VSS.n508 VSS.n458 1.41009
R5796 VSS.n1900 VSS.n253 1.40762
R5797 VSS VSS.n1988 1.4075
R5798 VSS.n1531 VSS 1.4075
R5799 VSS.n1988 VSS.n1987 1.38665
R5800 VSS.n1532 VSS.n1531 1.38665
R5801 VSS.n447 VSS.n416 1.37675
R5802 VSS.n1990 VSS.n1989 1.37018
R5803 VSS.n1530 VSS.n1529 1.37018
R5804 VSS.n1917 VSS.n1916 1.33468
R5805 VSS.n1537 VSS.n1536 1.33468
R5806 VSS.n941 VSS.n939 1.2945
R5807 VSS.n1039 VSS.n952 1.2945
R5808 VSS.n1912 VSS.n1911 1.22172
R5809 VSS.n1576 VSS.n889 1.22017
R5810 VSS.n31 VSS.n30 1.21059
R5811 VSS.n1041 VSS.n247 1.20771
R5812 VSS.n1889 VSS.n930 1.20771
R5813 VSS.n465 VSS.n247 1.20771
R5814 VSS.n733 VSS.n247 1.20771
R5815 VSS.n979 VSS.n247 1.20771
R5816 VSS.n975 VSS.n247 1.20771
R5817 VSS.n972 VSS.n247 1.20771
R5818 VSS.n968 VSS.n247 1.20771
R5819 VSS.n965 VSS.n247 1.20771
R5820 VSS.n954 VSS.n247 1.20771
R5821 VSS.n950 VSS.n247 1.20771
R5822 VSS.n1889 VSS.n1115 1.20771
R5823 VSS.n1889 VSS.n1140 1.20771
R5824 VSS.n2088 VSS.n105 1.20748
R5825 VSS.n467 VSS.n247 1.20748
R5826 VSS.n651 VSS.n247 1.20748
R5827 VSS.n1051 VSS.n247 1.20748
R5828 VSS.n2070 VSS.n2069 1.19833
R5829 VSS.n1574 VSS.n1572 1.19802
R5830 VSS.n1579 VSS.n1481 1.18517
R5831 VSS.n1583 VSS.n1582 1.18517
R5832 VSS.n1926 VSS.n1925 1.18334
R5833 VSS.n2082 VSS.n199 1.18334
R5834 VSS.n1951 VSS.n1950 1.14066
R5835 VSS.n1539 VSS.n1538 1.14066
R5836 VSS.n1764 VSS.n247 1.05436
R5837 VSS.n2085 VSS.n169 1.05301
R5838 VSS.n1909 VSS.n247 1.05282
R5839 VSS.n1893 VSS.n247 1.00035
R5840 VSS.n1889 VSS.n630 1.00018
R5841 VSS.n1889 VSS.n1000 1.00018
R5842 VSS.n1889 VSS.n1053 1.00018
R5843 VSS.n1669 VSS.n247 0.999947
R5844 VSS.n1616 VSS.n247 0.999852
R5845 VSS.n1644 VSS.n247 0.999835
R5846 VSS.n408 VSS.n31 0.997477
R5847 VSS.n2088 VSS.n24 0.988885
R5848 VSS.n2085 VSS.n197 0.988796
R5849 VSS.n1700 VSS.n1360 0.950313
R5850 VSS.n2088 VSS.n15 0.947759
R5851 VSS.n1889 VSS.n448 0.947759
R5852 VSS.n1889 VSS.n931 0.947759
R5853 VSS.n399 VSS.n187 0.943586
R5854 VSS.n187 VSS.n186 0.936643
R5855 VSS.n16 VSS.n15 0.899143
R5856 VSS.n941 VSS.n931 0.899143
R5857 VSS.n448 VSS.n447 0.899143
R5858 VSS.n2085 VSS.n187 0.859982
R5859 VSS.n24 VSS.n23 0.858206
R5860 VSS.n197 VSS.n196 0.857891
R5861 VSS.n1765 VSS.n1764 0.854032
R5862 VSS.n1909 VSS.n1908 0.851769
R5863 VSS.n169 VSS.n168 0.849766
R5864 VSS.n186 VSS.n169 0.844692
R5865 VSS.n1910 VSS.n1909 0.842667
R5866 VSS.n1764 VSS.n1763 0.841029
R5867 VSS.n1509 VSS.n1508 0.824784
R5868 VSS.n1922 VSS.n1914 0.824784
R5869 VSS.n1863 VSS.n1862 0.765137
R5870 VSS.n1897 VSS.n1896 0.765137
R5871 VSS.n1613 VSS.n1611 0.765137
R5872 VSS.n1623 VSS.n1614 0.765137
R5873 VSS.n1641 VSS.n1639 0.765137
R5874 VSS.n1651 VSS.n1642 0.765137
R5875 VSS.n1666 VSS.n1664 0.765137
R5876 VSS.n1676 VSS.n1667 0.765137
R5877 VSS.n30 VSS.n15 0.758814
R5878 VSS.n1141 VSS.n931 0.758814
R5879 VSS.n1321 VSS.n448 0.758814
R5880 VSS.n1568 VSS.n1567 0.737031
R5881 VSS.n1567 VSS.n1566 0.732117
R5882 VSS.n1576 VSS.n1575 0.724494
R5883 VSS.n1913 VSS.n1912 0.724494
R5884 VSS.n1534 VSS.n1497 0.708996
R5885 VSS.n1527 VSS.n1496 0.708996
R5886 VSS.n23 VSS.n14 0.704151
R5887 VSS.n168 VSS.n156 0.704151
R5888 VSS.n196 VSS.n156 0.702785
R5889 VSS.n16 VSS.n14 0.702785
R5890 VSS.n1554 VSS.n1497 0.701765
R5891 VSS.n1560 VSS.n1496 0.701765
R5892 VSS.n1508 VSS.n197 0.672792
R5893 VSS.n1922 VSS.n24 0.672457
R5894 VSS.n243 VSS.n219 0.669736
R5895 VSS.n1632 VSS.n1360 0.666953
R5896 VSS.n1841 VSS.n1700 0.666953
R5897 VSS.n241 VSS.n226 0.66177
R5898 VSS.n1889 VSS.n456 0.650675
R5899 VSS.n808 VSS.n247 0.650675
R5900 VSS.n809 VSS.n247 0.650675
R5901 VSS.n802 VSS.n247 0.650675
R5902 VSS.n803 VSS.n247 0.650675
R5903 VSS.n799 VSS.n247 0.650675
R5904 VSS.n800 VSS.n247 0.650675
R5905 VSS.n795 VSS.n247 0.650675
R5906 VSS.n796 VSS.n247 0.650675
R5907 VSS.n792 VSS.n247 0.650675
R5908 VSS.n793 VSS.n247 0.650675
R5909 VSS.n788 VSS.n247 0.650675
R5910 VSS.n789 VSS.n247 0.650675
R5911 VSS.n785 VSS.n247 0.650675
R5912 VSS.n786 VSS.n247 0.650675
R5913 VSS.n781 VSS.n247 0.650675
R5914 VSS.n782 VSS.n247 0.650675
R5915 VSS.n778 VSS.n247 0.650675
R5916 VSS.n779 VSS.n247 0.650675
R5917 VSS.n774 VSS.n247 0.650675
R5918 VSS.n775 VSS.n247 0.650675
R5919 VSS.n771 VSS.n247 0.650675
R5920 VSS.n772 VSS.n247 0.650675
R5921 VSS.n767 VSS.n247 0.650675
R5922 VSS.n768 VSS.n247 0.650675
R5923 VSS.n764 VSS.n247 0.650675
R5924 VSS.n765 VSS.n247 0.650675
R5925 VSS.n760 VSS.n247 0.650675
R5926 VSS.n761 VSS.n247 0.650675
R5927 VSS.n757 VSS.n247 0.650675
R5928 VSS.n758 VSS.n247 0.650675
R5929 VSS.n753 VSS.n247 0.650675
R5930 VSS.n754 VSS.n247 0.650675
R5931 VSS.n750 VSS.n247 0.650675
R5932 VSS.n751 VSS.n247 0.650675
R5933 VSS.n746 VSS.n247 0.650675
R5934 VSS.n747 VSS.n247 0.650675
R5935 VSS.n743 VSS.n247 0.650675
R5936 VSS.n744 VSS.n247 0.650675
R5937 VSS.n739 VSS.n247 0.650675
R5938 VSS.n740 VSS.n247 0.650675
R5939 VSS.n737 VSS.n247 0.650675
R5940 VSS.n735 VSS.n247 0.650675
R5941 VSS.n653 VSS.n247 0.650675
R5942 VSS.n655 VSS.n247 0.650675
R5943 VSS.n657 VSS.n247 0.650675
R5944 VSS.n659 VSS.n247 0.650675
R5945 VSS.n661 VSS.n247 0.650675
R5946 VSS.n663 VSS.n247 0.650675
R5947 VSS.n665 VSS.n247 0.650675
R5948 VSS.n667 VSS.n247 0.650675
R5949 VSS.n669 VSS.n247 0.650675
R5950 VSS.n671 VSS.n247 0.650675
R5951 VSS.n673 VSS.n247 0.650675
R5952 VSS.n675 VSS.n247 0.650675
R5953 VSS.n677 VSS.n247 0.650675
R5954 VSS.n679 VSS.n247 0.650675
R5955 VSS.n681 VSS.n247 0.650675
R5956 VSS.n683 VSS.n247 0.650675
R5957 VSS.n685 VSS.n247 0.650675
R5958 VSS.n687 VSS.n247 0.650675
R5959 VSS.n689 VSS.n247 0.650675
R5960 VSS.n691 VSS.n247 0.650675
R5961 VSS.n693 VSS.n247 0.650675
R5962 VSS.n695 VSS.n247 0.650675
R5963 VSS.n697 VSS.n247 0.650675
R5964 VSS.n699 VSS.n247 0.650675
R5965 VSS.n701 VSS.n247 0.650675
R5966 VSS.n703 VSS.n247 0.650675
R5967 VSS.n705 VSS.n247 0.650675
R5968 VSS.n707 VSS.n247 0.650675
R5969 VSS.n709 VSS.n247 0.650675
R5970 VSS.n711 VSS.n247 0.650675
R5971 VSS.n713 VSS.n247 0.650675
R5972 VSS.n715 VSS.n247 0.650675
R5973 VSS.n717 VSS.n247 0.650675
R5974 VSS.n719 VSS.n247 0.650675
R5975 VSS.n721 VSS.n247 0.650675
R5976 VSS.n723 VSS.n247 0.650675
R5977 VSS.n725 VSS.n247 0.650675
R5978 VSS.n727 VSS.n247 0.650675
R5979 VSS.n729 VSS.n247 0.650675
R5980 VSS.n520 VSS.n247 0.650675
R5981 VSS.n517 VSS.n247 0.650675
R5982 VSS.n515 VSS.n247 0.650675
R5983 VSS.n996 VSS.n247 0.650675
R5984 VSS.n998 VSS.n247 0.650675
R5985 VSS.n1001 VSS.n247 0.650675
R5986 VSS.n1002 VSS.n247 0.650675
R5987 VSS.n1007 VSS.n247 0.650675
R5988 VSS.n1008 VSS.n247 0.650675
R5989 VSS.n1014 VSS.n247 0.650675
R5990 VSS.n1015 VSS.n247 0.650675
R5991 VSS.n1048 VSS.n247 0.650675
R5992 VSS.n1050 VSS.n247 0.650675
R5993 VSS.n1889 VSS.n810 0.650675
R5994 VSS.n1889 VSS.n804 0.650675
R5995 VSS.n1889 VSS.n801 0.650675
R5996 VSS.n1889 VSS.n797 0.650675
R5997 VSS.n1889 VSS.n794 0.650675
R5998 VSS.n1889 VSS.n790 0.650675
R5999 VSS.n1889 VSS.n787 0.650675
R6000 VSS.n1889 VSS.n783 0.650675
R6001 VSS.n1889 VSS.n780 0.650675
R6002 VSS.n1889 VSS.n773 0.650675
R6003 VSS.n1889 VSS.n769 0.650675
R6004 VSS.n1889 VSS.n766 0.650675
R6005 VSS.n1889 VSS.n762 0.650675
R6006 VSS.n1889 VSS.n759 0.650675
R6007 VSS.n1889 VSS.n755 0.650675
R6008 VSS.n1889 VSS.n752 0.650675
R6009 VSS.n1889 VSS.n748 0.650675
R6010 VSS.n1889 VSS.n745 0.650675
R6011 VSS.n1889 VSS.n741 0.650675
R6012 VSS.n1889 VSS.n738 0.650675
R6013 VSS.n1889 VSS.n736 0.650675
R6014 VSS.n1889 VSS.n734 0.650675
R6015 VSS.n1889 VSS.n625 0.650675
R6016 VSS.n1889 VSS.n620 0.650675
R6017 VSS.n1889 VSS.n614 0.650675
R6018 VSS.n1889 VSS.n609 0.650675
R6019 VSS.n1889 VSS.n603 0.650675
R6020 VSS.n1889 VSS.n598 0.650675
R6021 VSS.n1889 VSS.n592 0.650675
R6022 VSS.n1889 VSS.n587 0.650675
R6023 VSS.n1889 VSS.n581 0.650675
R6024 VSS.n1889 VSS.n570 0.650675
R6025 VSS.n1889 VSS.n565 0.650675
R6026 VSS.n1889 VSS.n559 0.650675
R6027 VSS.n1889 VSS.n554 0.650675
R6028 VSS.n1889 VSS.n548 0.650675
R6029 VSS.n1889 VSS.n543 0.650675
R6030 VSS.n1889 VSS.n537 0.650675
R6031 VSS.n1889 VSS.n532 0.650675
R6032 VSS.n1889 VSS.n526 0.650675
R6033 VSS.n1889 VSS.n521 0.650675
R6034 VSS.n1889 VSS.n518 0.650675
R6035 VSS.n1889 VSS.n516 0.650675
R6036 VSS.n1889 VSS.n514 0.650675
R6037 VSS.n1889 VSS.n995 0.650675
R6038 VSS.n1889 VSS.n997 0.650675
R6039 VSS.n1889 VSS.n999 0.650675
R6040 VSS.n1889 VSS.n1003 0.650675
R6041 VSS.n1889 VSS.n1009 0.650675
R6042 VSS.n1889 VSS.n1016 0.650675
R6043 VSS.n1889 VSS.n1024 0.650675
R6044 VSS.n1889 VSS.n1047 0.650675
R6045 VSS.n1889 VSS.n1049 0.650675
R6046 VSS.n1889 VSS.n1052 0.650675
R6047 VSS.n1889 VSS.n1059 0.650675
R6048 VSS.n1889 VSS.n1066 0.650675
R6049 VSS.n1889 VSS.n1073 0.650675
R6050 VSS.n1889 VSS.n1079 0.650675
R6051 VSS.n1889 VSS.n1083 0.650675
R6052 VSS.n1889 VSS.n1089 0.650675
R6053 VSS.n1889 VSS.n1093 0.650675
R6054 VSS.n1889 VSS.n1098 0.650675
R6055 VSS.n1889 VSS.n1102 0.650675
R6056 VSS.n1889 VSS.n1106 0.650675
R6057 VSS.n1889 VSS.n1110 0.650675
R6058 VSS.n1889 VSS.n1120 0.650675
R6059 VSS.n1889 VSS.n1131 0.650675
R6060 VSS.n1889 VSS.n1136 0.650675
R6061 VSS.n1889 VSS.n1151 0.650675
R6062 VSS.n1889 VSS.n1154 0.650675
R6063 VSS.n1889 VSS.n1159 0.650675
R6064 VSS.n1889 VSS.n1166 0.650675
R6065 VSS.n1889 VSS.n1173 0.650675
R6066 VSS.n1889 VSS.n1181 0.650675
R6067 VSS.n1889 VSS.n1188 0.650675
R6068 VSS.n1889 VSS.n1196 0.650675
R6069 VSS.n1889 VSS.n1203 0.650675
R6070 VSS.n1889 VSS.n1211 0.650675
R6071 VSS.n1889 VSS.n1218 0.650675
R6072 VSS.n1889 VSS.n1226 0.650675
R6073 VSS.n1889 VSS.n1241 0.650675
R6074 VSS.n1889 VSS.n1248 0.650675
R6075 VSS.n1889 VSS.n1256 0.650675
R6076 VSS.n1889 VSS.n1263 0.650675
R6077 VSS.n1889 VSS.n1271 0.650675
R6078 VSS.n1889 VSS.n1278 0.650675
R6079 VSS.n1889 VSS.n1286 0.650675
R6080 VSS.n1889 VSS.n1293 0.650675
R6081 VSS.n1889 VSS.n1301 0.650675
R6082 VSS.n1889 VSS.n1307 0.650675
R6083 VSS.n1889 VSS.n1311 0.650675
R6084 VSS.n1889 VSS.n1313 0.650675
R6085 VSS.n1889 VSS.n1316 0.650675
R6086 VSS.n1889 VSS.n394 0.650675
R6087 VSS.n1889 VSS.n390 0.650675
R6088 VSS.n1889 VSS.n386 0.650675
R6089 VSS.n1889 VSS.n382 0.650675
R6090 VSS.n1889 VSS.n377 0.650675
R6091 VSS.n1889 VSS.n373 0.650675
R6092 VSS.n1889 VSS.n368 0.650675
R6093 VSS.n1889 VSS.n364 0.650675
R6094 VSS.n1889 VSS.n360 0.650675
R6095 VSS.n1889 VSS.n356 0.650675
R6096 VSS.n1889 VSS.n352 0.650675
R6097 VSS.n1889 VSS.n347 0.650675
R6098 VSS.n1889 VSS.n343 0.650675
R6099 VSS.n1889 VSS.n339 0.650675
R6100 VSS.n1889 VSS.n335 0.650675
R6101 VSS.n1889 VSS.n330 0.650675
R6102 VSS.n1889 VSS.n326 0.650675
R6103 VSS.n1889 VSS.n321 0.650675
R6104 VSS.n1889 VSS.n317 0.650675
R6105 VSS.n1889 VSS.n314 0.650675
R6106 VSS.n1889 VSS.n310 0.650675
R6107 VSS.n1889 VSS.n301 0.650675
R6108 VSS.n1889 VSS.n293 0.650675
R6109 VSS.n1889 VSS.n289 0.650675
R6110 VSS.n1889 VSS.n285 0.650675
R6111 VSS.n1889 VSS.n282 0.650675
R6112 VSS.n1889 VSS.n280 0.650675
R6113 VSS.n1889 VSS.n278 0.650675
R6114 VSS.n1889 VSS.n277 0.650675
R6115 VSS.n1889 VSS.n275 0.650675
R6116 VSS.n1889 VSS.n274 0.650675
R6117 VSS.n1889 VSS.n271 0.650675
R6118 VSS.n1889 VSS.n269 0.650675
R6119 VSS.n1889 VSS.n266 0.650675
R6120 VSS.n1889 VSS.n264 0.650675
R6121 VSS.n1889 VSS.n261 0.650675
R6122 VSS.n1889 VSS.n953 0.650571
R6123 VSS.n1889 VSS.n949 0.650571
R6124 VSS.n1881 VSS.n247 0.650571
R6125 VSS.n2088 VSS.n21 0.650322
R6126 VSS.n1057 VSS.n247 0.650322
R6127 VSS.n1058 VSS.n247 0.650322
R6128 VSS.n1064 VSS.n247 0.650322
R6129 VSS.n1065 VSS.n247 0.650322
R6130 VSS.n1082 VSS.n247 0.650322
R6131 VSS.n1092 VSS.n247 0.650322
R6132 VSS.n1101 VSS.n247 0.650322
R6133 VSS.n1105 VSS.n247 0.650322
R6134 VSS.n1109 VSS.n247 0.650322
R6135 VSS.n1114 VSS.n247 0.650322
R6136 VSS.n1119 VSS.n247 0.650322
R6137 VSS.n936 VSS.n247 0.650322
R6138 VSS.n1139 VSS.n247 0.650322
R6139 VSS.n1150 VSS.n247 0.650322
R6140 VSS.n1153 VSS.n247 0.650322
R6141 VSS.n1157 VSS.n247 0.650322
R6142 VSS.n1158 VSS.n247 0.650322
R6143 VSS.n1164 VSS.n247 0.650322
R6144 VSS.n1165 VSS.n247 0.650322
R6145 VSS.n1171 VSS.n247 0.650322
R6146 VSS.n1172 VSS.n247 0.650322
R6147 VSS.n1179 VSS.n247 0.650322
R6148 VSS.n1180 VSS.n247 0.650322
R6149 VSS.n1186 VSS.n247 0.650322
R6150 VSS.n1187 VSS.n247 0.650322
R6151 VSS.n1194 VSS.n247 0.650322
R6152 VSS.n1195 VSS.n247 0.650322
R6153 VSS.n1201 VSS.n247 0.650322
R6154 VSS.n1202 VSS.n247 0.650322
R6155 VSS.n1209 VSS.n247 0.650322
R6156 VSS.n1210 VSS.n247 0.650322
R6157 VSS.n1216 VSS.n247 0.650322
R6158 VSS.n1217 VSS.n247 0.650322
R6159 VSS.n1224 VSS.n247 0.650322
R6160 VSS.n1225 VSS.n247 0.650322
R6161 VSS.n1231 VSS.n247 0.650322
R6162 VSS.n1232 VSS.n247 0.650322
R6163 VSS.n1239 VSS.n247 0.650322
R6164 VSS.n1240 VSS.n247 0.650322
R6165 VSS.n1246 VSS.n247 0.650322
R6166 VSS.n1247 VSS.n247 0.650322
R6167 VSS.n1254 VSS.n247 0.650322
R6168 VSS.n1255 VSS.n247 0.650322
R6169 VSS.n1261 VSS.n247 0.650322
R6170 VSS.n1262 VSS.n247 0.650322
R6171 VSS.n1269 VSS.n247 0.650322
R6172 VSS.n1270 VSS.n247 0.650322
R6173 VSS.n1276 VSS.n247 0.650322
R6174 VSS.n1277 VSS.n247 0.650322
R6175 VSS.n1284 VSS.n247 0.650322
R6176 VSS.n1285 VSS.n247 0.650322
R6177 VSS.n1291 VSS.n247 0.650322
R6178 VSS.n1292 VSS.n247 0.650322
R6179 VSS.n1299 VSS.n247 0.650322
R6180 VSS.n1300 VSS.n247 0.650322
R6181 VSS.n1306 VSS.n247 0.650322
R6182 VSS.n1310 VSS.n247 0.650322
R6183 VSS.n1312 VSS.n247 0.650322
R6184 VSS.n1314 VSS.n247 0.650322
R6185 VSS.n393 VSS.n247 0.650322
R6186 VSS.n389 VSS.n247 0.650322
R6187 VSS.n385 VSS.n247 0.650322
R6188 VSS.n418 VSS.n247 0.650322
R6189 VSS.n420 VSS.n247 0.650322
R6190 VSS.n422 VSS.n247 0.650322
R6191 VSS.n424 VSS.n247 0.650322
R6192 VSS.n426 VSS.n247 0.650322
R6193 VSS.n428 VSS.n247 0.650322
R6194 VSS.n430 VSS.n247 0.650322
R6195 VSS.n432 VSS.n247 0.650322
R6196 VSS.n434 VSS.n247 0.650322
R6197 VSS.n355 VSS.n247 0.650322
R6198 VSS.n346 VSS.n247 0.650322
R6199 VSS.n338 VSS.n247 0.650322
R6200 VSS.n329 VSS.n247 0.650322
R6201 VSS.n320 VSS.n247 0.650322
R6202 VSS.n316 VSS.n247 0.650322
R6203 VSS.n313 VSS.n247 0.650322
R6204 VSS.n309 VSS.n247 0.650322
R6205 VSS.n438 VSS.n247 0.650322
R6206 VSS.n441 VSS.n247 0.650322
R6207 VSS.n288 VSS.n247 0.650322
R6208 VSS.n284 VSS.n247 0.650322
R6209 VSS.n281 VSS.n247 0.650322
R6210 VSS.n279 VSS.n247 0.650322
R6211 VSS.n449 VSS.n247 0.650322
R6212 VSS.n1335 VSS.n247 0.650322
R6213 VSS.n451 VSS.n247 0.650322
R6214 VSS.n1342 VSS.n247 0.650322
R6215 VSS.n453 VSS.n247 0.650322
R6216 VSS.n270 VSS.n247 0.650322
R6217 VSS.n265 VSS.n247 0.650322
R6218 VSS.n455 VSS.n247 0.650322
R6219 VSS.n1853 VSS.n247 0.650322
R6220 VSS.n1885 VSS.n247 0.650322
R6221 VSS.n1877 VSS.n247 0.650322
R6222 VSS.n1873 VSS.n247 0.650322
R6223 VSS.n2088 VSS.n38 0.650322
R6224 VSS.n2088 VSS.n56 0.650322
R6225 VSS.n2088 VSS.n63 0.650322
R6226 VSS.n2088 VSS.n81 0.650322
R6227 VSS.n2088 VSS.n91 0.650322
R6228 VSS.n1493 VSS.n1492 0.633311
R6229 VSS.n1564 VSS.n1563 0.598882
R6230 VSS.n1598 VSS.n1410 0.569144
R6231 VSS.n30 VSS.n29 0.543252
R6232 VSS.n1889 VSS.n776 0.542754
R6233 VSS.n1889 VSS.n576 0.542754
R6234 VSS.n1889 VSS.n1233 0.542754
R6235 VSS.n232 VSS.n231 0.534828
R6236 VSS.n1563 VSS.n1562 0.52883
R6237 VSS.n1494 VSS.n1493 0.522061
R6238 VSS.n226 VSS.n225 0.521016
R6239 VSS.n1557 VSS.n1556 0.510347
R6240 VSS.n1889 VSS.n512 0.505313
R6241 VSS.n2090 VSS.n1 0.5005
R6242 VSS.n2091 VSS.n2090 0.5005
R6243 VSS.n2092 VSS.n1 0.5005
R6244 VSS.n2092 VSS.n2091 0.5005
R6245 VSS.n1928 VSS.n236 0.492466
R6246 VSS.n219 VSS.n218 0.485807
R6247 VSS.n1551 VSS.n1550 0.485541
R6248 VSS.n1023 VSS.n247 0.482747
R6249 VSS.n1072 VSS.n247 0.482388
R6250 VSS.n1347 VSS.n247 0.482388
R6251 VSS.n1558 VSS.n1557 0.479982
R6252 VSS.n231 VSS.n230 0.472931
R6253 VSS.n1552 VSS.n1551 0.463895
R6254 VSS.n237 VSS.n236 0.461084
R6255 VSS.n178 VSS.n29 0.434881
R6256 VSS.n436 VSS.n247 0.420405
R6257 VSS.n1567 VSS.n1489 0.414059
R6258 VSS.n2088 VSS.n31 0.41133
R6259 VSS.n1827 VSS.n1701 0.397967
R6260 VSS.n1632 VSS.n1631 0.383593
R6261 VSS.n1496 VSS.n1489 0.3641
R6262 VSS.n1497 VSS.n1489 0.3641
R6263 VSS.n1840 VSS.n1701 0.347513
R6264 VSS.n636 VSS.n247 0.28477
R6265 VSS.n1889 VSS.n1145 0.28477
R6266 VSS.n1142 VSS.n1141 0.276713
R6267 VSS.n1322 VSS.n1321 0.276713
R6268 VSS.n447 VSS.n306 0.276713
R6269 VSS.n1977 VSS.n1976 0.268558
R6270 VSS.n1978 VSS.n1977 0.268558
R6271 VSS.n2017 VSS.n2016 0.268558
R6272 VSS.n2018 VSS.n2017 0.268558
R6273 VSS.n2057 VSS.n2056 0.268558
R6274 VSS.n2058 VSS.n2057 0.268558
R6275 VSS.n1631 VSS.n1410 0.266553
R6276 VSS.n1841 VSS.n1840 0.266553
R6277 VSS.n2088 VSS.n18 0.256862
R6278 VSS.n177 VSS.n175 0.254017
R6279 VSS.n180 VSS.n177 0.254017
R6280 VSS.n399 VSS.n398 0.254017
R6281 VSS.n406 VSS.n398 0.254017
R6282 VSS.n23 VSS.n12 0.250994
R6283 VSS.n1819 VSS.n1818 0.2505
R6284 VSS.n1819 VSS.n0 0.2505
R6285 VSS.n1975 VSS.n1974 0.250378
R6286 VSS.n1976 VSS.n1975 0.250378
R6287 VSS.n1979 VSS.n1978 0.250378
R6288 VSS.n1980 VSS.n1979 0.250378
R6289 VSS.n2015 VSS.n2014 0.250378
R6290 VSS.n2016 VSS.n2015 0.250378
R6291 VSS.n2019 VSS.n2018 0.250378
R6292 VSS.n2020 VSS.n2019 0.250378
R6293 VSS.n2055 VSS.n2054 0.250378
R6294 VSS.n2056 VSS.n2055 0.250378
R6295 VSS.n2059 VSS.n2058 0.250378
R6296 VSS.n2060 VSS.n2059 0.250378
R6297 VSS.n1765 VSS.n1746 0.243829
R6298 VSS.n1763 VSS.n1762 0.243829
R6299 VSS.n1908 VSS.n249 0.243829
R6300 VSS.n1910 VSS.n248 0.243829
R6301 VSS.n146 VSS.n145 0.223034
R6302 VSS.n1800 VSS.n158 0.223034
R6303 VSS.n175 VSS.n171 0.223034
R6304 VSS.n180 VSS.n179 0.223034
R6305 VSS.n407 VSS.n406 0.223034
R6306 VSS.n1974 VSS.n1973 0.219382
R6307 VSS.n1981 VSS.n1980 0.219382
R6308 VSS.n2014 VSS.n2013 0.219382
R6309 VSS.n2021 VSS.n2020 0.219382
R6310 VSS.n2054 VSS.n2053 0.219382
R6311 VSS.n2061 VSS.n2060 0.219382
R6312 VSS.n1846 VSS.n1352 0.201663
R6313 VSS.n1846 VSS.n1844 0.201663
R6314 VSS.n1355 VSS.n1354 0.201663
R6315 VSS.n1354 VSS.n1353 0.201663
R6316 VSS.n1709 VSS.n1708 0.201663
R6317 VSS.n1708 VSS.n1705 0.201663
R6318 VSS.n1714 VSS.n1713 0.201663
R6319 VSS.n1713 VSS.n1710 0.201663
R6320 VSS.n1720 VSS.n1719 0.201663
R6321 VSS.n1719 VSS.n1718 0.201663
R6322 VSS.n1723 VSS.n1722 0.201663
R6323 VSS.n1722 VSS.n1721 0.201663
R6324 VSS.n1467 VSS.n1466 0.201663
R6325 VSS.n1480 VSS.n1479 0.201663
R6326 VSS.n1479 VSS.n1478 0.201663
R6327 VSS.n1477 VSS.n1476 0.201663
R6328 VSS.n1476 VSS.n1475 0.201663
R6329 VSS.n1474 VSS.n1473 0.201663
R6330 VSS.n1473 VSS.n1472 0.201663
R6331 VSS.n1471 VSS.n1470 0.201663
R6332 VSS.n1470 VSS.n1469 0.201663
R6333 VSS.n1465 VSS.n1464 0.201663
R6334 VSS.n1464 VSS.n1463 0.201663
R6335 VSS.n1462 VSS.n1461 0.201663
R6336 VSS.n1461 VSS.n1460 0.201663
R6337 VSS.n1459 VSS.n1458 0.201663
R6338 VSS.n1458 VSS.n1457 0.201663
R6339 VSS.n1456 VSS.n1455 0.201663
R6340 VSS.n1455 VSS.n1454 0.201663
R6341 VSS.n1362 VSS.n1361 0.201663
R6342 VSS.n1389 VSS.n1388 0.201663
R6343 VSS.n1378 VSS.n1377 0.201663
R6344 VSS.n1406 VSS.n1405 0.201663
R6345 VSS.n1405 VSS.n1404 0.201663
R6346 VSS.n1635 VSS.n1634 0.201663
R6347 VSS.n1634 VSS.n1403 0.201663
R6348 VSS.n1402 VSS.n1401 0.201663
R6349 VSS.n1401 VSS.n1400 0.201663
R6350 VSS.n1399 VSS.n1398 0.201663
R6351 VSS.n1398 VSS.n1397 0.201663
R6352 VSS.n1396 VSS.n1395 0.201663
R6353 VSS.n1395 VSS.n1394 0.201663
R6354 VSS.n1393 VSS.n1392 0.201663
R6355 VSS.n1392 VSS.n1391 0.201663
R6356 VSS.n1387 VSS.n1386 0.201663
R6357 VSS.n1386 VSS.n1385 0.201663
R6358 VSS.n1384 VSS.n1383 0.201663
R6359 VSS.n1383 VSS.n1382 0.201663
R6360 VSS.n1381 VSS.n1380 0.201663
R6361 VSS.n1380 VSS.n1379 0.201663
R6362 VSS.n1377 VSS.n1376 0.201663
R6363 VSS.n1375 VSS.n1374 0.201663
R6364 VSS.n1374 VSS.n1373 0.201663
R6365 VSS.n1372 VSS.n1371 0.201663
R6366 VSS.n1371 VSS.n1370 0.201663
R6367 VSS.n1369 VSS.n1368 0.201663
R6368 VSS.n1368 VSS.n1367 0.201663
R6369 VSS.n1366 VSS.n1365 0.201663
R6370 VSS.n1365 VSS.n1364 0.201663
R6371 VSS.n1684 VSS.n1683 0.201663
R6372 VSS.n1683 VSS.n1682 0.201663
R6373 VSS.n1687 VSS.n1686 0.201663
R6374 VSS.n1686 VSS.n1685 0.201663
R6375 VSS.n1690 VSS.n1689 0.201663
R6376 VSS.n1689 VSS.n1688 0.201663
R6377 VSS.n1694 VSS.n1693 0.201663
R6378 VSS.n1693 VSS.n1691 0.201663
R6379 VSS.n1413 VSS.n1412 0.201663
R6380 VSS.n1412 VSS.n1411 0.201663
R6381 VSS.n1626 VSS.n1625 0.201663
R6382 VSS.n1625 VSS.n1608 0.201663
R6383 VSS.n1040 VSS.n1039 0.195092
R6384 VSS.n1900 VSS.n1899 0.194752
R6385 VSS.n1812 VSS.n17 0.189972
R6386 VSS.n1605 VSS.n1604 0.188
R6387 VSS.n1839 VSS.n1838 0.188
R6388 VSS.n1828 VSS.n1825 0.188
R6389 VSS.n1823 VSS.n1822 0.188
R6390 VSS.n1605 VSS.n1410 0.188
R6391 VSS.n1840 VSS.n1839 0.188
R6392 VSS.n1828 VSS.n1827 0.188
R6393 VSS.n1826 VSS.n1823 0.188
R6394 VSS.n1417 VSS.n942 0.187772
R6395 VSS.n1861 VSS.n460 0.183983
R6396 VSS.n1619 VSS.n250 0.18385
R6397 VSS.n1637 VSS.n990 0.18385
R6398 VSS.n1647 VSS.n251 0.18385
R6399 VSS.n1662 VSS.n634 0.18385
R6400 VSS.n1672 VSS.n252 0.18385
R6401 VSS.n1829 VSS.n1828 0.15978
R6402 VSS.n1046 VSS.n247 0.154674
R6403 VSS.n1828 VSS.n1823 0.149513
R6404 VSS.n1827 VSS.n1826 0.149513
R6405 VSS.n1906 VSS.n250 0.146306
R6406 VSS.n1904 VSS.n251 0.146306
R6407 VSS.n1902 VSS.n252 0.146306
R6408 VSS.n731 VSS.n634 0.146306
R6409 VSS.n990 VSS.n989 0.146306
R6410 VSS.n508 VSS.n460 0.146176
R6411 VSS.n17 VSS.n16 0.146176
R6412 VSS.n1315 VSS.n247 0.139708
R6413 VSS.n1889 VSS.n308 0.139602
R6414 VSS.n1889 VSS.n287 0.139602
R6415 VSS.n994 VSS.n247 0.139583
R6416 VSS.n1421 VSS.n247 0.139377
R6417 VSS.n307 VSS.n247 0.139377
R6418 VSS.n286 VSS.n247 0.139377
R6419 VSS.n2088 VSS.n13 0.139317
R6420 VSS.n2088 VSS.n59 0.139317
R6421 VSS.n2088 VSS.n88 0.139317
R6422 VSS.n1762 VSS.n1761 0.138628
R6423 VSS.n1448 VSS.n248 0.138628
R6424 VSS.n1433 VSS.n249 0.138628
R6425 VSS.n1746 VSS.n1745 0.138628
R6426 VSS.n1899 VSS.n1898 0.136065
R6427 VSS.n1609 VSS.n1040 0.135726
R6428 VSS.n1826 VSS.n0 0.134553
R6429 VSS.n253 VSS.n247 0.126015
R6430 VSS.n1889 VSS.n458 0.123612
R6431 VSS.n1905 VSS.n247 0.123154
R6432 VSS.n1907 VSS.n247 0.123154
R6433 VSS.n2092 VSS.n0 0.119593
R6434 VSS.n1603 VSS.n1602 0.117247
R6435 VSS.n1702 VSS.n1356 0.117247
R6436 VSS.n1830 VSS.n1829 0.117247
R6437 VSS.n1607 VSS.n1606 0.1171
R6438 VSS.n1835 VSS.n1834 0.1171
R6439 VSS.n1889 VSS.n952 0.113473
R6440 VSS.n1889 VSS.n939 0.113473
R6441 VSS.n1731 VSS.n306 0.109648
R6442 VSS.n1753 VSS.n1322 0.109648
R6443 VSS.n1447 VSS.n1142 0.109648
R6444 VSS.n1606 VSS.n1605 0.109473
R6445 VSS.n1839 VSS.n1835 0.109473
R6446 VSS.n1605 VSS.n1603 0.109327
R6447 VSS.n1839 VSS.n1702 0.109327
R6448 VSS.n2 VSS.n1 0.109142
R6449 VSS.n2091 VSS.n2 0.109142
R6450 VSS.n2071 VSS.n1917 0.0973819
R6451 VSS.n1537 VSS.n1489 0.0973819
R6452 VSS.n1823 VSS.n1820 0.0967133
R6453 VSS.n2069 VSS.n245 0.093878
R6454 VSS.n1574 VSS.n1573 0.0926566
R6455 VSS.n1573 VSS.n1481 0.0886171
R6456 VSS.n1582 VSS.n245 0.0873957
R6457 VSS.n2071 VSS.n236 0.086287
R6458 VSS.n1551 VSS.n1489 0.0841527
R6459 VSS.n1654 VSS.n1653 0.08146
R6460 VSS.n1655 VSS.n1654 0.08146
R6461 VSS.n1656 VSS.n1655 0.08146
R6462 VSS.n1657 VSS.n1656 0.08146
R6463 VSS.n1658 VSS.n1657 0.08146
R6464 VSS.n1659 VSS.n1658 0.08146
R6465 VSS.n1660 VSS.n1659 0.08146
R6466 VSS.n1661 VSS.n1660 0.08146
R6467 VSS.n1679 VSS.n1678 0.08146
R6468 VSS.n1680 VSS.n1679 0.08146
R6469 VSS.n1681 VSS.n1680 0.08146
R6470 VSS.n1699 VSS.n1681 0.08146
R6471 VSS.n1699 VSS.n1698 0.08146
R6472 VSS.n1698 VSS.n1697 0.08146
R6473 VSS.n1697 VSS.n1696 0.08146
R6474 VSS.n1696 VSS.n1695 0.08146
R6475 VSS.n1595 VSS.n1594 0.08146
R6476 VSS.n1596 VSS.n1595 0.08146
R6477 VSS.n1597 VSS.n1596 0.08146
R6478 VSS.n1598 VSS.n1597 0.08146
R6479 VSS.n1599 VSS.n1598 0.08146
R6480 VSS.n1600 VSS.n1599 0.08146
R6481 VSS.n1601 VSS.n1600 0.08146
R6482 VSS.n1602 VSS.n1601 0.08146
R6483 VSS.n1834 VSS.n1833 0.08146
R6484 VSS.n1831 VSS.n1830 0.08146
R6485 VSS.n1801 VSS.n1800 0.0797347
R6486 VSS.n1582 VSS.n217 0.0791548
R6487 VSS.n2071 VSS.n1951 0.0785311
R6488 VSS.n1538 VSS.n1489 0.0785311
R6489 VSS.n1624 VSS.n1407 0.07838
R6490 VSS.n1652 VSS.n1636 0.07838
R6491 VSS.n1653 VSS.n1652 0.07838
R6492 VSS.n1677 VSS.n1661 0.07838
R6493 VSS.n1678 VSS.n1677 0.07838
R6494 VSS.n1695 VSS.n257 0.07838
R6495 VSS.n1594 VSS.n1593 0.07838
R6496 VSS.n1627 VSS.n1624 0.07838
R6497 VSS.n1843 VSS.n257 0.07838
R6498 VSS.n1491 VSS.n1481 0.0777068
R6499 VSS.n144 VSS.n12 0.0723476
R6500 VSS.n2071 VSS.n231 0.0721613
R6501 VSS.n1425 VSS.n1417 0.070439
R6502 VSS.n145 VSS.n144 0.070439
R6503 VSS.n1773 VSS.n1772 0.070439
R6504 VSS.n942 VSS.n941 0.0701667
R6505 VSS.n1492 VSS.n1491 0.0701249
R6506 VSS.n218 VSS.n217 0.0686438
R6507 VSS.n1557 VSS.n1489 0.0651427
R6508 VSS.n140 VSS.n2 0.0644015
R6509 VSS.n121 VSS.n2 0.0644015
R6510 VSS.n409 VSS.n408 0.0617333
R6511 VSS.n2071 VSS.n1988 0.0599538
R6512 VSS.n2071 VSS.n1989 0.0599538
R6513 VSS.n1531 VSS.n1489 0.0599538
R6514 VSS.n1530 VSS.n1489 0.0599538
R6515 VSS.n144 VSS.n119 0.0592831
R6516 VSS.n144 VSS.n126 0.0592831
R6517 VSS.n144 VSS.n127 0.0592831
R6518 VSS.n144 VSS.n143 0.0592831
R6519 VSS.n1426 VSS.n1425 0.0592831
R6520 VSS.n1773 VSS.n1728 0.0592831
R6521 VSS.n1786 VSS.n1781 0.0592831
R6522 VSS.n2067 VSS.n2032 0.0524268
R6523 VSS.n2027 VSS.n1992 0.0524268
R6524 VSS.n1987 VSS.n1952 0.0524268
R6525 VSS.n1548 VSS.n1547 0.0505591
R6526 VSS.n1633 VSS.n1409 0.0488871
R6527 VSS.n1630 VSS.n1629 0.0488871
R6528 VSS.n1842 VSS.n1359 0.0488871
R6529 VSS.n1631 VSS.n1630 0.0488871
R6530 VSS.n1633 VSS.n1632 0.0488871
R6531 VSS.n1842 VSS.n1841 0.0488871
R6532 VSS.n1971 VSS.n1915 0.0461613
R6533 VSS.n2011 VSS.n1991 0.0461613
R6534 VSS.n1534 VSS.n1533 0.0461613
R6535 VSS.n1535 VSS.n1534 0.0461613
R6536 VSS.n1527 VSS.n1526 0.0461613
R6537 VSS.n1528 VSS.n1527 0.0461613
R6538 VSS.n2051 VSS.n2031 0.0458268
R6539 VSS.n1568 VSS.n1490 0.0458268
R6540 VSS.n1570 VSS.n1569 0.0457937
R6541 VSS.n1820 VSS.n1811 0.0431366
R6542 VSS.n1820 VSS.n1816 0.0431366
R6543 VSS.n1862 VSS.n257 0.0421192
R6544 VSS.n1896 VSS.n257 0.0421192
R6545 VSS.n1624 VSS.n1613 0.0421192
R6546 VSS.n1624 VSS.n1623 0.0421192
R6547 VSS.n1652 VSS.n1641 0.0421192
R6548 VSS.n1652 VSS.n1651 0.0421192
R6549 VSS.n1677 VSS.n1666 0.0421192
R6550 VSS.n1677 VSS.n1676 0.0421192
R6551 VSS.n1633 VSS.n1407 0.04098
R6552 VSS.n1636 VSS.n1633 0.04098
R6553 VSS.n1630 VSS.n1607 0.04098
R6554 VSS.n1630 VSS.n1627 0.04098
R6555 VSS.n1843 VSS.n1842 0.04098
R6556 VSS.n1842 VSS.n1356 0.04098
R6557 VSS.n1833 VSS.n1832 0.04098
R6558 VSS.n1832 VSS.n1831 0.04098
R6559 VSS.n1593 VSS.n1581 0.0398706
R6560 VSS.n1593 VSS.n1592 0.0398706
R6561 VSS.n1669 VSS.n1668 0.0396337
R6562 VSS.n1644 VSS.n1643 0.0395455
R6563 VSS.n1616 VSS.n1615 0.0393109
R6564 VSS.n1615 VSS.n1053 0.0392231
R6565 VSS.n1643 VSS.n1000 0.0392231
R6566 VSS.n1668 VSS.n630 0.0392231
R6567 VSS.n1893 VSS.n1892 0.0387534
R6568 VSS.n1820 VSS.n1819 0.03834
R6569 VSS.n1585 VSS.n1584 0.037882
R6570 VSS.n1584 VSS.n1317 0.037882
R6571 VSS.n1892 VSS.n259 0.0368727
R6572 VSS.n179 VSS.n178 0.0357621
R6573 VSS.n408 VSS.n407 0.0357621
R6574 VSS.n186 VSS.n171 0.0357621
R6575 VSS.n168 VSS.n158 0.0357621
R6576 VSS.n196 VSS.n146 0.0357621
R6577 VSS.n1569 VSS.n1568 0.0353175
R6578 VSS.n2031 VSS.n2030 0.0343756
R6579 VSS.n1522 VSS.n1490 0.0343756
R6580 VSS.n1991 VSS.n1990 0.0340411
R6581 VSS.n1916 VSS.n1915 0.0340411
R6582 VSS.n1533 VSS.n1532 0.0340411
R6583 VSS.n1536 VSS.n1535 0.0340411
R6584 VSS.n1526 VSS.n1525 0.0340411
R6585 VSS.n1529 VSS.n1528 0.0340411
R6586 VSS.n1547 VSS.n1499 0.034014
R6587 VSS.n1519 VSS.n1518 0.034014
R6588 VSS.n1520 VSS.n1519 0.034014
R6589 VSS.n1521 VSS.n1520 0.034014
R6590 VSS.n1948 VSS.n1946 0.034014
R6591 VSS.n1946 VSS.n1944 0.034014
R6592 VSS.n1944 VSS.n1942 0.034014
R6593 VSS.n1937 VSS.n1935 0.034014
R6594 VSS.n1935 VSS.n1933 0.034014
R6595 VSS.n1832 VSS.n1717 0.0338333
R6596 VSS.n1832 VSS.n1701 0.0338333
R6597 VSS.n1933 VSS.n1931 0.0326523
R6598 VSS.n2053 VSS.n2051 0.0321096
R6599 VSS.n2013 VSS.n2011 0.0321096
R6600 VSS.n1973 VSS.n1971 0.0321096
R6601 VSS.n1982 VSS.n1981 0.0321096
R6602 VSS.n2022 VSS.n2021 0.0321096
R6603 VSS.n2062 VSS.n2061 0.0321096
R6604 VSS.n1735 VSS.n1734 0.031258
R6605 VSS.n1749 VSS.n1748 0.031258
R6606 VSS.n1445 VSS.n1444 0.031258
R6607 VSS.n1759 VSS.n1758 0.031258
R6608 VSS.n1435 VSS.n1434 0.031258
R6609 VSS.n1441 VSS.n1440 0.031258
R6610 VSS.n1727 VSS.n1726 0.031258
R6611 VSS.n1784 VSS.n1783 0.031258
R6612 VSS.n2081 VSS.n2 0.0311992
R6613 VSS.n1920 VSS.n2 0.0311992
R6614 VSS.n25 VSS.n5 0.0306964
R6615 VSS.n1766 VSS.n247 0.0297165
R6616 VSS.n1829 VSS.n1724 0.0291125
R6617 VSS.n1835 VSS.n1703 0.0291125
R6618 VSS.n1751 VSS.n1702 0.0291125
R6619 VSS.n1603 VSS.n1438 0.0291125
R6620 VSS.n1835 VSS.n1704 0.0291125
R6621 VSS.n1755 VSS.n1702 0.0291125
R6622 VSS.n1603 VSS.n1453 0.0291125
R6623 VSS.n1606 VSS.n1414 0.0291125
R6624 VSS.n1606 VSS.n1437 0.0291125
R6625 VSS.n1829 VSS.n1790 0.0291125
R6626 VSS.n202 VSS.n5 0.0290837
R6627 VSS.n1971 VSS.n1952 0.0286296
R6628 VSS.n2011 VSS.n1992 0.0286296
R6629 VSS.n2051 VSS.n2032 0.0286296
R6630 VSS.n1785 VSS.n1724 0.0281144
R6631 VSS.n1733 VSS.n1703 0.0281144
R6632 VSS.n1752 VSS.n1751 0.0281144
R6633 VSS.n1446 VSS.n1438 0.0281144
R6634 VSS.n1740 VSS.n1704 0.0281144
R6635 VSS.n1760 VSS.n1755 0.0281144
R6636 VSS.n1453 VSS.n1439 0.0281144
R6637 VSS.n1428 VSS.n1414 0.0281144
R6638 VSS.n1437 VSS.n1415 0.0281144
R6639 VSS.n1790 VSS.n1725 0.0281144
R6640 VSS.n1889 VSS.n416 0.0269979
R6641 VSS.n1550 VSS.n1549 0.0269714
R6642 VSS.n1549 VSS.n1548 0.0262188
R6643 VSS.n230 VSS.n229 0.0255512
R6644 VSS.n225 VSS.n223 0.0255512
R6645 VSS.n1515 VSS.n1499 0.0253874
R6646 VSS.n1518 VSS.n1517 0.0253874
R6647 VSS.n1540 VSS.n1521 0.0253874
R6648 VSS.n1510 VSS.n1509 0.0253874
R6649 VSS.n1918 VSS.n1914 0.0253874
R6650 VSS.n1949 VSS.n1948 0.0253874
R6651 VSS.n1942 VSS.n1940 0.0253874
R6652 VSS.n1938 VSS.n1937 0.0253874
R6653 VSS.n233 VSS.n232 0.0247494
R6654 VSS.n1794 VSS.n87 0.0233033
R6655 VSS.n142 VSS.n140 0.0229738
R6656 VSS.n125 VSS.n121 0.0229738
R6657 VSS.n1495 VSS.n1494 0.0223867
R6658 VSS.n1561 VSS.n1560 0.0219867
R6659 VSS.n1560 VSS.n1559 0.0219867
R6660 VSS.n2022 VSS.n242 0.0219867
R6661 VSS.n2062 VSS.n244 0.0219867
R6662 VSS.n1742 VSS.n1739 0.0216549
R6663 VSS.n1432 VSS.n1431 0.0216549
R6664 VSS.n1566 VSS.n1565 0.0216528
R6665 VSS.n1555 VSS.n1554 0.0216528
R6666 VSS.n1554 VSS.n1553 0.0216528
R6667 VSS.n1982 VSS.n238 0.0216528
R6668 VSS.n1809 VSS.n1795 0.0215704
R6669 VSS.n1744 VSS.n1743 0.0208704
R6670 VSS.n1430 VSS.n1429 0.0208704
R6671 VSS VSS.n2092 0.0204467
R6672 VSS.n2071 VSS.n226 0.0204189
R6673 VSS.n1736 VSS.n1732 0.0202884
R6674 VSS.n1750 VSS.n1747 0.0202884
R6675 VSS.n1443 VSS.n1442 0.0202884
R6676 VSS.n1743 VSS.n1741 0.0202884
R6677 VSS.n1757 VSS.n1756 0.0202884
R6678 VSS.n1436 VSS.n1416 0.0202884
R6679 VSS.n1452 VSS.n1451 0.0202884
R6680 VSS.n1430 VSS.n1427 0.0202884
R6681 VSS.n1789 VSS.n1788 0.0202884
R6682 VSS.n1782 VSS.n1729 0.0202884
R6683 VSS.n1657 VSS.n1360 0.0197308
R6684 VSS.n1700 VSS.n1699 0.0197308
R6685 VSS.n1815 VSS.n86 0.0197113
R6686 VSS.n1810 VSS.n1792 0.0197113
R6687 VSS.n1493 VSS.n1489 0.019362
R6688 VSS.n1598 VSS.n1468 0.0186622
R6689 VSS.n1699 VSS.n1363 0.0186622
R6690 VSS.n1657 VSS.n1390 0.0186622
R6691 VSS.n1575 VSS.n1574 0.018056
R6692 VSS.n2069 VSS.n1913 0.018056
R6693 VSS.n1650 VSS.n1644 0.0174607
R6694 VSS.n1675 VSS.n1669 0.0173727
R6695 VSS.n2071 VSS.n219 0.0172471
R6696 VSS.n1566 VSS.n1495 0.0168525
R6697 VSS.n1612 VSS.n1053 0.0167849
R6698 VSS.n1640 VSS.n1000 0.0167849
R6699 VSS.n1665 VSS.n630 0.0167849
R6700 VSS.n1622 VSS.n1616 0.0166963
R6701 VSS.n1565 VSS.n1564 0.0166062
R6702 VSS.n1556 VSS.n1555 0.0166062
R6703 VSS.n1553 VSS.n1552 0.0166062
R6704 VSS.n238 VSS.n237 0.0166062
R6705 VSS.n1540 VSS.n1539 0.0162826
R6706 VSS.n1950 VSS.n1949 0.0162826
R6707 VSS.n1562 VSS.n1561 0.0162723
R6708 VSS.n1559 VSS.n1558 0.0162723
R6709 VSS.n242 VSS.n241 0.0162723
R6710 VSS.n244 VSS.n243 0.0162723
R6711 VSS.n1895 VSS.n1893 0.0162547
R6712 VSS.n124 VSS.n123 0.0153413
R6713 VSS.n123 VSS.n119 0.0153413
R6714 VSS.n126 VSS.n120 0.0153413
R6715 VSS.n122 VSS.n120 0.0153413
R6716 VSS.n139 VSS.n138 0.0153413
R6717 VSS.n139 VSS.n127 0.0153413
R6718 VSS.n143 VSS.n137 0.0153413
R6719 VSS.n141 VSS.n137 0.0153413
R6720 VSS.n1591 VSS.n1585 0.0153166
R6721 VSS.n1580 VSS.n1317 0.0153166
R6722 VSS.n1929 VSS.n1928 0.0153046
R6723 VSS.n1982 VSS.n233 0.0144784
R6724 VSS.n1581 VSS.n1579 0.0143464
R6725 VSS.n1592 VSS.n1583 0.0143464
R6726 VSS.n2022 VSS.n229 0.0136762
R6727 VSS.n2062 VSS.n223 0.0136762
R6728 VSS.n1815 VSS.n87 0.0133878
R6729 VSS.n1563 VSS.n1489 0.0126361
R6730 VSS.n1819 VSS.n2 0.01238
R6731 VSS.n1795 VSS.n1794 0.0122746
R6732 VSS.n1868 VSS.n1867 0.0122417
R6733 VSS.n1037 VSS.n1036 0.0118857
R6734 VSS.n1036 VSS.n1035 0.0118857
R6735 VSS.n1035 VSS.n1034 0.0118857
R6736 VSS.n1034 VSS.n1033 0.0118857
R6737 VSS.n1033 VSS.n1032 0.0118857
R6738 VSS.n1032 VSS.n1031 0.0118857
R6739 VSS.n1028 VSS.n1027 0.0118857
R6740 VSS.n1027 VSS.n1026 0.0118857
R6741 VSS.n1017 VSS.n1013 0.0118857
R6742 VSS.n1012 VSS.n1011 0.0118857
R6743 VSS.n1010 VSS.n1006 0.0118857
R6744 VSS.n523 VSS.n522 0.0118857
R6745 VSS.n525 VSS.n524 0.0118857
R6746 VSS.n528 VSS.n527 0.0118857
R6747 VSS.n534 VSS.n533 0.0118857
R6748 VSS.n536 VSS.n535 0.0118857
R6749 VSS.n539 VSS.n538 0.0118857
R6750 VSS.n545 VSS.n544 0.0118857
R6751 VSS.n547 VSS.n546 0.0118857
R6752 VSS.n550 VSS.n549 0.0118857
R6753 VSS.n556 VSS.n555 0.0118857
R6754 VSS.n558 VSS.n557 0.0118857
R6755 VSS.n561 VSS.n560 0.0118857
R6756 VSS.n567 VSS.n566 0.0118857
R6757 VSS.n569 VSS.n568 0.0118857
R6758 VSS.n572 VSS.n571 0.0118857
R6759 VSS.n578 VSS.n577 0.0118857
R6760 VSS.n580 VSS.n579 0.0118857
R6761 VSS.n583 VSS.n582 0.0118857
R6762 VSS.n589 VSS.n588 0.0118857
R6763 VSS.n591 VSS.n590 0.0118857
R6764 VSS.n594 VSS.n593 0.0118857
R6765 VSS.n600 VSS.n599 0.0118857
R6766 VSS.n602 VSS.n601 0.0118857
R6767 VSS.n605 VSS.n604 0.0118857
R6768 VSS.n611 VSS.n610 0.0118857
R6769 VSS.n613 VSS.n612 0.0118857
R6770 VSS.n616 VSS.n615 0.0118857
R6771 VSS.n622 VSS.n621 0.0118857
R6772 VSS.n624 VSS.n623 0.0118857
R6773 VSS.n627 VSS.n626 0.0118857
R6774 VSS.n887 VSS.n886 0.0118857
R6775 VSS.n885 VSS.n884 0.0118857
R6776 VSS.n883 VSS.n882 0.0118857
R6777 VSS.n879 VSS.n878 0.0118857
R6778 VSS.n877 VSS.n876 0.0118857
R6779 VSS.n875 VSS.n874 0.0118857
R6780 VSS.n871 VSS.n870 0.0118857
R6781 VSS.n869 VSS.n868 0.0118857
R6782 VSS.n867 VSS.n866 0.0118857
R6783 VSS.n863 VSS.n862 0.0118857
R6784 VSS.n861 VSS.n860 0.0118857
R6785 VSS.n859 VSS.n858 0.0118857
R6786 VSS.n855 VSS.n854 0.0118857
R6787 VSS.n853 VSS.n852 0.0118857
R6788 VSS.n851 VSS.n850 0.0118857
R6789 VSS.n847 VSS.n846 0.0118857
R6790 VSS.n845 VSS.n844 0.0118857
R6791 VSS.n843 VSS.n842 0.0118857
R6792 VSS.n839 VSS.n838 0.0118857
R6793 VSS.n837 VSS.n836 0.0118857
R6794 VSS.n835 VSS.n834 0.0118857
R6795 VSS.n831 VSS.n830 0.0118857
R6796 VSS.n829 VSS.n828 0.0118857
R6797 VSS.n827 VSS.n826 0.0118857
R6798 VSS.n823 VSS.n822 0.0118857
R6799 VSS.n821 VSS.n820 0.0118857
R6800 VSS.n819 VSS.n818 0.0118857
R6801 VSS.n807 VSS.n806 0.0118857
R6802 VSS.n812 VSS.n811 0.0118857
R6803 VSS.n814 VSS.n813 0.0118857
R6804 VSS.n813 VSS.n812 0.0118857
R6805 VSS.n811 VSS.n807 0.0118857
R6806 VSS.n806 VSS.n805 0.0118857
R6807 VSS.n818 VSS.n817 0.0118857
R6808 VSS.n820 VSS.n819 0.0118857
R6809 VSS.n823 VSS.n821 0.0118857
R6810 VSS.n826 VSS.n825 0.0118857
R6811 VSS.n828 VSS.n827 0.0118857
R6812 VSS.n831 VSS.n829 0.0118857
R6813 VSS.n834 VSS.n833 0.0118857
R6814 VSS.n836 VSS.n835 0.0118857
R6815 VSS.n839 VSS.n837 0.0118857
R6816 VSS.n842 VSS.n841 0.0118857
R6817 VSS.n844 VSS.n843 0.0118857
R6818 VSS.n847 VSS.n845 0.0118857
R6819 VSS.n850 VSS.n849 0.0118857
R6820 VSS.n852 VSS.n851 0.0118857
R6821 VSS.n855 VSS.n853 0.0118857
R6822 VSS.n858 VSS.n857 0.0118857
R6823 VSS.n860 VSS.n859 0.0118857
R6824 VSS.n863 VSS.n861 0.0118857
R6825 VSS.n866 VSS.n865 0.0118857
R6826 VSS.n868 VSS.n867 0.0118857
R6827 VSS.n871 VSS.n869 0.0118857
R6828 VSS.n874 VSS.n873 0.0118857
R6829 VSS.n876 VSS.n875 0.0118857
R6830 VSS.n879 VSS.n877 0.0118857
R6831 VSS.n882 VSS.n881 0.0118857
R6832 VSS.n884 VSS.n883 0.0118857
R6833 VSS.n887 VSS.n885 0.0118857
R6834 VSS.n628 VSS.n627 0.0118857
R6835 VSS.n626 VSS.n624 0.0118857
R6836 VSS.n623 VSS.n622 0.0118857
R6837 VSS.n617 VSS.n616 0.0118857
R6838 VSS.n615 VSS.n613 0.0118857
R6839 VSS.n612 VSS.n611 0.0118857
R6840 VSS.n606 VSS.n605 0.0118857
R6841 VSS.n604 VSS.n602 0.0118857
R6842 VSS.n601 VSS.n600 0.0118857
R6843 VSS.n595 VSS.n594 0.0118857
R6844 VSS.n593 VSS.n591 0.0118857
R6845 VSS.n590 VSS.n589 0.0118857
R6846 VSS.n584 VSS.n583 0.0118857
R6847 VSS.n582 VSS.n580 0.0118857
R6848 VSS.n579 VSS.n578 0.0118857
R6849 VSS.n573 VSS.n572 0.0118857
R6850 VSS.n571 VSS.n569 0.0118857
R6851 VSS.n568 VSS.n567 0.0118857
R6852 VSS.n562 VSS.n561 0.0118857
R6853 VSS.n560 VSS.n558 0.0118857
R6854 VSS.n557 VSS.n556 0.0118857
R6855 VSS.n551 VSS.n550 0.0118857
R6856 VSS.n549 VSS.n547 0.0118857
R6857 VSS.n546 VSS.n545 0.0118857
R6858 VSS.n540 VSS.n539 0.0118857
R6859 VSS.n538 VSS.n536 0.0118857
R6860 VSS.n535 VSS.n534 0.0118857
R6861 VSS.n529 VSS.n528 0.0118857
R6862 VSS.n527 VSS.n525 0.0118857
R6863 VSS.n524 VSS.n523 0.0118857
R6864 VSS.n1006 VSS.n1005 0.0118857
R6865 VSS.n1011 VSS.n1010 0.0118857
R6866 VSS.n1013 VSS.n1012 0.0118857
R6867 VSS.n1021 VSS.n1020 0.0118857
R6868 VSS.n1308 VSS.n1305 0.0118857
R6869 VSS.n1304 VSS.n1303 0.0118857
R6870 VSS.n1302 VSS.n1298 0.0118857
R6871 VSS.n1294 VSS.n1290 0.0118857
R6872 VSS.n1289 VSS.n1288 0.0118857
R6873 VSS.n1287 VSS.n1283 0.0118857
R6874 VSS.n1279 VSS.n1275 0.0118857
R6875 VSS.n1274 VSS.n1273 0.0118857
R6876 VSS.n1272 VSS.n1268 0.0118857
R6877 VSS.n1264 VSS.n1260 0.0118857
R6878 VSS.n1259 VSS.n1258 0.0118857
R6879 VSS.n1257 VSS.n1253 0.0118857
R6880 VSS.n1249 VSS.n1245 0.0118857
R6881 VSS.n1244 VSS.n1243 0.0118857
R6882 VSS.n1242 VSS.n1238 0.0118857
R6883 VSS.n1234 VSS.n1230 0.0118857
R6884 VSS.n1229 VSS.n1228 0.0118857
R6885 VSS.n1227 VSS.n1223 0.0118857
R6886 VSS.n1219 VSS.n1215 0.0118857
R6887 VSS.n1214 VSS.n1213 0.0118857
R6888 VSS.n1212 VSS.n1208 0.0118857
R6889 VSS.n1204 VSS.n1200 0.0118857
R6890 VSS.n1199 VSS.n1198 0.0118857
R6891 VSS.n1197 VSS.n1193 0.0118857
R6892 VSS.n1189 VSS.n1185 0.0118857
R6893 VSS.n1184 VSS.n1183 0.0118857
R6894 VSS.n1182 VSS.n1178 0.0118857
R6895 VSS.n1174 VSS.n1170 0.0118857
R6896 VSS.n1169 VSS.n1168 0.0118857
R6897 VSS.n1167 VSS.n1163 0.0118857
R6898 VSS.n1162 VSS.n1161 0.0118857
R6899 VSS.n1160 VSS.n1156 0.0118857
R6900 VSS.n1149 VSS.n1148 0.0118857
R6901 VSS.n1148 VSS.n1147 0.0118857
R6902 VSS.n1147 VSS.n1146 0.0118857
R6903 VSS.n1146 VSS.n1138 0.0118857
R6904 VSS.n1138 VSS.n1137 0.0118857
R6905 VSS.n1137 VSS.n1133 0.0118857
R6906 VSS.n1133 VSS.n1132 0.0118857
R6907 VSS.n1132 VSS.n1129 0.0118857
R6908 VSS.n1129 VSS.n1128 0.0118857
R6909 VSS.n1125 VSS.n1124 0.0118857
R6910 VSS.n1124 VSS.n1123 0.0118857
R6911 VSS.n1123 VSS.n1122 0.0118857
R6912 VSS.n1122 VSS.n1121 0.0118857
R6913 VSS.n1121 VSS.n1118 0.0118857
R6914 VSS.n1118 VSS.n1117 0.0118857
R6915 VSS.n1117 VSS.n1113 0.0118857
R6916 VSS.n1113 VSS.n1112 0.0118857
R6917 VSS.n1107 VSS.n1104 0.0118857
R6918 VSS.n1104 VSS.n1103 0.0118857
R6919 VSS.n1103 VSS.n1100 0.0118857
R6920 VSS.n1100 VSS.n1099 0.0118857
R6921 VSS.n1099 VSS.n1095 0.0118857
R6922 VSS.n1095 VSS.n1094 0.0118857
R6923 VSS.n1094 VSS.n1091 0.0118857
R6924 VSS.n1091 VSS.n1090 0.0118857
R6925 VSS.n1090 VSS.n1086 0.0118857
R6926 VSS.n1086 VSS.n1085 0.0118857
R6927 VSS.n1080 VSS.n1076 0.0118857
R6928 VSS.n1076 VSS.n1075 0.0118857
R6929 VSS.n1067 VSS.n1063 0.0118857
R6930 VSS.n1062 VSS.n1061 0.0118857
R6931 VSS.n1060 VSS.n1056 0.0118857
R6932 VSS.n1056 VSS.n1055 0.0118857
R6933 VSS.n1061 VSS.n1060 0.0118857
R6934 VSS.n1063 VSS.n1062 0.0118857
R6935 VSS.n1071 VSS.n1070 0.0118857
R6936 VSS.n1156 VSS.n1155 0.0118857
R6937 VSS.n1161 VSS.n1160 0.0118857
R6938 VSS.n1163 VSS.n1162 0.0118857
R6939 VSS.n1168 VSS.n1167 0.0118857
R6940 VSS.n1170 VSS.n1169 0.0118857
R6941 VSS.n1178 VSS.n1177 0.0118857
R6942 VSS.n1183 VSS.n1182 0.0118857
R6943 VSS.n1185 VSS.n1184 0.0118857
R6944 VSS.n1193 VSS.n1192 0.0118857
R6945 VSS.n1198 VSS.n1197 0.0118857
R6946 VSS.n1200 VSS.n1199 0.0118857
R6947 VSS.n1208 VSS.n1207 0.0118857
R6948 VSS.n1213 VSS.n1212 0.0118857
R6949 VSS.n1215 VSS.n1214 0.0118857
R6950 VSS.n1223 VSS.n1222 0.0118857
R6951 VSS.n1228 VSS.n1227 0.0118857
R6952 VSS.n1230 VSS.n1229 0.0118857
R6953 VSS.n1238 VSS.n1237 0.0118857
R6954 VSS.n1243 VSS.n1242 0.0118857
R6955 VSS.n1245 VSS.n1244 0.0118857
R6956 VSS.n1253 VSS.n1252 0.0118857
R6957 VSS.n1258 VSS.n1257 0.0118857
R6958 VSS.n1260 VSS.n1259 0.0118857
R6959 VSS.n1268 VSS.n1267 0.0118857
R6960 VSS.n1273 VSS.n1272 0.0118857
R6961 VSS.n1275 VSS.n1274 0.0118857
R6962 VSS.n1283 VSS.n1282 0.0118857
R6963 VSS.n1288 VSS.n1287 0.0118857
R6964 VSS.n1290 VSS.n1289 0.0118857
R6965 VSS.n1298 VSS.n1297 0.0118857
R6966 VSS.n1303 VSS.n1302 0.0118857
R6967 VSS.n1305 VSS.n1304 0.0118857
R6968 VSS.n1890 VSS.n260 0.0118857
R6969 VSS.n1852 VSS.n1851 0.0118857
R6970 VSS.n1850 VSS.n1849 0.0118857
R6971 VSS.n1351 VSS.n1350 0.0118857
R6972 VSS.n1346 VSS.n1345 0.0118857
R6973 VSS.n1341 VSS.n1339 0.0118857
R6974 VSS.n1338 VSS.n1337 0.0118857
R6975 VSS.n1334 VSS.n1333 0.0118857
R6976 VSS.n1332 VSS.n1331 0.0118857
R6977 VSS.n1330 VSS.n1329 0.0118857
R6978 VSS.n1327 VSS.n1325 0.0118857
R6979 VSS.n1324 VSS.n1323 0.0118857
R6980 VSS.n294 VSS.n290 0.0118857
R6981 VSS.n296 VSS.n295 0.0118857
R6982 VSS.n299 VSS.n298 0.0118857
R6983 VSS.n302 VSS.n300 0.0118857
R6984 VSS.n304 VSS.n303 0.0118857
R6985 VSS.n311 VSS.n305 0.0118857
R6986 VSS.n318 VSS.n315 0.0118857
R6987 VSS.n322 VSS.n319 0.0118857
R6988 VSS.n327 VSS.n323 0.0118857
R6989 VSS.n331 VSS.n328 0.0118857
R6990 VSS.n336 VSS.n332 0.0118857
R6991 VSS.n344 VSS.n340 0.0118857
R6992 VSS.n348 VSS.n345 0.0118857
R6993 VSS.n353 VSS.n349 0.0118857
R6994 VSS.n361 VSS.n357 0.0118857
R6995 VSS.n365 VSS.n363 0.0118857
R6996 VSS.n369 VSS.n367 0.0118857
R6997 VSS.n371 VSS.n370 0.0118857
R6998 VSS.n374 VSS.n372 0.0118857
R6999 VSS.n378 VSS.n376 0.0118857
R7000 VSS.n380 VSS.n379 0.0118857
R7001 VSS.n383 VSS.n381 0.0118857
R7002 VSS.n387 VSS.n384 0.0118857
R7003 VSS.n391 VSS.n388 0.0118857
R7004 VSS.n397 VSS.n395 0.0118857
R7005 VSS.n410 VSS.n395 0.0118857
R7006 VSS.n388 VSS.n387 0.0118857
R7007 VSS.n384 VSS.n383 0.0118857
R7008 VSS.n381 VSS.n380 0.0118857
R7009 VSS.n379 VSS.n378 0.0118857
R7010 VSS.n412 VSS.n376 0.0118857
R7011 VSS.n372 VSS.n371 0.0118857
R7012 VSS.n370 VSS.n369 0.0118857
R7013 VSS.n414 VSS.n367 0.0118857
R7014 VSS.n362 VSS.n361 0.0118857
R7015 VSS.n354 VSS.n353 0.0118857
R7016 VSS.n349 VSS.n348 0.0118857
R7017 VSS.n345 VSS.n344 0.0118857
R7018 VSS.n337 VSS.n336 0.0118857
R7019 VSS.n332 VSS.n331 0.0118857
R7020 VSS.n328 VSS.n327 0.0118857
R7021 VSS.n323 VSS.n322 0.0118857
R7022 VSS.n319 VSS.n318 0.0118857
R7023 VSS.n312 VSS.n311 0.0118857
R7024 VSS.n305 VSS.n304 0.0118857
R7025 VSS.n303 VSS.n302 0.0118857
R7026 VSS.n300 VSS.n299 0.0118857
R7027 VSS.n297 VSS.n296 0.0118857
R7028 VSS.n295 VSS.n294 0.0118857
R7029 VSS.n1323 VSS.n290 0.0118857
R7030 VSS.n1325 VSS.n1324 0.0118857
R7031 VSS.n1327 VSS.n1326 0.0118857
R7032 VSS.n1331 VSS.n1330 0.0118857
R7033 VSS.n1333 VSS.n1332 0.0118857
R7034 VSS.n1337 VSS.n1334 0.0118857
R7035 VSS.n1339 VSS.n1338 0.0118857
R7036 VSS.n1341 VSS.n1340 0.0118857
R7037 VSS.n1350 VSS.n1349 0.0118857
R7038 VSS.n1849 VSS.n1848 0.0118857
R7039 VSS.n1851 VSS.n1850 0.0118857
R7040 VSS.n1852 VSS.n260 0.0118857
R7041 VSS.n37 VSS.n36 0.0118857
R7042 VSS.n40 VSS.n39 0.0118857
R7043 VSS.n44 VSS.n43 0.0118857
R7044 VSS.n50 VSS.n49 0.0118857
R7045 VSS.n54 VSS.n53 0.0118857
R7046 VSS.n62 VSS.n61 0.0118857
R7047 VSS.n65 VSS.n64 0.0118857
R7048 VSS.n69 VSS.n68 0.0118857
R7049 VSS.n75 VSS.n74 0.0118857
R7050 VSS.n79 VSS.n78 0.0118857
R7051 VSS.n83 VSS.n82 0.0118857
R7052 VSS.n90 VSS.n89 0.0118857
R7053 VSS.n94 VSS.n93 0.0118857
R7054 VSS.n101 VSS.n99 0.0118857
R7055 VSS.n100 VSS.n11 0.0118857
R7056 VSS.n9 VSS.n8 0.0118857
R7057 VSS.n8 VSS.n7 0.0118857
R7058 VSS.n7 VSS.n6 0.0118857
R7059 VSS.n101 VSS.n100 0.0118857
R7060 VSS.n89 VSS.n83 0.0118857
R7061 VSS.n82 VSS.n79 0.0118857
R7062 VSS.n78 VSS.n75 0.0118857
R7063 VSS.n68 VSS.n65 0.0118857
R7064 VSS.n64 VSS.n62 0.0118857
R7065 VSS.n57 VSS.n54 0.0118857
R7066 VSS.n53 VSS.n50 0.0118857
R7067 VSS.n43 VSS.n40 0.0118857
R7068 VSS.n39 VSS.n37 0.0118857
R7069 VSS.n2079 VSS.n202 0.0118009
R7070 VSS.n1919 VSS.n25 0.0116691
R7071 VSS.n1814 VSS.n85 0.0116549
R7072 VSS.n1814 VSS.n84 0.0116549
R7073 VSS.n1799 VSS.n1791 0.0116549
R7074 VSS.n1803 VSS.n1791 0.0116549
R7075 VSS.n1754 VSS.n1747 0.0115582
R7076 VSS.n1450 VSS.n1442 0.0115582
R7077 VSS.n1756 VSS.n1754 0.0115582
R7078 VSS.n1451 VSS.n1450 0.0115582
R7079 VSS.n1788 VSS.n1787 0.0115582
R7080 VSS.n1787 VSS.n1729 0.0115582
R7081 VSS.n2082 VSS.n2081 0.0112967
R7082 VSS.n1925 VSS.n1920 0.0112967
R7083 VSS.n1739 VSS.n1736 0.0112672
R7084 VSS.n1432 VSS.n1416 0.0112672
R7085 VSS.n1813 VSS.n86 0.0110352
R7086 VSS.n1813 VSS.n85 0.0110352
R7087 VSS.n1812 VSS.n84 0.0110352
R7088 VSS.n1801 VSS.n1799 0.0110352
R7089 VSS.n1803 VSS.n1802 0.0110352
R7090 VSS.n1802 VSS.n1792 0.0110352
R7091 VSS.n1515 VSS.n199 0.0110217
R7092 VSS.n1517 VSS.n199 0.0110217
R7093 VSS.n1940 VSS.n1926 0.0110217
R7094 VSS.n1938 VSS.n1926 0.0110217
R7095 VSS.n408 VSS.n33 0.0108889
R7096 VSS.n178 VSS.n58 0.0108889
R7097 VSS.n178 VSS.n60 0.0108889
R7098 VSS.n144 VSS.n129 0.0108889
R7099 VSS.n144 VSS.n10 0.0108889
R7100 VSS.n1735 VSS.n1732 0.0108877
R7101 VSS.n1750 VSS.n1749 0.0108877
R7102 VSS.n1444 VSS.n1443 0.0108877
R7103 VSS.n1742 VSS.n1741 0.0108877
R7104 VSS.n1758 VSS.n1757 0.0108877
R7105 VSS.n1436 VSS.n1435 0.0108877
R7106 VSS.n1452 VSS.n1441 0.0108877
R7107 VSS.n1431 VSS.n1427 0.0108877
R7108 VSS.n1789 VSS.n1727 0.0108877
R7109 VSS.n1783 VSS.n1782 0.0108877
R7110 VSS.n1818 VSS.n1817 0.0105833
R7111 VSS.n2090 VSS.n3 0.0105833
R7112 VSS.n1739 VSS.n1731 0.0101032
R7113 VSS.n1745 VSS.n1739 0.0101032
R7114 VSS.n1433 VSS.n1432 0.0101032
R7115 VSS.n1432 VSS.n1426 0.0101032
R7116 VSS.n1754 VSS.n1753 0.00981217
R7117 VSS.n1450 VSS.n1447 0.00981217
R7118 VSS.n1761 VSS.n1754 0.00981217
R7119 VSS.n1450 VSS.n1448 0.00981217
R7120 VSS.n1787 VSS.n1728 0.00981217
R7121 VSS.n1787 VSS.n1786 0.00981217
R7122 VSS.n1931 VSS.n1929 0.00967235
R7123 VSS.n1409 VSS 0.00951389
R7124 VSS.n1604 VSS 0.00951389
R7125 VSS.n1629 VSS 0.00951389
R7126 VSS.n1359 VSS 0.00951389
R7127 VSS.n1838 VSS 0.00951389
R7128 VSS.n1717 VSS 0.00951389
R7129 VSS.n1825 VSS 0.00951389
R7130 VSS.n1822 VSS 0.00951389
R7131 VSS.n1405 VSS.n1029 0.00936111
R7132 VSS.n1634 VSS.n1019 0.00936111
R7133 VSS.n1401 VSS.n531 0.00936111
R7134 VSS.n1377 VSS.n618 0.00936111
R7135 VSS.n1374 VSS.n749 0.00936111
R7136 VSS.n1693 VSS.n816 0.00936111
R7137 VSS.n1479 VSS.n1295 0.00936111
R7138 VSS.n1455 VSS.n1176 0.00936111
R7139 VSS.n1412 VSS.n1081 0.00936111
R7140 VSS.n1625 VSS.n1069 0.00936111
R7141 VSS.n1846 VSS.n1845 0.00936111
R7142 VSS.n1354 VSS.n1344 0.00936111
R7143 VSS.n1708 VSS.n1707 0.00936111
R7144 VSS.n1722 VSS.n375 0.00936111
R7145 VSS.n1794 VSS.n92 0.00905556
R7146 VSS.n1398 VSS.n542 0.00813889
R7147 VSS.n1380 VSS.n607 0.00813889
R7148 VSS.n1371 VSS.n756 0.00813889
R7149 VSS.n1689 VSS.n824 0.00813889
R7150 VSS.n1476 VSS.n1280 0.00813889
R7151 VSS.n1458 VSS.n1191 0.00813889
R7152 VSS.n1713 VSS.n1712 0.00813889
R7153 VSS.n1719 VSS.n366 0.00813889
R7154 VSS.n1615 VSS.n1038 0.007375
R7155 VSS.n1643 VSS.n1004 0.007375
R7156 VSS.n1643 VSS.n519 0.007375
R7157 VSS.n1668 VSS.n629 0.007375
R7158 VSS.n1668 VSS.n742 0.007375
R7159 VSS.n1892 VSS.n258 0.007375
R7160 VSS.n1584 VSS.n1309 0.007375
R7161 VSS.n1615 VSS.n1054 0.007375
R7162 VSS.n1892 VSS.n1891 0.007375
R7163 VSS.n1612 VSS.n1045 0.00733367
R7164 VSS.n1622 VSS.n1621 0.00733367
R7165 VSS.n1640 VSS.n993 0.00733367
R7166 VSS.n1650 VSS.n1649 0.00733367
R7167 VSS.n1665 VSS.n631 0.00733367
R7168 VSS.n1675 VSS.n1674 0.00733367
R7169 VSS.n1865 VSS.n1860 0.00733367
R7170 VSS.n1895 VSS.n1894 0.00733367
R7171 VSS.n1580 VSS.n1320 0.00696446
R7172 VSS.n1591 VSS.n1590 0.00696446
R7173 VSS.n1395 VSS.n553 0.00691667
R7174 VSS.n1389 VSS.n574 0.00691667
R7175 VSS.n1383 VSS.n596 0.00691667
R7176 VSS.n1368 VSS.n763 0.00691667
R7177 VSS.n1362 VSS.n848 0.00691667
R7178 VSS.n1686 VSS.n832 0.00691667
R7179 VSS.n1473 VSS.n1265 0.00691667
R7180 VSS.n1467 VSS.n1236 0.00691667
R7181 VSS.n1461 VSS.n1206 0.00691667
R7182 VSS VSS.n1126 0.00676389
R7183 VSS VSS.n1837 0.00676389
R7184 VSS VSS.n47 0.00676389
R7185 VSS VSS.n72 0.00676389
R7186 VSS VSS.n97 0.00676389
R7187 VSS VSS.n2089 0.00676389
R7188 VSS.n1450 VSS.n1152 0.00630556
R7189 VSS.n1754 VSS.n1328 0.00630556
R7190 VSS.n1787 VSS.n392 0.00630556
R7191 VSS.n1031 VSS.n1030 0.00619286
R7192 VSS.n1026 VSS.n1025 0.00619286
R7193 VSS.n1408 VSS.n1021 0.00619286
R7194 VSS.n1020 VSS.n1019 0.00619286
R7195 VSS.n1005 VSS.n1004 0.00619286
R7196 VSS.n530 VSS.n529 0.00619286
R7197 VSS.n541 VSS.n540 0.00619286
R7198 VSS.n552 VSS.n551 0.00619286
R7199 VSS.n563 VSS.n562 0.00619286
R7200 VSS.n574 VSS.n573 0.00619286
R7201 VSS.n585 VSS.n584 0.00619286
R7202 VSS.n596 VSS.n595 0.00619286
R7203 VSS.n607 VSS.n606 0.00619286
R7204 VSS.n618 VSS.n617 0.00619286
R7205 VSS.n629 VSS.n628 0.00619286
R7206 VSS.n881 VSS.n880 0.00619286
R7207 VSS.n873 VSS.n872 0.00619286
R7208 VSS.n865 VSS.n864 0.00619286
R7209 VSS.n857 VSS.n856 0.00619286
R7210 VSS.n849 VSS.n848 0.00619286
R7211 VSS.n841 VSS.n840 0.00619286
R7212 VSS.n833 VSS.n832 0.00619286
R7213 VSS.n825 VSS.n824 0.00619286
R7214 VSS.n817 VSS.n816 0.00619286
R7215 VSS.n1692 VSS.n805 0.00619286
R7216 VSS.n822 VSS.n798 0.00619286
R7217 VSS.n830 VSS.n791 0.00619286
R7218 VSS.n838 VSS.n784 0.00619286
R7219 VSS.n846 VSS.n777 0.00619286
R7220 VSS.n854 VSS.n770 0.00619286
R7221 VSS.n862 VSS.n763 0.00619286
R7222 VSS.n870 VSS.n756 0.00619286
R7223 VSS.n878 VSS.n749 0.00619286
R7224 VSS.n886 VSS.n742 0.00619286
R7225 VSS.n621 VSS.n619 0.00619286
R7226 VSS.n610 VSS.n608 0.00619286
R7227 VSS.n599 VSS.n597 0.00619286
R7228 VSS.n588 VSS.n586 0.00619286
R7229 VSS.n577 VSS.n575 0.00619286
R7230 VSS.n566 VSS.n564 0.00619286
R7231 VSS.n555 VSS.n553 0.00619286
R7232 VSS.n544 VSS.n542 0.00619286
R7233 VSS.n533 VSS.n531 0.00619286
R7234 VSS.n522 VSS.n519 0.00619286
R7235 VSS.n1018 VSS.n1017 0.00619286
R7236 VSS.n1029 VSS.n1028 0.00619286
R7237 VSS.n1038 VSS.n1037 0.00619286
R7238 VSS.n1297 VSS.n1296 0.00619286
R7239 VSS.n1282 VSS.n1281 0.00619286
R7240 VSS.n1267 VSS.n1266 0.00619286
R7241 VSS.n1252 VSS.n1251 0.00619286
R7242 VSS.n1237 VSS.n1236 0.00619286
R7243 VSS.n1222 VSS.n1221 0.00619286
R7244 VSS.n1207 VSS.n1206 0.00619286
R7245 VSS.n1192 VSS.n1191 0.00619286
R7246 VSS.n1177 VSS.n1176 0.00619286
R7247 VSS.n1155 VSS.n1152 0.00619286
R7248 VSS.n1128 VSS.n1127 0.00619286
R7249 VSS.n1112 VSS.n1111 0.00619286
R7250 VSS.n1085 VSS.n1084 0.00619286
R7251 VSS.n1075 VSS.n1074 0.00619286
R7252 VSS.n1628 VSS.n1071 0.00619286
R7253 VSS.n1070 VSS.n1069 0.00619286
R7254 VSS.n1055 VSS.n1054 0.00619286
R7255 VSS.n1068 VSS.n1067 0.00619286
R7256 VSS.n1081 VSS.n1080 0.00619286
R7257 VSS.n1108 VSS.n1107 0.00619286
R7258 VSS.n1126 VSS.n1125 0.00619286
R7259 VSS.n1175 VSS.n1174 0.00619286
R7260 VSS.n1190 VSS.n1189 0.00619286
R7261 VSS.n1205 VSS.n1204 0.00619286
R7262 VSS.n1220 VSS.n1219 0.00619286
R7263 VSS.n1235 VSS.n1234 0.00619286
R7264 VSS.n1250 VSS.n1249 0.00619286
R7265 VSS.n1265 VSS.n1264 0.00619286
R7266 VSS.n1280 VSS.n1279 0.00619286
R7267 VSS.n1295 VSS.n1294 0.00619286
R7268 VSS.n1309 VSS.n1308 0.00619286
R7269 VSS.n814 VSS.n258 0.00619286
R7270 VSS.n1449 VSS.n1149 0.00619286
R7271 VSS.n1891 VSS.n1890 0.00619286
R7272 VSS.n1845 VSS.n1351 0.00619286
R7273 VSS.n1358 VSS.n1346 0.00619286
R7274 VSS.n1340 VSS.n276 0.00619286
R7275 VSS.n1326 VSS.n283 0.00619286
R7276 VSS.n1837 VSS.n298 0.00619286
R7277 VSS.n1738 VSS.n315 0.00619286
R7278 VSS.n1707 VSS.n340 0.00619286
R7279 VSS.n1712 VSS.n357 0.00619286
R7280 VSS.n1716 VSS.n363 0.00619286
R7281 VSS.n415 VSS.n414 0.00619286
R7282 VSS.n413 VSS.n412 0.00619286
R7283 VSS.n411 VSS.n410 0.00619286
R7284 VSS.n409 VSS.n397 0.00619286
R7285 VSS.n392 VSS.n391 0.00619286
R7286 VSS.n375 VSS.n374 0.00619286
R7287 VSS.n366 VSS.n365 0.00619286
R7288 VSS.n1329 VSS.n1328 0.00619286
R7289 VSS.n1345 VSS.n1344 0.00619286
R7290 VSS.n1715 VSS.n362 0.00619286
R7291 VSS.n1711 VSS.n354 0.00619286
R7292 VSS.n1706 VSS.n337 0.00619286
R7293 VSS.n1737 VSS.n312 0.00619286
R7294 VSS.n1836 VSS.n297 0.00619286
R7295 VSS.n1357 VSS.n1349 0.00619286
R7296 VSS.n1848 VSS.n1847 0.00619286
R7297 VSS.n58 VSS.n57 0.00619286
R7298 VSS.n129 VSS.n11 0.00619286
R7299 VSS.n6 VSS.n3 0.00619286
R7300 VSS.n10 VSS.n9 0.00619286
R7301 VSS.n99 VSS.n97 0.00619286
R7302 VSS.n93 VSS.n92 0.00619286
R7303 VSS.n74 VSS.n72 0.00619286
R7304 VSS.n61 VSS.n60 0.00619286
R7305 VSS.n49 VSS.n47 0.00619286
R7306 VSS.n36 VSS.n33 0.00619286
R7307 VSS.n1824 VSS.n44 0.00619286
R7308 VSS.n1821 VSS.n69 0.00619286
R7309 VSS.n1793 VSS.n90 0.00619286
R7310 VSS.n1817 VSS.n94 0.00619286
R7311 VSS.n1432 VSS.n1108 0.00615278
R7312 VSS.n1739 VSS.n1738 0.00615278
R7313 VSS.n1392 VSS.n563 0.00569444
R7314 VSS.n1392 VSS.n564 0.00569444
R7315 VSS.n1386 VSS.n585 0.00569444
R7316 VSS.n1386 VSS.n586 0.00569444
R7317 VSS.n1365 VSS.n856 0.00569444
R7318 VSS.n1365 VSS.n770 0.00569444
R7319 VSS.n1683 VSS.n840 0.00569444
R7320 VSS.n1683 VSS.n784 0.00569444
R7321 VSS.n1470 VSS.n1251 0.00569444
R7322 VSS.n1470 VSS.n1250 0.00569444
R7323 VSS.n1464 VSS.n1221 0.00569444
R7324 VSS.n1464 VSS.n1220 0.00569444
R7325 VSS.n2080 VSS.n201 0.00554065
R7326 VSS.n1919 VSS.n26 0.00554065
R7327 VSS.n1604 VSS.n1127 0.00538889
R7328 VSS.n1838 VSS.n1836 0.00538889
R7329 VSS.n1825 VSS.n1824 0.00538889
R7330 VSS.n1822 VSS.n1821 0.00538889
R7331 VSS.n2071 VSS.n2028 0.00531777
R7332 VSS.n1524 VSS.n1489 0.00531777
R7333 VSS.n1432 VSS.n1111 0.00523611
R7334 VSS.n1739 VSS.n1737 0.00523611
R7335 VSS VSS.n1716 0.00523611
R7336 VSS.n2071 VSS.n2029 0.00518055
R7337 VSS.n1523 VSS.n1489 0.00518055
R7338 VSS.n1450 VSS.n1449 0.00508333
R7339 VSS.n1754 VSS.n283 0.00508333
R7340 VSS.n1787 VSS.n411 0.00508333
R7341 VSS.n2071 VSS.n2068 0.00505688
R7342 VSS.n1571 VSS.n1489 0.00483734
R7343 VSS.n1868 VSS.n259 0.00474667
R7344 VSS.n1572 VSS.n1489 0.00464419
R7345 VSS.n1889 VSS.n509 0.00456101
R7346 VSS.n1889 VSS.n732 0.00456101
R7347 VSS.n1901 VSS.n247 0.00448719
R7348 VSS.n1395 VSS.n552 0.00447222
R7349 VSS.n1383 VSS.n597 0.00447222
R7350 VSS.n1368 VSS.n864 0.00447222
R7351 VSS.n1686 VSS.n791 0.00447222
R7352 VSS.n1473 VSS.n1266 0.00447222
R7353 VSS.n1461 VSS.n1205 0.00447222
R7354 VSS.n1611 VSS.n1043 0.00446794
R7355 VSS.n1611 VSS.n1044 0.00446794
R7356 VSS.n1617 VSS.n1614 0.00446794
R7357 VSS.n1618 VSS.n1614 0.00446794
R7358 VSS.n1639 VSS.n991 0.00446794
R7359 VSS.n1639 VSS.n992 0.00446794
R7360 VSS.n1645 VSS.n1642 0.00446794
R7361 VSS.n1646 VSS.n1642 0.00446794
R7362 VSS.n1664 VSS.n633 0.00446794
R7363 VSS.n1664 VSS.n632 0.00446794
R7364 VSS.n1670 VSS.n1667 0.00446794
R7365 VSS.n1671 VSS.n1667 0.00446794
R7366 VSS.n1863 VSS.n513 0.00446794
R7367 VSS.n1863 VSS.n510 0.00446794
R7368 VSS.n1897 VSS.n256 0.00446794
R7369 VSS.n1897 VSS.n254 0.00446794
R7370 VSS.n2071 VSS.n2070 0.00443581
R7371 VSS.n1889 VSS.n889 0.0044121
R7372 VSS.n1903 VSS.n247 0.00434143
R7373 VSS.n1389 VSS 0.00431944
R7374 VSS.n1362 VSS 0.00431944
R7375 VSS.n1467 VSS 0.00431944
R7376 VSS.n1818 VSS 0.00431944
R7377 VSS.n2090 VSS 0.00431944
R7378 VSS.n1578 VSS.n1318 0.00425355
R7379 VSS.n1578 VSS.n1319 0.00425355
R7380 VSS.n1588 VSS.n1586 0.00425355
R7381 VSS.n1588 VSS.n1587 0.00425355
R7382 VSS.n1609 VSS.n1043 0.00424749
R7383 VSS.n1610 VSS.n1044 0.00424749
R7384 VSS.n1610 VSS.n1045 0.00424749
R7385 VSS.n1621 VSS.n1620 0.00424749
R7386 VSS.n1620 VSS.n1617 0.00424749
R7387 VSS.n1619 VSS.n1618 0.00424749
R7388 VSS.n1637 VSS.n991 0.00424749
R7389 VSS.n1638 VSS.n992 0.00424749
R7390 VSS.n1638 VSS.n993 0.00424749
R7391 VSS.n1649 VSS.n1648 0.00424749
R7392 VSS.n1648 VSS.n1645 0.00424749
R7393 VSS.n1647 VSS.n1646 0.00424749
R7394 VSS.n1662 VSS.n633 0.00424749
R7395 VSS.n1663 VSS.n632 0.00424749
R7396 VSS.n1663 VSS.n631 0.00424749
R7397 VSS.n1674 VSS.n1673 0.00424749
R7398 VSS.n1673 VSS.n1670 0.00424749
R7399 VSS.n1672 VSS.n1671 0.00424749
R7400 VSS.n1861 VSS.n513 0.00424749
R7401 VSS.n1864 VSS.n510 0.00424749
R7402 VSS.n1865 VSS.n1864 0.00424749
R7403 VSS.n1894 VSS.n255 0.00424749
R7404 VSS.n256 VSS.n255 0.00424749
R7405 VSS.n1898 VSS.n254 0.00424749
R7406 VSS.n1577 VSS.n1318 0.00404502
R7407 VSS.n1482 VSS.n1319 0.00404502
R7408 VSS.n1482 VSS.n1320 0.00404502
R7409 VSS.n1590 VSS.n1589 0.00404502
R7410 VSS.n1589 VSS.n1586 0.00404502
R7411 VSS.n1587 VSS.n246 0.00404502
R7412 VSS VSS.n1408 0.00401389
R7413 VSS VSS.n1628 0.00401389
R7414 VSS VSS.n1358 0.00401389
R7415 VSS.n1717 VSS.n1715 0.00386111
R7416 VSS.n1781 VSS.n1780 0.00377694
R7417 VSS.n1577 VSS.n1576 0.00362796
R7418 VSS.n1912 VSS.n246 0.00362796
R7419 VSS.n2084 VSS.n2083 0.00342683
R7420 VSS.n2083 VSS.n108 0.00342683
R7421 VSS.n1924 VSS.n27 0.00342683
R7422 VSS.n1924 VSS.n28 0.00342683
R7423 VSS.n1911 VSS.n247 0.00332747
R7424 VSS.n2084 VSS.n198 0.00326423
R7425 VSS.n200 VSS.n108 0.00326423
R7426 VSS.n201 VSS.n200 0.00326423
R7427 VSS.n1921 VSS.n26 0.00326423
R7428 VSS.n1921 VSS.n27 0.00326423
R7429 VSS.n1923 VSS.n28 0.00326423
R7430 VSS.n1398 VSS.n541 0.00325
R7431 VSS.n1380 VSS.n608 0.00325
R7432 VSS.n1371 VSS.n872 0.00325
R7433 VSS.n1689 VSS.n798 0.00325
R7434 VSS.n1476 VSS.n1281 0.00325
R7435 VSS.n1458 VSS.n1190 0.00325
R7436 VSS.n1713 VSS.n1711 0.00325
R7437 VSS.n1719 VSS.n415 0.00325
R7438 VSS VSS.n575 0.00309722
R7439 VSS VSS.n777 0.00309722
R7440 VSS VSS.n1235 0.00309722
R7441 VSS.n1508 VSS.n198 0.00293902
R7442 VSS.n1923 VSS.n1922 0.00293902
R7443 VSS.n2089 VSS.n5 0.00279167
R7444 VSS.n1409 VSS.n1025 0.00263889
R7445 VSS.n1629 VSS.n1074 0.00263889
R7446 VSS.n1359 VSS.n1357 0.00263889
R7447 VSS.n1390 VSS.n1389 0.00243172
R7448 VSS.n1363 VSS.n1362 0.00243172
R7449 VSS.n1468 VSS.n1467 0.00243172
R7450 VSS.n1810 VSS.n1809 0.00235915
R7451 VSS.n1794 VSS.n1793 0.00233333
R7452 VSS.n1405 VSS.n1030 0.00202778
R7453 VSS.n1634 VSS.n1018 0.00202778
R7454 VSS.n1401 VSS.n530 0.00202778
R7455 VSS.n1377 VSS.n619 0.00202778
R7456 VSS.n1374 VSS.n880 0.00202778
R7457 VSS.n1693 VSS.n1692 0.00202778
R7458 VSS.n1479 VSS.n1296 0.00202778
R7459 VSS.n1455 VSS.n1175 0.00202778
R7460 VSS.n1412 VSS.n1084 0.00202778
R7461 VSS.n1625 VSS.n1068 0.00202778
R7462 VSS.n1847 VSS.n1846 0.00202778
R7463 VSS.n1354 VSS.n276 0.00202778
R7464 VSS.n1708 VSS.n1706 0.00202778
R7465 VSS.n1722 VSS.n413 0.00202778
R7466 VSS.n2078 VSS.n109 0.00185713
R7467 VSS.n1927 VSS.n215 0.00166667
R7468 VSS.n2078 VSS.n2077 0.00166667
R7469 VSS.n1546 VSS.n1545 0.00166667
R7470 VSS.n2063 VSS.n222 0.00166667
R7471 VSS.n2023 VSS.n228 0.00166667
R7472 VSS.n1883 VSS.n1855 0.00166667
R7473 VSS.n1888 VSS.n1887 0.00166667
R7474 VSS.n1771 VSS.n417 0.00166667
R7475 VSS.n1776 VSS.n1730 0.00166667
R7476 VSS.n132 VSS.n130 0.0015
R7477 VSS.n135 VSS.n130 0.0015
R7478 VSS.n132 VSS.n128 0.0015
R7479 VSS.n1489 VSS.n1485 0.00136828
R7480 VSS.n1489 VSS.n1488 0.00136828
R7481 VSS.n1489 VSS.n1484 0.00136828
R7482 VSS.n1489 VSS.n1483 0.00136828
R7483 VSS.n1776 VSS.n247 0.00133332
R7484 VSS.n1889 VSS.n417 0.00133332
R7485 VSS.n1545 VSS.n1498 0.00133332
R7486 VSS.n2077 VSS.n4 0.00133332
R7487 VSS.n2071 VSS.n215 0.00133332
R7488 VSS.n2071 VSS.n228 0.00133332
R7489 VSS.n2071 VSS.n222 0.00133332
R7490 VSS.n1889 VSS.n1888 0.00133332
R7491 VSS.n1879 VSS.n1855 0.00133332
R7492 VSS.n1867 VSS.n1860 0.00116132
R7493 VSS.n2085 VSS.n109 0.00114285
R7494 VSS.n2071 VSS.n224 0.00105915
R7495 VSS.n2071 VSS.n221 0.00103271
R7496 VSS.n2071 VSS.n227 0.00100347
R7497 VSS.n2071 VSS.n239 0.00100314
R7498 VSS.n2071 VSS.n240 0.00100314
R7499 VSS.n2071 VSS.n204 0.00100034
R7500 VSS.n2071 VSS.n234 0.00100034
R7501 VSS.n2071 VSS.n220 0.00100031
R7502 VSS.n1489 VSS.n1487 0.00100004
R7503 VSS.n2072 VSS.n216 0.001
R7504 VSS.n216 VSS.n205 0.001
R7505 VSS.n1947 VSS.n206 0.001
R7506 VSS.n1945 VSS.n207 0.001
R7507 VSS.n1943 VSS.n208 0.001
R7508 VSS.n1941 VSS.n209 0.001
R7509 VSS.n1939 VSS.n210 0.001
R7510 VSS.n1936 VSS.n211 0.001
R7511 VSS.n1934 VSS.n212 0.001
R7512 VSS.n1932 VSS.n213 0.001
R7513 VSS.n1930 VSS.n214 0.001
R7514 VSS.n1546 VSS.n1500 0.001
R7515 VSS.n1502 VSS.n1501 0.001
R7516 VSS.n1516 VSS.n1503 0.001
R7517 VSS.n1514 VSS.n1504 0.001
R7518 VSS.n1513 VSS.n1505 0.001
R7519 VSS.n1512 VSS.n1506 0.001
R7520 VSS.n1511 VSS.n1507 0.001
R7521 VSS.n1542 VSS.n1541 0.001
R7522 VSS.n1889 VSS.n511 0.001
R7523 VSS.n1866 VSS.n1859 0.001
R7524 VSS.n1778 VSS.n1730 0.001
R7525 VSS.n1767 VSS.n247 0.001
R7526 VSS.n118 VSS.n117 0.001
R7527 VSS.n131 VSS.n118 0.001
R7528 VSS.n136 VSS.n135 0.001
R7529 VSS.n128 VSS.n4 0.001
R7530 VSS.n1798 VSS.n157 0.001
R7531 VSS.n1805 VSS.n1798 0.001
R7532 VSS.n1804 VSS.n1796 0.001
R7533 VSS.n1808 VSS.n1807 0.001
R7534 VSS.n174 VSS.n170 0.001
R7535 VSS.n174 VSS.n172 0.001
R7536 VSS.n176 VSS.n173 0.001
R7537 VSS.n182 VSS.n181 0.001
R7538 VSS.n400 VSS.n195 0.001
R7539 VSS.n401 VSS.n400 0.001
R7540 VSS.n403 VSS.n402 0.001
R7541 VSS.n405 VSS.n404 0.001
R7542 VSS.n2071 VSS.n2066 0.001
R7543 VSS.n2034 VSS.n2033 0.001
R7544 VSS.n2052 VSS.n2035 0.001
R7545 VSS.n2050 VSS.n2036 0.001
R7546 VSS.n2049 VSS.n2037 0.001
R7547 VSS.n2048 VSS.n2038 0.001
R7548 VSS.n2047 VSS.n2039 0.001
R7549 VSS.n2046 VSS.n2040 0.001
R7550 VSS.n2045 VSS.n2041 0.001
R7551 VSS.n2044 VSS.n2042 0.001
R7552 VSS.n2064 VSS.n2043 0.001
R7553 VSS.n2026 VSS.n1993 0.001
R7554 VSS.n1994 VSS.n1993 0.001
R7555 VSS.n2012 VSS.n1995 0.001
R7556 VSS.n2010 VSS.n1996 0.001
R7557 VSS.n2009 VSS.n1997 0.001
R7558 VSS.n2008 VSS.n1998 0.001
R7559 VSS.n2007 VSS.n1999 0.001
R7560 VSS.n2006 VSS.n2000 0.001
R7561 VSS.n2005 VSS.n2001 0.001
R7562 VSS.n2004 VSS.n2002 0.001
R7563 VSS.n2024 VSS.n2003 0.001
R7564 VSS.n1986 VSS.n1953 0.001
R7565 VSS.n1954 VSS.n1953 0.001
R7566 VSS.n1972 VSS.n1955 0.001
R7567 VSS.n1970 VSS.n1956 0.001
R7568 VSS.n1969 VSS.n1957 0.001
R7569 VSS.n1968 VSS.n1958 0.001
R7570 VSS.n1967 VSS.n1959 0.001
R7571 VSS.n1966 VSS.n1960 0.001
R7572 VSS.n1965 VSS.n1961 0.001
R7573 VSS.n1964 VSS.n1962 0.001
R7574 VSS.n1984 VSS.n1963 0.001
R7575 VSS.n1983 VSS.n235 0.001
R7576 VSS.n2071 VSS.n1986 0.001
R7577 VSS.n2071 VSS.n2026 0.001
R7578 VSS.n2043 VSS.n2042 0.001
R7579 VSS.n2044 VSS.n2041 0.001
R7580 VSS.n2045 VSS.n2040 0.001
R7581 VSS.n2046 VSS.n2039 0.001
R7582 VSS.n2047 VSS.n2038 0.001
R7583 VSS.n2048 VSS.n2037 0.001
R7584 VSS.n2049 VSS.n2036 0.001
R7585 VSS.n2050 VSS.n2035 0.001
R7586 VSS.n2052 VSS.n2034 0.001
R7587 VSS.n2066 VSS.n2033 0.001
R7588 VSS.n2003 VSS.n2002 0.001
R7589 VSS.n2004 VSS.n2001 0.001
R7590 VSS.n2005 VSS.n2000 0.001
R7591 VSS.n2006 VSS.n1999 0.001
R7592 VSS.n2007 VSS.n1998 0.001
R7593 VSS.n2008 VSS.n1997 0.001
R7594 VSS.n2009 VSS.n1996 0.001
R7595 VSS.n2010 VSS.n1995 0.001
R7596 VSS.n2012 VSS.n1994 0.001
R7597 VSS.n1963 VSS.n1962 0.001
R7598 VSS.n1964 VSS.n1961 0.001
R7599 VSS.n1965 VSS.n1960 0.001
R7600 VSS.n1966 VSS.n1959 0.001
R7601 VSS.n1967 VSS.n1958 0.001
R7602 VSS.n1968 VSS.n1957 0.001
R7603 VSS.n1969 VSS.n1956 0.001
R7604 VSS.n1970 VSS.n1955 0.001
R7605 VSS.n1972 VSS.n1954 0.001
R7606 VSS.n1543 VSS.n1489 0.001
R7607 VSS.n2085 VSS.n195 0.001
R7608 VSS.n2085 VSS.n170 0.001
R7609 VSS.n2085 VSS.n157 0.001
R7610 VSS.n2085 VSS.n117 0.001
R7611 VSS.n136 VSS.n131 0.001
R7612 VSS.n176 VSS.n172 0.001
R7613 VSS.n181 VSS.n173 0.001
R7614 VSS.n182 VSS.n4 0.001
R7615 VSS.n402 VSS.n401 0.001
R7616 VSS.n405 VSS.n403 0.001
R7617 VSS.n404 VSS.n4 0.001
R7618 VSS.n1779 VSS.n1767 0.001
R7619 VSS.n1889 VSS.n940 0.001
R7620 VSS.n1423 VSS.n1420 0.001
R7621 VSS.n1424 VSS.n1419 0.001
R7622 VSS.n1889 VSS.n1116 0.001
R7623 VSS.n1420 VSS.n940 0.001
R7624 VSS.n1418 VSS.n1116 0.001
R7625 VSS.n1419 VSS.n1418 0.001
R7626 VSS.n1424 VSS.n1423 0.001
R7627 VSS.n1543 VSS.n1498 0.001
R7628 VSS.n1542 VSS.n1489 0.001
R7629 VSS.n1541 VSS.n1507 0.001
R7630 VSS.n1511 VSS.n1506 0.001
R7631 VSS.n1512 VSS.n1505 0.001
R7632 VSS.n1513 VSS.n1504 0.001
R7633 VSS.n1514 VSS.n1503 0.001
R7634 VSS.n1516 VSS.n1502 0.001
R7635 VSS.n1501 VSS.n1500 0.001
R7636 VSS.n2072 VSS.n2071 0.001
R7637 VSS.n1930 VSS.n213 0.001
R7638 VSS.n1932 VSS.n212 0.001
R7639 VSS.n1934 VSS.n211 0.001
R7640 VSS.n1936 VSS.n210 0.001
R7641 VSS.n1939 VSS.n209 0.001
R7642 VSS.n1941 VSS.n208 0.001
R7643 VSS.n1943 VSS.n207 0.001
R7644 VSS.n1945 VSS.n206 0.001
R7645 VSS.n1947 VSS.n205 0.001
R7646 VSS.n1927 VSS.n214 0.001
R7647 VSS.n1984 VSS.n1983 0.001
R7648 VSS.n2071 VSS.n235 0.001
R7649 VSS.n2024 VSS.n2023 0.001
R7650 VSS.n2064 VSS.n2063 0.001
R7651 VSS.n1879 VSS.n1859 0.001
R7652 VSS.n1866 VSS.n511 0.001
R7653 VSS.n1889 VSS.n815 0.001
R7654 VSS.n1872 VSS.n1870 0.001
R7655 VSS.n1875 VSS.n1869 0.001
R7656 VSS.n1883 VSS.n1854 0.001
R7657 VSS.n1887 VSS.n1854 0.001
R7658 VSS.n1879 VSS.n1869 0.001
R7659 VSS.n1875 VSS.n1870 0.001
R7660 VSS.n1872 VSS.n815 0.001
R7661 VSS.n1771 VSS.n1769 0.001
R7662 VSS.n1775 VSS.n1770 0.001
R7663 VSS.n1889 VSS.n396 0.001
R7664 VSS.n1774 VSS.n396 0.001
R7665 VSS.n1775 VSS.n1774 0.001
R7666 VSS.n1770 VSS.n1769 0.001
R7667 VSS.n1779 VSS.n1778 0.001
R7668 VSS.n1805 VSS.n1804 0.001
R7669 VSS.n1808 VSS.n1796 0.001
R7670 VSS.n1807 VSS.n4 0.001
R7671 VSS.n2080 VSS.n2079 0.000987805
R7672 VSS.n1539 VSS.n1510 0.000978261
R7673 VSS.n1950 VSS.n1918 0.000978261
R7674 a_25788_n4603.t0 a_25788_n4603.t1 30.6351
R7675 a_25290_n4603.t0 a_25290_n4603.t1 30.6351
R7676 iqmod_mfb_lpf_pex_half_1.iqmod_mfb_lpf_pex_R1_0.v_b iqmod_mfb_lpf_pex_half_1.iqmod_mfb_lpf_pex_R1_0.v_b.n1 0.0487581
R7677 iqmod_mfb_lpf_pex_half_1.iqmod_mfb_lpf_pex_R1_0.v_b iqmod_mfb_lpf_pex_half_1.iqmod_mfb_lpf_pex_R1_0.v_b.t0 17.2661
R7678 iqmod_mfb_lpf_pex_half_1.iqmod_mfb_lpf_pex_R1_0.v_b.n1 iqmod_mfb_lpf_pex_half_1.iqmod_mfb_lpf_pex_R1_0.v_b.n2 7.20381
R7679 iqmod_mfb_lpf_pex_half_1.iqmod_mfb_lpf_pex_R1_0.v_b.n1 iqmod_mfb_lpf_pex_half_1.iqmod_mfb_lpf_pex_R1_0.v_b 19.3729
R7680 iqmod_mfb_lpf_pex_half_1.iqmod_mfb_lpf_pex_R1_0.v_b.n3 iqmod_mfb_lpf_pex_half_1.iqmod_mfb_lpf_pex_R1_0.v_b 0.0188857
R7681 iqmod_mfb_lpf_pex_half_1.iqmod_mfb_lpf_pex_R1_0.v_b.n3 iqmod_mfb_lpf_pex_half_1.iqmod_mfb_lpf_pex_R1_0.v_b.t9 0.00628571
R7682 iqmod_mfb_lpf_pex_half_1.iqmod_mfb_lpf_pex_R1_0.v_b.t9 iqmod_mfb_lpf_pex_half_1.iqmod_mfb_lpf_pex_R1_0.v_b.t8 0.04226
R7683 iqmod_mfb_lpf_pex_half_1.iqmod_mfb_lpf_pex_R1_0.v_b.t8 iqmod_mfb_lpf_pex_half_1.iqmod_mfb_lpf_pex_R1_0.v_b.t7 0.04226
R7684 iqmod_mfb_lpf_pex_half_1.iqmod_mfb_lpf_pex_R1_0.v_b.t10 iqmod_mfb_lpf_pex_half_1.iqmod_mfb_lpf_pex_R1_0.v_b.n3 0.0364743
R7685 iqmod_mfb_lpf_pex_half_1.iqmod_mfb_lpf_pex_R1_0.v_b.t11 iqmod_mfb_lpf_pex_half_1.iqmod_mfb_lpf_pex_R1_0.v_b.t10 0.04226
R7686 iqmod_mfb_lpf_pex_half_1.iqmod_mfb_lpf_pex_R1_0.v_b.n2 iqmod_mfb_lpf_pex_half_1.iqmod_mfb_lpf_pex_R1_0.v_b.t1 0.0237913
R7687 iqmod_mfb_lpf_pex_half_1.iqmod_mfb_lpf_pex_R1_0.v_b.n2 iqmod_mfb_lpf_pex_half_1.iqmod_mfb_lpf_pex_R1_0.v_b.t3 0.109209
R7688 iqmod_mfb_lpf_pex_half_1.iqmod_mfb_lpf_pex_R1_0.v_b.t3 iqmod_mfb_lpf_pex_half_1.iqmod_mfb_lpf_pex_R1_0.v_b.t6 0.1325
R7689 iqmod_mfb_lpf_pex_half_1.iqmod_mfb_lpf_pex_R1_0.v_b.t1 iqmod_mfb_lpf_pex_half_1.iqmod_mfb_lpf_pex_R1_0.v_b.t4 0.1325
R7690 iqmod_mfb_lpf_pex_half_1.iqmod_mfb_lpf_pex_R1_0.v_b.t4 iqmod_mfb_lpf_pex_half_1.iqmod_mfb_lpf_pex_R1_0.v_b.t5 0.1325
R7691 iqmod_mfb_lpf_pex_half_1.iqmod_mfb_lpf_pex_R1_0.v_b iqmod_mfb_lpf_pex_half_1.iqmod_mfb_lpf_pex_R1_0.v_b.n0 0.0161129
R7692 iqmod_mfb_lpf_pex_half_1.iqmod_mfb_lpf_pex_R1_0.v_b.n1 iqmod_mfb_lpf_pex_half_1.iqmod_mfb_lpf_pex_R1_0.v_b.n0 0.064371
R7693 iqmod_mfb_lpf_pex_half_1.iqmod_mfb_lpf_pex_R1_0.v_b.n0 iqmod_mfb_lpf_pex_half_1.iqmod_mfb_lpf_pex_R1_0.v_b.t2 17.2505
R7694 a_37874_n4303.t0 a_37874_n4303.t1 30.6351
R7695 a_12906_n4603.t0 a_12906_n4603.t1 30.6351
R7696 a_13404_n4303.t0 a_13404_n4303.t1 30.6351
R7697 a_636_n4603.t0 a_636_n4603.t1 30.6351
R7698 iqmod_mfb_lpf_pex_half_1.iqmod_mfb_lpf_pex_R2_0.v_a.t1 iqmod_mfb_lpf_pex_half_1.iqmod_mfb_lpf_pex_R2_0.v_a.n4 17.2505
R7699 iqmod_mfb_lpf_pex_half_1.iqmod_mfb_lpf_pex_R2_0.v_a iqmod_mfb_lpf_pex_half_1.iqmod_mfb_lpf_pex_R2_0.v_a.n4 0.0161129
R7700 iqmod_mfb_lpf_pex_half_1.iqmod_mfb_lpf_pex_R2_0.v_a.n4 iqmod_mfb_lpf_pex_half_1.iqmod_mfb_lpf_pex_R2_0.v_a.n2 2.48792
R7701 iqmod_mfb_lpf_pex_half_1.iqmod_mfb_lpf_pex_R2_0.v_a.n2 iqmod_mfb_lpf_pex_half_1.iqmod_mfb_lpf_pex_R2_0.v_a.n3 7.38463
R7702 iqmod_mfb_lpf_pex_half_1.iqmod_mfb_lpf_pex_R2_0.v_a.n3 iqmod_mfb_lpf_pex_half_1.iqmod_mfb_lpf_pex_R2_0.v_a.t0 0.0237435
R7703 iqmod_mfb_lpf_pex_half_1.iqmod_mfb_lpf_pex_R2_0.v_a.n3 iqmod_mfb_lpf_pex_half_1.iqmod_mfb_lpf_pex_R2_0.v_a.t3 0.109257
R7704 iqmod_mfb_lpf_pex_half_1.iqmod_mfb_lpf_pex_R2_0.v_a.t0 iqmod_mfb_lpf_pex_half_1.iqmod_mfb_lpf_pex_R2_0.v_a.t2 0.1325
R7705 iqmod_mfb_lpf_pex_half_1.iqmod_mfb_lpf_pex_R2_0.v_a.n2 iqmod_mfb_lpf_pex_half_1.iqmod_mfb_lpf_pex_R2_0.v_a 6.07889
R7706 iqmod_mfb_lpf_pex_half_1.iqmod_mfb_lpf_pex_R2_0.v_a iqmod_mfb_lpf_pex_half_1.iqmod_mfb_lpf_pex_R2_0.v_a.n1 0.0161129
R7707 iqmod_mfb_lpf_pex_half_1.iqmod_mfb_lpf_pex_R2_0.v_a.n1 iqmod_mfb_lpf_pex_half_1.iqmod_mfb_lpf_pex_R2_0.v_a 0.319855
R7708 iqmod_mfb_lpf_pex_half_1.iqmod_mfb_lpf_pex_R2_0.v_a.t4 iqmod_mfb_lpf_pex_half_1.iqmod_mfb_lpf_pex_R2_0.v_a 17.2661
R7709 iqmod_mfb_lpf_pex_half_1.iqmod_mfb_lpf_pex_R2_0.v_a.t5 iqmod_mfb_lpf_pex_half_1.iqmod_mfb_lpf_pex_R2_0.v_a.n1 17.2505
R7710 iqmod_mfb_lpf_pex_half_1.iqmod_mfb_lpf_pex_R2_0.v_a.n0 iqmod_mfb_lpf_pex_half_1.iqmod_mfb_lpf_pex_R2_0.v_a 0.0188857
R7711 iqmod_mfb_lpf_pex_half_1.iqmod_mfb_lpf_pex_R2_0.v_a.n0 iqmod_mfb_lpf_pex_half_1.iqmod_mfb_lpf_pex_R2_0.v_a.t7 0.00628571
R7712 iqmod_mfb_lpf_pex_half_1.iqmod_mfb_lpf_pex_R2_0.v_a.t7 iqmod_mfb_lpf_pex_half_1.iqmod_mfb_lpf_pex_R2_0.v_a.t6 0.04226
R7713 iqmod_mfb_lpf_pex_half_1.iqmod_mfb_lpf_pex_R2_0.v_a.t8 iqmod_mfb_lpf_pex_half_1.iqmod_mfb_lpf_pex_R2_0.v_a.n0 0.0364743
R7714 a_6620_n4303.t0 a_6620_n4303.t1 30.6351
R7715 a_6122_n4303.t0 a_6122_n4303.t1 30.6351
R7716 iqmod_mfb_lpf_pex_half_1.iqmod_mfb_lpf_pex_ota_core_hybrid_bm_half_0.iqmod_mfb_lpf_pex_ota_core_inv_NF20$1_1.vin.t1 iqmod_mfb_lpf_pex_half_1.iqmod_mfb_lpf_pex_ota_core_hybrid_bm_half_0.iqmod_mfb_lpf_pex_ota_core_inv_NF20$1_1.vin.t0 30.5857
R7717 iqmod_mfb_lpf_pex_half_1.vinp.t6 iqmod_mfb_lpf_pex_half_1.vinp.n0 10.8541
R7718 iqmod_mfb_lpf_pex_half_1.iqmod_mfb_lpf_pex_ota_core_hybrid_bm_half_0.vinp iqmod_mfb_lpf_pex_half_1.iqmod_mfb_lpf_pex_ota_core_hybrid_bm_half_0.iqmod_mfb_lpf_pex_ota_core_spdt_switch$1_0.iqmod_mfb_lpf_pex_ota_core_spdt_switch_tg$2_1.v_a 5.2969
R7719 iqmod_mfb_lpf_pex_half_1.iqmod_mfb_lpf_pex_ota_core_hybrid_bm_half_0.iqmod_mfb_lpf_pex_ota_core_spdt_switch$1_0.iqmod_mfb_lpf_pex_ota_core_spdt_switch_tg$2_1.v_a iqmod_mfb_lpf_pex_half_1.vinp.n4 0.00974
R7720 iqmod_mfb_lpf_pex_half_1.vinp.n4 iqmod_mfb_lpf_pex_half_1.vinp.n3 0.09026
R7721 iqmod_mfb_lpf_pex_half_1.vinp.n3 iqmod_mfb_lpf_pex_half_1.vinp.n0 0.09026
R7722 iqmod_mfb_lpf_pex_half_1.vinp.n0 iqmod_mfb_lpf_pex_half_1.vinp.n2 0.09026
R7723 iqmod_mfb_lpf_pex_half_1.vinp.n4 iqmod_mfb_lpf_pex_half_1.vinp.t4 10.8535
R7724 iqmod_mfb_lpf_pex_half_1.vinp.n4 iqmod_mfb_lpf_pex_half_1.vinp.t0 3.59068
R7725 iqmod_mfb_lpf_pex_half_1.vinp.n3 iqmod_mfb_lpf_pex_half_1.vinp.t5 10.8541
R7726 iqmod_mfb_lpf_pex_half_1.vinp.n3 iqmod_mfb_lpf_pex_half_1.vinp.t1 3.59112
R7727 iqmod_mfb_lpf_pex_half_1.vinp.n2 iqmod_mfb_lpf_pex_half_1.vinp.t7 10.8541
R7728 iqmod_mfb_lpf_pex_half_1.vinp.n2 iqmod_mfb_lpf_pex_half_1.vinp.t3 3.59068
R7729 iqmod_mfb_lpf_pex_half_1.iqmod_mfb_lpf_pex_ota_core_hybrid_bm_half_0.iqmod_mfb_lpf_pex_ota_core_spdt_switch$1_0.v_a iqmod_mfb_lpf_pex_half_1.iqmod_mfb_lpf_pex_ota_core_hybrid_bm_half_0.vinp 0.0115
R7730 iqmod_mfb_lpf_pex_half_1.iqmod_mfb_lpf_pex_ota_core_hybrid_bm_half_0.iqmod_mfb_lpf_pex_ota_core_spdt_switch$1_0.v_a iqmod_mfb_lpf_pex_half_1.vinp.n1 14.3466
R7731 iqmod_mfb_lpf_pex_half_1.vinp.t9 iqmod_mfb_lpf_pex_half_1.vinp.n1 7.24781
R7732 iqmod_mfb_lpf_pex_half_1.vinp.n1 iqmod_mfb_lpf_pex_half_1.iqmod_mfb_lpf_pex_R3_0.v_b 1.2105
R7733 iqmod_mfb_lpf_pex_half_1.vinp.t8 iqmod_mfb_lpf_pex_half_1.iqmod_mfb_lpf_pex_R3_0.v_b 17.2661
R7734 iqmod_mfb_lpf_pex_half_1.vinp.n0 iqmod_mfb_lpf_pex_half_1.vinp.t2 3.59112
R7735 iqmod_mfb_lpf_pex_half_1.iqmod_mfb_lpf_pex_ota_core_hybrid_bm_half_0.iqmod_mfb_lpf_pex_ota_core_spdt_switch$1_0.iqmod_mfb_lpf_pex_ota_core_spdt_switch_inv$2_0.vout.t1 iqmod_mfb_lpf_pex_half_1.iqmod_mfb_lpf_pex_ota_core_hybrid_bm_half_0.iqmod_mfb_lpf_pex_ota_core_spdt_switch$1_0.iqmod_mfb_lpf_pex_ota_core_spdt_switch_inv$2_0.vout 14.9798
R7736 iqmod_mfb_lpf_pex_half_1.iqmod_mfb_lpf_pex_ota_core_hybrid_bm_half_0.iqmod_mfb_lpf_pex_ota_core_spdt_switch$1_0.iqmod_mfb_lpf_pex_ota_core_spdt_switch_inv$2_0.vout iqmod_mfb_lpf_pex_half_1.iqmod_mfb_lpf_pex_ota_core_hybrid_bm_half_0.iqmod_mfb_lpf_pex_ota_core_spdt_switch$1_0.iqmod_mfb_lpf_pex_ota_core_spdt_switch_inv$2_0.vout.n3 0.17034
R7737 iqmod_mfb_lpf_pex_half_1.iqmod_mfb_lpf_pex_ota_core_hybrid_bm_half_0.iqmod_mfb_lpf_pex_ota_core_spdt_switch$1_0.iqmod_mfb_lpf_pex_ota_core_spdt_switch_inv$2_0.vout iqmod_mfb_lpf_pex_half_1.iqmod_mfb_lpf_pex_ota_core_hybrid_bm_half_0.iqmod_mfb_lpf_pex_ota_core_spdt_switch$1_0.iqmod_mfb_lpf_pex_ota_core_spdt_switch_inv$2_0.vout.t0 3.25207
R7738 iqmod_mfb_lpf_pex_half_1.iqmod_mfb_lpf_pex_ota_core_hybrid_bm_half_0.iqmod_mfb_lpf_pex_ota_core_spdt_switch$1_0.iqmod_mfb_lpf_pex_ota_core_spdt_switch_inv$2_0.vout.n3 iqmod_mfb_lpf_pex_half_1.iqmod_mfb_lpf_pex_ota_core_hybrid_bm_half_0.iqmod_mfb_lpf_pex_ota_core_spdt_switch$1_0.iqmod_mfb_lpf_pex_ota_core_spdt_switch_inv$2_0.vout.n2 13.3461
R7739 iqmod_mfb_lpf_pex_half_1.iqmod_mfb_lpf_pex_ota_core_hybrid_bm_half_0.iqmod_mfb_lpf_pex_ota_core_spdt_switch$1_0.iqmod_mfb_lpf_pex_ota_core_spdt_switch_inv$2_0.vout iqmod_mfb_lpf_pex_half_1.iqmod_mfb_lpf_pex_ota_core_hybrid_bm_half_0.iqmod_mfb_lpf_pex_ota_core_spdt_switch$1_0.iqmod_mfb_lpf_pex_ota_core_spdt_switch_inv$2_0.vout.n2 0.0335
R7740 iqmod_mfb_lpf_pex_half_1.iqmod_mfb_lpf_pex_ota_core_hybrid_bm_half_0.iqmod_mfb_lpf_pex_ota_core_spdt_switch$1_0.iqmod_mfb_lpf_pex_ota_core_spdt_switch_inv$2_0.vout.n2 iqmod_mfb_lpf_pex_half_1.iqmod_mfb_lpf_pex_ota_core_hybrid_bm_half_0.iqmod_mfb_lpf_pex_ota_core_spdt_switch$1_0.iqmod_mfb_lpf_pex_ota_core_spdt_switch_inv$2_0.vout.t2 3.12406
R7741 iqmod_mfb_lpf_pex_half_1.iqmod_mfb_lpf_pex_ota_core_hybrid_bm_half_0.iqmod_mfb_lpf_pex_ota_core_spdt_switch$1_0.iqmod_mfb_lpf_pex_ota_core_spdt_switch_inv$2_0.vout.n3 iqmod_mfb_lpf_pex_half_1.iqmod_mfb_lpf_pex_ota_core_hybrid_bm_half_0.iqmod_mfb_lpf_pex_ota_core_spdt_switch$1_0.iqmod_mfb_lpf_pex_ota_core_spdt_switch_inv$2_0.vout.n0 3.2859
R7742 iqmod_mfb_lpf_pex_half_1.iqmod_mfb_lpf_pex_ota_core_hybrid_bm_half_0.iqmod_mfb_lpf_pex_ota_core_spdt_switch$1_0.iqmod_mfb_lpf_pex_ota_core_spdt_switch_inv$2_0.vout iqmod_mfb_lpf_pex_half_1.iqmod_mfb_lpf_pex_ota_core_hybrid_bm_half_0.iqmod_mfb_lpf_pex_ota_core_spdt_switch$1_0.iqmod_mfb_lpf_pex_ota_core_spdt_switch_inv$2_0.vout.n0 0.0335
R7743 iqmod_mfb_lpf_pex_half_1.iqmod_mfb_lpf_pex_ota_core_hybrid_bm_half_0.iqmod_mfb_lpf_pex_ota_core_spdt_switch$1_0.iqmod_mfb_lpf_pex_ota_core_spdt_switch_inv$2_0.vout.n1 iqmod_mfb_lpf_pex_half_1.iqmod_mfb_lpf_pex_ota_core_hybrid_bm_half_0.iqmod_mfb_lpf_pex_ota_core_spdt_switch$1_0.iqmod_mfb_lpf_pex_ota_core_spdt_switch_inv$2_0.vout.t4 0.00137204
R7744 iqmod_mfb_lpf_pex_half_1.iqmod_mfb_lpf_pex_ota_core_hybrid_bm_half_0.iqmod_mfb_lpf_pex_ota_core_spdt_switch$1_0.iqmod_mfb_lpf_pex_ota_core_spdt_switch_inv$2_0.vout.n0 iqmod_mfb_lpf_pex_half_1.iqmod_mfb_lpf_pex_ota_core_hybrid_bm_half_0.iqmod_mfb_lpf_pex_ota_core_spdt_switch$1_0.iqmod_mfb_lpf_pex_ota_core_spdt_switch_inv$2_0.vout.n1 3.12245
R7745 iqmod_mfb_lpf_pex_half_1.iqmod_mfb_lpf_pex_ota_core_hybrid_bm_half_0.iqmod_mfb_lpf_pex_ota_core_spdt_switch$1_0.iqmod_mfb_lpf_pex_ota_core_spdt_switch_inv$2_0.vout.n1 iqmod_mfb_lpf_pex_half_1.iqmod_mfb_lpf_pex_ota_core_hybrid_bm_half_0.iqmod_mfb_lpf_pex_ota_core_spdt_switch$1_0.iqmod_mfb_lpf_pex_ota_core_spdt_switch_inv$2_0.vout.t3 0.00262788
R7746 iqmod_mfb_lpf_pex_half_1.iqmod_mfb_lpf_pex_ota_core_hybrid_bm_half_0.iqmod_mfb_lpf_pex_ota_core_tg$1_0.di_tg_ctrl_n.t0 iqmod_mfb_lpf_pex_half_1.iqmod_mfb_lpf_pex_ota_core_hybrid_bm_half_0.iqmod_mfb_lpf_pex_ota_core_tg$1_0.di_tg_ctrl_n 14.9798
R7747 iqmod_mfb_lpf_pex_half_1.iqmod_mfb_lpf_pex_ota_core_hybrid_bm_half_0.iqmod_mfb_lpf_pex_ota_core_tg$1_0.di_tg_ctrl_n iqmod_mfb_lpf_pex_half_1.iqmod_mfb_lpf_pex_ota_core_hybrid_bm_half_0.iqmod_mfb_lpf_pex_ota_core_tg$1_0.di_tg_ctrl_n.n8 0.17914
R7748 iqmod_mfb_lpf_pex_half_1.iqmod_mfb_lpf_pex_ota_core_hybrid_bm_half_0.iqmod_mfb_lpf_pex_ota_core_tg$1_0.di_tg_ctrl_n iqmod_mfb_lpf_pex_half_1.iqmod_mfb_lpf_pex_ota_core_hybrid_bm_half_0.iqmod_mfb_lpf_pex_ota_core_tg$1_0.di_tg_ctrl_n.t1 3.25207
R7749 iqmod_mfb_lpf_pex_half_1.iqmod_mfb_lpf_pex_ota_core_hybrid_bm_half_0.iqmod_mfb_lpf_pex_ota_core_tg$1_0.di_tg_ctrl_n.n8 iqmod_mfb_lpf_pex_half_1.iqmod_mfb_lpf_pex_ota_core_hybrid_bm_half_0.iqmod_mfb_lpf_pex_ota_core_tg$1_0.di_tg_ctrl_n.n1 12.8885
R7750 iqmod_mfb_lpf_pex_half_1.iqmod_mfb_lpf_pex_ota_core_hybrid_bm_half_0.iqmod_mfb_lpf_pex_ota_core_tg$1_0.di_tg_ctrl_n.n8 iqmod_mfb_lpf_pex_half_1.iqmod_mfb_lpf_pex_ota_core_hybrid_bm_half_0.iqmod_mfb_lpf_pex_ota_core_tg$1_0.di_tg_ctrl_n.n3 1.5493
R7751 iqmod_mfb_lpf_pex_half_1.iqmod_mfb_lpf_pex_ota_core_hybrid_bm_half_0.iqmod_mfb_lpf_pex_ota_core_tg$1_0.di_tg_ctrl_n.n3 iqmod_mfb_lpf_pex_half_1.iqmod_mfb_lpf_pex_ota_core_hybrid_bm_half_0.iqmod_mfb_lpf_pex_ota_core_tg$1_0.di_tg_ctrl_n.n7 5.6795
R7752 iqmod_mfb_lpf_pex_half_1.iqmod_mfb_lpf_pex_ota_core_hybrid_bm_half_0.iqmod_mfb_lpf_pex_ota_core_tg$1_0.di_tg_ctrl_n iqmod_mfb_lpf_pex_half_1.iqmod_mfb_lpf_pex_ota_core_hybrid_bm_half_0.iqmod_mfb_lpf_pex_ota_core_tg$1_0.di_tg_ctrl_n.n7 0.0335
R7753 iqmod_mfb_lpf_pex_half_1.iqmod_mfb_lpf_pex_ota_core_hybrid_bm_half_0.iqmod_mfb_lpf_pex_ota_core_tg$1_0.di_tg_ctrl_n.n7 iqmod_mfb_lpf_pex_half_1.iqmod_mfb_lpf_pex_ota_core_hybrid_bm_half_0.iqmod_mfb_lpf_pex_ota_core_tg$1_0.di_tg_ctrl_n.t4 3.12406
R7754 iqmod_mfb_lpf_pex_half_1.iqmod_mfb_lpf_pex_ota_core_hybrid_bm_half_0.iqmod_mfb_lpf_pex_ota_core_tg$1_0.di_tg_ctrl_n.n5 iqmod_mfb_lpf_pex_half_1.iqmod_mfb_lpf_pex_ota_core_hybrid_bm_half_0.iqmod_mfb_lpf_pex_ota_core_tg$1_0.di_tg_ctrl_n.n4 1.1255
R7755 iqmod_mfb_lpf_pex_half_1.iqmod_mfb_lpf_pex_ota_core_hybrid_bm_half_0.iqmod_mfb_lpf_pex_ota_core_tg$1_0.di_tg_ctrl_n.n3 iqmod_mfb_lpf_pex_half_1.iqmod_mfb_lpf_pex_ota_core_hybrid_bm_half_0.iqmod_mfb_lpf_pex_ota_core_tg$1_0.di_tg_ctrl_n.n5 26.9504
R7756 iqmod_mfb_lpf_pex_half_1.iqmod_mfb_lpf_pex_ota_core_hybrid_bm_half_0.iqmod_mfb_lpf_pex_ota_core_tg$1_0.di_tg_ctrl_n.n5 iqmod_mfb_lpf_pex_half_1.iqmod_mfb_lpf_pex_ota_core_hybrid_bm_half_0.iqmod_mfb_lpf_pex_ota_core_tg$1_0.di_tg_ctrl_n.n6 49.0109
R7757 iqmod_mfb_lpf_pex_half_1.iqmod_mfb_lpf_pex_ota_core_hybrid_bm_half_0.iqmod_mfb_lpf_pex_ota_core_tg$1_0.di_tg_ctrl_n iqmod_mfb_lpf_pex_half_1.iqmod_mfb_lpf_pex_ota_core_hybrid_bm_half_0.iqmod_mfb_lpf_pex_ota_core_tg$1_0.di_tg_ctrl_n.n6 0.0335
R7758 iqmod_mfb_lpf_pex_half_1.iqmod_mfb_lpf_pex_ota_core_hybrid_bm_half_0.iqmod_mfb_lpf_pex_ota_core_tg$1_0.di_tg_ctrl_n.n6 iqmod_mfb_lpf_pex_half_1.iqmod_mfb_lpf_pex_ota_core_hybrid_bm_half_0.iqmod_mfb_lpf_pex_ota_core_tg$1_0.di_tg_ctrl_n.t2 3.12406
R7759 iqmod_mfb_lpf_pex_half_1.iqmod_mfb_lpf_pex_ota_core_hybrid_bm_half_0.iqmod_mfb_lpf_pex_ota_core_tg$1_0.di_tg_ctrl_n iqmod_mfb_lpf_pex_half_1.iqmod_mfb_lpf_pex_ota_core_hybrid_bm_half_0.iqmod_mfb_lpf_pex_ota_core_tg$1_0.di_tg_ctrl_n.n4 0.0335
R7760 iqmod_mfb_lpf_pex_half_1.iqmod_mfb_lpf_pex_ota_core_hybrid_bm_half_0.iqmod_mfb_lpf_pex_ota_core_tg$1_0.di_tg_ctrl_n.n4 iqmod_mfb_lpf_pex_half_1.iqmod_mfb_lpf_pex_ota_core_hybrid_bm_half_0.iqmod_mfb_lpf_pex_ota_core_tg$1_0.di_tg_ctrl_n.t3 3.12406
R7761 iqmod_mfb_lpf_pex_half_1.iqmod_mfb_lpf_pex_ota_core_hybrid_bm_half_0.iqmod_mfb_lpf_pex_ota_core_tg$1_0.di_tg_ctrl_n iqmod_mfb_lpf_pex_half_1.iqmod_mfb_lpf_pex_ota_core_hybrid_bm_half_0.iqmod_mfb_lpf_pex_ota_core_tg$1_0.di_tg_ctrl_n.n1 0.0335
R7762 iqmod_mfb_lpf_pex_half_1.iqmod_mfb_lpf_pex_ota_core_hybrid_bm_half_0.iqmod_mfb_lpf_pex_ota_core_tg$1_0.di_tg_ctrl_n.n2 iqmod_mfb_lpf_pex_half_1.iqmod_mfb_lpf_pex_ota_core_hybrid_bm_half_0.iqmod_mfb_lpf_pex_ota_core_tg$1_0.di_tg_ctrl_n.t7 0.00137204
R7763 iqmod_mfb_lpf_pex_half_1.iqmod_mfb_lpf_pex_ota_core_hybrid_bm_half_0.iqmod_mfb_lpf_pex_ota_core_tg$1_0.di_tg_ctrl_n.n1 iqmod_mfb_lpf_pex_half_1.iqmod_mfb_lpf_pex_ota_core_hybrid_bm_half_0.iqmod_mfb_lpf_pex_ota_core_tg$1_0.di_tg_ctrl_n.n2 3.12245
R7764 iqmod_mfb_lpf_pex_half_1.iqmod_mfb_lpf_pex_ota_core_hybrid_bm_half_0.iqmod_mfb_lpf_pex_ota_core_tg$1_0.di_tg_ctrl_n.n2 iqmod_mfb_lpf_pex_half_1.iqmod_mfb_lpf_pex_ota_core_hybrid_bm_half_0.iqmod_mfb_lpf_pex_ota_core_tg$1_0.di_tg_ctrl_n.t6 0.00262788
R7765 iqmod_mfb_lpf_pex_half_1.iqmod_mfb_lpf_pex_ota_core_hybrid_bm_half_0.iqmod_mfb_lpf_pex_ota_core_tg$1_0.di_tg_ctrl_n.n8 iqmod_mfb_lpf_pex_half_1.iqmod_mfb_lpf_pex_ota_core_hybrid_bm_half_0.iqmod_mfb_lpf_pex_ota_core_tg$1_0.di_tg_ctrl_n 4.55638
R7766 iqmod_mfb_lpf_pex_half_1.iqmod_mfb_lpf_pex_ota_core_hybrid_bm_half_0.iqmod_mfb_lpf_pex_ota_core_tg$1_0.di_tg_ctrl_n iqmod_mfb_lpf_pex_half_1.iqmod_mfb_lpf_pex_ota_core_hybrid_bm_half_0.iqmod_mfb_lpf_pex_ota_core_tg$1_0.di_tg_ctrl_n.n0 0.03174
R7767 iqmod_mfb_lpf_pex_half_1.iqmod_mfb_lpf_pex_ota_core_hybrid_bm_half_0.iqmod_mfb_lpf_pex_ota_core_tg$1_0.di_tg_ctrl_n.t8 iqmod_mfb_lpf_pex_half_1.iqmod_mfb_lpf_pex_ota_core_hybrid_bm_half_0.iqmod_mfb_lpf_pex_ota_core_tg$1_0.di_tg_ctrl_n.n0 12.3425
R7768 iqmod_mfb_lpf_pex_half_1.iqmod_mfb_lpf_pex_ota_core_hybrid_bm_half_0.iqmod_mfb_lpf_pex_ota_core_tg$1_0.di_tg_ctrl_n.t5 iqmod_mfb_lpf_pex_half_1.iqmod_mfb_lpf_pex_ota_core_hybrid_bm_half_0.iqmod_mfb_lpf_pex_ota_core_tg$1_0.di_tg_ctrl_n.n0 12.3425
R7769 iqmod_mfb_lpf_pex_half_1.iqmod_mfb_lpf_pex_ota_core_hybrid_bm_half_0.iqmod_mfb_lpf_pex_ota_core_inv_NF20$1_0.vout.t21 iqmod_mfb_lpf_pex_half_1.iqmod_mfb_lpf_pex_ota_core_hybrid_bm_half_0.iqmod_mfb_lpf_pex_ota_core_inv_NF20$1_0.vout.n0 10.2939
R7770 iqmod_mfb_lpf_pex_half_1.iqmod_mfb_lpf_pex_ota_core_hybrid_bm_half_0.iqmod_mfb_lpf_pex_ota_core_inv_NF20$1_0.vout.n50 iqmod_mfb_lpf_pex_half_1.iqmod_mfb_lpf_pex_ota_core_hybrid_bm_half_0.iqmod_mfb_lpf_pex_ota_core_inv_NF20$1_0.vout.n51 0.16242
R7771 iqmod_mfb_lpf_pex_half_1.iqmod_mfb_lpf_pex_ota_core_hybrid_bm_half_0.iqmod_mfb_lpf_pex_ota_core_inv_NF20$1_0.vout.n49 iqmod_mfb_lpf_pex_half_1.iqmod_mfb_lpf_pex_ota_core_hybrid_bm_half_0.iqmod_mfb_lpf_pex_ota_core_inv_NF20$1_0.vout.n50 0.16242
R7772 iqmod_mfb_lpf_pex_half_1.iqmod_mfb_lpf_pex_ota_core_hybrid_bm_half_0.iqmod_mfb_lpf_pex_ota_core_inv_NF20$1_0.vout.n48 iqmod_mfb_lpf_pex_half_1.iqmod_mfb_lpf_pex_ota_core_hybrid_bm_half_0.iqmod_mfb_lpf_pex_ota_core_inv_NF20$1_0.vout.n49 0.16242
R7773 iqmod_mfb_lpf_pex_half_1.iqmod_mfb_lpf_pex_ota_core_hybrid_bm_half_0.iqmod_mfb_lpf_pex_ota_core_inv_NF20$1_0.vout.n47 iqmod_mfb_lpf_pex_half_1.iqmod_mfb_lpf_pex_ota_core_hybrid_bm_half_0.iqmod_mfb_lpf_pex_ota_core_inv_NF20$1_0.vout.n48 0.16242
R7774 iqmod_mfb_lpf_pex_half_1.iqmod_mfb_lpf_pex_ota_core_hybrid_bm_half_0.iqmod_mfb_lpf_pex_ota_core_inv_NF20$1_0.vout.n46 iqmod_mfb_lpf_pex_half_1.iqmod_mfb_lpf_pex_ota_core_hybrid_bm_half_0.iqmod_mfb_lpf_pex_ota_core_inv_NF20$1_0.vout.n47 0.16242
R7775 iqmod_mfb_lpf_pex_half_1.iqmod_mfb_lpf_pex_ota_core_hybrid_bm_half_0.iqmod_mfb_lpf_pex_ota_core_inv_NF20$1_0.vout.n45 iqmod_mfb_lpf_pex_half_1.iqmod_mfb_lpf_pex_ota_core_hybrid_bm_half_0.iqmod_mfb_lpf_pex_ota_core_inv_NF20$1_0.vout.n46 0.16242
R7776 iqmod_mfb_lpf_pex_half_1.iqmod_mfb_lpf_pex_ota_core_hybrid_bm_half_0.iqmod_mfb_lpf_pex_ota_core_inv_NF20$1_0.vout.n44 iqmod_mfb_lpf_pex_half_1.iqmod_mfb_lpf_pex_ota_core_hybrid_bm_half_0.iqmod_mfb_lpf_pex_ota_core_inv_NF20$1_0.vout.n45 0.16242
R7777 iqmod_mfb_lpf_pex_half_1.iqmod_mfb_lpf_pex_ota_core_hybrid_bm_half_0.iqmod_mfb_lpf_pex_ota_core_inv_NF20$1_0.vout.n43 iqmod_mfb_lpf_pex_half_1.iqmod_mfb_lpf_pex_ota_core_hybrid_bm_half_0.iqmod_mfb_lpf_pex_ota_core_inv_NF20$1_0.vout.n44 0.16242
R7778 iqmod_mfb_lpf_pex_half_1.iqmod_mfb_lpf_pex_ota_core_hybrid_bm_half_0.iqmod_mfb_lpf_pex_ota_core_inv_NF20$1_0.vout.n0 iqmod_mfb_lpf_pex_half_1.iqmod_mfb_lpf_pex_ota_core_hybrid_bm_half_0.iqmod_mfb_lpf_pex_ota_core_inv_NF20$1_0.vout.n43 0.16242
R7779 iqmod_mfb_lpf_pex_half_1.iqmod_mfb_lpf_pex_ota_core_hybrid_bm_half_0.iqmod_mfb_lpf_pex_ota_core_inv_NF20$1_0.vout iqmod_mfb_lpf_pex_half_1.iqmod_mfb_lpf_pex_ota_core_hybrid_bm_half_0.iqmod_mfb_lpf_pex_ota_core_inv_NF20$1_0.vout.n0 0.0151667
R7780 iqmod_mfb_lpf_pex_half_1.iqmod_mfb_lpf_pex_ota_core_hybrid_bm_half_0.iqmod_mfb_lpf_pex_ota_core_inv_NF20$1_0.vout.n51 iqmod_mfb_lpf_pex_half_1.iqmod_mfb_lpf_pex_ota_core_hybrid_bm_half_0.iqmod_mfb_lpf_pex_ota_core_inv_NF20$1_0.vout.t22 2.0693
R7781 iqmod_mfb_lpf_pex_half_1.iqmod_mfb_lpf_pex_ota_core_hybrid_bm_half_0.iqmod_mfb_lpf_pex_ota_core_inv_NF20$1_0.vout.n51 iqmod_mfb_lpf_pex_half_1.iqmod_mfb_lpf_pex_ota_core_hybrid_bm_half_0.iqmod_mfb_lpf_pex_ota_core_inv_NF20$1_0.vout.t12 10.2939
R7782 iqmod_mfb_lpf_pex_half_1.iqmod_mfb_lpf_pex_ota_core_hybrid_bm_half_0.iqmod_mfb_lpf_pex_ota_core_inv_NF20$1_0.vout.n50 iqmod_mfb_lpf_pex_half_1.iqmod_mfb_lpf_pex_ota_core_hybrid_bm_half_0.iqmod_mfb_lpf_pex_ota_core_inv_NF20$1_0.vout.t23 2.0693
R7783 iqmod_mfb_lpf_pex_half_1.iqmod_mfb_lpf_pex_ota_core_hybrid_bm_half_0.iqmod_mfb_lpf_pex_ota_core_inv_NF20$1_0.vout.n50 iqmod_mfb_lpf_pex_half_1.iqmod_mfb_lpf_pex_ota_core_hybrid_bm_half_0.iqmod_mfb_lpf_pex_ota_core_inv_NF20$1_0.vout.t13 10.2939
R7784 iqmod_mfb_lpf_pex_half_1.iqmod_mfb_lpf_pex_ota_core_hybrid_bm_half_0.iqmod_mfb_lpf_pex_ota_core_inv_NF20$1_0.vout.n49 iqmod_mfb_lpf_pex_half_1.iqmod_mfb_lpf_pex_ota_core_hybrid_bm_half_0.iqmod_mfb_lpf_pex_ota_core_inv_NF20$1_0.vout.t24 2.0693
R7785 iqmod_mfb_lpf_pex_half_1.iqmod_mfb_lpf_pex_ota_core_hybrid_bm_half_0.iqmod_mfb_lpf_pex_ota_core_inv_NF20$1_0.vout.n49 iqmod_mfb_lpf_pex_half_1.iqmod_mfb_lpf_pex_ota_core_hybrid_bm_half_0.iqmod_mfb_lpf_pex_ota_core_inv_NF20$1_0.vout.t14 10.2939
R7786 iqmod_mfb_lpf_pex_half_1.iqmod_mfb_lpf_pex_ota_core_hybrid_bm_half_0.iqmod_mfb_lpf_pex_ota_core_inv_NF20$1_0.vout.n48 iqmod_mfb_lpf_pex_half_1.iqmod_mfb_lpf_pex_ota_core_hybrid_bm_half_0.iqmod_mfb_lpf_pex_ota_core_inv_NF20$1_0.vout.t25 2.0693
R7787 iqmod_mfb_lpf_pex_half_1.iqmod_mfb_lpf_pex_ota_core_hybrid_bm_half_0.iqmod_mfb_lpf_pex_ota_core_inv_NF20$1_0.vout.n48 iqmod_mfb_lpf_pex_half_1.iqmod_mfb_lpf_pex_ota_core_hybrid_bm_half_0.iqmod_mfb_lpf_pex_ota_core_inv_NF20$1_0.vout.t15 10.2939
R7788 iqmod_mfb_lpf_pex_half_1.iqmod_mfb_lpf_pex_ota_core_hybrid_bm_half_0.iqmod_mfb_lpf_pex_ota_core_inv_NF20$1_0.vout.n47 iqmod_mfb_lpf_pex_half_1.iqmod_mfb_lpf_pex_ota_core_hybrid_bm_half_0.iqmod_mfb_lpf_pex_ota_core_inv_NF20$1_0.vout.t26 2.0693
R7789 iqmod_mfb_lpf_pex_half_1.iqmod_mfb_lpf_pex_ota_core_hybrid_bm_half_0.iqmod_mfb_lpf_pex_ota_core_inv_NF20$1_0.vout.n47 iqmod_mfb_lpf_pex_half_1.iqmod_mfb_lpf_pex_ota_core_hybrid_bm_half_0.iqmod_mfb_lpf_pex_ota_core_inv_NF20$1_0.vout.t16 10.2939
R7790 iqmod_mfb_lpf_pex_half_1.iqmod_mfb_lpf_pex_ota_core_hybrid_bm_half_0.iqmod_mfb_lpf_pex_ota_core_inv_NF20$1_0.vout.n46 iqmod_mfb_lpf_pex_half_1.iqmod_mfb_lpf_pex_ota_core_hybrid_bm_half_0.iqmod_mfb_lpf_pex_ota_core_inv_NF20$1_0.vout.t27 2.0884
R7791 iqmod_mfb_lpf_pex_half_1.iqmod_mfb_lpf_pex_ota_core_hybrid_bm_half_0.iqmod_mfb_lpf_pex_ota_core_inv_NF20$1_0.vout.n46 iqmod_mfb_lpf_pex_half_1.iqmod_mfb_lpf_pex_ota_core_hybrid_bm_half_0.iqmod_mfb_lpf_pex_ota_core_inv_NF20$1_0.vout.t17 10.2939
R7792 iqmod_mfb_lpf_pex_half_1.iqmod_mfb_lpf_pex_ota_core_hybrid_bm_half_0.iqmod_mfb_lpf_pex_ota_core_inv_NF20$1_0.vout.n45 iqmod_mfb_lpf_pex_half_1.iqmod_mfb_lpf_pex_ota_core_hybrid_bm_half_0.iqmod_mfb_lpf_pex_ota_core_inv_NF20$1_0.vout.t28 2.0884
R7793 iqmod_mfb_lpf_pex_half_1.iqmod_mfb_lpf_pex_ota_core_hybrid_bm_half_0.iqmod_mfb_lpf_pex_ota_core_inv_NF20$1_0.vout.n45 iqmod_mfb_lpf_pex_half_1.iqmod_mfb_lpf_pex_ota_core_hybrid_bm_half_0.iqmod_mfb_lpf_pex_ota_core_inv_NF20$1_0.vout.t18 10.2939
R7794 iqmod_mfb_lpf_pex_half_1.iqmod_mfb_lpf_pex_ota_core_hybrid_bm_half_0.iqmod_mfb_lpf_pex_ota_core_inv_NF20$1_0.vout.n44 iqmod_mfb_lpf_pex_half_1.iqmod_mfb_lpf_pex_ota_core_hybrid_bm_half_0.iqmod_mfb_lpf_pex_ota_core_inv_NF20$1_0.vout.t29 2.0884
R7795 iqmod_mfb_lpf_pex_half_1.iqmod_mfb_lpf_pex_ota_core_hybrid_bm_half_0.iqmod_mfb_lpf_pex_ota_core_inv_NF20$1_0.vout.n44 iqmod_mfb_lpf_pex_half_1.iqmod_mfb_lpf_pex_ota_core_hybrid_bm_half_0.iqmod_mfb_lpf_pex_ota_core_inv_NF20$1_0.vout.t19 10.2939
R7796 iqmod_mfb_lpf_pex_half_1.iqmod_mfb_lpf_pex_ota_core_hybrid_bm_half_0.iqmod_mfb_lpf_pex_ota_core_inv_NF20$1_0.vout.n43 iqmod_mfb_lpf_pex_half_1.iqmod_mfb_lpf_pex_ota_core_hybrid_bm_half_0.iqmod_mfb_lpf_pex_ota_core_inv_NF20$1_0.vout.t30 2.0884
R7797 iqmod_mfb_lpf_pex_half_1.iqmod_mfb_lpf_pex_ota_core_hybrid_bm_half_0.iqmod_mfb_lpf_pex_ota_core_inv_NF20$1_0.vout.n43 iqmod_mfb_lpf_pex_half_1.iqmod_mfb_lpf_pex_ota_core_hybrid_bm_half_0.iqmod_mfb_lpf_pex_ota_core_inv_NF20$1_0.vout.t20 10.2939
R7798 iqmod_mfb_lpf_pex_half_1.iqmod_mfb_lpf_pex_ota_core_hybrid_bm_half_0.iqmod_mfb_lpf_pex_ota_core_inv_NF20$1_0.vout.n51 iqmod_mfb_lpf_pex_half_1.iqmod_mfb_lpf_pex_ota_core_hybrid_bm_half_0.iqmod_mfb_lpf_pex_ota_core_inv_NF20$1_0.vout.n16 0.228273
R7799 iqmod_mfb_lpf_pex_half_1.iqmod_mfb_lpf_pex_ota_core_hybrid_bm_half_0.iqmod_mfb_lpf_pex_ota_core_inv_NF20$1_0.vout.n16 iqmod_mfb_lpf_pex_half_1.iqmod_mfb_lpf_pex_ota_core_hybrid_bm_half_0.iqmod_mfb_lpf_pex_ota_core_inv_NF20$1_0.vout.n17 3.82976
R7800 iqmod_mfb_lpf_pex_half_1.iqmod_mfb_lpf_pex_ota_core_hybrid_bm_half_0.iqmod_mfb_lpf_pex_ota_core_inv_NF20$1_0.vout.n17 iqmod_mfb_lpf_pex_half_1.iqmod_mfb_lpf_pex_ota_core_hybrid_bm_half_0.iqmod_mfb_lpf_pex_ota_core_inv_NF20$1_0.vout.n42 0.228273
R7801 iqmod_mfb_lpf_pex_half_1.iqmod_mfb_lpf_pex_ota_core_hybrid_bm_half_0.iqmod_mfb_lpf_pex_ota_core_inv_NF20$1_0.vout.n42 iqmod_mfb_lpf_pex_half_1.iqmod_mfb_lpf_pex_ota_core_hybrid_bm_half_0.iqmod_mfb_lpf_pex_ota_core_inv_NF20$1_0.vout.n41 0.16242
R7802 iqmod_mfb_lpf_pex_half_1.iqmod_mfb_lpf_pex_ota_core_hybrid_bm_half_0.iqmod_mfb_lpf_pex_ota_core_inv_NF20$1_0.vout.n41 iqmod_mfb_lpf_pex_half_1.iqmod_mfb_lpf_pex_ota_core_hybrid_bm_half_0.iqmod_mfb_lpf_pex_ota_core_inv_NF20$1_0.vout.n40 0.16242
R7803 iqmod_mfb_lpf_pex_half_1.iqmod_mfb_lpf_pex_ota_core_hybrid_bm_half_0.iqmod_mfb_lpf_pex_ota_core_inv_NF20$1_0.vout.n40 iqmod_mfb_lpf_pex_half_1.iqmod_mfb_lpf_pex_ota_core_hybrid_bm_half_0.iqmod_mfb_lpf_pex_ota_core_inv_NF20$1_0.vout.n39 0.16242
R7804 iqmod_mfb_lpf_pex_half_1.iqmod_mfb_lpf_pex_ota_core_hybrid_bm_half_0.iqmod_mfb_lpf_pex_ota_core_inv_NF20$1_0.vout.n39 iqmod_mfb_lpf_pex_half_1.iqmod_mfb_lpf_pex_ota_core_hybrid_bm_half_0.iqmod_mfb_lpf_pex_ota_core_inv_NF20$1_0.vout.n38 0.16242
R7805 iqmod_mfb_lpf_pex_half_1.iqmod_mfb_lpf_pex_ota_core_hybrid_bm_half_0.iqmod_mfb_lpf_pex_ota_core_inv_NF20$1_0.vout.n38 iqmod_mfb_lpf_pex_half_1.iqmod_mfb_lpf_pex_ota_core_hybrid_bm_half_0.iqmod_mfb_lpf_pex_ota_core_inv_NF20$1_0.vout.n37 0.16242
R7806 iqmod_mfb_lpf_pex_half_1.iqmod_mfb_lpf_pex_ota_core_hybrid_bm_half_0.iqmod_mfb_lpf_pex_ota_core_inv_NF20$1_0.vout.n37 iqmod_mfb_lpf_pex_half_1.iqmod_mfb_lpf_pex_ota_core_hybrid_bm_half_0.iqmod_mfb_lpf_pex_ota_core_inv_NF20$1_0.vout.n36 0.16242
R7807 iqmod_mfb_lpf_pex_half_1.iqmod_mfb_lpf_pex_ota_core_hybrid_bm_half_0.iqmod_mfb_lpf_pex_ota_core_inv_NF20$1_0.vout.n36 iqmod_mfb_lpf_pex_half_1.iqmod_mfb_lpf_pex_ota_core_hybrid_bm_half_0.iqmod_mfb_lpf_pex_ota_core_inv_NF20$1_0.vout.n35 0.16242
R7808 iqmod_mfb_lpf_pex_half_1.iqmod_mfb_lpf_pex_ota_core_hybrid_bm_half_0.iqmod_mfb_lpf_pex_ota_core_inv_NF20$1_0.vout.n35 iqmod_mfb_lpf_pex_half_1.iqmod_mfb_lpf_pex_ota_core_hybrid_bm_half_0.iqmod_mfb_lpf_pex_ota_core_inv_NF20$1_0.vout.n34 0.16242
R7809 iqmod_mfb_lpf_pex_half_1.iqmod_mfb_lpf_pex_ota_core_hybrid_bm_half_0.iqmod_mfb_lpf_pex_ota_core_inv_NF20$1_0.vout.n34 iqmod_mfb_lpf_pex_half_1.iqmod_mfb_lpf_pex_ota_core_hybrid_bm_half_0.iqmod_mfb_lpf_pex_ota_core_inv_NF20$1_0.vout.n33 0.16242
R7810 iqmod_mfb_lpf_pex_half_1.iqmod_mfb_lpf_pex_ota_core_hybrid_bm_half_0.iqmod_mfb_lpf_pex_ota_core_inv_NF20$1_0.vout.n33 iqmod_mfb_lpf_pex_half_1.iqmod_mfb_lpf_pex_ota_core_hybrid_bm_half_0.iqmod_mfb_lpf_pex_ota_core_inv_NF20$1_0.vout 0.0151667
R7811 iqmod_mfb_lpf_pex_half_1.iqmod_mfb_lpf_pex_ota_core_hybrid_bm_half_0.iqmod_mfb_lpf_pex_ota_core_inv_NF20$1_0.vout.n42 iqmod_mfb_lpf_pex_half_1.iqmod_mfb_lpf_pex_ota_core_hybrid_bm_half_0.iqmod_mfb_lpf_pex_ota_core_inv_NF20$1_0.vout.t36 10.2939
R7812 iqmod_mfb_lpf_pex_half_1.iqmod_mfb_lpf_pex_ota_core_hybrid_bm_half_0.iqmod_mfb_lpf_pex_ota_core_inv_NF20$1_0.vout.n42 iqmod_mfb_lpf_pex_half_1.iqmod_mfb_lpf_pex_ota_core_hybrid_bm_half_0.iqmod_mfb_lpf_pex_ota_core_inv_NF20$1_0.vout.t46 2.0693
R7813 iqmod_mfb_lpf_pex_half_1.iqmod_mfb_lpf_pex_ota_core_hybrid_bm_half_0.iqmod_mfb_lpf_pex_ota_core_inv_NF20$1_0.vout.n41 iqmod_mfb_lpf_pex_half_1.iqmod_mfb_lpf_pex_ota_core_hybrid_bm_half_0.iqmod_mfb_lpf_pex_ota_core_inv_NF20$1_0.vout.t37 10.2939
R7814 iqmod_mfb_lpf_pex_half_1.iqmod_mfb_lpf_pex_ota_core_hybrid_bm_half_0.iqmod_mfb_lpf_pex_ota_core_inv_NF20$1_0.vout.n41 iqmod_mfb_lpf_pex_half_1.iqmod_mfb_lpf_pex_ota_core_hybrid_bm_half_0.iqmod_mfb_lpf_pex_ota_core_inv_NF20$1_0.vout.t47 2.0693
R7815 iqmod_mfb_lpf_pex_half_1.iqmod_mfb_lpf_pex_ota_core_hybrid_bm_half_0.iqmod_mfb_lpf_pex_ota_core_inv_NF20$1_0.vout.n40 iqmod_mfb_lpf_pex_half_1.iqmod_mfb_lpf_pex_ota_core_hybrid_bm_half_0.iqmod_mfb_lpf_pex_ota_core_inv_NF20$1_0.vout.t38 10.2939
R7816 iqmod_mfb_lpf_pex_half_1.iqmod_mfb_lpf_pex_ota_core_hybrid_bm_half_0.iqmod_mfb_lpf_pex_ota_core_inv_NF20$1_0.vout.n40 iqmod_mfb_lpf_pex_half_1.iqmod_mfb_lpf_pex_ota_core_hybrid_bm_half_0.iqmod_mfb_lpf_pex_ota_core_inv_NF20$1_0.vout.t48 2.0693
R7817 iqmod_mfb_lpf_pex_half_1.iqmod_mfb_lpf_pex_ota_core_hybrid_bm_half_0.iqmod_mfb_lpf_pex_ota_core_inv_NF20$1_0.vout.n39 iqmod_mfb_lpf_pex_half_1.iqmod_mfb_lpf_pex_ota_core_hybrid_bm_half_0.iqmod_mfb_lpf_pex_ota_core_inv_NF20$1_0.vout.t39 10.2939
R7818 iqmod_mfb_lpf_pex_half_1.iqmod_mfb_lpf_pex_ota_core_hybrid_bm_half_0.iqmod_mfb_lpf_pex_ota_core_inv_NF20$1_0.vout.n39 iqmod_mfb_lpf_pex_half_1.iqmod_mfb_lpf_pex_ota_core_hybrid_bm_half_0.iqmod_mfb_lpf_pex_ota_core_inv_NF20$1_0.vout.t49 2.0693
R7819 iqmod_mfb_lpf_pex_half_1.iqmod_mfb_lpf_pex_ota_core_hybrid_bm_half_0.iqmod_mfb_lpf_pex_ota_core_inv_NF20$1_0.vout.n38 iqmod_mfb_lpf_pex_half_1.iqmod_mfb_lpf_pex_ota_core_hybrid_bm_half_0.iqmod_mfb_lpf_pex_ota_core_inv_NF20$1_0.vout.t40 10.2939
R7820 iqmod_mfb_lpf_pex_half_1.iqmod_mfb_lpf_pex_ota_core_hybrid_bm_half_0.iqmod_mfb_lpf_pex_ota_core_inv_NF20$1_0.vout.n38 iqmod_mfb_lpf_pex_half_1.iqmod_mfb_lpf_pex_ota_core_hybrid_bm_half_0.iqmod_mfb_lpf_pex_ota_core_inv_NF20$1_0.vout.t50 2.0693
R7821 iqmod_mfb_lpf_pex_half_1.iqmod_mfb_lpf_pex_ota_core_hybrid_bm_half_0.iqmod_mfb_lpf_pex_ota_core_inv_NF20$1_0.vout.n37 iqmod_mfb_lpf_pex_half_1.iqmod_mfb_lpf_pex_ota_core_hybrid_bm_half_0.iqmod_mfb_lpf_pex_ota_core_inv_NF20$1_0.vout.t41 10.2939
R7822 iqmod_mfb_lpf_pex_half_1.iqmod_mfb_lpf_pex_ota_core_hybrid_bm_half_0.iqmod_mfb_lpf_pex_ota_core_inv_NF20$1_0.vout.n37 iqmod_mfb_lpf_pex_half_1.iqmod_mfb_lpf_pex_ota_core_hybrid_bm_half_0.iqmod_mfb_lpf_pex_ota_core_inv_NF20$1_0.vout.t51 2.08789
R7823 iqmod_mfb_lpf_pex_half_1.iqmod_mfb_lpf_pex_ota_core_hybrid_bm_half_0.iqmod_mfb_lpf_pex_ota_core_inv_NF20$1_0.vout.n36 iqmod_mfb_lpf_pex_half_1.iqmod_mfb_lpf_pex_ota_core_hybrid_bm_half_0.iqmod_mfb_lpf_pex_ota_core_inv_NF20$1_0.vout.t42 10.2939
R7824 iqmod_mfb_lpf_pex_half_1.iqmod_mfb_lpf_pex_ota_core_hybrid_bm_half_0.iqmod_mfb_lpf_pex_ota_core_inv_NF20$1_0.vout.n36 iqmod_mfb_lpf_pex_half_1.iqmod_mfb_lpf_pex_ota_core_hybrid_bm_half_0.iqmod_mfb_lpf_pex_ota_core_inv_NF20$1_0.vout.t52 2.08789
R7825 iqmod_mfb_lpf_pex_half_1.iqmod_mfb_lpf_pex_ota_core_hybrid_bm_half_0.iqmod_mfb_lpf_pex_ota_core_inv_NF20$1_0.vout.n35 iqmod_mfb_lpf_pex_half_1.iqmod_mfb_lpf_pex_ota_core_hybrid_bm_half_0.iqmod_mfb_lpf_pex_ota_core_inv_NF20$1_0.vout.t43 10.2939
R7826 iqmod_mfb_lpf_pex_half_1.iqmod_mfb_lpf_pex_ota_core_hybrid_bm_half_0.iqmod_mfb_lpf_pex_ota_core_inv_NF20$1_0.vout.n35 iqmod_mfb_lpf_pex_half_1.iqmod_mfb_lpf_pex_ota_core_hybrid_bm_half_0.iqmod_mfb_lpf_pex_ota_core_inv_NF20$1_0.vout.t53 2.08789
R7827 iqmod_mfb_lpf_pex_half_1.iqmod_mfb_lpf_pex_ota_core_hybrid_bm_half_0.iqmod_mfb_lpf_pex_ota_core_inv_NF20$1_0.vout.n34 iqmod_mfb_lpf_pex_half_1.iqmod_mfb_lpf_pex_ota_core_hybrid_bm_half_0.iqmod_mfb_lpf_pex_ota_core_inv_NF20$1_0.vout.t44 10.2939
R7828 iqmod_mfb_lpf_pex_half_1.iqmod_mfb_lpf_pex_ota_core_hybrid_bm_half_0.iqmod_mfb_lpf_pex_ota_core_inv_NF20$1_0.vout.n34 iqmod_mfb_lpf_pex_half_1.iqmod_mfb_lpf_pex_ota_core_hybrid_bm_half_0.iqmod_mfb_lpf_pex_ota_core_inv_NF20$1_0.vout.t54 2.08789
R7829 iqmod_mfb_lpf_pex_half_1.iqmod_mfb_lpf_pex_ota_core_hybrid_bm_half_0.iqmod_mfb_lpf_pex_ota_core_inv_NF20$1_0.vout.n33 iqmod_mfb_lpf_pex_half_1.iqmod_mfb_lpf_pex_ota_core_hybrid_bm_half_0.iqmod_mfb_lpf_pex_ota_core_inv_NF20$1_0.vout.t45 10.2939
R7830 iqmod_mfb_lpf_pex_half_1.iqmod_mfb_lpf_pex_ota_core_hybrid_bm_half_0.iqmod_mfb_lpf_pex_ota_core_inv_NF20$1_0.vout.n33 iqmod_mfb_lpf_pex_half_1.iqmod_mfb_lpf_pex_ota_core_hybrid_bm_half_0.iqmod_mfb_lpf_pex_ota_core_inv_NF20$1_0.vout.t55 2.08789
R7831 iqmod_mfb_lpf_pex_half_1.iqmod_mfb_lpf_pex_ota_core_hybrid_bm_half_0.iqmod_mfb_lpf_pex_ota_core_inv_NF20$1_0.vout iqmod_mfb_lpf_pex_half_1.iqmod_mfb_lpf_pex_ota_core_hybrid_bm_half_0.iqmod_mfb_lpf_pex_ota_core_inv_NF20$1_0.vout.n32 0.00974
R7832 iqmod_mfb_lpf_pex_half_1.iqmod_mfb_lpf_pex_ota_core_hybrid_bm_half_0.iqmod_mfb_lpf_pex_ota_core_inv_NF20$1_0.vout.n30 iqmod_mfb_lpf_pex_half_1.iqmod_mfb_lpf_pex_ota_core_hybrid_bm_half_0.iqmod_mfb_lpf_pex_ota_core_inv_NF20$1_0.vout.n25 0.0265126
R7833 iqmod_mfb_lpf_pex_half_1.iqmod_mfb_lpf_pex_ota_core_hybrid_bm_half_0.iqmod_mfb_lpf_pex_ota_core_inv_NF20$1_0.vout.n25 iqmod_mfb_lpf_pex_half_1.iqmod_mfb_lpf_pex_ota_core_hybrid_bm_half_0.iqmod_mfb_lpf_pex_ota_core_inv_NF20$1_0.vout.n24 0.12194
R7834 iqmod_mfb_lpf_pex_half_1.iqmod_mfb_lpf_pex_ota_core_hybrid_bm_half_0.iqmod_mfb_lpf_pex_ota_core_inv_NF20$1_0.vout.n24 iqmod_mfb_lpf_pex_half_1.iqmod_mfb_lpf_pex_ota_core_hybrid_bm_half_0.iqmod_mfb_lpf_pex_ota_core_inv_NF20$1_0.vout.n23 0.12194
R7835 iqmod_mfb_lpf_pex_half_1.iqmod_mfb_lpf_pex_ota_core_hybrid_bm_half_0.iqmod_mfb_lpf_pex_ota_core_inv_NF20$1_0.vout.n23 iqmod_mfb_lpf_pex_half_1.iqmod_mfb_lpf_pex_ota_core_hybrid_bm_half_0.iqmod_mfb_lpf_pex_ota_core_inv_NF20$1_0.vout.n31 0.0265126
R7836 iqmod_mfb_lpf_pex_half_1.iqmod_mfb_lpf_pex_ota_core_hybrid_bm_half_0.iqmod_mfb_lpf_pex_ota_core_inv_NF20$1_0.vout.n22 iqmod_mfb_lpf_pex_half_1.iqmod_mfb_lpf_pex_ota_core_hybrid_bm_half_0.iqmod_mfb_lpf_pex_ota_core_inv_NF20$1_0.vout 0.4119
R7837 iqmod_mfb_lpf_pex_half_1.iqmod_mfb_lpf_pex_ota_core_hybrid_bm_half_0.iqmod_mfb_lpf_pex_ota_core_inv_NF20$1_0.vout iqmod_mfb_lpf_pex_half_1.iqmod_mfb_lpf_pex_ota_core_hybrid_bm_half_0.iqmod_mfb_lpf_pex_ota_core_inv_NF20$1_0.vout.n21 0.00974
R7838 iqmod_mfb_lpf_pex_half_1.iqmod_mfb_lpf_pex_ota_core_hybrid_bm_half_0.iqmod_mfb_lpf_pex_ota_core_inv_NF20$1_0.vout.n20 iqmod_mfb_lpf_pex_half_1.iqmod_mfb_lpf_pex_ota_core_hybrid_bm_half_0.iqmod_mfb_lpf_pex_ota_core_inv_NF20$1_0.vout.n21 0.09026
R7839 iqmod_mfb_lpf_pex_half_1.iqmod_mfb_lpf_pex_ota_core_hybrid_bm_half_0.iqmod_mfb_lpf_pex_ota_core_inv_NF20$1_0.vout.n19 iqmod_mfb_lpf_pex_half_1.iqmod_mfb_lpf_pex_ota_core_hybrid_bm_half_0.iqmod_mfb_lpf_pex_ota_core_inv_NF20$1_0.vout.n20 0.09026
R7840 iqmod_mfb_lpf_pex_half_1.iqmod_mfb_lpf_pex_ota_core_hybrid_bm_half_0.iqmod_mfb_lpf_pex_ota_core_inv_NF20$1_0.vout.n18 iqmod_mfb_lpf_pex_half_1.iqmod_mfb_lpf_pex_ota_core_hybrid_bm_half_0.iqmod_mfb_lpf_pex_ota_core_inv_NF20$1_0.vout.n19 0.09026
R7841 iqmod_mfb_lpf_pex_half_1.iqmod_mfb_lpf_pex_ota_core_hybrid_bm_half_0.iqmod_mfb_lpf_pex_ota_core_inv_NF20$1_0.vout.n17 iqmod_mfb_lpf_pex_half_1.iqmod_mfb_lpf_pex_ota_core_hybrid_bm_half_0.iqmod_mfb_lpf_pex_ota_core_inv_NF20$1_0.vout.n18 1.6787
R7842 iqmod_mfb_lpf_pex_half_1.iqmod_mfb_lpf_pex_ota_core_hybrid_bm_half_0.iqmod_mfb_lpf_pex_ota_core_inv_NF20$1_0.vout.n32 iqmod_mfb_lpf_pex_half_1.iqmod_mfb_lpf_pex_ota_core_hybrid_bm_half_0.iqmod_mfb_lpf_pex_ota_core_inv_NF20$1_0.vout.n30 0.0847067
R7843 iqmod_mfb_lpf_pex_half_1.iqmod_mfb_lpf_pex_ota_core_hybrid_bm_half_0.iqmod_mfb_lpf_pex_ota_core_inv_NF20$1_0.vout.n22 iqmod_mfb_lpf_pex_half_1.iqmod_mfb_lpf_pex_ota_core_hybrid_bm_half_0.iqmod_mfb_lpf_pex_ota_core_inv_NF20$1_0.vout.n31 0.0847067
R7844 iqmod_mfb_lpf_pex_half_1.iqmod_mfb_lpf_pex_ota_core_hybrid_bm_half_0.iqmod_mfb_lpf_pex_ota_core_inv_NF20$1_0.vout.n31 iqmod_mfb_lpf_pex_half_1.iqmod_mfb_lpf_pex_ota_core_hybrid_bm_half_0.iqmod_mfb_lpf_pex_ota_core_inv_NF20$1_0.vout.n29 0.754036
R7845 iqmod_mfb_lpf_pex_half_1.iqmod_mfb_lpf_pex_ota_core_hybrid_bm_half_0.iqmod_mfb_lpf_pex_ota_core_inv_NF20$1_0.vout.n30 iqmod_mfb_lpf_pex_half_1.iqmod_mfb_lpf_pex_ota_core_hybrid_bm_half_0.iqmod_mfb_lpf_pex_ota_core_inv_NF20$1_0.vout.n29 0.754036
R7846 iqmod_mfb_lpf_pex_half_1.iqmod_mfb_lpf_pex_ota_core_hybrid_bm_half_0.iqmod_mfb_lpf_pex_ota_core_inv_NF20$1_0.vout.n24 iqmod_mfb_lpf_pex_half_1.iqmod_mfb_lpf_pex_ota_core_hybrid_bm_half_0.iqmod_mfb_lpf_pex_ota_core_inv_NF20$1_0.vout.n29 0.254024
R7847 iqmod_mfb_lpf_pex_half_1.iqmod_mfb_lpf_pex_ota_core_hybrid_bm_half_0.iqmod_mfb_lpf_pex_ota_core_inv_NF20$1_0.vout.t57 iqmod_mfb_lpf_pex_half_1.iqmod_mfb_lpf_pex_ota_core_hybrid_bm_half_0.iqmod_mfb_lpf_pex_ota_core_inv_NF20$1_0.vout.n29 1.53248
R7848 iqmod_mfb_lpf_pex_half_1.iqmod_mfb_lpf_pex_ota_core_hybrid_bm_half_0.iqmod_mfb_lpf_pex_ota_core_inv_NF20$1_0.vout.n32 iqmod_mfb_lpf_pex_half_1.iqmod_mfb_lpf_pex_ota_core_hybrid_bm_half_0.iqmod_mfb_lpf_pex_ota_core_inv_NF20$1_0.vout.n28 0.83231
R7849 iqmod_mfb_lpf_pex_half_1.iqmod_mfb_lpf_pex_ota_core_hybrid_bm_half_0.iqmod_mfb_lpf_pex_ota_core_inv_NF20$1_0.vout.n28 iqmod_mfb_lpf_pex_half_1.iqmod_mfb_lpf_pex_ota_core_hybrid_bm_half_0.iqmod_mfb_lpf_pex_ota_core_inv_NF20$1_0.vout.n26 0.578786
R7850 iqmod_mfb_lpf_pex_half_1.iqmod_mfb_lpf_pex_ota_core_hybrid_bm_half_0.iqmod_mfb_lpf_pex_ota_core_inv_NF20$1_0.vout.n26 iqmod_mfb_lpf_pex_half_1.iqmod_mfb_lpf_pex_ota_core_hybrid_bm_half_0.iqmod_mfb_lpf_pex_ota_core_inv_NF20$1_0.vout.n27 0.578786
R7851 iqmod_mfb_lpf_pex_half_1.iqmod_mfb_lpf_pex_ota_core_hybrid_bm_half_0.iqmod_mfb_lpf_pex_ota_core_inv_NF20$1_0.vout.n28 iqmod_mfb_lpf_pex_half_1.iqmod_mfb_lpf_pex_ota_core_hybrid_bm_half_0.iqmod_mfb_lpf_pex_ota_core_inv_NF20$1_0.vout.n25 0.254024
R7852 iqmod_mfb_lpf_pex_half_1.iqmod_mfb_lpf_pex_ota_core_hybrid_bm_half_0.iqmod_mfb_lpf_pex_ota_core_inv_NF20$1_0.vout.n27 iqmod_mfb_lpf_pex_half_1.iqmod_mfb_lpf_pex_ota_core_hybrid_bm_half_0.iqmod_mfb_lpf_pex_ota_core_inv_NF20$1_0.vout.n23 0.254024
R7853 iqmod_mfb_lpf_pex_half_1.iqmod_mfb_lpf_pex_ota_core_hybrid_bm_half_0.iqmod_mfb_lpf_pex_ota_core_inv_NF20$1_0.vout.n27 iqmod_mfb_lpf_pex_half_1.iqmod_mfb_lpf_pex_ota_core_hybrid_bm_half_0.iqmod_mfb_lpf_pex_ota_core_inv_NF20$1_0.vout.n22 0.83231
R7854 iqmod_mfb_lpf_pex_half_1.iqmod_mfb_lpf_pex_ota_core_hybrid_bm_half_0.iqmod_mfb_lpf_pex_ota_core_inv_NF20$1_0.vout.n26 iqmod_mfb_lpf_pex_half_1.iqmod_mfb_lpf_pex_ota_core_hybrid_bm_half_0.iqmod_mfb_lpf_pex_ota_core_inv_NF20$1_0.vout.n24 0.254024
R7855 iqmod_mfb_lpf_pex_half_1.iqmod_mfb_lpf_pex_ota_core_hybrid_bm_half_0.iqmod_mfb_lpf_pex_ota_core_inv_NF20$1_0.vout.t56 iqmod_mfb_lpf_pex_half_1.iqmod_mfb_lpf_pex_ota_core_hybrid_bm_half_0.iqmod_mfb_lpf_pex_ota_core_inv_NF20$1_0.vout.n26 1.53248
R7856 iqmod_mfb_lpf_pex_half_1.iqmod_mfb_lpf_pex_ota_core_hybrid_bm_half_0.iqmod_mfb_lpf_pex_ota_core_inv_NF20$1_0.vout.n21 iqmod_mfb_lpf_pex_half_1.iqmod_mfb_lpf_pex_ota_core_hybrid_bm_half_0.iqmod_mfb_lpf_pex_ota_core_inv_NF20$1_0.vout.t6 10.8541
R7857 iqmod_mfb_lpf_pex_half_1.iqmod_mfb_lpf_pex_ota_core_hybrid_bm_half_0.iqmod_mfb_lpf_pex_ota_core_inv_NF20$1_0.vout.n21 iqmod_mfb_lpf_pex_half_1.iqmod_mfb_lpf_pex_ota_core_hybrid_bm_half_0.iqmod_mfb_lpf_pex_ota_core_inv_NF20$1_0.vout.t34 3.59068
R7858 iqmod_mfb_lpf_pex_half_1.iqmod_mfb_lpf_pex_ota_core_hybrid_bm_half_0.iqmod_mfb_lpf_pex_ota_core_inv_NF20$1_0.vout.n20 iqmod_mfb_lpf_pex_half_1.iqmod_mfb_lpf_pex_ota_core_hybrid_bm_half_0.iqmod_mfb_lpf_pex_ota_core_inv_NF20$1_0.vout.t7 10.8541
R7859 iqmod_mfb_lpf_pex_half_1.iqmod_mfb_lpf_pex_ota_core_hybrid_bm_half_0.iqmod_mfb_lpf_pex_ota_core_inv_NF20$1_0.vout.n20 iqmod_mfb_lpf_pex_half_1.iqmod_mfb_lpf_pex_ota_core_hybrid_bm_half_0.iqmod_mfb_lpf_pex_ota_core_inv_NF20$1_0.vout.t32 3.59112
R7860 iqmod_mfb_lpf_pex_half_1.iqmod_mfb_lpf_pex_ota_core_hybrid_bm_half_0.iqmod_mfb_lpf_pex_ota_core_inv_NF20$1_0.vout.n19 iqmod_mfb_lpf_pex_half_1.iqmod_mfb_lpf_pex_ota_core_hybrid_bm_half_0.iqmod_mfb_lpf_pex_ota_core_inv_NF20$1_0.vout.t4 10.8541
R7861 iqmod_mfb_lpf_pex_half_1.iqmod_mfb_lpf_pex_ota_core_hybrid_bm_half_0.iqmod_mfb_lpf_pex_ota_core_inv_NF20$1_0.vout.n19 iqmod_mfb_lpf_pex_half_1.iqmod_mfb_lpf_pex_ota_core_hybrid_bm_half_0.iqmod_mfb_lpf_pex_ota_core_inv_NF20$1_0.vout.t33 3.59112
R7862 iqmod_mfb_lpf_pex_half_1.iqmod_mfb_lpf_pex_ota_core_hybrid_bm_half_0.iqmod_mfb_lpf_pex_ota_core_inv_NF20$1_0.vout.n18 iqmod_mfb_lpf_pex_half_1.iqmod_mfb_lpf_pex_ota_core_hybrid_bm_half_0.iqmod_mfb_lpf_pex_ota_core_inv_NF20$1_0.vout.t5 10.8541
R7863 iqmod_mfb_lpf_pex_half_1.iqmod_mfb_lpf_pex_ota_core_hybrid_bm_half_0.iqmod_mfb_lpf_pex_ota_core_inv_NF20$1_0.vout.n18 iqmod_mfb_lpf_pex_half_1.iqmod_mfb_lpf_pex_ota_core_hybrid_bm_half_0.iqmod_mfb_lpf_pex_ota_core_inv_NF20$1_0.vout.t35 3.59068
R7864 iqmod_mfb_lpf_pex_half_1.iqmod_mfb_lpf_pex_ota_core_hybrid_bm_half_0.iqmod_mfb_lpf_pex_ota_core_inv_NF20$1_0.vout iqmod_mfb_lpf_pex_half_1.iqmod_mfb_lpf_pex_ota_core_hybrid_bm_half_0.iqmod_mfb_lpf_pex_ota_core_inv_NF20$1_0.vout.n15 0.00974
R7865 iqmod_mfb_lpf_pex_half_1.iqmod_mfb_lpf_pex_ota_core_hybrid_bm_half_0.iqmod_mfb_lpf_pex_ota_core_inv_NF20$1_0.vout.n13 iqmod_mfb_lpf_pex_half_1.iqmod_mfb_lpf_pex_ota_core_hybrid_bm_half_0.iqmod_mfb_lpf_pex_ota_core_inv_NF20$1_0.vout.n8 0.0265126
R7866 iqmod_mfb_lpf_pex_half_1.iqmod_mfb_lpf_pex_ota_core_hybrid_bm_half_0.iqmod_mfb_lpf_pex_ota_core_inv_NF20$1_0.vout.n8 iqmod_mfb_lpf_pex_half_1.iqmod_mfb_lpf_pex_ota_core_hybrid_bm_half_0.iqmod_mfb_lpf_pex_ota_core_inv_NF20$1_0.vout.n7 0.12194
R7867 iqmod_mfb_lpf_pex_half_1.iqmod_mfb_lpf_pex_ota_core_hybrid_bm_half_0.iqmod_mfb_lpf_pex_ota_core_inv_NF20$1_0.vout.n7 iqmod_mfb_lpf_pex_half_1.iqmod_mfb_lpf_pex_ota_core_hybrid_bm_half_0.iqmod_mfb_lpf_pex_ota_core_inv_NF20$1_0.vout.n6 0.12194
R7868 iqmod_mfb_lpf_pex_half_1.iqmod_mfb_lpf_pex_ota_core_hybrid_bm_half_0.iqmod_mfb_lpf_pex_ota_core_inv_NF20$1_0.vout.n6 iqmod_mfb_lpf_pex_half_1.iqmod_mfb_lpf_pex_ota_core_hybrid_bm_half_0.iqmod_mfb_lpf_pex_ota_core_inv_NF20$1_0.vout.n14 0.0265126
R7869 iqmod_mfb_lpf_pex_half_1.iqmod_mfb_lpf_pex_ota_core_hybrid_bm_half_0.iqmod_mfb_lpf_pex_ota_core_inv_NF20$1_0.vout.n5 iqmod_mfb_lpf_pex_half_1.iqmod_mfb_lpf_pex_ota_core_hybrid_bm_half_0.iqmod_mfb_lpf_pex_ota_core_inv_NF20$1_0.vout 0.4119
R7870 iqmod_mfb_lpf_pex_half_1.iqmod_mfb_lpf_pex_ota_core_hybrid_bm_half_0.iqmod_mfb_lpf_pex_ota_core_inv_NF20$1_0.vout iqmod_mfb_lpf_pex_half_1.iqmod_mfb_lpf_pex_ota_core_hybrid_bm_half_0.iqmod_mfb_lpf_pex_ota_core_inv_NF20$1_0.vout.n4 0.00974
R7871 iqmod_mfb_lpf_pex_half_1.iqmod_mfb_lpf_pex_ota_core_hybrid_bm_half_0.iqmod_mfb_lpf_pex_ota_core_inv_NF20$1_0.vout.n3 iqmod_mfb_lpf_pex_half_1.iqmod_mfb_lpf_pex_ota_core_hybrid_bm_half_0.iqmod_mfb_lpf_pex_ota_core_inv_NF20$1_0.vout.n4 0.09026
R7872 iqmod_mfb_lpf_pex_half_1.iqmod_mfb_lpf_pex_ota_core_hybrid_bm_half_0.iqmod_mfb_lpf_pex_ota_core_inv_NF20$1_0.vout.n2 iqmod_mfb_lpf_pex_half_1.iqmod_mfb_lpf_pex_ota_core_hybrid_bm_half_0.iqmod_mfb_lpf_pex_ota_core_inv_NF20$1_0.vout.n3 0.09026
R7873 iqmod_mfb_lpf_pex_half_1.iqmod_mfb_lpf_pex_ota_core_hybrid_bm_half_0.iqmod_mfb_lpf_pex_ota_core_inv_NF20$1_0.vout.n1 iqmod_mfb_lpf_pex_half_1.iqmod_mfb_lpf_pex_ota_core_hybrid_bm_half_0.iqmod_mfb_lpf_pex_ota_core_inv_NF20$1_0.vout.n2 0.09026
R7874 iqmod_mfb_lpf_pex_half_1.iqmod_mfb_lpf_pex_ota_core_hybrid_bm_half_0.iqmod_mfb_lpf_pex_ota_core_inv_NF20$1_0.vout.n16 iqmod_mfb_lpf_pex_half_1.iqmod_mfb_lpf_pex_ota_core_hybrid_bm_half_0.iqmod_mfb_lpf_pex_ota_core_inv_NF20$1_0.vout.n1 1.6787
R7875 iqmod_mfb_lpf_pex_half_1.iqmod_mfb_lpf_pex_ota_core_hybrid_bm_half_0.iqmod_mfb_lpf_pex_ota_core_inv_NF20$1_0.vout.n15 iqmod_mfb_lpf_pex_half_1.iqmod_mfb_lpf_pex_ota_core_hybrid_bm_half_0.iqmod_mfb_lpf_pex_ota_core_inv_NF20$1_0.vout.n13 0.0847067
R7876 iqmod_mfb_lpf_pex_half_1.iqmod_mfb_lpf_pex_ota_core_hybrid_bm_half_0.iqmod_mfb_lpf_pex_ota_core_inv_NF20$1_0.vout.n5 iqmod_mfb_lpf_pex_half_1.iqmod_mfb_lpf_pex_ota_core_hybrid_bm_half_0.iqmod_mfb_lpf_pex_ota_core_inv_NF20$1_0.vout.n14 0.0847067
R7877 iqmod_mfb_lpf_pex_half_1.iqmod_mfb_lpf_pex_ota_core_hybrid_bm_half_0.iqmod_mfb_lpf_pex_ota_core_inv_NF20$1_0.vout.n14 iqmod_mfb_lpf_pex_half_1.iqmod_mfb_lpf_pex_ota_core_hybrid_bm_half_0.iqmod_mfb_lpf_pex_ota_core_inv_NF20$1_0.vout.n12 0.754036
R7878 iqmod_mfb_lpf_pex_half_1.iqmod_mfb_lpf_pex_ota_core_hybrid_bm_half_0.iqmod_mfb_lpf_pex_ota_core_inv_NF20$1_0.vout.n13 iqmod_mfb_lpf_pex_half_1.iqmod_mfb_lpf_pex_ota_core_hybrid_bm_half_0.iqmod_mfb_lpf_pex_ota_core_inv_NF20$1_0.vout.n12 0.754036
R7879 iqmod_mfb_lpf_pex_half_1.iqmod_mfb_lpf_pex_ota_core_hybrid_bm_half_0.iqmod_mfb_lpf_pex_ota_core_inv_NF20$1_0.vout.n7 iqmod_mfb_lpf_pex_half_1.iqmod_mfb_lpf_pex_ota_core_hybrid_bm_half_0.iqmod_mfb_lpf_pex_ota_core_inv_NF20$1_0.vout.n12 0.254024
R7880 iqmod_mfb_lpf_pex_half_1.iqmod_mfb_lpf_pex_ota_core_hybrid_bm_half_0.iqmod_mfb_lpf_pex_ota_core_inv_NF20$1_0.vout.t59 iqmod_mfb_lpf_pex_half_1.iqmod_mfb_lpf_pex_ota_core_hybrid_bm_half_0.iqmod_mfb_lpf_pex_ota_core_inv_NF20$1_0.vout.n12 1.53248
R7881 iqmod_mfb_lpf_pex_half_1.iqmod_mfb_lpf_pex_ota_core_hybrid_bm_half_0.iqmod_mfb_lpf_pex_ota_core_inv_NF20$1_0.vout.n15 iqmod_mfb_lpf_pex_half_1.iqmod_mfb_lpf_pex_ota_core_hybrid_bm_half_0.iqmod_mfb_lpf_pex_ota_core_inv_NF20$1_0.vout.n11 0.83231
R7882 iqmod_mfb_lpf_pex_half_1.iqmod_mfb_lpf_pex_ota_core_hybrid_bm_half_0.iqmod_mfb_lpf_pex_ota_core_inv_NF20$1_0.vout.n11 iqmod_mfb_lpf_pex_half_1.iqmod_mfb_lpf_pex_ota_core_hybrid_bm_half_0.iqmod_mfb_lpf_pex_ota_core_inv_NF20$1_0.vout.n9 0.578786
R7883 iqmod_mfb_lpf_pex_half_1.iqmod_mfb_lpf_pex_ota_core_hybrid_bm_half_0.iqmod_mfb_lpf_pex_ota_core_inv_NF20$1_0.vout.n9 iqmod_mfb_lpf_pex_half_1.iqmod_mfb_lpf_pex_ota_core_hybrid_bm_half_0.iqmod_mfb_lpf_pex_ota_core_inv_NF20$1_0.vout.n10 0.578786
R7884 iqmod_mfb_lpf_pex_half_1.iqmod_mfb_lpf_pex_ota_core_hybrid_bm_half_0.iqmod_mfb_lpf_pex_ota_core_inv_NF20$1_0.vout.n11 iqmod_mfb_lpf_pex_half_1.iqmod_mfb_lpf_pex_ota_core_hybrid_bm_half_0.iqmod_mfb_lpf_pex_ota_core_inv_NF20$1_0.vout.n8 0.254024
R7885 iqmod_mfb_lpf_pex_half_1.iqmod_mfb_lpf_pex_ota_core_hybrid_bm_half_0.iqmod_mfb_lpf_pex_ota_core_inv_NF20$1_0.vout.n10 iqmod_mfb_lpf_pex_half_1.iqmod_mfb_lpf_pex_ota_core_hybrid_bm_half_0.iqmod_mfb_lpf_pex_ota_core_inv_NF20$1_0.vout.n6 0.254024
R7886 iqmod_mfb_lpf_pex_half_1.iqmod_mfb_lpf_pex_ota_core_hybrid_bm_half_0.iqmod_mfb_lpf_pex_ota_core_inv_NF20$1_0.vout.n10 iqmod_mfb_lpf_pex_half_1.iqmod_mfb_lpf_pex_ota_core_hybrid_bm_half_0.iqmod_mfb_lpf_pex_ota_core_inv_NF20$1_0.vout.n5 0.83231
R7887 iqmod_mfb_lpf_pex_half_1.iqmod_mfb_lpf_pex_ota_core_hybrid_bm_half_0.iqmod_mfb_lpf_pex_ota_core_inv_NF20$1_0.vout.n9 iqmod_mfb_lpf_pex_half_1.iqmod_mfb_lpf_pex_ota_core_hybrid_bm_half_0.iqmod_mfb_lpf_pex_ota_core_inv_NF20$1_0.vout.n7 0.254024
R7888 iqmod_mfb_lpf_pex_half_1.iqmod_mfb_lpf_pex_ota_core_hybrid_bm_half_0.iqmod_mfb_lpf_pex_ota_core_inv_NF20$1_0.vout.t58 iqmod_mfb_lpf_pex_half_1.iqmod_mfb_lpf_pex_ota_core_hybrid_bm_half_0.iqmod_mfb_lpf_pex_ota_core_inv_NF20$1_0.vout.n9 1.53248
R7889 iqmod_mfb_lpf_pex_half_1.iqmod_mfb_lpf_pex_ota_core_hybrid_bm_half_0.iqmod_mfb_lpf_pex_ota_core_inv_NF20$1_0.vout.n4 iqmod_mfb_lpf_pex_half_1.iqmod_mfb_lpf_pex_ota_core_hybrid_bm_half_0.iqmod_mfb_lpf_pex_ota_core_inv_NF20$1_0.vout.t0 3.58916
R7890 iqmod_mfb_lpf_pex_half_1.iqmod_mfb_lpf_pex_ota_core_hybrid_bm_half_0.iqmod_mfb_lpf_pex_ota_core_inv_NF20$1_0.vout.n4 iqmod_mfb_lpf_pex_half_1.iqmod_mfb_lpf_pex_ota_core_hybrid_bm_half_0.iqmod_mfb_lpf_pex_ota_core_inv_NF20$1_0.vout.t8 10.8541
R7891 iqmod_mfb_lpf_pex_half_1.iqmod_mfb_lpf_pex_ota_core_hybrid_bm_half_0.iqmod_mfb_lpf_pex_ota_core_inv_NF20$1_0.vout.n3 iqmod_mfb_lpf_pex_half_1.iqmod_mfb_lpf_pex_ota_core_hybrid_bm_half_0.iqmod_mfb_lpf_pex_ota_core_inv_NF20$1_0.vout.t1 3.59112
R7892 iqmod_mfb_lpf_pex_half_1.iqmod_mfb_lpf_pex_ota_core_hybrid_bm_half_0.iqmod_mfb_lpf_pex_ota_core_inv_NF20$1_0.vout.n3 iqmod_mfb_lpf_pex_half_1.iqmod_mfb_lpf_pex_ota_core_hybrid_bm_half_0.iqmod_mfb_lpf_pex_ota_core_inv_NF20$1_0.vout.t9 10.8541
R7893 iqmod_mfb_lpf_pex_half_1.iqmod_mfb_lpf_pex_ota_core_hybrid_bm_half_0.iqmod_mfb_lpf_pex_ota_core_inv_NF20$1_0.vout.n2 iqmod_mfb_lpf_pex_half_1.iqmod_mfb_lpf_pex_ota_core_hybrid_bm_half_0.iqmod_mfb_lpf_pex_ota_core_inv_NF20$1_0.vout.t2 3.59112
R7894 iqmod_mfb_lpf_pex_half_1.iqmod_mfb_lpf_pex_ota_core_hybrid_bm_half_0.iqmod_mfb_lpf_pex_ota_core_inv_NF20$1_0.vout.n2 iqmod_mfb_lpf_pex_half_1.iqmod_mfb_lpf_pex_ota_core_hybrid_bm_half_0.iqmod_mfb_lpf_pex_ota_core_inv_NF20$1_0.vout.t10 10.8541
R7895 iqmod_mfb_lpf_pex_half_1.iqmod_mfb_lpf_pex_ota_core_hybrid_bm_half_0.iqmod_mfb_lpf_pex_ota_core_inv_NF20$1_0.vout.n1 iqmod_mfb_lpf_pex_half_1.iqmod_mfb_lpf_pex_ota_core_hybrid_bm_half_0.iqmod_mfb_lpf_pex_ota_core_inv_NF20$1_0.vout.t3 3.59068
R7896 iqmod_mfb_lpf_pex_half_1.iqmod_mfb_lpf_pex_ota_core_hybrid_bm_half_0.iqmod_mfb_lpf_pex_ota_core_inv_NF20$1_0.vout.n1 iqmod_mfb_lpf_pex_half_1.iqmod_mfb_lpf_pex_ota_core_hybrid_bm_half_0.iqmod_mfb_lpf_pex_ota_core_inv_NF20$1_0.vout.t11 10.8541
R7897 iqmod_mfb_lpf_pex_half_1.iqmod_mfb_lpf_pex_ota_core_hybrid_bm_half_0.iqmod_mfb_lpf_pex_ota_core_inv_NF20$1_0.vout.n0 iqmod_mfb_lpf_pex_half_1.iqmod_mfb_lpf_pex_ota_core_hybrid_bm_half_0.iqmod_mfb_lpf_pex_ota_core_inv_NF20$1_0.vout.t31 2.0884
R7898 iqmod_mfb_lpf_pex_half_1.iqmod_mfb_lpf_pex_ota_core_hybrid_bm_half_0.iqmod_mfb_lpf_pex_ota_core_inv_NF6$1_1.vout.t8 iqmod_mfb_lpf_pex_half_1.iqmod_mfb_lpf_pex_ota_core_hybrid_bm_half_0.iqmod_mfb_lpf_pex_ota_core_inv_NF6$1_1.vout 14.9798
R7899 iqmod_mfb_lpf_pex_half_1.iqmod_mfb_lpf_pex_ota_core_hybrid_bm_half_0.iqmod_mfb_lpf_pex_ota_core_inv_NF6$1_1.vout.n32 iqmod_mfb_lpf_pex_half_1.iqmod_mfb_lpf_pex_ota_core_hybrid_bm_half_0.iqmod_mfb_lpf_pex_ota_core_inv_NF6$1_1.vout.n33 0.09026
R7900 iqmod_mfb_lpf_pex_half_1.iqmod_mfb_lpf_pex_ota_core_hybrid_bm_half_0.iqmod_mfb_lpf_pex_ota_core_inv_NF6$1_1.vout iqmod_mfb_lpf_pex_half_1.iqmod_mfb_lpf_pex_ota_core_hybrid_bm_half_0.iqmod_mfb_lpf_pex_ota_core_inv_NF6$1_1.vout.n32 0.09026
R7901 iqmod_mfb_lpf_pex_half_1.iqmod_mfb_lpf_pex_ota_core_hybrid_bm_half_0.iqmod_mfb_lpf_pex_ota_core_inv_NF6$1_1.vout iqmod_mfb_lpf_pex_half_1.iqmod_mfb_lpf_pex_ota_core_hybrid_bm_half_0.iqmod_mfb_lpf_pex_ota_core_inv_NF6$1_1.vout.t23 3.25207
R7902 iqmod_mfb_lpf_pex_half_1.iqmod_mfb_lpf_pex_ota_core_hybrid_bm_half_0.iqmod_mfb_lpf_pex_ota_core_inv_NF6$1_1.vout.n33 iqmod_mfb_lpf_pex_half_1.iqmod_mfb_lpf_pex_ota_core_hybrid_bm_half_0.iqmod_mfb_lpf_pex_ota_core_inv_NF6$1_1.vout.t6 14.9798
R7903 iqmod_mfb_lpf_pex_half_1.iqmod_mfb_lpf_pex_ota_core_hybrid_bm_half_0.iqmod_mfb_lpf_pex_ota_core_inv_NF6$1_1.vout.n33 iqmod_mfb_lpf_pex_half_1.iqmod_mfb_lpf_pex_ota_core_hybrid_bm_half_0.iqmod_mfb_lpf_pex_ota_core_inv_NF6$1_1.vout.t21 3.25207
R7904 iqmod_mfb_lpf_pex_half_1.iqmod_mfb_lpf_pex_ota_core_hybrid_bm_half_0.iqmod_mfb_lpf_pex_ota_core_inv_NF6$1_1.vout.n32 iqmod_mfb_lpf_pex_half_1.iqmod_mfb_lpf_pex_ota_core_hybrid_bm_half_0.iqmod_mfb_lpf_pex_ota_core_inv_NF6$1_1.vout.t7 14.9798
R7905 iqmod_mfb_lpf_pex_half_1.iqmod_mfb_lpf_pex_ota_core_hybrid_bm_half_0.iqmod_mfb_lpf_pex_ota_core_inv_NF6$1_1.vout.n32 iqmod_mfb_lpf_pex_half_1.iqmod_mfb_lpf_pex_ota_core_hybrid_bm_half_0.iqmod_mfb_lpf_pex_ota_core_inv_NF6$1_1.vout.t22 3.25207
R7906 iqmod_mfb_lpf_pex_half_1.iqmod_mfb_lpf_pex_ota_core_hybrid_bm_half_0.iqmod_mfb_lpf_pex_ota_core_inv_NF6$1_1.vout.n31 iqmod_mfb_lpf_pex_half_1.iqmod_mfb_lpf_pex_ota_core_hybrid_bm_half_0.iqmod_mfb_lpf_pex_ota_core_inv_NF6$1_1.vout.n30 0.16242
R7907 iqmod_mfb_lpf_pex_half_1.iqmod_mfb_lpf_pex_ota_core_hybrid_bm_half_0.iqmod_mfb_lpf_pex_ota_core_inv_NF6$1_1.vout.n30 iqmod_mfb_lpf_pex_half_1.iqmod_mfb_lpf_pex_ota_core_hybrid_bm_half_0.iqmod_mfb_lpf_pex_ota_core_inv_NF6$1_1.vout.n29 0.16242
R7908 iqmod_mfb_lpf_pex_half_1.iqmod_mfb_lpf_pex_ota_core_hybrid_bm_half_0.iqmod_mfb_lpf_pex_ota_core_inv_NF6$1_1.vout.n29 iqmod_mfb_lpf_pex_half_1.iqmod_mfb_lpf_pex_ota_core_hybrid_bm_half_0.iqmod_mfb_lpf_pex_ota_core_inv_NF6$1_1.vout 0.0151667
R7909 iqmod_mfb_lpf_pex_half_1.iqmod_mfb_lpf_pex_ota_core_hybrid_bm_half_0.iqmod_mfb_lpf_pex_ota_core_inv_NF6$1_1.vout iqmod_mfb_lpf_pex_half_1.iqmod_mfb_lpf_pex_ota_core_hybrid_bm_half_0.iqmod_mfb_lpf_pex_ota_core_inv_NF6$1_1.vout.n33 0.436687
R7910 iqmod_mfb_lpf_pex_half_1.iqmod_mfb_lpf_pex_ota_core_hybrid_bm_half_0.iqmod_mfb_lpf_pex_ota_core_inv_NF6$1_1.vout.n31 iqmod_mfb_lpf_pex_half_1.iqmod_mfb_lpf_pex_ota_core_hybrid_bm_half_0.iqmod_mfb_lpf_pex_ota_core_inv_NF6$1_1.vout.t12 10.2939
R7911 iqmod_mfb_lpf_pex_half_1.iqmod_mfb_lpf_pex_ota_core_hybrid_bm_half_0.iqmod_mfb_lpf_pex_ota_core_inv_NF6$1_1.vout.t18 iqmod_mfb_lpf_pex_half_1.iqmod_mfb_lpf_pex_ota_core_hybrid_bm_half_0.iqmod_mfb_lpf_pex_ota_core_inv_NF6$1_1.vout.n31 2.0693
R7912 iqmod_mfb_lpf_pex_half_1.iqmod_mfb_lpf_pex_ota_core_hybrid_bm_half_0.iqmod_mfb_lpf_pex_ota_core_inv_NF6$1_1.vout.n30 iqmod_mfb_lpf_pex_half_1.iqmod_mfb_lpf_pex_ota_core_hybrid_bm_half_0.iqmod_mfb_lpf_pex_ota_core_inv_NF6$1_1.vout.t13 10.2939
R7913 iqmod_mfb_lpf_pex_half_1.iqmod_mfb_lpf_pex_ota_core_hybrid_bm_half_0.iqmod_mfb_lpf_pex_ota_core_inv_NF6$1_1.vout.t19 iqmod_mfb_lpf_pex_half_1.iqmod_mfb_lpf_pex_ota_core_hybrid_bm_half_0.iqmod_mfb_lpf_pex_ota_core_inv_NF6$1_1.vout.n30 2.0693
R7914 iqmod_mfb_lpf_pex_half_1.iqmod_mfb_lpf_pex_ota_core_hybrid_bm_half_0.iqmod_mfb_lpf_pex_ota_core_inv_NF6$1_1.vout.n29 iqmod_mfb_lpf_pex_half_1.iqmod_mfb_lpf_pex_ota_core_hybrid_bm_half_0.iqmod_mfb_lpf_pex_ota_core_inv_NF6$1_1.vout.t14 10.2939
R7915 iqmod_mfb_lpf_pex_half_1.iqmod_mfb_lpf_pex_ota_core_hybrid_bm_half_0.iqmod_mfb_lpf_pex_ota_core_inv_NF6$1_1.vout.t20 iqmod_mfb_lpf_pex_half_1.iqmod_mfb_lpf_pex_ota_core_hybrid_bm_half_0.iqmod_mfb_lpf_pex_ota_core_inv_NF6$1_1.vout.n29 2.0693
R7916 iqmod_mfb_lpf_pex_half_1.iqmod_mfb_lpf_pex_ota_core_hybrid_bm_half_0.iqmod_mfb_lpf_pex_ota_core_inv_NF6$1_1.vout.n11 iqmod_mfb_lpf_pex_half_1.iqmod_mfb_lpf_pex_ota_core_hybrid_bm_half_0.iqmod_mfb_lpf_pex_ota_core_inv_NF6$1_1.vout.n31 0.471593
R7917 iqmod_mfb_lpf_pex_half_1.iqmod_mfb_lpf_pex_ota_core_hybrid_bm_half_0.iqmod_mfb_lpf_pex_ota_core_inv_NF6$1_1.vout.n11 iqmod_mfb_lpf_pex_half_1.iqmod_mfb_lpf_pex_ota_core_hybrid_bm_half_0.iqmod_mfb_lpf_pex_ota_core_inv_NF6$1_1.vout.n12 3.82976
R7918 iqmod_mfb_lpf_pex_half_1.iqmod_mfb_lpf_pex_ota_core_hybrid_bm_half_0.iqmod_mfb_lpf_pex_ota_core_inv_NF6$1_1.vout.n12 iqmod_mfb_lpf_pex_half_1.iqmod_mfb_lpf_pex_ota_core_hybrid_bm_half_0.iqmod_mfb_lpf_pex_ota_core_inv_NF6$1_1.vout.n28 0.471593
R7919 iqmod_mfb_lpf_pex_half_1.iqmod_mfb_lpf_pex_ota_core_hybrid_bm_half_0.iqmod_mfb_lpf_pex_ota_core_inv_NF6$1_1.vout.n28 iqmod_mfb_lpf_pex_half_1.iqmod_mfb_lpf_pex_ota_core_hybrid_bm_half_0.iqmod_mfb_lpf_pex_ota_core_inv_NF6$1_1.vout.n27 0.16242
R7920 iqmod_mfb_lpf_pex_half_1.iqmod_mfb_lpf_pex_ota_core_hybrid_bm_half_0.iqmod_mfb_lpf_pex_ota_core_inv_NF6$1_1.vout.n27 iqmod_mfb_lpf_pex_half_1.iqmod_mfb_lpf_pex_ota_core_hybrid_bm_half_0.iqmod_mfb_lpf_pex_ota_core_inv_NF6$1_1.vout.n26 0.16242
R7921 iqmod_mfb_lpf_pex_half_1.iqmod_mfb_lpf_pex_ota_core_hybrid_bm_half_0.iqmod_mfb_lpf_pex_ota_core_inv_NF6$1_1.vout.n26 iqmod_mfb_lpf_pex_half_1.iqmod_mfb_lpf_pex_ota_core_hybrid_bm_half_0.iqmod_mfb_lpf_pex_ota_core_inv_NF6$1_1.vout 0.0151667
R7922 iqmod_mfb_lpf_pex_half_1.iqmod_mfb_lpf_pex_ota_core_hybrid_bm_half_0.iqmod_mfb_lpf_pex_ota_core_inv_NF6$1_1.vout.n28 iqmod_mfb_lpf_pex_half_1.iqmod_mfb_lpf_pex_ota_core_hybrid_bm_half_0.iqmod_mfb_lpf_pex_ota_core_inv_NF6$1_1.vout.t15 2.06738
R7923 iqmod_mfb_lpf_pex_half_1.iqmod_mfb_lpf_pex_ota_core_hybrid_bm_half_0.iqmod_mfb_lpf_pex_ota_core_inv_NF6$1_1.vout.n28 iqmod_mfb_lpf_pex_half_1.iqmod_mfb_lpf_pex_ota_core_hybrid_bm_half_0.iqmod_mfb_lpf_pex_ota_core_inv_NF6$1_1.vout.t9 10.2939
R7924 iqmod_mfb_lpf_pex_half_1.iqmod_mfb_lpf_pex_ota_core_hybrid_bm_half_0.iqmod_mfb_lpf_pex_ota_core_inv_NF6$1_1.vout.t16 iqmod_mfb_lpf_pex_half_1.iqmod_mfb_lpf_pex_ota_core_hybrid_bm_half_0.iqmod_mfb_lpf_pex_ota_core_inv_NF6$1_1.vout.n27 2.0693
R7925 iqmod_mfb_lpf_pex_half_1.iqmod_mfb_lpf_pex_ota_core_hybrid_bm_half_0.iqmod_mfb_lpf_pex_ota_core_inv_NF6$1_1.vout.n27 iqmod_mfb_lpf_pex_half_1.iqmod_mfb_lpf_pex_ota_core_hybrid_bm_half_0.iqmod_mfb_lpf_pex_ota_core_inv_NF6$1_1.vout.t10 10.2939
R7926 iqmod_mfb_lpf_pex_half_1.iqmod_mfb_lpf_pex_ota_core_hybrid_bm_half_0.iqmod_mfb_lpf_pex_ota_core_inv_NF6$1_1.vout.t17 iqmod_mfb_lpf_pex_half_1.iqmod_mfb_lpf_pex_ota_core_hybrid_bm_half_0.iqmod_mfb_lpf_pex_ota_core_inv_NF6$1_1.vout.n26 2.0693
R7927 iqmod_mfb_lpf_pex_half_1.iqmod_mfb_lpf_pex_ota_core_hybrid_bm_half_0.iqmod_mfb_lpf_pex_ota_core_inv_NF6$1_1.vout.n26 iqmod_mfb_lpf_pex_half_1.iqmod_mfb_lpf_pex_ota_core_hybrid_bm_half_0.iqmod_mfb_lpf_pex_ota_core_inv_NF6$1_1.vout.t11 10.2939
R7928 iqmod_mfb_lpf_pex_half_1.iqmod_mfb_lpf_pex_ota_core_hybrid_bm_half_0.iqmod_mfb_lpf_pex_ota_core_inv_NF6$1_1.vout iqmod_mfb_lpf_pex_half_1.iqmod_mfb_lpf_pex_ota_core_hybrid_bm_half_0.iqmod_mfb_lpf_pex_ota_core_inv_NF6$1_1.vout.n25 0.436687
R7929 iqmod_mfb_lpf_pex_half_1.iqmod_mfb_lpf_pex_ota_core_hybrid_bm_half_0.iqmod_mfb_lpf_pex_ota_core_inv_NF6$1_1.vout.n25 iqmod_mfb_lpf_pex_half_1.iqmod_mfb_lpf_pex_ota_core_hybrid_bm_half_0.iqmod_mfb_lpf_pex_ota_core_inv_NF6$1_1.vout.n24 0.09026
R7930 iqmod_mfb_lpf_pex_half_1.iqmod_mfb_lpf_pex_ota_core_hybrid_bm_half_0.iqmod_mfb_lpf_pex_ota_core_inv_NF6$1_1.vout.n24 iqmod_mfb_lpf_pex_half_1.iqmod_mfb_lpf_pex_ota_core_hybrid_bm_half_0.iqmod_mfb_lpf_pex_ota_core_inv_NF6$1_1.vout 0.09026
R7931 iqmod_mfb_lpf_pex_half_1.iqmod_mfb_lpf_pex_ota_core_hybrid_bm_half_0.iqmod_mfb_lpf_pex_ota_core_inv_NF6$1_1.vout.t2 iqmod_mfb_lpf_pex_half_1.iqmod_mfb_lpf_pex_ota_core_hybrid_bm_half_0.iqmod_mfb_lpf_pex_ota_core_inv_NF6$1_1.vout 3.25207
R7932 iqmod_mfb_lpf_pex_half_1.iqmod_mfb_lpf_pex_ota_core_hybrid_bm_half_0.iqmod_mfb_lpf_pex_ota_core_inv_NF6$1_1.vout iqmod_mfb_lpf_pex_half_1.iqmod_mfb_lpf_pex_ota_core_hybrid_bm_half_0.iqmod_mfb_lpf_pex_ota_core_inv_NF6$1_1.vout.t5 14.9798
R7933 iqmod_mfb_lpf_pex_half_1.iqmod_mfb_lpf_pex_ota_core_hybrid_bm_half_0.iqmod_mfb_lpf_pex_ota_core_inv_NF6$1_1.vout.t0 iqmod_mfb_lpf_pex_half_1.iqmod_mfb_lpf_pex_ota_core_hybrid_bm_half_0.iqmod_mfb_lpf_pex_ota_core_inv_NF6$1_1.vout.n25 3.25207
R7934 iqmod_mfb_lpf_pex_half_1.iqmod_mfb_lpf_pex_ota_core_hybrid_bm_half_0.iqmod_mfb_lpf_pex_ota_core_inv_NF6$1_1.vout.n25 iqmod_mfb_lpf_pex_half_1.iqmod_mfb_lpf_pex_ota_core_hybrid_bm_half_0.iqmod_mfb_lpf_pex_ota_core_inv_NF6$1_1.vout.t3 14.9798
R7935 iqmod_mfb_lpf_pex_half_1.iqmod_mfb_lpf_pex_ota_core_hybrid_bm_half_0.iqmod_mfb_lpf_pex_ota_core_inv_NF6$1_1.vout.t1 iqmod_mfb_lpf_pex_half_1.iqmod_mfb_lpf_pex_ota_core_hybrid_bm_half_0.iqmod_mfb_lpf_pex_ota_core_inv_NF6$1_1.vout.n24 3.25207
R7936 iqmod_mfb_lpf_pex_half_1.iqmod_mfb_lpf_pex_ota_core_hybrid_bm_half_0.iqmod_mfb_lpf_pex_ota_core_inv_NF6$1_1.vout.n24 iqmod_mfb_lpf_pex_half_1.iqmod_mfb_lpf_pex_ota_core_hybrid_bm_half_0.iqmod_mfb_lpf_pex_ota_core_inv_NF6$1_1.vout.t4 14.9798
R7937 iqmod_mfb_lpf_pex_half_1.iqmod_mfb_lpf_pex_ota_core_hybrid_bm_half_0.iqmod_mfb_lpf_pex_ota_core_inv_NF6$1_1.vout iqmod_mfb_lpf_pex_half_1.iqmod_mfb_lpf_pex_ota_core_hybrid_bm_half_0.iqmod_mfb_lpf_pex_ota_core_inv_NF6$1_1.vout.n23 0.00974
R7938 iqmod_mfb_lpf_pex_half_1.iqmod_mfb_lpf_pex_ota_core_hybrid_bm_half_0.iqmod_mfb_lpf_pex_ota_core_inv_NF6$1_1.vout.n21 iqmod_mfb_lpf_pex_half_1.iqmod_mfb_lpf_pex_ota_core_hybrid_bm_half_0.iqmod_mfb_lpf_pex_ota_core_inv_NF6$1_1.vout.n16 0.0265126
R7939 iqmod_mfb_lpf_pex_half_1.iqmod_mfb_lpf_pex_ota_core_hybrid_bm_half_0.iqmod_mfb_lpf_pex_ota_core_inv_NF6$1_1.vout.n16 iqmod_mfb_lpf_pex_half_1.iqmod_mfb_lpf_pex_ota_core_hybrid_bm_half_0.iqmod_mfb_lpf_pex_ota_core_inv_NF6$1_1.vout.n15 0.12194
R7940 iqmod_mfb_lpf_pex_half_1.iqmod_mfb_lpf_pex_ota_core_hybrid_bm_half_0.iqmod_mfb_lpf_pex_ota_core_inv_NF6$1_1.vout.n15 iqmod_mfb_lpf_pex_half_1.iqmod_mfb_lpf_pex_ota_core_hybrid_bm_half_0.iqmod_mfb_lpf_pex_ota_core_inv_NF6$1_1.vout.n14 0.12194
R7941 iqmod_mfb_lpf_pex_half_1.iqmod_mfb_lpf_pex_ota_core_hybrid_bm_half_0.iqmod_mfb_lpf_pex_ota_core_inv_NF6$1_1.vout.n14 iqmod_mfb_lpf_pex_half_1.iqmod_mfb_lpf_pex_ota_core_hybrid_bm_half_0.iqmod_mfb_lpf_pex_ota_core_inv_NF6$1_1.vout.n22 0.0265126
R7942 iqmod_mfb_lpf_pex_half_1.iqmod_mfb_lpf_pex_ota_core_hybrid_bm_half_0.iqmod_mfb_lpf_pex_ota_core_inv_NF6$1_1.vout.n13 iqmod_mfb_lpf_pex_half_1.iqmod_mfb_lpf_pex_ota_core_hybrid_bm_half_0.iqmod_mfb_lpf_pex_ota_core_inv_NF6$1_1.vout.n12 1.67826
R7943 iqmod_mfb_lpf_pex_half_1.iqmod_mfb_lpf_pex_ota_core_hybrid_bm_half_0.iqmod_mfb_lpf_pex_ota_core_inv_NF6$1_1.vout.n23 iqmod_mfb_lpf_pex_half_1.iqmod_mfb_lpf_pex_ota_core_hybrid_bm_half_0.iqmod_mfb_lpf_pex_ota_core_inv_NF6$1_1.vout.n21 0.0847067
R7944 iqmod_mfb_lpf_pex_half_1.iqmod_mfb_lpf_pex_ota_core_hybrid_bm_half_0.iqmod_mfb_lpf_pex_ota_core_inv_NF6$1_1.vout.n13 iqmod_mfb_lpf_pex_half_1.iqmod_mfb_lpf_pex_ota_core_hybrid_bm_half_0.iqmod_mfb_lpf_pex_ota_core_inv_NF6$1_1.vout.n22 0.0847067
R7945 iqmod_mfb_lpf_pex_half_1.iqmod_mfb_lpf_pex_ota_core_hybrid_bm_half_0.iqmod_mfb_lpf_pex_ota_core_inv_NF6$1_1.vout.n22 iqmod_mfb_lpf_pex_half_1.iqmod_mfb_lpf_pex_ota_core_hybrid_bm_half_0.iqmod_mfb_lpf_pex_ota_core_inv_NF6$1_1.vout.n20 0.754036
R7946 iqmod_mfb_lpf_pex_half_1.iqmod_mfb_lpf_pex_ota_core_hybrid_bm_half_0.iqmod_mfb_lpf_pex_ota_core_inv_NF6$1_1.vout.n21 iqmod_mfb_lpf_pex_half_1.iqmod_mfb_lpf_pex_ota_core_hybrid_bm_half_0.iqmod_mfb_lpf_pex_ota_core_inv_NF6$1_1.vout.n20 0.754036
R7947 iqmod_mfb_lpf_pex_half_1.iqmod_mfb_lpf_pex_ota_core_hybrid_bm_half_0.iqmod_mfb_lpf_pex_ota_core_inv_NF6$1_1.vout.n15 iqmod_mfb_lpf_pex_half_1.iqmod_mfb_lpf_pex_ota_core_hybrid_bm_half_0.iqmod_mfb_lpf_pex_ota_core_inv_NF6$1_1.vout.n20 0.254024
R7948 iqmod_mfb_lpf_pex_half_1.iqmod_mfb_lpf_pex_ota_core_hybrid_bm_half_0.iqmod_mfb_lpf_pex_ota_core_inv_NF6$1_1.vout.t27 iqmod_mfb_lpf_pex_half_1.iqmod_mfb_lpf_pex_ota_core_hybrid_bm_half_0.iqmod_mfb_lpf_pex_ota_core_inv_NF6$1_1.vout.n20 1.53248
R7949 iqmod_mfb_lpf_pex_half_1.iqmod_mfb_lpf_pex_ota_core_hybrid_bm_half_0.iqmod_mfb_lpf_pex_ota_core_inv_NF6$1_1.vout.n23 iqmod_mfb_lpf_pex_half_1.iqmod_mfb_lpf_pex_ota_core_hybrid_bm_half_0.iqmod_mfb_lpf_pex_ota_core_inv_NF6$1_1.vout.n19 0.83231
R7950 iqmod_mfb_lpf_pex_half_1.iqmod_mfb_lpf_pex_ota_core_hybrid_bm_half_0.iqmod_mfb_lpf_pex_ota_core_inv_NF6$1_1.vout.n19 iqmod_mfb_lpf_pex_half_1.iqmod_mfb_lpf_pex_ota_core_hybrid_bm_half_0.iqmod_mfb_lpf_pex_ota_core_inv_NF6$1_1.vout.n17 0.578786
R7951 iqmod_mfb_lpf_pex_half_1.iqmod_mfb_lpf_pex_ota_core_hybrid_bm_half_0.iqmod_mfb_lpf_pex_ota_core_inv_NF6$1_1.vout.n17 iqmod_mfb_lpf_pex_half_1.iqmod_mfb_lpf_pex_ota_core_hybrid_bm_half_0.iqmod_mfb_lpf_pex_ota_core_inv_NF6$1_1.vout.n18 0.578786
R7952 iqmod_mfb_lpf_pex_half_1.iqmod_mfb_lpf_pex_ota_core_hybrid_bm_half_0.iqmod_mfb_lpf_pex_ota_core_inv_NF6$1_1.vout.n19 iqmod_mfb_lpf_pex_half_1.iqmod_mfb_lpf_pex_ota_core_hybrid_bm_half_0.iqmod_mfb_lpf_pex_ota_core_inv_NF6$1_1.vout.n16 0.254024
R7953 iqmod_mfb_lpf_pex_half_1.iqmod_mfb_lpf_pex_ota_core_hybrid_bm_half_0.iqmod_mfb_lpf_pex_ota_core_inv_NF6$1_1.vout.n18 iqmod_mfb_lpf_pex_half_1.iqmod_mfb_lpf_pex_ota_core_hybrid_bm_half_0.iqmod_mfb_lpf_pex_ota_core_inv_NF6$1_1.vout.n14 0.254024
R7954 iqmod_mfb_lpf_pex_half_1.iqmod_mfb_lpf_pex_ota_core_hybrid_bm_half_0.iqmod_mfb_lpf_pex_ota_core_inv_NF6$1_1.vout.n18 iqmod_mfb_lpf_pex_half_1.iqmod_mfb_lpf_pex_ota_core_hybrid_bm_half_0.iqmod_mfb_lpf_pex_ota_core_inv_NF6$1_1.vout.n13 0.83231
R7955 iqmod_mfb_lpf_pex_half_1.iqmod_mfb_lpf_pex_ota_core_hybrid_bm_half_0.iqmod_mfb_lpf_pex_ota_core_inv_NF6$1_1.vout.n17 iqmod_mfb_lpf_pex_half_1.iqmod_mfb_lpf_pex_ota_core_hybrid_bm_half_0.iqmod_mfb_lpf_pex_ota_core_inv_NF6$1_1.vout.n15 0.254024
R7956 iqmod_mfb_lpf_pex_half_1.iqmod_mfb_lpf_pex_ota_core_hybrid_bm_half_0.iqmod_mfb_lpf_pex_ota_core_inv_NF6$1_1.vout.t26 iqmod_mfb_lpf_pex_half_1.iqmod_mfb_lpf_pex_ota_core_hybrid_bm_half_0.iqmod_mfb_lpf_pex_ota_core_inv_NF6$1_1.vout.n17 1.53248
R7957 iqmod_mfb_lpf_pex_half_1.iqmod_mfb_lpf_pex_ota_core_hybrid_bm_half_0.iqmod_mfb_lpf_pex_ota_core_inv_NF6$1_1.vout iqmod_mfb_lpf_pex_half_1.iqmod_mfb_lpf_pex_ota_core_hybrid_bm_half_0.iqmod_mfb_lpf_pex_ota_core_inv_NF6$1_1.vout.n10 0.00974
R7958 iqmod_mfb_lpf_pex_half_1.iqmod_mfb_lpf_pex_ota_core_hybrid_bm_half_0.iqmod_mfb_lpf_pex_ota_core_inv_NF6$1_1.vout.n8 iqmod_mfb_lpf_pex_half_1.iqmod_mfb_lpf_pex_ota_core_hybrid_bm_half_0.iqmod_mfb_lpf_pex_ota_core_inv_NF6$1_1.vout.n3 0.0265126
R7959 iqmod_mfb_lpf_pex_half_1.iqmod_mfb_lpf_pex_ota_core_hybrid_bm_half_0.iqmod_mfb_lpf_pex_ota_core_inv_NF6$1_1.vout.n3 iqmod_mfb_lpf_pex_half_1.iqmod_mfb_lpf_pex_ota_core_hybrid_bm_half_0.iqmod_mfb_lpf_pex_ota_core_inv_NF6$1_1.vout.n2 0.12194
R7960 iqmod_mfb_lpf_pex_half_1.iqmod_mfb_lpf_pex_ota_core_hybrid_bm_half_0.iqmod_mfb_lpf_pex_ota_core_inv_NF6$1_1.vout.n2 iqmod_mfb_lpf_pex_half_1.iqmod_mfb_lpf_pex_ota_core_hybrid_bm_half_0.iqmod_mfb_lpf_pex_ota_core_inv_NF6$1_1.vout.n1 0.12194
R7961 iqmod_mfb_lpf_pex_half_1.iqmod_mfb_lpf_pex_ota_core_hybrid_bm_half_0.iqmod_mfb_lpf_pex_ota_core_inv_NF6$1_1.vout.n1 iqmod_mfb_lpf_pex_half_1.iqmod_mfb_lpf_pex_ota_core_hybrid_bm_half_0.iqmod_mfb_lpf_pex_ota_core_inv_NF6$1_1.vout.n9 0.0265126
R7962 iqmod_mfb_lpf_pex_half_1.iqmod_mfb_lpf_pex_ota_core_hybrid_bm_half_0.iqmod_mfb_lpf_pex_ota_core_inv_NF6$1_1.vout.n0 iqmod_mfb_lpf_pex_half_1.iqmod_mfb_lpf_pex_ota_core_hybrid_bm_half_0.iqmod_mfb_lpf_pex_ota_core_inv_NF6$1_1.vout.n11 1.67826
R7963 iqmod_mfb_lpf_pex_half_1.iqmod_mfb_lpf_pex_ota_core_hybrid_bm_half_0.iqmod_mfb_lpf_pex_ota_core_inv_NF6$1_1.vout.n10 iqmod_mfb_lpf_pex_half_1.iqmod_mfb_lpf_pex_ota_core_hybrid_bm_half_0.iqmod_mfb_lpf_pex_ota_core_inv_NF6$1_1.vout.n8 0.0847067
R7964 iqmod_mfb_lpf_pex_half_1.iqmod_mfb_lpf_pex_ota_core_hybrid_bm_half_0.iqmod_mfb_lpf_pex_ota_core_inv_NF6$1_1.vout.n0 iqmod_mfb_lpf_pex_half_1.iqmod_mfb_lpf_pex_ota_core_hybrid_bm_half_0.iqmod_mfb_lpf_pex_ota_core_inv_NF6$1_1.vout.n9 0.0847067
R7965 iqmod_mfb_lpf_pex_half_1.iqmod_mfb_lpf_pex_ota_core_hybrid_bm_half_0.iqmod_mfb_lpf_pex_ota_core_inv_NF6$1_1.vout.n9 iqmod_mfb_lpf_pex_half_1.iqmod_mfb_lpf_pex_ota_core_hybrid_bm_half_0.iqmod_mfb_lpf_pex_ota_core_inv_NF6$1_1.vout.n7 0.754036
R7966 iqmod_mfb_lpf_pex_half_1.iqmod_mfb_lpf_pex_ota_core_hybrid_bm_half_0.iqmod_mfb_lpf_pex_ota_core_inv_NF6$1_1.vout.n8 iqmod_mfb_lpf_pex_half_1.iqmod_mfb_lpf_pex_ota_core_hybrid_bm_half_0.iqmod_mfb_lpf_pex_ota_core_inv_NF6$1_1.vout.n7 0.754036
R7967 iqmod_mfb_lpf_pex_half_1.iqmod_mfb_lpf_pex_ota_core_hybrid_bm_half_0.iqmod_mfb_lpf_pex_ota_core_inv_NF6$1_1.vout.n2 iqmod_mfb_lpf_pex_half_1.iqmod_mfb_lpf_pex_ota_core_hybrid_bm_half_0.iqmod_mfb_lpf_pex_ota_core_inv_NF6$1_1.vout.n7 0.254024
R7968 iqmod_mfb_lpf_pex_half_1.iqmod_mfb_lpf_pex_ota_core_hybrid_bm_half_0.iqmod_mfb_lpf_pex_ota_core_inv_NF6$1_1.vout.t25 iqmod_mfb_lpf_pex_half_1.iqmod_mfb_lpf_pex_ota_core_hybrid_bm_half_0.iqmod_mfb_lpf_pex_ota_core_inv_NF6$1_1.vout.n7 1.53248
R7969 iqmod_mfb_lpf_pex_half_1.iqmod_mfb_lpf_pex_ota_core_hybrid_bm_half_0.iqmod_mfb_lpf_pex_ota_core_inv_NF6$1_1.vout.n10 iqmod_mfb_lpf_pex_half_1.iqmod_mfb_lpf_pex_ota_core_hybrid_bm_half_0.iqmod_mfb_lpf_pex_ota_core_inv_NF6$1_1.vout.n6 0.83231
R7970 iqmod_mfb_lpf_pex_half_1.iqmod_mfb_lpf_pex_ota_core_hybrid_bm_half_0.iqmod_mfb_lpf_pex_ota_core_inv_NF6$1_1.vout.n6 iqmod_mfb_lpf_pex_half_1.iqmod_mfb_lpf_pex_ota_core_hybrid_bm_half_0.iqmod_mfb_lpf_pex_ota_core_inv_NF6$1_1.vout.n4 0.578786
R7971 iqmod_mfb_lpf_pex_half_1.iqmod_mfb_lpf_pex_ota_core_hybrid_bm_half_0.iqmod_mfb_lpf_pex_ota_core_inv_NF6$1_1.vout.n4 iqmod_mfb_lpf_pex_half_1.iqmod_mfb_lpf_pex_ota_core_hybrid_bm_half_0.iqmod_mfb_lpf_pex_ota_core_inv_NF6$1_1.vout.n5 0.578786
R7972 iqmod_mfb_lpf_pex_half_1.iqmod_mfb_lpf_pex_ota_core_hybrid_bm_half_0.iqmod_mfb_lpf_pex_ota_core_inv_NF6$1_1.vout.n6 iqmod_mfb_lpf_pex_half_1.iqmod_mfb_lpf_pex_ota_core_hybrid_bm_half_0.iqmod_mfb_lpf_pex_ota_core_inv_NF6$1_1.vout.n3 0.254024
R7973 iqmod_mfb_lpf_pex_half_1.iqmod_mfb_lpf_pex_ota_core_hybrid_bm_half_0.iqmod_mfb_lpf_pex_ota_core_inv_NF6$1_1.vout.n5 iqmod_mfb_lpf_pex_half_1.iqmod_mfb_lpf_pex_ota_core_hybrid_bm_half_0.iqmod_mfb_lpf_pex_ota_core_inv_NF6$1_1.vout.n1 0.254024
R7974 iqmod_mfb_lpf_pex_half_1.iqmod_mfb_lpf_pex_ota_core_hybrid_bm_half_0.iqmod_mfb_lpf_pex_ota_core_inv_NF6$1_1.vout.n5 iqmod_mfb_lpf_pex_half_1.iqmod_mfb_lpf_pex_ota_core_hybrid_bm_half_0.iqmod_mfb_lpf_pex_ota_core_inv_NF6$1_1.vout.n0 0.83231
R7975 iqmod_mfb_lpf_pex_half_1.iqmod_mfb_lpf_pex_ota_core_hybrid_bm_half_0.iqmod_mfb_lpf_pex_ota_core_inv_NF6$1_1.vout.n4 iqmod_mfb_lpf_pex_half_1.iqmod_mfb_lpf_pex_ota_core_hybrid_bm_half_0.iqmod_mfb_lpf_pex_ota_core_inv_NF6$1_1.vout.n2 0.254024
R7976 iqmod_mfb_lpf_pex_half_1.iqmod_mfb_lpf_pex_ota_core_hybrid_bm_half_0.iqmod_mfb_lpf_pex_ota_core_inv_NF6$1_1.vout.t24 iqmod_mfb_lpf_pex_half_1.iqmod_mfb_lpf_pex_ota_core_hybrid_bm_half_0.iqmod_mfb_lpf_pex_ota_core_inv_NF6$1_1.vout.n4 1.53248
R7977 iqmod_mfb_lpf_pex_half_1.iqmod_mfb_lpf_pex_ota_core_hybrid_bm_half_0.iqmod_mfb_lpf_pex_ota_core_tg$1_0.v_b.t8 iqmod_mfb_lpf_pex_half_1.iqmod_mfb_lpf_pex_ota_core_hybrid_bm_half_0.iqmod_mfb_lpf_pex_ota_core_tg$1_0.v_b.n0 10.2939
R7978 iqmod_mfb_lpf_pex_half_1.iqmod_mfb_lpf_pex_ota_core_hybrid_bm_half_0.iqmod_mfb_lpf_pex_ota_core_tg$1_0.v_b.n126 iqmod_mfb_lpf_pex_half_1.iqmod_mfb_lpf_pex_ota_core_hybrid_bm_half_0.iqmod_mfb_lpf_pex_ota_core_tg$1_0.v_b.n127 0.16242
R7979 iqmod_mfb_lpf_pex_half_1.iqmod_mfb_lpf_pex_ota_core_hybrid_bm_half_0.iqmod_mfb_lpf_pex_ota_core_tg$1_0.v_b.n0 iqmod_mfb_lpf_pex_half_1.iqmod_mfb_lpf_pex_ota_core_hybrid_bm_half_0.iqmod_mfb_lpf_pex_ota_core_tg$1_0.v_b.n126 0.16242
R7980 iqmod_mfb_lpf_pex_half_1.iqmod_mfb_lpf_pex_ota_core_hybrid_bm_half_0.iqmod_mfb_lpf_pex_ota_core_tg$1_0.v_b iqmod_mfb_lpf_pex_half_1.iqmod_mfb_lpf_pex_ota_core_hybrid_bm_half_0.iqmod_mfb_lpf_pex_ota_core_tg$1_0.v_b.n0 0.0151667
R7981 iqmod_mfb_lpf_pex_half_1.iqmod_mfb_lpf_pex_ota_core_hybrid_bm_half_0.iqmod_mfb_lpf_pex_ota_core_tg$1_0.v_b.n127 iqmod_mfb_lpf_pex_half_1.iqmod_mfb_lpf_pex_ota_core_hybrid_bm_half_0.iqmod_mfb_lpf_pex_ota_core_tg$1_0.v_b.t6 10.2939
R7982 iqmod_mfb_lpf_pex_half_1.iqmod_mfb_lpf_pex_ota_core_hybrid_bm_half_0.iqmod_mfb_lpf_pex_ota_core_tg$1_0.v_b.n127 iqmod_mfb_lpf_pex_half_1.iqmod_mfb_lpf_pex_ota_core_hybrid_bm_half_0.iqmod_mfb_lpf_pex_ota_core_tg$1_0.v_b.t12 2.0693
R7983 iqmod_mfb_lpf_pex_half_1.iqmod_mfb_lpf_pex_ota_core_hybrid_bm_half_0.iqmod_mfb_lpf_pex_ota_core_tg$1_0.v_b.n126 iqmod_mfb_lpf_pex_half_1.iqmod_mfb_lpf_pex_ota_core_hybrid_bm_half_0.iqmod_mfb_lpf_pex_ota_core_tg$1_0.v_b.t7 10.2939
R7984 iqmod_mfb_lpf_pex_half_1.iqmod_mfb_lpf_pex_ota_core_hybrid_bm_half_0.iqmod_mfb_lpf_pex_ota_core_tg$1_0.v_b.n126 iqmod_mfb_lpf_pex_half_1.iqmod_mfb_lpf_pex_ota_core_hybrid_bm_half_0.iqmod_mfb_lpf_pex_ota_core_tg$1_0.v_b.t13 2.0693
R7985 iqmod_mfb_lpf_pex_half_1.iqmod_mfb_lpf_pex_ota_core_hybrid_bm_half_0.iqmod_mfb_lpf_pex_ota_core_tg$1_0.v_b.n127 iqmod_mfb_lpf_pex_half_1.iqmod_mfb_lpf_pex_ota_core_hybrid_bm_half_0.iqmod_mfb_lpf_pex_ota_core_tg$1_0.v_b.n54 0.454433
R7986 iqmod_mfb_lpf_pex_half_1.iqmod_mfb_lpf_pex_ota_core_hybrid_bm_half_0.iqmod_mfb_lpf_pex_ota_core_tg$1_0.v_b.n54 iqmod_mfb_lpf_pex_half_1.iqmod_mfb_lpf_pex_ota_core_hybrid_bm_half_0.iqmod_mfb_lpf_pex_ota_core_tg$1_0.v_b.n112 1.69355
R7987 iqmod_mfb_lpf_pex_half_1.iqmod_mfb_lpf_pex_ota_core_hybrid_bm_half_0.iqmod_mfb_lpf_pex_ota_core_tg$1_0.v_b.n112 iqmod_mfb_lpf_pex_half_1.iqmod_mfb_lpf_pex_ota_core_hybrid_bm_half_0.iqmod_mfb_lpf_pex_ota_core_tg$1_0.v_b.n125 0.443671
R7988 iqmod_mfb_lpf_pex_half_1.iqmod_mfb_lpf_pex_ota_core_hybrid_bm_half_0.iqmod_mfb_lpf_pex_ota_core_tg$1_0.v_b.n125 iqmod_mfb_lpf_pex_half_1.iqmod_mfb_lpf_pex_ota_core_hybrid_bm_half_0.iqmod_mfb_lpf_pex_ota_core_tg$1_0.v_b.n55 1.69355
R7989 iqmod_mfb_lpf_pex_half_1.iqmod_mfb_lpf_pex_ota_core_hybrid_bm_half_0.iqmod_mfb_lpf_pex_ota_core_tg$1_0.v_b.n124 iqmod_mfb_lpf_pex_half_1.iqmod_mfb_lpf_pex_ota_core_hybrid_bm_half_0.iqmod_mfb_lpf_pex_ota_core_tg$1_0.v_b.n125 5.0609
R7990 iqmod_mfb_lpf_pex_half_1.iqmod_mfb_lpf_pex_ota_core_hybrid_bm_half_0.iqmod_mfb_lpf_pex_ota_core_tg$1_0.v_b.n123 iqmod_mfb_lpf_pex_half_1.iqmod_mfb_lpf_pex_ota_core_hybrid_bm_half_0.iqmod_mfb_lpf_pex_ota_core_tg$1_0.v_b.n124 0.443671
R7991 iqmod_mfb_lpf_pex_half_1.iqmod_mfb_lpf_pex_ota_core_hybrid_bm_half_0.iqmod_mfb_lpf_pex_ota_core_tg$1_0.v_b.n112 iqmod_mfb_lpf_pex_half_1.iqmod_mfb_lpf_pex_ota_core_hybrid_bm_half_0.iqmod_mfb_lpf_pex_ota_core_tg$1_0.v_b.n123 5.0609
R7992 iqmod_mfb_lpf_pex_half_1.iqmod_mfb_lpf_pex_ota_core_hybrid_bm_half_0.iqmod_mfb_lpf_pex_ota_core_tg$1_0.v_b.n122 iqmod_mfb_lpf_pex_half_1.iqmod_mfb_lpf_pex_ota_core_hybrid_bm_half_0.iqmod_mfb_lpf_pex_ota_core_tg$1_0.v_b.n121 0.16242
R7993 iqmod_mfb_lpf_pex_half_1.iqmod_mfb_lpf_pex_ota_core_hybrid_bm_half_0.iqmod_mfb_lpf_pex_ota_core_tg$1_0.v_b.n121 iqmod_mfb_lpf_pex_half_1.iqmod_mfb_lpf_pex_ota_core_hybrid_bm_half_0.iqmod_mfb_lpf_pex_ota_core_tg$1_0.v_b.n120 0.16242
R7994 iqmod_mfb_lpf_pex_half_1.iqmod_mfb_lpf_pex_ota_core_hybrid_bm_half_0.iqmod_mfb_lpf_pex_ota_core_tg$1_0.v_b.n120 iqmod_mfb_lpf_pex_half_1.iqmod_mfb_lpf_pex_ota_core_hybrid_bm_half_0.iqmod_mfb_lpf_pex_ota_core_tg$1_0.v_b 0.0151667
R7995 iqmod_mfb_lpf_pex_half_1.iqmod_mfb_lpf_pex_ota_core_hybrid_bm_half_0.iqmod_mfb_lpf_pex_ota_core_tg$1_0.v_b iqmod_mfb_lpf_pex_half_1.iqmod_mfb_lpf_pex_ota_core_hybrid_bm_half_0.iqmod_mfb_lpf_pex_ota_core_tg$1_0.v_b.n123 1.89389
R7996 iqmod_mfb_lpf_pex_half_1.iqmod_mfb_lpf_pex_ota_core_hybrid_bm_half_0.iqmod_mfb_lpf_pex_ota_core_tg$1_0.v_b.n122 iqmod_mfb_lpf_pex_half_1.iqmod_mfb_lpf_pex_ota_core_hybrid_bm_half_0.iqmod_mfb_lpf_pex_ota_core_tg$1_0.v_b.t15 10.2939
R7997 iqmod_mfb_lpf_pex_half_1.iqmod_mfb_lpf_pex_ota_core_hybrid_bm_half_0.iqmod_mfb_lpf_pex_ota_core_tg$1_0.v_b.t18 iqmod_mfb_lpf_pex_half_1.iqmod_mfb_lpf_pex_ota_core_hybrid_bm_half_0.iqmod_mfb_lpf_pex_ota_core_tg$1_0.v_b.n122 2.0693
R7998 iqmod_mfb_lpf_pex_half_1.iqmod_mfb_lpf_pex_ota_core_hybrid_bm_half_0.iqmod_mfb_lpf_pex_ota_core_tg$1_0.v_b.n121 iqmod_mfb_lpf_pex_half_1.iqmod_mfb_lpf_pex_ota_core_hybrid_bm_half_0.iqmod_mfb_lpf_pex_ota_core_tg$1_0.v_b.t16 10.2939
R7999 iqmod_mfb_lpf_pex_half_1.iqmod_mfb_lpf_pex_ota_core_hybrid_bm_half_0.iqmod_mfb_lpf_pex_ota_core_tg$1_0.v_b.t19 iqmod_mfb_lpf_pex_half_1.iqmod_mfb_lpf_pex_ota_core_hybrid_bm_half_0.iqmod_mfb_lpf_pex_ota_core_tg$1_0.v_b.n121 2.0693
R8000 iqmod_mfb_lpf_pex_half_1.iqmod_mfb_lpf_pex_ota_core_hybrid_bm_half_0.iqmod_mfb_lpf_pex_ota_core_tg$1_0.v_b.n120 iqmod_mfb_lpf_pex_half_1.iqmod_mfb_lpf_pex_ota_core_hybrid_bm_half_0.iqmod_mfb_lpf_pex_ota_core_tg$1_0.v_b.t17 10.2939
R8001 iqmod_mfb_lpf_pex_half_1.iqmod_mfb_lpf_pex_ota_core_hybrid_bm_half_0.iqmod_mfb_lpf_pex_ota_core_tg$1_0.v_b.t20 iqmod_mfb_lpf_pex_half_1.iqmod_mfb_lpf_pex_ota_core_hybrid_bm_half_0.iqmod_mfb_lpf_pex_ota_core_tg$1_0.v_b.n120 2.0693
R8002 iqmod_mfb_lpf_pex_half_1.iqmod_mfb_lpf_pex_ota_core_hybrid_bm_half_0.iqmod_mfb_lpf_pex_ota_core_tg$1_0.v_b.n119 iqmod_mfb_lpf_pex_half_1.iqmod_mfb_lpf_pex_ota_core_hybrid_bm_half_0.iqmod_mfb_lpf_pex_ota_core_tg$1_0.v_b.n118 0.09026
R8003 iqmod_mfb_lpf_pex_half_1.iqmod_mfb_lpf_pex_ota_core_hybrid_bm_half_0.iqmod_mfb_lpf_pex_ota_core_tg$1_0.v_b.n118 iqmod_mfb_lpf_pex_half_1.iqmod_mfb_lpf_pex_ota_core_hybrid_bm_half_0.iqmod_mfb_lpf_pex_ota_core_tg$1_0.v_b 0.09026
R8004 iqmod_mfb_lpf_pex_half_1.iqmod_mfb_lpf_pex_ota_core_hybrid_bm_half_0.iqmod_mfb_lpf_pex_ota_core_tg$1_0.v_b iqmod_mfb_lpf_pex_half_1.iqmod_mfb_lpf_pex_ota_core_hybrid_bm_half_0.iqmod_mfb_lpf_pex_ota_core_tg$1_0.v_b.n122 0.451353
R8005 iqmod_mfb_lpf_pex_half_1.iqmod_mfb_lpf_pex_ota_core_hybrid_bm_half_0.iqmod_mfb_lpf_pex_ota_core_tg$1_0.v_b iqmod_mfb_lpf_pex_half_1.iqmod_mfb_lpf_pex_ota_core_hybrid_bm_half_0.iqmod_mfb_lpf_pex_ota_core_tg$1_0.v_b.t23 14.9798
R8006 iqmod_mfb_lpf_pex_half_1.iqmod_mfb_lpf_pex_ota_core_hybrid_bm_half_0.iqmod_mfb_lpf_pex_ota_core_tg$1_0.v_b.t29 iqmod_mfb_lpf_pex_half_1.iqmod_mfb_lpf_pex_ota_core_hybrid_bm_half_0.iqmod_mfb_lpf_pex_ota_core_tg$1_0.v_b 3.25207
R8007 iqmod_mfb_lpf_pex_half_1.iqmod_mfb_lpf_pex_ota_core_hybrid_bm_half_0.iqmod_mfb_lpf_pex_ota_core_tg$1_0.v_b.n119 iqmod_mfb_lpf_pex_half_1.iqmod_mfb_lpf_pex_ota_core_hybrid_bm_half_0.iqmod_mfb_lpf_pex_ota_core_tg$1_0.v_b.t21 14.9798
R8008 iqmod_mfb_lpf_pex_half_1.iqmod_mfb_lpf_pex_ota_core_hybrid_bm_half_0.iqmod_mfb_lpf_pex_ota_core_tg$1_0.v_b.t27 iqmod_mfb_lpf_pex_half_1.iqmod_mfb_lpf_pex_ota_core_hybrid_bm_half_0.iqmod_mfb_lpf_pex_ota_core_tg$1_0.v_b.n119 3.25207
R8009 iqmod_mfb_lpf_pex_half_1.iqmod_mfb_lpf_pex_ota_core_hybrid_bm_half_0.iqmod_mfb_lpf_pex_ota_core_tg$1_0.v_b.n118 iqmod_mfb_lpf_pex_half_1.iqmod_mfb_lpf_pex_ota_core_hybrid_bm_half_0.iqmod_mfb_lpf_pex_ota_core_tg$1_0.v_b.t22 14.9798
R8010 iqmod_mfb_lpf_pex_half_1.iqmod_mfb_lpf_pex_ota_core_hybrid_bm_half_0.iqmod_mfb_lpf_pex_ota_core_tg$1_0.v_b.t28 iqmod_mfb_lpf_pex_half_1.iqmod_mfb_lpf_pex_ota_core_hybrid_bm_half_0.iqmod_mfb_lpf_pex_ota_core_tg$1_0.v_b.n118 3.25207
R8011 iqmod_mfb_lpf_pex_half_1.iqmod_mfb_lpf_pex_ota_core_hybrid_bm_half_0.iqmod_mfb_lpf_pex_ota_core_tg$1_0.v_b.n117 iqmod_mfb_lpf_pex_half_1.iqmod_mfb_lpf_pex_ota_core_hybrid_bm_half_0.iqmod_mfb_lpf_pex_ota_core_tg$1_0.v_b.n116 0.16242
R8012 iqmod_mfb_lpf_pex_half_1.iqmod_mfb_lpf_pex_ota_core_hybrid_bm_half_0.iqmod_mfb_lpf_pex_ota_core_tg$1_0.v_b.n116 iqmod_mfb_lpf_pex_half_1.iqmod_mfb_lpf_pex_ota_core_hybrid_bm_half_0.iqmod_mfb_lpf_pex_ota_core_tg$1_0.v_b.n115 0.16242
R8013 iqmod_mfb_lpf_pex_half_1.iqmod_mfb_lpf_pex_ota_core_hybrid_bm_half_0.iqmod_mfb_lpf_pex_ota_core_tg$1_0.v_b.n115 iqmod_mfb_lpf_pex_half_1.iqmod_mfb_lpf_pex_ota_core_hybrid_bm_half_0.iqmod_mfb_lpf_pex_ota_core_tg$1_0.v_b 0.0151667
R8014 iqmod_mfb_lpf_pex_half_1.iqmod_mfb_lpf_pex_ota_core_hybrid_bm_half_0.iqmod_mfb_lpf_pex_ota_core_tg$1_0.v_b iqmod_mfb_lpf_pex_half_1.iqmod_mfb_lpf_pex_ota_core_hybrid_bm_half_0.iqmod_mfb_lpf_pex_ota_core_tg$1_0.v_b.n124 1.89389
R8015 iqmod_mfb_lpf_pex_half_1.iqmod_mfb_lpf_pex_ota_core_hybrid_bm_half_0.iqmod_mfb_lpf_pex_ota_core_tg$1_0.v_b.t33 iqmod_mfb_lpf_pex_half_1.iqmod_mfb_lpf_pex_ota_core_hybrid_bm_half_0.iqmod_mfb_lpf_pex_ota_core_tg$1_0.v_b.n117 2.0693
R8016 iqmod_mfb_lpf_pex_half_1.iqmod_mfb_lpf_pex_ota_core_hybrid_bm_half_0.iqmod_mfb_lpf_pex_ota_core_tg$1_0.v_b.n117 iqmod_mfb_lpf_pex_half_1.iqmod_mfb_lpf_pex_ota_core_hybrid_bm_half_0.iqmod_mfb_lpf_pex_ota_core_tg$1_0.v_b.t30 10.2939
R8017 iqmod_mfb_lpf_pex_half_1.iqmod_mfb_lpf_pex_ota_core_hybrid_bm_half_0.iqmod_mfb_lpf_pex_ota_core_tg$1_0.v_b.t34 iqmod_mfb_lpf_pex_half_1.iqmod_mfb_lpf_pex_ota_core_hybrid_bm_half_0.iqmod_mfb_lpf_pex_ota_core_tg$1_0.v_b.n116 2.0693
R8018 iqmod_mfb_lpf_pex_half_1.iqmod_mfb_lpf_pex_ota_core_hybrid_bm_half_0.iqmod_mfb_lpf_pex_ota_core_tg$1_0.v_b.n116 iqmod_mfb_lpf_pex_half_1.iqmod_mfb_lpf_pex_ota_core_hybrid_bm_half_0.iqmod_mfb_lpf_pex_ota_core_tg$1_0.v_b.t31 10.2939
R8019 iqmod_mfb_lpf_pex_half_1.iqmod_mfb_lpf_pex_ota_core_hybrid_bm_half_0.iqmod_mfb_lpf_pex_ota_core_tg$1_0.v_b.t35 iqmod_mfb_lpf_pex_half_1.iqmod_mfb_lpf_pex_ota_core_hybrid_bm_half_0.iqmod_mfb_lpf_pex_ota_core_tg$1_0.v_b.n115 2.0693
R8020 iqmod_mfb_lpf_pex_half_1.iqmod_mfb_lpf_pex_ota_core_hybrid_bm_half_0.iqmod_mfb_lpf_pex_ota_core_tg$1_0.v_b.n115 iqmod_mfb_lpf_pex_half_1.iqmod_mfb_lpf_pex_ota_core_hybrid_bm_half_0.iqmod_mfb_lpf_pex_ota_core_tg$1_0.v_b.t32 10.2939
R8021 iqmod_mfb_lpf_pex_half_1.iqmod_mfb_lpf_pex_ota_core_hybrid_bm_half_0.iqmod_mfb_lpf_pex_ota_core_tg$1_0.v_b.n114 iqmod_mfb_lpf_pex_half_1.iqmod_mfb_lpf_pex_ota_core_hybrid_bm_half_0.iqmod_mfb_lpf_pex_ota_core_tg$1_0.v_b.n113 0.09026
R8022 iqmod_mfb_lpf_pex_half_1.iqmod_mfb_lpf_pex_ota_core_hybrid_bm_half_0.iqmod_mfb_lpf_pex_ota_core_tg$1_0.v_b.n113 iqmod_mfb_lpf_pex_half_1.iqmod_mfb_lpf_pex_ota_core_hybrid_bm_half_0.iqmod_mfb_lpf_pex_ota_core_tg$1_0.v_b 0.09026
R8023 iqmod_mfb_lpf_pex_half_1.iqmod_mfb_lpf_pex_ota_core_hybrid_bm_half_0.iqmod_mfb_lpf_pex_ota_core_tg$1_0.v_b iqmod_mfb_lpf_pex_half_1.iqmod_mfb_lpf_pex_ota_core_hybrid_bm_half_0.iqmod_mfb_lpf_pex_ota_core_tg$1_0.v_b.n117 0.451353
R8024 iqmod_mfb_lpf_pex_half_1.iqmod_mfb_lpf_pex_ota_core_hybrid_bm_half_0.iqmod_mfb_lpf_pex_ota_core_tg$1_0.v_b.t2 iqmod_mfb_lpf_pex_half_1.iqmod_mfb_lpf_pex_ota_core_hybrid_bm_half_0.iqmod_mfb_lpf_pex_ota_core_tg$1_0.v_b 3.25207
R8025 iqmod_mfb_lpf_pex_half_1.iqmod_mfb_lpf_pex_ota_core_hybrid_bm_half_0.iqmod_mfb_lpf_pex_ota_core_tg$1_0.v_b iqmod_mfb_lpf_pex_half_1.iqmod_mfb_lpf_pex_ota_core_hybrid_bm_half_0.iqmod_mfb_lpf_pex_ota_core_tg$1_0.v_b.t26 14.9798
R8026 iqmod_mfb_lpf_pex_half_1.iqmod_mfb_lpf_pex_ota_core_hybrid_bm_half_0.iqmod_mfb_lpf_pex_ota_core_tg$1_0.v_b.n114 iqmod_mfb_lpf_pex_half_1.iqmod_mfb_lpf_pex_ota_core_hybrid_bm_half_0.iqmod_mfb_lpf_pex_ota_core_tg$1_0.v_b.t0 3.25011
R8027 iqmod_mfb_lpf_pex_half_1.iqmod_mfb_lpf_pex_ota_core_hybrid_bm_half_0.iqmod_mfb_lpf_pex_ota_core_tg$1_0.v_b.n114 iqmod_mfb_lpf_pex_half_1.iqmod_mfb_lpf_pex_ota_core_hybrid_bm_half_0.iqmod_mfb_lpf_pex_ota_core_tg$1_0.v_b.t24 14.9798
R8028 iqmod_mfb_lpf_pex_half_1.iqmod_mfb_lpf_pex_ota_core_hybrid_bm_half_0.iqmod_mfb_lpf_pex_ota_core_tg$1_0.v_b.t1 iqmod_mfb_lpf_pex_half_1.iqmod_mfb_lpf_pex_ota_core_hybrid_bm_half_0.iqmod_mfb_lpf_pex_ota_core_tg$1_0.v_b.n113 3.25207
R8029 iqmod_mfb_lpf_pex_half_1.iqmod_mfb_lpf_pex_ota_core_hybrid_bm_half_0.iqmod_mfb_lpf_pex_ota_core_tg$1_0.v_b.n113 iqmod_mfb_lpf_pex_half_1.iqmod_mfb_lpf_pex_ota_core_hybrid_bm_half_0.iqmod_mfb_lpf_pex_ota_core_tg$1_0.v_b.t25 14.9798
R8030 iqmod_mfb_lpf_pex_half_1.iqmod_mfb_lpf_pex_ota_core_hybrid_bm_half_0.iqmod_mfb_lpf_pex_ota_core_tg$1_0.v_b.n55 iqmod_mfb_lpf_pex_half_1.iqmod_mfb_lpf_pex_ota_core_hybrid_bm_half_0.iqmod_mfb_lpf_pex_ota_core_tg$1_0.v_b.n111 0.454433
R8031 iqmod_mfb_lpf_pex_half_1.iqmod_mfb_lpf_pex_ota_core_hybrid_bm_half_0.iqmod_mfb_lpf_pex_ota_core_tg$1_0.v_b.n111 iqmod_mfb_lpf_pex_half_1.iqmod_mfb_lpf_pex_ota_core_hybrid_bm_half_0.iqmod_mfb_lpf_pex_ota_core_tg$1_0.v_b.n110 0.16242
R8032 iqmod_mfb_lpf_pex_half_1.iqmod_mfb_lpf_pex_ota_core_hybrid_bm_half_0.iqmod_mfb_lpf_pex_ota_core_tg$1_0.v_b.n110 iqmod_mfb_lpf_pex_half_1.iqmod_mfb_lpf_pex_ota_core_hybrid_bm_half_0.iqmod_mfb_lpf_pex_ota_core_tg$1_0.v_b.n109 0.16242
R8033 iqmod_mfb_lpf_pex_half_1.iqmod_mfb_lpf_pex_ota_core_hybrid_bm_half_0.iqmod_mfb_lpf_pex_ota_core_tg$1_0.v_b.n109 iqmod_mfb_lpf_pex_half_1.iqmod_mfb_lpf_pex_ota_core_hybrid_bm_half_0.iqmod_mfb_lpf_pex_ota_core_tg$1_0.v_b 0.0151667
R8034 iqmod_mfb_lpf_pex_half_1.iqmod_mfb_lpf_pex_ota_core_hybrid_bm_half_0.iqmod_mfb_lpf_pex_ota_core_tg$1_0.v_b.n111 iqmod_mfb_lpf_pex_half_1.iqmod_mfb_lpf_pex_ota_core_hybrid_bm_half_0.iqmod_mfb_lpf_pex_ota_core_tg$1_0.v_b.t9 2.0693
R8035 iqmod_mfb_lpf_pex_half_1.iqmod_mfb_lpf_pex_ota_core_hybrid_bm_half_0.iqmod_mfb_lpf_pex_ota_core_tg$1_0.v_b.n111 iqmod_mfb_lpf_pex_half_1.iqmod_mfb_lpf_pex_ota_core_hybrid_bm_half_0.iqmod_mfb_lpf_pex_ota_core_tg$1_0.v_b.t3 10.2939
R8036 iqmod_mfb_lpf_pex_half_1.iqmod_mfb_lpf_pex_ota_core_hybrid_bm_half_0.iqmod_mfb_lpf_pex_ota_core_tg$1_0.v_b.n110 iqmod_mfb_lpf_pex_half_1.iqmod_mfb_lpf_pex_ota_core_hybrid_bm_half_0.iqmod_mfb_lpf_pex_ota_core_tg$1_0.v_b.t10 2.0693
R8037 iqmod_mfb_lpf_pex_half_1.iqmod_mfb_lpf_pex_ota_core_hybrid_bm_half_0.iqmod_mfb_lpf_pex_ota_core_tg$1_0.v_b.n110 iqmod_mfb_lpf_pex_half_1.iqmod_mfb_lpf_pex_ota_core_hybrid_bm_half_0.iqmod_mfb_lpf_pex_ota_core_tg$1_0.v_b.t4 10.2939
R8038 iqmod_mfb_lpf_pex_half_1.iqmod_mfb_lpf_pex_ota_core_hybrid_bm_half_0.iqmod_mfb_lpf_pex_ota_core_tg$1_0.v_b.n109 iqmod_mfb_lpf_pex_half_1.iqmod_mfb_lpf_pex_ota_core_hybrid_bm_half_0.iqmod_mfb_lpf_pex_ota_core_tg$1_0.v_b.t11 2.0693
R8039 iqmod_mfb_lpf_pex_half_1.iqmod_mfb_lpf_pex_ota_core_hybrid_bm_half_0.iqmod_mfb_lpf_pex_ota_core_tg$1_0.v_b.n109 iqmod_mfb_lpf_pex_half_1.iqmod_mfb_lpf_pex_ota_core_hybrid_bm_half_0.iqmod_mfb_lpf_pex_ota_core_tg$1_0.v_b.t5 10.2939
R8040 iqmod_mfb_lpf_pex_half_1.iqmod_mfb_lpf_pex_ota_core_hybrid_bm_half_0.iqmod_mfb_lpf_pex_ota_core_tg$1_0.v_b iqmod_mfb_lpf_pex_half_1.iqmod_mfb_lpf_pex_ota_core_hybrid_bm_half_0.iqmod_mfb_lpf_pex_ota_core_tg$1_0.v_b.n108 0.00974
R8041 iqmod_mfb_lpf_pex_half_1.iqmod_mfb_lpf_pex_ota_core_hybrid_bm_half_0.iqmod_mfb_lpf_pex_ota_core_tg$1_0.v_b.n73 iqmod_mfb_lpf_pex_half_1.iqmod_mfb_lpf_pex_ota_core_hybrid_bm_half_0.iqmod_mfb_lpf_pex_ota_core_tg$1_0.v_b.n92 0.0265126
R8042 iqmod_mfb_lpf_pex_half_1.iqmod_mfb_lpf_pex_ota_core_hybrid_bm_half_0.iqmod_mfb_lpf_pex_ota_core_tg$1_0.v_b.n72 iqmod_mfb_lpf_pex_half_1.iqmod_mfb_lpf_pex_ota_core_hybrid_bm_half_0.iqmod_mfb_lpf_pex_ota_core_tg$1_0.v_b.n73 0.12194
R8043 iqmod_mfb_lpf_pex_half_1.iqmod_mfb_lpf_pex_ota_core_hybrid_bm_half_0.iqmod_mfb_lpf_pex_ota_core_tg$1_0.v_b.n71 iqmod_mfb_lpf_pex_half_1.iqmod_mfb_lpf_pex_ota_core_hybrid_bm_half_0.iqmod_mfb_lpf_pex_ota_core_tg$1_0.v_b.n72 0.12194
R8044 iqmod_mfb_lpf_pex_half_1.iqmod_mfb_lpf_pex_ota_core_hybrid_bm_half_0.iqmod_mfb_lpf_pex_ota_core_tg$1_0.v_b.n70 iqmod_mfb_lpf_pex_half_1.iqmod_mfb_lpf_pex_ota_core_hybrid_bm_half_0.iqmod_mfb_lpf_pex_ota_core_tg$1_0.v_b.n71 0.12194
R8045 iqmod_mfb_lpf_pex_half_1.iqmod_mfb_lpf_pex_ota_core_hybrid_bm_half_0.iqmod_mfb_lpf_pex_ota_core_tg$1_0.v_b.n69 iqmod_mfb_lpf_pex_half_1.iqmod_mfb_lpf_pex_ota_core_hybrid_bm_half_0.iqmod_mfb_lpf_pex_ota_core_tg$1_0.v_b.n70 0.12194
R8046 iqmod_mfb_lpf_pex_half_1.iqmod_mfb_lpf_pex_ota_core_hybrid_bm_half_0.iqmod_mfb_lpf_pex_ota_core_tg$1_0.v_b.n68 iqmod_mfb_lpf_pex_half_1.iqmod_mfb_lpf_pex_ota_core_hybrid_bm_half_0.iqmod_mfb_lpf_pex_ota_core_tg$1_0.v_b.n69 0.12194
R8047 iqmod_mfb_lpf_pex_half_1.iqmod_mfb_lpf_pex_ota_core_hybrid_bm_half_0.iqmod_mfb_lpf_pex_ota_core_tg$1_0.v_b.n67 iqmod_mfb_lpf_pex_half_1.iqmod_mfb_lpf_pex_ota_core_hybrid_bm_half_0.iqmod_mfb_lpf_pex_ota_core_tg$1_0.v_b.n68 0.12194
R8048 iqmod_mfb_lpf_pex_half_1.iqmod_mfb_lpf_pex_ota_core_hybrid_bm_half_0.iqmod_mfb_lpf_pex_ota_core_tg$1_0.v_b.n66 iqmod_mfb_lpf_pex_half_1.iqmod_mfb_lpf_pex_ota_core_hybrid_bm_half_0.iqmod_mfb_lpf_pex_ota_core_tg$1_0.v_b.n67 0.12194
R8049 iqmod_mfb_lpf_pex_half_1.iqmod_mfb_lpf_pex_ota_core_hybrid_bm_half_0.iqmod_mfb_lpf_pex_ota_core_tg$1_0.v_b.n65 iqmod_mfb_lpf_pex_half_1.iqmod_mfb_lpf_pex_ota_core_hybrid_bm_half_0.iqmod_mfb_lpf_pex_ota_core_tg$1_0.v_b.n66 0.12194
R8050 iqmod_mfb_lpf_pex_half_1.iqmod_mfb_lpf_pex_ota_core_hybrid_bm_half_0.iqmod_mfb_lpf_pex_ota_core_tg$1_0.v_b.n64 iqmod_mfb_lpf_pex_half_1.iqmod_mfb_lpf_pex_ota_core_hybrid_bm_half_0.iqmod_mfb_lpf_pex_ota_core_tg$1_0.v_b.n65 0.12194
R8051 iqmod_mfb_lpf_pex_half_1.iqmod_mfb_lpf_pex_ota_core_hybrid_bm_half_0.iqmod_mfb_lpf_pex_ota_core_tg$1_0.v_b.n63 iqmod_mfb_lpf_pex_half_1.iqmod_mfb_lpf_pex_ota_core_hybrid_bm_half_0.iqmod_mfb_lpf_pex_ota_core_tg$1_0.v_b.n64 0.12194
R8052 iqmod_mfb_lpf_pex_half_1.iqmod_mfb_lpf_pex_ota_core_hybrid_bm_half_0.iqmod_mfb_lpf_pex_ota_core_tg$1_0.v_b.n62 iqmod_mfb_lpf_pex_half_1.iqmod_mfb_lpf_pex_ota_core_hybrid_bm_half_0.iqmod_mfb_lpf_pex_ota_core_tg$1_0.v_b.n63 0.12194
R8053 iqmod_mfb_lpf_pex_half_1.iqmod_mfb_lpf_pex_ota_core_hybrid_bm_half_0.iqmod_mfb_lpf_pex_ota_core_tg$1_0.v_b.n61 iqmod_mfb_lpf_pex_half_1.iqmod_mfb_lpf_pex_ota_core_hybrid_bm_half_0.iqmod_mfb_lpf_pex_ota_core_tg$1_0.v_b.n62 0.12194
R8054 iqmod_mfb_lpf_pex_half_1.iqmod_mfb_lpf_pex_ota_core_hybrid_bm_half_0.iqmod_mfb_lpf_pex_ota_core_tg$1_0.v_b.n60 iqmod_mfb_lpf_pex_half_1.iqmod_mfb_lpf_pex_ota_core_hybrid_bm_half_0.iqmod_mfb_lpf_pex_ota_core_tg$1_0.v_b.n61 0.12194
R8055 iqmod_mfb_lpf_pex_half_1.iqmod_mfb_lpf_pex_ota_core_hybrid_bm_half_0.iqmod_mfb_lpf_pex_ota_core_tg$1_0.v_b.n59 iqmod_mfb_lpf_pex_half_1.iqmod_mfb_lpf_pex_ota_core_hybrid_bm_half_0.iqmod_mfb_lpf_pex_ota_core_tg$1_0.v_b.n60 0.12194
R8056 iqmod_mfb_lpf_pex_half_1.iqmod_mfb_lpf_pex_ota_core_hybrid_bm_half_0.iqmod_mfb_lpf_pex_ota_core_tg$1_0.v_b.n58 iqmod_mfb_lpf_pex_half_1.iqmod_mfb_lpf_pex_ota_core_hybrid_bm_half_0.iqmod_mfb_lpf_pex_ota_core_tg$1_0.v_b.n59 0.12194
R8057 iqmod_mfb_lpf_pex_half_1.iqmod_mfb_lpf_pex_ota_core_hybrid_bm_half_0.iqmod_mfb_lpf_pex_ota_core_tg$1_0.v_b.n57 iqmod_mfb_lpf_pex_half_1.iqmod_mfb_lpf_pex_ota_core_hybrid_bm_half_0.iqmod_mfb_lpf_pex_ota_core_tg$1_0.v_b.n58 0.12194
R8058 iqmod_mfb_lpf_pex_half_1.iqmod_mfb_lpf_pex_ota_core_hybrid_bm_half_0.iqmod_mfb_lpf_pex_ota_core_tg$1_0.v_b.n107 iqmod_mfb_lpf_pex_half_1.iqmod_mfb_lpf_pex_ota_core_hybrid_bm_half_0.iqmod_mfb_lpf_pex_ota_core_tg$1_0.v_b.n57 0.0265126
R8059 iqmod_mfb_lpf_pex_half_1.iqmod_mfb_lpf_pex_ota_core_hybrid_bm_half_0.iqmod_mfb_lpf_pex_ota_core_tg$1_0.v_b.n55 iqmod_mfb_lpf_pex_half_1.iqmod_mfb_lpf_pex_ota_core_hybrid_bm_half_0.iqmod_mfb_lpf_pex_ota_core_tg$1_0.v_b.n56 1.69542
R8060 iqmod_mfb_lpf_pex_half_1.iqmod_mfb_lpf_pex_ota_core_hybrid_bm_half_0.iqmod_mfb_lpf_pex_ota_core_tg$1_0.v_b.n92 iqmod_mfb_lpf_pex_half_1.iqmod_mfb_lpf_pex_ota_core_hybrid_bm_half_0.iqmod_mfb_lpf_pex_ota_core_tg$1_0.v_b.n108 0.0847067
R8061 iqmod_mfb_lpf_pex_half_1.iqmod_mfb_lpf_pex_ota_core_hybrid_bm_half_0.iqmod_mfb_lpf_pex_ota_core_tg$1_0.v_b.n93 iqmod_mfb_lpf_pex_half_1.iqmod_mfb_lpf_pex_ota_core_hybrid_bm_half_0.iqmod_mfb_lpf_pex_ota_core_tg$1_0.v_b.n94 0.578786
R8062 iqmod_mfb_lpf_pex_half_1.iqmod_mfb_lpf_pex_ota_core_hybrid_bm_half_0.iqmod_mfb_lpf_pex_ota_core_tg$1_0.v_b.n94 iqmod_mfb_lpf_pex_half_1.iqmod_mfb_lpf_pex_ota_core_hybrid_bm_half_0.iqmod_mfb_lpf_pex_ota_core_tg$1_0.v_b.n95 0.578786
R8063 iqmod_mfb_lpf_pex_half_1.iqmod_mfb_lpf_pex_ota_core_hybrid_bm_half_0.iqmod_mfb_lpf_pex_ota_core_tg$1_0.v_b.n95 iqmod_mfb_lpf_pex_half_1.iqmod_mfb_lpf_pex_ota_core_hybrid_bm_half_0.iqmod_mfb_lpf_pex_ota_core_tg$1_0.v_b.n96 0.578786
R8064 iqmod_mfb_lpf_pex_half_1.iqmod_mfb_lpf_pex_ota_core_hybrid_bm_half_0.iqmod_mfb_lpf_pex_ota_core_tg$1_0.v_b.n96 iqmod_mfb_lpf_pex_half_1.iqmod_mfb_lpf_pex_ota_core_hybrid_bm_half_0.iqmod_mfb_lpf_pex_ota_core_tg$1_0.v_b.n97 0.578786
R8065 iqmod_mfb_lpf_pex_half_1.iqmod_mfb_lpf_pex_ota_core_hybrid_bm_half_0.iqmod_mfb_lpf_pex_ota_core_tg$1_0.v_b.n97 iqmod_mfb_lpf_pex_half_1.iqmod_mfb_lpf_pex_ota_core_hybrid_bm_half_0.iqmod_mfb_lpf_pex_ota_core_tg$1_0.v_b.n98 0.578786
R8066 iqmod_mfb_lpf_pex_half_1.iqmod_mfb_lpf_pex_ota_core_hybrid_bm_half_0.iqmod_mfb_lpf_pex_ota_core_tg$1_0.v_b.n98 iqmod_mfb_lpf_pex_half_1.iqmod_mfb_lpf_pex_ota_core_hybrid_bm_half_0.iqmod_mfb_lpf_pex_ota_core_tg$1_0.v_b.n99 0.578786
R8067 iqmod_mfb_lpf_pex_half_1.iqmod_mfb_lpf_pex_ota_core_hybrid_bm_half_0.iqmod_mfb_lpf_pex_ota_core_tg$1_0.v_b.n99 iqmod_mfb_lpf_pex_half_1.iqmod_mfb_lpf_pex_ota_core_hybrid_bm_half_0.iqmod_mfb_lpf_pex_ota_core_tg$1_0.v_b.n91 0.578786
R8068 iqmod_mfb_lpf_pex_half_1.iqmod_mfb_lpf_pex_ota_core_hybrid_bm_half_0.iqmod_mfb_lpf_pex_ota_core_tg$1_0.v_b.n91 iqmod_mfb_lpf_pex_half_1.iqmod_mfb_lpf_pex_ota_core_hybrid_bm_half_0.iqmod_mfb_lpf_pex_ota_core_tg$1_0.v_b.n100 0.578786
R8069 iqmod_mfb_lpf_pex_half_1.iqmod_mfb_lpf_pex_ota_core_hybrid_bm_half_0.iqmod_mfb_lpf_pex_ota_core_tg$1_0.v_b.n100 iqmod_mfb_lpf_pex_half_1.iqmod_mfb_lpf_pex_ota_core_hybrid_bm_half_0.iqmod_mfb_lpf_pex_ota_core_tg$1_0.v_b.n101 0.578786
R8070 iqmod_mfb_lpf_pex_half_1.iqmod_mfb_lpf_pex_ota_core_hybrid_bm_half_0.iqmod_mfb_lpf_pex_ota_core_tg$1_0.v_b.n101 iqmod_mfb_lpf_pex_half_1.iqmod_mfb_lpf_pex_ota_core_hybrid_bm_half_0.iqmod_mfb_lpf_pex_ota_core_tg$1_0.v_b.n102 0.578786
R8071 iqmod_mfb_lpf_pex_half_1.iqmod_mfb_lpf_pex_ota_core_hybrid_bm_half_0.iqmod_mfb_lpf_pex_ota_core_tg$1_0.v_b.n102 iqmod_mfb_lpf_pex_half_1.iqmod_mfb_lpf_pex_ota_core_hybrid_bm_half_0.iqmod_mfb_lpf_pex_ota_core_tg$1_0.v_b.n103 0.578786
R8072 iqmod_mfb_lpf_pex_half_1.iqmod_mfb_lpf_pex_ota_core_hybrid_bm_half_0.iqmod_mfb_lpf_pex_ota_core_tg$1_0.v_b.n103 iqmod_mfb_lpf_pex_half_1.iqmod_mfb_lpf_pex_ota_core_hybrid_bm_half_0.iqmod_mfb_lpf_pex_ota_core_tg$1_0.v_b.n104 0.578786
R8073 iqmod_mfb_lpf_pex_half_1.iqmod_mfb_lpf_pex_ota_core_hybrid_bm_half_0.iqmod_mfb_lpf_pex_ota_core_tg$1_0.v_b.n104 iqmod_mfb_lpf_pex_half_1.iqmod_mfb_lpf_pex_ota_core_hybrid_bm_half_0.iqmod_mfb_lpf_pex_ota_core_tg$1_0.v_b.n105 0.578786
R8074 iqmod_mfb_lpf_pex_half_1.iqmod_mfb_lpf_pex_ota_core_hybrid_bm_half_0.iqmod_mfb_lpf_pex_ota_core_tg$1_0.v_b.n105 iqmod_mfb_lpf_pex_half_1.iqmod_mfb_lpf_pex_ota_core_hybrid_bm_half_0.iqmod_mfb_lpf_pex_ota_core_tg$1_0.v_b.n106 0.578786
R8075 iqmod_mfb_lpf_pex_half_1.iqmod_mfb_lpf_pex_ota_core_hybrid_bm_half_0.iqmod_mfb_lpf_pex_ota_core_tg$1_0.v_b.n56 iqmod_mfb_lpf_pex_half_1.iqmod_mfb_lpf_pex_ota_core_hybrid_bm_half_0.iqmod_mfb_lpf_pex_ota_core_tg$1_0.v_b.n107 0.0847067
R8076 iqmod_mfb_lpf_pex_half_1.iqmod_mfb_lpf_pex_ota_core_hybrid_bm_half_0.iqmod_mfb_lpf_pex_ota_core_tg$1_0.v_b.n107 iqmod_mfb_lpf_pex_half_1.iqmod_mfb_lpf_pex_ota_core_hybrid_bm_half_0.iqmod_mfb_lpf_pex_ota_core_tg$1_0.v_b.n106 0.754036
R8077 iqmod_mfb_lpf_pex_half_1.iqmod_mfb_lpf_pex_ota_core_hybrid_bm_half_0.iqmod_mfb_lpf_pex_ota_core_tg$1_0.v_b.n58 iqmod_mfb_lpf_pex_half_1.iqmod_mfb_lpf_pex_ota_core_hybrid_bm_half_0.iqmod_mfb_lpf_pex_ota_core_tg$1_0.v_b.n106 0.254024
R8078 iqmod_mfb_lpf_pex_half_1.iqmod_mfb_lpf_pex_ota_core_hybrid_bm_half_0.iqmod_mfb_lpf_pex_ota_core_tg$1_0.v_b.n59 iqmod_mfb_lpf_pex_half_1.iqmod_mfb_lpf_pex_ota_core_hybrid_bm_half_0.iqmod_mfb_lpf_pex_ota_core_tg$1_0.v_b.n105 0.254024
R8079 iqmod_mfb_lpf_pex_half_1.iqmod_mfb_lpf_pex_ota_core_hybrid_bm_half_0.iqmod_mfb_lpf_pex_ota_core_tg$1_0.v_b.n60 iqmod_mfb_lpf_pex_half_1.iqmod_mfb_lpf_pex_ota_core_hybrid_bm_half_0.iqmod_mfb_lpf_pex_ota_core_tg$1_0.v_b.n104 0.254024
R8080 iqmod_mfb_lpf_pex_half_1.iqmod_mfb_lpf_pex_ota_core_hybrid_bm_half_0.iqmod_mfb_lpf_pex_ota_core_tg$1_0.v_b.n61 iqmod_mfb_lpf_pex_half_1.iqmod_mfb_lpf_pex_ota_core_hybrid_bm_half_0.iqmod_mfb_lpf_pex_ota_core_tg$1_0.v_b.n103 0.254024
R8081 iqmod_mfb_lpf_pex_half_1.iqmod_mfb_lpf_pex_ota_core_hybrid_bm_half_0.iqmod_mfb_lpf_pex_ota_core_tg$1_0.v_b.n62 iqmod_mfb_lpf_pex_half_1.iqmod_mfb_lpf_pex_ota_core_hybrid_bm_half_0.iqmod_mfb_lpf_pex_ota_core_tg$1_0.v_b.n102 0.254024
R8082 iqmod_mfb_lpf_pex_half_1.iqmod_mfb_lpf_pex_ota_core_hybrid_bm_half_0.iqmod_mfb_lpf_pex_ota_core_tg$1_0.v_b.n63 iqmod_mfb_lpf_pex_half_1.iqmod_mfb_lpf_pex_ota_core_hybrid_bm_half_0.iqmod_mfb_lpf_pex_ota_core_tg$1_0.v_b.n101 0.254024
R8083 iqmod_mfb_lpf_pex_half_1.iqmod_mfb_lpf_pex_ota_core_hybrid_bm_half_0.iqmod_mfb_lpf_pex_ota_core_tg$1_0.v_b.n64 iqmod_mfb_lpf_pex_half_1.iqmod_mfb_lpf_pex_ota_core_hybrid_bm_half_0.iqmod_mfb_lpf_pex_ota_core_tg$1_0.v_b.n100 0.254024
R8084 iqmod_mfb_lpf_pex_half_1.iqmod_mfb_lpf_pex_ota_core_hybrid_bm_half_0.iqmod_mfb_lpf_pex_ota_core_tg$1_0.v_b.n66 iqmod_mfb_lpf_pex_half_1.iqmod_mfb_lpf_pex_ota_core_hybrid_bm_half_0.iqmod_mfb_lpf_pex_ota_core_tg$1_0.v_b.n99 0.254024
R8085 iqmod_mfb_lpf_pex_half_1.iqmod_mfb_lpf_pex_ota_core_hybrid_bm_half_0.iqmod_mfb_lpf_pex_ota_core_tg$1_0.v_b.n67 iqmod_mfb_lpf_pex_half_1.iqmod_mfb_lpf_pex_ota_core_hybrid_bm_half_0.iqmod_mfb_lpf_pex_ota_core_tg$1_0.v_b.n98 0.254024
R8086 iqmod_mfb_lpf_pex_half_1.iqmod_mfb_lpf_pex_ota_core_hybrid_bm_half_0.iqmod_mfb_lpf_pex_ota_core_tg$1_0.v_b.n68 iqmod_mfb_lpf_pex_half_1.iqmod_mfb_lpf_pex_ota_core_hybrid_bm_half_0.iqmod_mfb_lpf_pex_ota_core_tg$1_0.v_b.n97 0.254024
R8087 iqmod_mfb_lpf_pex_half_1.iqmod_mfb_lpf_pex_ota_core_hybrid_bm_half_0.iqmod_mfb_lpf_pex_ota_core_tg$1_0.v_b.n69 iqmod_mfb_lpf_pex_half_1.iqmod_mfb_lpf_pex_ota_core_hybrid_bm_half_0.iqmod_mfb_lpf_pex_ota_core_tg$1_0.v_b.n96 0.254024
R8088 iqmod_mfb_lpf_pex_half_1.iqmod_mfb_lpf_pex_ota_core_hybrid_bm_half_0.iqmod_mfb_lpf_pex_ota_core_tg$1_0.v_b.n70 iqmod_mfb_lpf_pex_half_1.iqmod_mfb_lpf_pex_ota_core_hybrid_bm_half_0.iqmod_mfb_lpf_pex_ota_core_tg$1_0.v_b.n95 0.254024
R8089 iqmod_mfb_lpf_pex_half_1.iqmod_mfb_lpf_pex_ota_core_hybrid_bm_half_0.iqmod_mfb_lpf_pex_ota_core_tg$1_0.v_b.n71 iqmod_mfb_lpf_pex_half_1.iqmod_mfb_lpf_pex_ota_core_hybrid_bm_half_0.iqmod_mfb_lpf_pex_ota_core_tg$1_0.v_b.n94 0.254024
R8090 iqmod_mfb_lpf_pex_half_1.iqmod_mfb_lpf_pex_ota_core_hybrid_bm_half_0.iqmod_mfb_lpf_pex_ota_core_tg$1_0.v_b.n72 iqmod_mfb_lpf_pex_half_1.iqmod_mfb_lpf_pex_ota_core_hybrid_bm_half_0.iqmod_mfb_lpf_pex_ota_core_tg$1_0.v_b.n93 0.254024
R8091 iqmod_mfb_lpf_pex_half_1.iqmod_mfb_lpf_pex_ota_core_hybrid_bm_half_0.iqmod_mfb_lpf_pex_ota_core_tg$1_0.v_b.n92 iqmod_mfb_lpf_pex_half_1.iqmod_mfb_lpf_pex_ota_core_hybrid_bm_half_0.iqmod_mfb_lpf_pex_ota_core_tg$1_0.v_b.n93 0.754036
R8092 iqmod_mfb_lpf_pex_half_1.iqmod_mfb_lpf_pex_ota_core_hybrid_bm_half_0.iqmod_mfb_lpf_pex_ota_core_tg$1_0.v_b.n65 iqmod_mfb_lpf_pex_half_1.iqmod_mfb_lpf_pex_ota_core_hybrid_bm_half_0.iqmod_mfb_lpf_pex_ota_core_tg$1_0.v_b.n91 0.254024
R8093 iqmod_mfb_lpf_pex_half_1.iqmod_mfb_lpf_pex_ota_core_hybrid_bm_half_0.iqmod_mfb_lpf_pex_ota_core_tg$1_0.v_b.n91 iqmod_mfb_lpf_pex_half_1.iqmod_mfb_lpf_pex_ota_core_hybrid_bm_half_0.iqmod_mfb_lpf_pex_ota_core_tg$1_0.v_b.t39 0.994013
R8094 iqmod_mfb_lpf_pex_half_1.iqmod_mfb_lpf_pex_ota_core_hybrid_bm_half_0.iqmod_mfb_lpf_pex_ota_core_tg$1_0.v_b.n108 iqmod_mfb_lpf_pex_half_1.iqmod_mfb_lpf_pex_ota_core_hybrid_bm_half_0.iqmod_mfb_lpf_pex_ota_core_tg$1_0.v_b.n90 0.83231
R8095 iqmod_mfb_lpf_pex_half_1.iqmod_mfb_lpf_pex_ota_core_hybrid_bm_half_0.iqmod_mfb_lpf_pex_ota_core_tg$1_0.v_b.n90 iqmod_mfb_lpf_pex_half_1.iqmod_mfb_lpf_pex_ota_core_hybrid_bm_half_0.iqmod_mfb_lpf_pex_ota_core_tg$1_0.v_b.n89 0.578786
R8096 iqmod_mfb_lpf_pex_half_1.iqmod_mfb_lpf_pex_ota_core_hybrid_bm_half_0.iqmod_mfb_lpf_pex_ota_core_tg$1_0.v_b.n89 iqmod_mfb_lpf_pex_half_1.iqmod_mfb_lpf_pex_ota_core_hybrid_bm_half_0.iqmod_mfb_lpf_pex_ota_core_tg$1_0.v_b.n88 0.578786
R8097 iqmod_mfb_lpf_pex_half_1.iqmod_mfb_lpf_pex_ota_core_hybrid_bm_half_0.iqmod_mfb_lpf_pex_ota_core_tg$1_0.v_b.n88 iqmod_mfb_lpf_pex_half_1.iqmod_mfb_lpf_pex_ota_core_hybrid_bm_half_0.iqmod_mfb_lpf_pex_ota_core_tg$1_0.v_b.n87 0.578786
R8098 iqmod_mfb_lpf_pex_half_1.iqmod_mfb_lpf_pex_ota_core_hybrid_bm_half_0.iqmod_mfb_lpf_pex_ota_core_tg$1_0.v_b.n87 iqmod_mfb_lpf_pex_half_1.iqmod_mfb_lpf_pex_ota_core_hybrid_bm_half_0.iqmod_mfb_lpf_pex_ota_core_tg$1_0.v_b.n86 0.578786
R8099 iqmod_mfb_lpf_pex_half_1.iqmod_mfb_lpf_pex_ota_core_hybrid_bm_half_0.iqmod_mfb_lpf_pex_ota_core_tg$1_0.v_b.n86 iqmod_mfb_lpf_pex_half_1.iqmod_mfb_lpf_pex_ota_core_hybrid_bm_half_0.iqmod_mfb_lpf_pex_ota_core_tg$1_0.v_b.n85 0.578786
R8100 iqmod_mfb_lpf_pex_half_1.iqmod_mfb_lpf_pex_ota_core_hybrid_bm_half_0.iqmod_mfb_lpf_pex_ota_core_tg$1_0.v_b.n85 iqmod_mfb_lpf_pex_half_1.iqmod_mfb_lpf_pex_ota_core_hybrid_bm_half_0.iqmod_mfb_lpf_pex_ota_core_tg$1_0.v_b.n84 0.578786
R8101 iqmod_mfb_lpf_pex_half_1.iqmod_mfb_lpf_pex_ota_core_hybrid_bm_half_0.iqmod_mfb_lpf_pex_ota_core_tg$1_0.v_b.n84 iqmod_mfb_lpf_pex_half_1.iqmod_mfb_lpf_pex_ota_core_hybrid_bm_half_0.iqmod_mfb_lpf_pex_ota_core_tg$1_0.v_b.n83 0.578786
R8102 iqmod_mfb_lpf_pex_half_1.iqmod_mfb_lpf_pex_ota_core_hybrid_bm_half_0.iqmod_mfb_lpf_pex_ota_core_tg$1_0.v_b.n83 iqmod_mfb_lpf_pex_half_1.iqmod_mfb_lpf_pex_ota_core_hybrid_bm_half_0.iqmod_mfb_lpf_pex_ota_core_tg$1_0.v_b.n74 0.578786
R8103 iqmod_mfb_lpf_pex_half_1.iqmod_mfb_lpf_pex_ota_core_hybrid_bm_half_0.iqmod_mfb_lpf_pex_ota_core_tg$1_0.v_b.n74 iqmod_mfb_lpf_pex_half_1.iqmod_mfb_lpf_pex_ota_core_hybrid_bm_half_0.iqmod_mfb_lpf_pex_ota_core_tg$1_0.v_b.n82 0.578786
R8104 iqmod_mfb_lpf_pex_half_1.iqmod_mfb_lpf_pex_ota_core_hybrid_bm_half_0.iqmod_mfb_lpf_pex_ota_core_tg$1_0.v_b.n82 iqmod_mfb_lpf_pex_half_1.iqmod_mfb_lpf_pex_ota_core_hybrid_bm_half_0.iqmod_mfb_lpf_pex_ota_core_tg$1_0.v_b.n81 0.578786
R8105 iqmod_mfb_lpf_pex_half_1.iqmod_mfb_lpf_pex_ota_core_hybrid_bm_half_0.iqmod_mfb_lpf_pex_ota_core_tg$1_0.v_b.n81 iqmod_mfb_lpf_pex_half_1.iqmod_mfb_lpf_pex_ota_core_hybrid_bm_half_0.iqmod_mfb_lpf_pex_ota_core_tg$1_0.v_b.n80 0.578786
R8106 iqmod_mfb_lpf_pex_half_1.iqmod_mfb_lpf_pex_ota_core_hybrid_bm_half_0.iqmod_mfb_lpf_pex_ota_core_tg$1_0.v_b.n80 iqmod_mfb_lpf_pex_half_1.iqmod_mfb_lpf_pex_ota_core_hybrid_bm_half_0.iqmod_mfb_lpf_pex_ota_core_tg$1_0.v_b.n79 0.578786
R8107 iqmod_mfb_lpf_pex_half_1.iqmod_mfb_lpf_pex_ota_core_hybrid_bm_half_0.iqmod_mfb_lpf_pex_ota_core_tg$1_0.v_b.n79 iqmod_mfb_lpf_pex_half_1.iqmod_mfb_lpf_pex_ota_core_hybrid_bm_half_0.iqmod_mfb_lpf_pex_ota_core_tg$1_0.v_b.n78 0.578786
R8108 iqmod_mfb_lpf_pex_half_1.iqmod_mfb_lpf_pex_ota_core_hybrid_bm_half_0.iqmod_mfb_lpf_pex_ota_core_tg$1_0.v_b.n78 iqmod_mfb_lpf_pex_half_1.iqmod_mfb_lpf_pex_ota_core_hybrid_bm_half_0.iqmod_mfb_lpf_pex_ota_core_tg$1_0.v_b.n77 0.578786
R8109 iqmod_mfb_lpf_pex_half_1.iqmod_mfb_lpf_pex_ota_core_hybrid_bm_half_0.iqmod_mfb_lpf_pex_ota_core_tg$1_0.v_b.n77 iqmod_mfb_lpf_pex_half_1.iqmod_mfb_lpf_pex_ota_core_hybrid_bm_half_0.iqmod_mfb_lpf_pex_ota_core_tg$1_0.v_b.n76 0.578786
R8110 iqmod_mfb_lpf_pex_half_1.iqmod_mfb_lpf_pex_ota_core_hybrid_bm_half_0.iqmod_mfb_lpf_pex_ota_core_tg$1_0.v_b.n76 iqmod_mfb_lpf_pex_half_1.iqmod_mfb_lpf_pex_ota_core_hybrid_bm_half_0.iqmod_mfb_lpf_pex_ota_core_tg$1_0.v_b.n75 0.578786
R8111 iqmod_mfb_lpf_pex_half_1.iqmod_mfb_lpf_pex_ota_core_hybrid_bm_half_0.iqmod_mfb_lpf_pex_ota_core_tg$1_0.v_b.n73 iqmod_mfb_lpf_pex_half_1.iqmod_mfb_lpf_pex_ota_core_hybrid_bm_half_0.iqmod_mfb_lpf_pex_ota_core_tg$1_0.v_b.n90 0.254024
R8112 iqmod_mfb_lpf_pex_half_1.iqmod_mfb_lpf_pex_ota_core_hybrid_bm_half_0.iqmod_mfb_lpf_pex_ota_core_tg$1_0.v_b.n72 iqmod_mfb_lpf_pex_half_1.iqmod_mfb_lpf_pex_ota_core_hybrid_bm_half_0.iqmod_mfb_lpf_pex_ota_core_tg$1_0.v_b.n89 0.254024
R8113 iqmod_mfb_lpf_pex_half_1.iqmod_mfb_lpf_pex_ota_core_hybrid_bm_half_0.iqmod_mfb_lpf_pex_ota_core_tg$1_0.v_b.n71 iqmod_mfb_lpf_pex_half_1.iqmod_mfb_lpf_pex_ota_core_hybrid_bm_half_0.iqmod_mfb_lpf_pex_ota_core_tg$1_0.v_b.n88 0.254024
R8114 iqmod_mfb_lpf_pex_half_1.iqmod_mfb_lpf_pex_ota_core_hybrid_bm_half_0.iqmod_mfb_lpf_pex_ota_core_tg$1_0.v_b.n70 iqmod_mfb_lpf_pex_half_1.iqmod_mfb_lpf_pex_ota_core_hybrid_bm_half_0.iqmod_mfb_lpf_pex_ota_core_tg$1_0.v_b.n87 0.254024
R8115 iqmod_mfb_lpf_pex_half_1.iqmod_mfb_lpf_pex_ota_core_hybrid_bm_half_0.iqmod_mfb_lpf_pex_ota_core_tg$1_0.v_b.n69 iqmod_mfb_lpf_pex_half_1.iqmod_mfb_lpf_pex_ota_core_hybrid_bm_half_0.iqmod_mfb_lpf_pex_ota_core_tg$1_0.v_b.n86 0.254024
R8116 iqmod_mfb_lpf_pex_half_1.iqmod_mfb_lpf_pex_ota_core_hybrid_bm_half_0.iqmod_mfb_lpf_pex_ota_core_tg$1_0.v_b.n68 iqmod_mfb_lpf_pex_half_1.iqmod_mfb_lpf_pex_ota_core_hybrid_bm_half_0.iqmod_mfb_lpf_pex_ota_core_tg$1_0.v_b.n85 0.254024
R8117 iqmod_mfb_lpf_pex_half_1.iqmod_mfb_lpf_pex_ota_core_hybrid_bm_half_0.iqmod_mfb_lpf_pex_ota_core_tg$1_0.v_b.n67 iqmod_mfb_lpf_pex_half_1.iqmod_mfb_lpf_pex_ota_core_hybrid_bm_half_0.iqmod_mfb_lpf_pex_ota_core_tg$1_0.v_b.n84 0.254024
R8118 iqmod_mfb_lpf_pex_half_1.iqmod_mfb_lpf_pex_ota_core_hybrid_bm_half_0.iqmod_mfb_lpf_pex_ota_core_tg$1_0.v_b.n66 iqmod_mfb_lpf_pex_half_1.iqmod_mfb_lpf_pex_ota_core_hybrid_bm_half_0.iqmod_mfb_lpf_pex_ota_core_tg$1_0.v_b.n83 0.254024
R8119 iqmod_mfb_lpf_pex_half_1.iqmod_mfb_lpf_pex_ota_core_hybrid_bm_half_0.iqmod_mfb_lpf_pex_ota_core_tg$1_0.v_b.n64 iqmod_mfb_lpf_pex_half_1.iqmod_mfb_lpf_pex_ota_core_hybrid_bm_half_0.iqmod_mfb_lpf_pex_ota_core_tg$1_0.v_b.n82 0.254024
R8120 iqmod_mfb_lpf_pex_half_1.iqmod_mfb_lpf_pex_ota_core_hybrid_bm_half_0.iqmod_mfb_lpf_pex_ota_core_tg$1_0.v_b.n63 iqmod_mfb_lpf_pex_half_1.iqmod_mfb_lpf_pex_ota_core_hybrid_bm_half_0.iqmod_mfb_lpf_pex_ota_core_tg$1_0.v_b.n81 0.254024
R8121 iqmod_mfb_lpf_pex_half_1.iqmod_mfb_lpf_pex_ota_core_hybrid_bm_half_0.iqmod_mfb_lpf_pex_ota_core_tg$1_0.v_b.n62 iqmod_mfb_lpf_pex_half_1.iqmod_mfb_lpf_pex_ota_core_hybrid_bm_half_0.iqmod_mfb_lpf_pex_ota_core_tg$1_0.v_b.n80 0.254024
R8122 iqmod_mfb_lpf_pex_half_1.iqmod_mfb_lpf_pex_ota_core_hybrid_bm_half_0.iqmod_mfb_lpf_pex_ota_core_tg$1_0.v_b.n61 iqmod_mfb_lpf_pex_half_1.iqmod_mfb_lpf_pex_ota_core_hybrid_bm_half_0.iqmod_mfb_lpf_pex_ota_core_tg$1_0.v_b.n79 0.254024
R8123 iqmod_mfb_lpf_pex_half_1.iqmod_mfb_lpf_pex_ota_core_hybrid_bm_half_0.iqmod_mfb_lpf_pex_ota_core_tg$1_0.v_b.n60 iqmod_mfb_lpf_pex_half_1.iqmod_mfb_lpf_pex_ota_core_hybrid_bm_half_0.iqmod_mfb_lpf_pex_ota_core_tg$1_0.v_b.n78 0.254024
R8124 iqmod_mfb_lpf_pex_half_1.iqmod_mfb_lpf_pex_ota_core_hybrid_bm_half_0.iqmod_mfb_lpf_pex_ota_core_tg$1_0.v_b.n59 iqmod_mfb_lpf_pex_half_1.iqmod_mfb_lpf_pex_ota_core_hybrid_bm_half_0.iqmod_mfb_lpf_pex_ota_core_tg$1_0.v_b.n77 0.254024
R8125 iqmod_mfb_lpf_pex_half_1.iqmod_mfb_lpf_pex_ota_core_hybrid_bm_half_0.iqmod_mfb_lpf_pex_ota_core_tg$1_0.v_b.n58 iqmod_mfb_lpf_pex_half_1.iqmod_mfb_lpf_pex_ota_core_hybrid_bm_half_0.iqmod_mfb_lpf_pex_ota_core_tg$1_0.v_b.n76 0.254024
R8126 iqmod_mfb_lpf_pex_half_1.iqmod_mfb_lpf_pex_ota_core_hybrid_bm_half_0.iqmod_mfb_lpf_pex_ota_core_tg$1_0.v_b.n57 iqmod_mfb_lpf_pex_half_1.iqmod_mfb_lpf_pex_ota_core_hybrid_bm_half_0.iqmod_mfb_lpf_pex_ota_core_tg$1_0.v_b.n75 0.254024
R8127 iqmod_mfb_lpf_pex_half_1.iqmod_mfb_lpf_pex_ota_core_hybrid_bm_half_0.iqmod_mfb_lpf_pex_ota_core_tg$1_0.v_b.n75 iqmod_mfb_lpf_pex_half_1.iqmod_mfb_lpf_pex_ota_core_hybrid_bm_half_0.iqmod_mfb_lpf_pex_ota_core_tg$1_0.v_b.n56 0.83231
R8128 iqmod_mfb_lpf_pex_half_1.iqmod_mfb_lpf_pex_ota_core_hybrid_bm_half_0.iqmod_mfb_lpf_pex_ota_core_tg$1_0.v_b.n65 iqmod_mfb_lpf_pex_half_1.iqmod_mfb_lpf_pex_ota_core_hybrid_bm_half_0.iqmod_mfb_lpf_pex_ota_core_tg$1_0.v_b.n74 0.254024
R8129 iqmod_mfb_lpf_pex_half_1.iqmod_mfb_lpf_pex_ota_core_hybrid_bm_half_0.iqmod_mfb_lpf_pex_ota_core_tg$1_0.v_b.n74 iqmod_mfb_lpf_pex_half_1.iqmod_mfb_lpf_pex_ota_core_hybrid_bm_half_0.iqmod_mfb_lpf_pex_ota_core_tg$1_0.v_b.t38 0.994013
R8130 iqmod_mfb_lpf_pex_half_1.iqmod_mfb_lpf_pex_ota_core_hybrid_bm_half_0.iqmod_mfb_lpf_pex_ota_core_tg$1_0.v_b iqmod_mfb_lpf_pex_half_1.iqmod_mfb_lpf_pex_ota_core_hybrid_bm_half_0.iqmod_mfb_lpf_pex_ota_core_tg$1_0.v_b.n53 0.00974
R8131 iqmod_mfb_lpf_pex_half_1.iqmod_mfb_lpf_pex_ota_core_hybrid_bm_half_0.iqmod_mfb_lpf_pex_ota_core_tg$1_0.v_b.n18 iqmod_mfb_lpf_pex_half_1.iqmod_mfb_lpf_pex_ota_core_hybrid_bm_half_0.iqmod_mfb_lpf_pex_ota_core_tg$1_0.v_b.n37 0.0265126
R8132 iqmod_mfb_lpf_pex_half_1.iqmod_mfb_lpf_pex_ota_core_hybrid_bm_half_0.iqmod_mfb_lpf_pex_ota_core_tg$1_0.v_b.n17 iqmod_mfb_lpf_pex_half_1.iqmod_mfb_lpf_pex_ota_core_hybrid_bm_half_0.iqmod_mfb_lpf_pex_ota_core_tg$1_0.v_b.n18 0.12194
R8133 iqmod_mfb_lpf_pex_half_1.iqmod_mfb_lpf_pex_ota_core_hybrid_bm_half_0.iqmod_mfb_lpf_pex_ota_core_tg$1_0.v_b.n16 iqmod_mfb_lpf_pex_half_1.iqmod_mfb_lpf_pex_ota_core_hybrid_bm_half_0.iqmod_mfb_lpf_pex_ota_core_tg$1_0.v_b.n17 0.12194
R8134 iqmod_mfb_lpf_pex_half_1.iqmod_mfb_lpf_pex_ota_core_hybrid_bm_half_0.iqmod_mfb_lpf_pex_ota_core_tg$1_0.v_b.n15 iqmod_mfb_lpf_pex_half_1.iqmod_mfb_lpf_pex_ota_core_hybrid_bm_half_0.iqmod_mfb_lpf_pex_ota_core_tg$1_0.v_b.n16 0.12194
R8135 iqmod_mfb_lpf_pex_half_1.iqmod_mfb_lpf_pex_ota_core_hybrid_bm_half_0.iqmod_mfb_lpf_pex_ota_core_tg$1_0.v_b.n14 iqmod_mfb_lpf_pex_half_1.iqmod_mfb_lpf_pex_ota_core_hybrid_bm_half_0.iqmod_mfb_lpf_pex_ota_core_tg$1_0.v_b.n15 0.12194
R8136 iqmod_mfb_lpf_pex_half_1.iqmod_mfb_lpf_pex_ota_core_hybrid_bm_half_0.iqmod_mfb_lpf_pex_ota_core_tg$1_0.v_b.n13 iqmod_mfb_lpf_pex_half_1.iqmod_mfb_lpf_pex_ota_core_hybrid_bm_half_0.iqmod_mfb_lpf_pex_ota_core_tg$1_0.v_b.n14 0.12194
R8137 iqmod_mfb_lpf_pex_half_1.iqmod_mfb_lpf_pex_ota_core_hybrid_bm_half_0.iqmod_mfb_lpf_pex_ota_core_tg$1_0.v_b.n12 iqmod_mfb_lpf_pex_half_1.iqmod_mfb_lpf_pex_ota_core_hybrid_bm_half_0.iqmod_mfb_lpf_pex_ota_core_tg$1_0.v_b.n13 0.12194
R8138 iqmod_mfb_lpf_pex_half_1.iqmod_mfb_lpf_pex_ota_core_hybrid_bm_half_0.iqmod_mfb_lpf_pex_ota_core_tg$1_0.v_b.n11 iqmod_mfb_lpf_pex_half_1.iqmod_mfb_lpf_pex_ota_core_hybrid_bm_half_0.iqmod_mfb_lpf_pex_ota_core_tg$1_0.v_b.n12 0.12194
R8139 iqmod_mfb_lpf_pex_half_1.iqmod_mfb_lpf_pex_ota_core_hybrid_bm_half_0.iqmod_mfb_lpf_pex_ota_core_tg$1_0.v_b.n10 iqmod_mfb_lpf_pex_half_1.iqmod_mfb_lpf_pex_ota_core_hybrid_bm_half_0.iqmod_mfb_lpf_pex_ota_core_tg$1_0.v_b.n11 0.12194
R8140 iqmod_mfb_lpf_pex_half_1.iqmod_mfb_lpf_pex_ota_core_hybrid_bm_half_0.iqmod_mfb_lpf_pex_ota_core_tg$1_0.v_b.n9 iqmod_mfb_lpf_pex_half_1.iqmod_mfb_lpf_pex_ota_core_hybrid_bm_half_0.iqmod_mfb_lpf_pex_ota_core_tg$1_0.v_b.n10 0.12194
R8141 iqmod_mfb_lpf_pex_half_1.iqmod_mfb_lpf_pex_ota_core_hybrid_bm_half_0.iqmod_mfb_lpf_pex_ota_core_tg$1_0.v_b.n8 iqmod_mfb_lpf_pex_half_1.iqmod_mfb_lpf_pex_ota_core_hybrid_bm_half_0.iqmod_mfb_lpf_pex_ota_core_tg$1_0.v_b.n9 0.12194
R8142 iqmod_mfb_lpf_pex_half_1.iqmod_mfb_lpf_pex_ota_core_hybrid_bm_half_0.iqmod_mfb_lpf_pex_ota_core_tg$1_0.v_b.n7 iqmod_mfb_lpf_pex_half_1.iqmod_mfb_lpf_pex_ota_core_hybrid_bm_half_0.iqmod_mfb_lpf_pex_ota_core_tg$1_0.v_b.n8 0.12194
R8143 iqmod_mfb_lpf_pex_half_1.iqmod_mfb_lpf_pex_ota_core_hybrid_bm_half_0.iqmod_mfb_lpf_pex_ota_core_tg$1_0.v_b.n6 iqmod_mfb_lpf_pex_half_1.iqmod_mfb_lpf_pex_ota_core_hybrid_bm_half_0.iqmod_mfb_lpf_pex_ota_core_tg$1_0.v_b.n7 0.12194
R8144 iqmod_mfb_lpf_pex_half_1.iqmod_mfb_lpf_pex_ota_core_hybrid_bm_half_0.iqmod_mfb_lpf_pex_ota_core_tg$1_0.v_b.n5 iqmod_mfb_lpf_pex_half_1.iqmod_mfb_lpf_pex_ota_core_hybrid_bm_half_0.iqmod_mfb_lpf_pex_ota_core_tg$1_0.v_b.n6 0.12194
R8145 iqmod_mfb_lpf_pex_half_1.iqmod_mfb_lpf_pex_ota_core_hybrid_bm_half_0.iqmod_mfb_lpf_pex_ota_core_tg$1_0.v_b.n4 iqmod_mfb_lpf_pex_half_1.iqmod_mfb_lpf_pex_ota_core_hybrid_bm_half_0.iqmod_mfb_lpf_pex_ota_core_tg$1_0.v_b.n5 0.12194
R8146 iqmod_mfb_lpf_pex_half_1.iqmod_mfb_lpf_pex_ota_core_hybrid_bm_half_0.iqmod_mfb_lpf_pex_ota_core_tg$1_0.v_b.n3 iqmod_mfb_lpf_pex_half_1.iqmod_mfb_lpf_pex_ota_core_hybrid_bm_half_0.iqmod_mfb_lpf_pex_ota_core_tg$1_0.v_b.n4 0.12194
R8147 iqmod_mfb_lpf_pex_half_1.iqmod_mfb_lpf_pex_ota_core_hybrid_bm_half_0.iqmod_mfb_lpf_pex_ota_core_tg$1_0.v_b.n2 iqmod_mfb_lpf_pex_half_1.iqmod_mfb_lpf_pex_ota_core_hybrid_bm_half_0.iqmod_mfb_lpf_pex_ota_core_tg$1_0.v_b.n3 0.12194
R8148 iqmod_mfb_lpf_pex_half_1.iqmod_mfb_lpf_pex_ota_core_hybrid_bm_half_0.iqmod_mfb_lpf_pex_ota_core_tg$1_0.v_b.n52 iqmod_mfb_lpf_pex_half_1.iqmod_mfb_lpf_pex_ota_core_hybrid_bm_half_0.iqmod_mfb_lpf_pex_ota_core_tg$1_0.v_b.n2 0.0265126
R8149 iqmod_mfb_lpf_pex_half_1.iqmod_mfb_lpf_pex_ota_core_hybrid_bm_half_0.iqmod_mfb_lpf_pex_ota_core_tg$1_0.v_b.n54 iqmod_mfb_lpf_pex_half_1.iqmod_mfb_lpf_pex_ota_core_hybrid_bm_half_0.iqmod_mfb_lpf_pex_ota_core_tg$1_0.v_b.n1 1.69542
R8150 iqmod_mfb_lpf_pex_half_1.iqmod_mfb_lpf_pex_ota_core_hybrid_bm_half_0.iqmod_mfb_lpf_pex_ota_core_tg$1_0.v_b.n37 iqmod_mfb_lpf_pex_half_1.iqmod_mfb_lpf_pex_ota_core_hybrid_bm_half_0.iqmod_mfb_lpf_pex_ota_core_tg$1_0.v_b.n53 0.0847067
R8151 iqmod_mfb_lpf_pex_half_1.iqmod_mfb_lpf_pex_ota_core_hybrid_bm_half_0.iqmod_mfb_lpf_pex_ota_core_tg$1_0.v_b.n38 iqmod_mfb_lpf_pex_half_1.iqmod_mfb_lpf_pex_ota_core_hybrid_bm_half_0.iqmod_mfb_lpf_pex_ota_core_tg$1_0.v_b.n39 0.578786
R8152 iqmod_mfb_lpf_pex_half_1.iqmod_mfb_lpf_pex_ota_core_hybrid_bm_half_0.iqmod_mfb_lpf_pex_ota_core_tg$1_0.v_b.n39 iqmod_mfb_lpf_pex_half_1.iqmod_mfb_lpf_pex_ota_core_hybrid_bm_half_0.iqmod_mfb_lpf_pex_ota_core_tg$1_0.v_b.n40 0.578786
R8153 iqmod_mfb_lpf_pex_half_1.iqmod_mfb_lpf_pex_ota_core_hybrid_bm_half_0.iqmod_mfb_lpf_pex_ota_core_tg$1_0.v_b.n40 iqmod_mfb_lpf_pex_half_1.iqmod_mfb_lpf_pex_ota_core_hybrid_bm_half_0.iqmod_mfb_lpf_pex_ota_core_tg$1_0.v_b.n41 0.578786
R8154 iqmod_mfb_lpf_pex_half_1.iqmod_mfb_lpf_pex_ota_core_hybrid_bm_half_0.iqmod_mfb_lpf_pex_ota_core_tg$1_0.v_b.n41 iqmod_mfb_lpf_pex_half_1.iqmod_mfb_lpf_pex_ota_core_hybrid_bm_half_0.iqmod_mfb_lpf_pex_ota_core_tg$1_0.v_b.n42 0.578786
R8155 iqmod_mfb_lpf_pex_half_1.iqmod_mfb_lpf_pex_ota_core_hybrid_bm_half_0.iqmod_mfb_lpf_pex_ota_core_tg$1_0.v_b.n42 iqmod_mfb_lpf_pex_half_1.iqmod_mfb_lpf_pex_ota_core_hybrid_bm_half_0.iqmod_mfb_lpf_pex_ota_core_tg$1_0.v_b.n43 0.578786
R8156 iqmod_mfb_lpf_pex_half_1.iqmod_mfb_lpf_pex_ota_core_hybrid_bm_half_0.iqmod_mfb_lpf_pex_ota_core_tg$1_0.v_b.n43 iqmod_mfb_lpf_pex_half_1.iqmod_mfb_lpf_pex_ota_core_hybrid_bm_half_0.iqmod_mfb_lpf_pex_ota_core_tg$1_0.v_b.n44 0.578786
R8157 iqmod_mfb_lpf_pex_half_1.iqmod_mfb_lpf_pex_ota_core_hybrid_bm_half_0.iqmod_mfb_lpf_pex_ota_core_tg$1_0.v_b.n44 iqmod_mfb_lpf_pex_half_1.iqmod_mfb_lpf_pex_ota_core_hybrid_bm_half_0.iqmod_mfb_lpf_pex_ota_core_tg$1_0.v_b.n36 0.578786
R8158 iqmod_mfb_lpf_pex_half_1.iqmod_mfb_lpf_pex_ota_core_hybrid_bm_half_0.iqmod_mfb_lpf_pex_ota_core_tg$1_0.v_b.n36 iqmod_mfb_lpf_pex_half_1.iqmod_mfb_lpf_pex_ota_core_hybrid_bm_half_0.iqmod_mfb_lpf_pex_ota_core_tg$1_0.v_b.n45 0.578786
R8159 iqmod_mfb_lpf_pex_half_1.iqmod_mfb_lpf_pex_ota_core_hybrid_bm_half_0.iqmod_mfb_lpf_pex_ota_core_tg$1_0.v_b.n45 iqmod_mfb_lpf_pex_half_1.iqmod_mfb_lpf_pex_ota_core_hybrid_bm_half_0.iqmod_mfb_lpf_pex_ota_core_tg$1_0.v_b.n46 0.578786
R8160 iqmod_mfb_lpf_pex_half_1.iqmod_mfb_lpf_pex_ota_core_hybrid_bm_half_0.iqmod_mfb_lpf_pex_ota_core_tg$1_0.v_b.n46 iqmod_mfb_lpf_pex_half_1.iqmod_mfb_lpf_pex_ota_core_hybrid_bm_half_0.iqmod_mfb_lpf_pex_ota_core_tg$1_0.v_b.n47 0.578786
R8161 iqmod_mfb_lpf_pex_half_1.iqmod_mfb_lpf_pex_ota_core_hybrid_bm_half_0.iqmod_mfb_lpf_pex_ota_core_tg$1_0.v_b.n47 iqmod_mfb_lpf_pex_half_1.iqmod_mfb_lpf_pex_ota_core_hybrid_bm_half_0.iqmod_mfb_lpf_pex_ota_core_tg$1_0.v_b.n48 0.578786
R8162 iqmod_mfb_lpf_pex_half_1.iqmod_mfb_lpf_pex_ota_core_hybrid_bm_half_0.iqmod_mfb_lpf_pex_ota_core_tg$1_0.v_b.n48 iqmod_mfb_lpf_pex_half_1.iqmod_mfb_lpf_pex_ota_core_hybrid_bm_half_0.iqmod_mfb_lpf_pex_ota_core_tg$1_0.v_b.n49 0.578786
R8163 iqmod_mfb_lpf_pex_half_1.iqmod_mfb_lpf_pex_ota_core_hybrid_bm_half_0.iqmod_mfb_lpf_pex_ota_core_tg$1_0.v_b.n49 iqmod_mfb_lpf_pex_half_1.iqmod_mfb_lpf_pex_ota_core_hybrid_bm_half_0.iqmod_mfb_lpf_pex_ota_core_tg$1_0.v_b.n50 0.578786
R8164 iqmod_mfb_lpf_pex_half_1.iqmod_mfb_lpf_pex_ota_core_hybrid_bm_half_0.iqmod_mfb_lpf_pex_ota_core_tg$1_0.v_b.n50 iqmod_mfb_lpf_pex_half_1.iqmod_mfb_lpf_pex_ota_core_hybrid_bm_half_0.iqmod_mfb_lpf_pex_ota_core_tg$1_0.v_b.n51 0.578786
R8165 iqmod_mfb_lpf_pex_half_1.iqmod_mfb_lpf_pex_ota_core_hybrid_bm_half_0.iqmod_mfb_lpf_pex_ota_core_tg$1_0.v_b.n1 iqmod_mfb_lpf_pex_half_1.iqmod_mfb_lpf_pex_ota_core_hybrid_bm_half_0.iqmod_mfb_lpf_pex_ota_core_tg$1_0.v_b.n52 0.0847067
R8166 iqmod_mfb_lpf_pex_half_1.iqmod_mfb_lpf_pex_ota_core_hybrid_bm_half_0.iqmod_mfb_lpf_pex_ota_core_tg$1_0.v_b.n52 iqmod_mfb_lpf_pex_half_1.iqmod_mfb_lpf_pex_ota_core_hybrid_bm_half_0.iqmod_mfb_lpf_pex_ota_core_tg$1_0.v_b.n51 0.754036
R8167 iqmod_mfb_lpf_pex_half_1.iqmod_mfb_lpf_pex_ota_core_hybrid_bm_half_0.iqmod_mfb_lpf_pex_ota_core_tg$1_0.v_b.n3 iqmod_mfb_lpf_pex_half_1.iqmod_mfb_lpf_pex_ota_core_hybrid_bm_half_0.iqmod_mfb_lpf_pex_ota_core_tg$1_0.v_b.n51 0.254024
R8168 iqmod_mfb_lpf_pex_half_1.iqmod_mfb_lpf_pex_ota_core_hybrid_bm_half_0.iqmod_mfb_lpf_pex_ota_core_tg$1_0.v_b.n4 iqmod_mfb_lpf_pex_half_1.iqmod_mfb_lpf_pex_ota_core_hybrid_bm_half_0.iqmod_mfb_lpf_pex_ota_core_tg$1_0.v_b.n50 0.254024
R8169 iqmod_mfb_lpf_pex_half_1.iqmod_mfb_lpf_pex_ota_core_hybrid_bm_half_0.iqmod_mfb_lpf_pex_ota_core_tg$1_0.v_b.n5 iqmod_mfb_lpf_pex_half_1.iqmod_mfb_lpf_pex_ota_core_hybrid_bm_half_0.iqmod_mfb_lpf_pex_ota_core_tg$1_0.v_b.n49 0.254024
R8170 iqmod_mfb_lpf_pex_half_1.iqmod_mfb_lpf_pex_ota_core_hybrid_bm_half_0.iqmod_mfb_lpf_pex_ota_core_tg$1_0.v_b.n6 iqmod_mfb_lpf_pex_half_1.iqmod_mfb_lpf_pex_ota_core_hybrid_bm_half_0.iqmod_mfb_lpf_pex_ota_core_tg$1_0.v_b.n48 0.254024
R8171 iqmod_mfb_lpf_pex_half_1.iqmod_mfb_lpf_pex_ota_core_hybrid_bm_half_0.iqmod_mfb_lpf_pex_ota_core_tg$1_0.v_b.n7 iqmod_mfb_lpf_pex_half_1.iqmod_mfb_lpf_pex_ota_core_hybrid_bm_half_0.iqmod_mfb_lpf_pex_ota_core_tg$1_0.v_b.n47 0.254024
R8172 iqmod_mfb_lpf_pex_half_1.iqmod_mfb_lpf_pex_ota_core_hybrid_bm_half_0.iqmod_mfb_lpf_pex_ota_core_tg$1_0.v_b.n8 iqmod_mfb_lpf_pex_half_1.iqmod_mfb_lpf_pex_ota_core_hybrid_bm_half_0.iqmod_mfb_lpf_pex_ota_core_tg$1_0.v_b.n46 0.254024
R8173 iqmod_mfb_lpf_pex_half_1.iqmod_mfb_lpf_pex_ota_core_hybrid_bm_half_0.iqmod_mfb_lpf_pex_ota_core_tg$1_0.v_b.n9 iqmod_mfb_lpf_pex_half_1.iqmod_mfb_lpf_pex_ota_core_hybrid_bm_half_0.iqmod_mfb_lpf_pex_ota_core_tg$1_0.v_b.n45 0.254024
R8174 iqmod_mfb_lpf_pex_half_1.iqmod_mfb_lpf_pex_ota_core_hybrid_bm_half_0.iqmod_mfb_lpf_pex_ota_core_tg$1_0.v_b.n11 iqmod_mfb_lpf_pex_half_1.iqmod_mfb_lpf_pex_ota_core_hybrid_bm_half_0.iqmod_mfb_lpf_pex_ota_core_tg$1_0.v_b.n44 0.254024
R8175 iqmod_mfb_lpf_pex_half_1.iqmod_mfb_lpf_pex_ota_core_hybrid_bm_half_0.iqmod_mfb_lpf_pex_ota_core_tg$1_0.v_b.n12 iqmod_mfb_lpf_pex_half_1.iqmod_mfb_lpf_pex_ota_core_hybrid_bm_half_0.iqmod_mfb_lpf_pex_ota_core_tg$1_0.v_b.n43 0.254024
R8176 iqmod_mfb_lpf_pex_half_1.iqmod_mfb_lpf_pex_ota_core_hybrid_bm_half_0.iqmod_mfb_lpf_pex_ota_core_tg$1_0.v_b.n13 iqmod_mfb_lpf_pex_half_1.iqmod_mfb_lpf_pex_ota_core_hybrid_bm_half_0.iqmod_mfb_lpf_pex_ota_core_tg$1_0.v_b.n42 0.254024
R8177 iqmod_mfb_lpf_pex_half_1.iqmod_mfb_lpf_pex_ota_core_hybrid_bm_half_0.iqmod_mfb_lpf_pex_ota_core_tg$1_0.v_b.n14 iqmod_mfb_lpf_pex_half_1.iqmod_mfb_lpf_pex_ota_core_hybrid_bm_half_0.iqmod_mfb_lpf_pex_ota_core_tg$1_0.v_b.n41 0.254024
R8178 iqmod_mfb_lpf_pex_half_1.iqmod_mfb_lpf_pex_ota_core_hybrid_bm_half_0.iqmod_mfb_lpf_pex_ota_core_tg$1_0.v_b.n15 iqmod_mfb_lpf_pex_half_1.iqmod_mfb_lpf_pex_ota_core_hybrid_bm_half_0.iqmod_mfb_lpf_pex_ota_core_tg$1_0.v_b.n40 0.254024
R8179 iqmod_mfb_lpf_pex_half_1.iqmod_mfb_lpf_pex_ota_core_hybrid_bm_half_0.iqmod_mfb_lpf_pex_ota_core_tg$1_0.v_b.n16 iqmod_mfb_lpf_pex_half_1.iqmod_mfb_lpf_pex_ota_core_hybrid_bm_half_0.iqmod_mfb_lpf_pex_ota_core_tg$1_0.v_b.n39 0.254024
R8180 iqmod_mfb_lpf_pex_half_1.iqmod_mfb_lpf_pex_ota_core_hybrid_bm_half_0.iqmod_mfb_lpf_pex_ota_core_tg$1_0.v_b.n17 iqmod_mfb_lpf_pex_half_1.iqmod_mfb_lpf_pex_ota_core_hybrid_bm_half_0.iqmod_mfb_lpf_pex_ota_core_tg$1_0.v_b.n38 0.254024
R8181 iqmod_mfb_lpf_pex_half_1.iqmod_mfb_lpf_pex_ota_core_hybrid_bm_half_0.iqmod_mfb_lpf_pex_ota_core_tg$1_0.v_b.n37 iqmod_mfb_lpf_pex_half_1.iqmod_mfb_lpf_pex_ota_core_hybrid_bm_half_0.iqmod_mfb_lpf_pex_ota_core_tg$1_0.v_b.n38 0.754036
R8182 iqmod_mfb_lpf_pex_half_1.iqmod_mfb_lpf_pex_ota_core_hybrid_bm_half_0.iqmod_mfb_lpf_pex_ota_core_tg$1_0.v_b.n10 iqmod_mfb_lpf_pex_half_1.iqmod_mfb_lpf_pex_ota_core_hybrid_bm_half_0.iqmod_mfb_lpf_pex_ota_core_tg$1_0.v_b.n36 0.254024
R8183 iqmod_mfb_lpf_pex_half_1.iqmod_mfb_lpf_pex_ota_core_hybrid_bm_half_0.iqmod_mfb_lpf_pex_ota_core_tg$1_0.v_b.n36 iqmod_mfb_lpf_pex_half_1.iqmod_mfb_lpf_pex_ota_core_hybrid_bm_half_0.iqmod_mfb_lpf_pex_ota_core_tg$1_0.v_b.t37 0.994013
R8184 iqmod_mfb_lpf_pex_half_1.iqmod_mfb_lpf_pex_ota_core_hybrid_bm_half_0.iqmod_mfb_lpf_pex_ota_core_tg$1_0.v_b.n53 iqmod_mfb_lpf_pex_half_1.iqmod_mfb_lpf_pex_ota_core_hybrid_bm_half_0.iqmod_mfb_lpf_pex_ota_core_tg$1_0.v_b.n35 0.83231
R8185 iqmod_mfb_lpf_pex_half_1.iqmod_mfb_lpf_pex_ota_core_hybrid_bm_half_0.iqmod_mfb_lpf_pex_ota_core_tg$1_0.v_b.n35 iqmod_mfb_lpf_pex_half_1.iqmod_mfb_lpf_pex_ota_core_hybrid_bm_half_0.iqmod_mfb_lpf_pex_ota_core_tg$1_0.v_b.n34 0.578786
R8186 iqmod_mfb_lpf_pex_half_1.iqmod_mfb_lpf_pex_ota_core_hybrid_bm_half_0.iqmod_mfb_lpf_pex_ota_core_tg$1_0.v_b.n34 iqmod_mfb_lpf_pex_half_1.iqmod_mfb_lpf_pex_ota_core_hybrid_bm_half_0.iqmod_mfb_lpf_pex_ota_core_tg$1_0.v_b.n33 0.578786
R8187 iqmod_mfb_lpf_pex_half_1.iqmod_mfb_lpf_pex_ota_core_hybrid_bm_half_0.iqmod_mfb_lpf_pex_ota_core_tg$1_0.v_b.n33 iqmod_mfb_lpf_pex_half_1.iqmod_mfb_lpf_pex_ota_core_hybrid_bm_half_0.iqmod_mfb_lpf_pex_ota_core_tg$1_0.v_b.n32 0.578786
R8188 iqmod_mfb_lpf_pex_half_1.iqmod_mfb_lpf_pex_ota_core_hybrid_bm_half_0.iqmod_mfb_lpf_pex_ota_core_tg$1_0.v_b.n32 iqmod_mfb_lpf_pex_half_1.iqmod_mfb_lpf_pex_ota_core_hybrid_bm_half_0.iqmod_mfb_lpf_pex_ota_core_tg$1_0.v_b.n31 0.578786
R8189 iqmod_mfb_lpf_pex_half_1.iqmod_mfb_lpf_pex_ota_core_hybrid_bm_half_0.iqmod_mfb_lpf_pex_ota_core_tg$1_0.v_b.n31 iqmod_mfb_lpf_pex_half_1.iqmod_mfb_lpf_pex_ota_core_hybrid_bm_half_0.iqmod_mfb_lpf_pex_ota_core_tg$1_0.v_b.n30 0.578786
R8190 iqmod_mfb_lpf_pex_half_1.iqmod_mfb_lpf_pex_ota_core_hybrid_bm_half_0.iqmod_mfb_lpf_pex_ota_core_tg$1_0.v_b.n30 iqmod_mfb_lpf_pex_half_1.iqmod_mfb_lpf_pex_ota_core_hybrid_bm_half_0.iqmod_mfb_lpf_pex_ota_core_tg$1_0.v_b.n29 0.578786
R8191 iqmod_mfb_lpf_pex_half_1.iqmod_mfb_lpf_pex_ota_core_hybrid_bm_half_0.iqmod_mfb_lpf_pex_ota_core_tg$1_0.v_b.n29 iqmod_mfb_lpf_pex_half_1.iqmod_mfb_lpf_pex_ota_core_hybrid_bm_half_0.iqmod_mfb_lpf_pex_ota_core_tg$1_0.v_b.n28 0.578786
R8192 iqmod_mfb_lpf_pex_half_1.iqmod_mfb_lpf_pex_ota_core_hybrid_bm_half_0.iqmod_mfb_lpf_pex_ota_core_tg$1_0.v_b.n28 iqmod_mfb_lpf_pex_half_1.iqmod_mfb_lpf_pex_ota_core_hybrid_bm_half_0.iqmod_mfb_lpf_pex_ota_core_tg$1_0.v_b.n19 0.578786
R8193 iqmod_mfb_lpf_pex_half_1.iqmod_mfb_lpf_pex_ota_core_hybrid_bm_half_0.iqmod_mfb_lpf_pex_ota_core_tg$1_0.v_b.n19 iqmod_mfb_lpf_pex_half_1.iqmod_mfb_lpf_pex_ota_core_hybrid_bm_half_0.iqmod_mfb_lpf_pex_ota_core_tg$1_0.v_b.n27 0.578786
R8194 iqmod_mfb_lpf_pex_half_1.iqmod_mfb_lpf_pex_ota_core_hybrid_bm_half_0.iqmod_mfb_lpf_pex_ota_core_tg$1_0.v_b.n27 iqmod_mfb_lpf_pex_half_1.iqmod_mfb_lpf_pex_ota_core_hybrid_bm_half_0.iqmod_mfb_lpf_pex_ota_core_tg$1_0.v_b.n26 0.578786
R8195 iqmod_mfb_lpf_pex_half_1.iqmod_mfb_lpf_pex_ota_core_hybrid_bm_half_0.iqmod_mfb_lpf_pex_ota_core_tg$1_0.v_b.n26 iqmod_mfb_lpf_pex_half_1.iqmod_mfb_lpf_pex_ota_core_hybrid_bm_half_0.iqmod_mfb_lpf_pex_ota_core_tg$1_0.v_b.n25 0.578786
R8196 iqmod_mfb_lpf_pex_half_1.iqmod_mfb_lpf_pex_ota_core_hybrid_bm_half_0.iqmod_mfb_lpf_pex_ota_core_tg$1_0.v_b.n25 iqmod_mfb_lpf_pex_half_1.iqmod_mfb_lpf_pex_ota_core_hybrid_bm_half_0.iqmod_mfb_lpf_pex_ota_core_tg$1_0.v_b.n24 0.578786
R8197 iqmod_mfb_lpf_pex_half_1.iqmod_mfb_lpf_pex_ota_core_hybrid_bm_half_0.iqmod_mfb_lpf_pex_ota_core_tg$1_0.v_b.n24 iqmod_mfb_lpf_pex_half_1.iqmod_mfb_lpf_pex_ota_core_hybrid_bm_half_0.iqmod_mfb_lpf_pex_ota_core_tg$1_0.v_b.n23 0.578786
R8198 iqmod_mfb_lpf_pex_half_1.iqmod_mfb_lpf_pex_ota_core_hybrid_bm_half_0.iqmod_mfb_lpf_pex_ota_core_tg$1_0.v_b.n23 iqmod_mfb_lpf_pex_half_1.iqmod_mfb_lpf_pex_ota_core_hybrid_bm_half_0.iqmod_mfb_lpf_pex_ota_core_tg$1_0.v_b.n22 0.578786
R8199 iqmod_mfb_lpf_pex_half_1.iqmod_mfb_lpf_pex_ota_core_hybrid_bm_half_0.iqmod_mfb_lpf_pex_ota_core_tg$1_0.v_b.n22 iqmod_mfb_lpf_pex_half_1.iqmod_mfb_lpf_pex_ota_core_hybrid_bm_half_0.iqmod_mfb_lpf_pex_ota_core_tg$1_0.v_b.n21 0.578786
R8200 iqmod_mfb_lpf_pex_half_1.iqmod_mfb_lpf_pex_ota_core_hybrid_bm_half_0.iqmod_mfb_lpf_pex_ota_core_tg$1_0.v_b.n21 iqmod_mfb_lpf_pex_half_1.iqmod_mfb_lpf_pex_ota_core_hybrid_bm_half_0.iqmod_mfb_lpf_pex_ota_core_tg$1_0.v_b.n20 0.578786
R8201 iqmod_mfb_lpf_pex_half_1.iqmod_mfb_lpf_pex_ota_core_hybrid_bm_half_0.iqmod_mfb_lpf_pex_ota_core_tg$1_0.v_b.n18 iqmod_mfb_lpf_pex_half_1.iqmod_mfb_lpf_pex_ota_core_hybrid_bm_half_0.iqmod_mfb_lpf_pex_ota_core_tg$1_0.v_b.n35 0.254024
R8202 iqmod_mfb_lpf_pex_half_1.iqmod_mfb_lpf_pex_ota_core_hybrid_bm_half_0.iqmod_mfb_lpf_pex_ota_core_tg$1_0.v_b.n17 iqmod_mfb_lpf_pex_half_1.iqmod_mfb_lpf_pex_ota_core_hybrid_bm_half_0.iqmod_mfb_lpf_pex_ota_core_tg$1_0.v_b.n34 0.254024
R8203 iqmod_mfb_lpf_pex_half_1.iqmod_mfb_lpf_pex_ota_core_hybrid_bm_half_0.iqmod_mfb_lpf_pex_ota_core_tg$1_0.v_b.n16 iqmod_mfb_lpf_pex_half_1.iqmod_mfb_lpf_pex_ota_core_hybrid_bm_half_0.iqmod_mfb_lpf_pex_ota_core_tg$1_0.v_b.n33 0.254024
R8204 iqmod_mfb_lpf_pex_half_1.iqmod_mfb_lpf_pex_ota_core_hybrid_bm_half_0.iqmod_mfb_lpf_pex_ota_core_tg$1_0.v_b.n15 iqmod_mfb_lpf_pex_half_1.iqmod_mfb_lpf_pex_ota_core_hybrid_bm_half_0.iqmod_mfb_lpf_pex_ota_core_tg$1_0.v_b.n32 0.254024
R8205 iqmod_mfb_lpf_pex_half_1.iqmod_mfb_lpf_pex_ota_core_hybrid_bm_half_0.iqmod_mfb_lpf_pex_ota_core_tg$1_0.v_b.n14 iqmod_mfb_lpf_pex_half_1.iqmod_mfb_lpf_pex_ota_core_hybrid_bm_half_0.iqmod_mfb_lpf_pex_ota_core_tg$1_0.v_b.n31 0.254024
R8206 iqmod_mfb_lpf_pex_half_1.iqmod_mfb_lpf_pex_ota_core_hybrid_bm_half_0.iqmod_mfb_lpf_pex_ota_core_tg$1_0.v_b.n13 iqmod_mfb_lpf_pex_half_1.iqmod_mfb_lpf_pex_ota_core_hybrid_bm_half_0.iqmod_mfb_lpf_pex_ota_core_tg$1_0.v_b.n30 0.254024
R8207 iqmod_mfb_lpf_pex_half_1.iqmod_mfb_lpf_pex_ota_core_hybrid_bm_half_0.iqmod_mfb_lpf_pex_ota_core_tg$1_0.v_b.n12 iqmod_mfb_lpf_pex_half_1.iqmod_mfb_lpf_pex_ota_core_hybrid_bm_half_0.iqmod_mfb_lpf_pex_ota_core_tg$1_0.v_b.n29 0.254024
R8208 iqmod_mfb_lpf_pex_half_1.iqmod_mfb_lpf_pex_ota_core_hybrid_bm_half_0.iqmod_mfb_lpf_pex_ota_core_tg$1_0.v_b.n11 iqmod_mfb_lpf_pex_half_1.iqmod_mfb_lpf_pex_ota_core_hybrid_bm_half_0.iqmod_mfb_lpf_pex_ota_core_tg$1_0.v_b.n28 0.254024
R8209 iqmod_mfb_lpf_pex_half_1.iqmod_mfb_lpf_pex_ota_core_hybrid_bm_half_0.iqmod_mfb_lpf_pex_ota_core_tg$1_0.v_b.n9 iqmod_mfb_lpf_pex_half_1.iqmod_mfb_lpf_pex_ota_core_hybrid_bm_half_0.iqmod_mfb_lpf_pex_ota_core_tg$1_0.v_b.n27 0.254024
R8210 iqmod_mfb_lpf_pex_half_1.iqmod_mfb_lpf_pex_ota_core_hybrid_bm_half_0.iqmod_mfb_lpf_pex_ota_core_tg$1_0.v_b.n8 iqmod_mfb_lpf_pex_half_1.iqmod_mfb_lpf_pex_ota_core_hybrid_bm_half_0.iqmod_mfb_lpf_pex_ota_core_tg$1_0.v_b.n26 0.254024
R8211 iqmod_mfb_lpf_pex_half_1.iqmod_mfb_lpf_pex_ota_core_hybrid_bm_half_0.iqmod_mfb_lpf_pex_ota_core_tg$1_0.v_b.n7 iqmod_mfb_lpf_pex_half_1.iqmod_mfb_lpf_pex_ota_core_hybrid_bm_half_0.iqmod_mfb_lpf_pex_ota_core_tg$1_0.v_b.n25 0.254024
R8212 iqmod_mfb_lpf_pex_half_1.iqmod_mfb_lpf_pex_ota_core_hybrid_bm_half_0.iqmod_mfb_lpf_pex_ota_core_tg$1_0.v_b.n6 iqmod_mfb_lpf_pex_half_1.iqmod_mfb_lpf_pex_ota_core_hybrid_bm_half_0.iqmod_mfb_lpf_pex_ota_core_tg$1_0.v_b.n24 0.254024
R8213 iqmod_mfb_lpf_pex_half_1.iqmod_mfb_lpf_pex_ota_core_hybrid_bm_half_0.iqmod_mfb_lpf_pex_ota_core_tg$1_0.v_b.n5 iqmod_mfb_lpf_pex_half_1.iqmod_mfb_lpf_pex_ota_core_hybrid_bm_half_0.iqmod_mfb_lpf_pex_ota_core_tg$1_0.v_b.n23 0.254024
R8214 iqmod_mfb_lpf_pex_half_1.iqmod_mfb_lpf_pex_ota_core_hybrid_bm_half_0.iqmod_mfb_lpf_pex_ota_core_tg$1_0.v_b.n4 iqmod_mfb_lpf_pex_half_1.iqmod_mfb_lpf_pex_ota_core_hybrid_bm_half_0.iqmod_mfb_lpf_pex_ota_core_tg$1_0.v_b.n22 0.254024
R8215 iqmod_mfb_lpf_pex_half_1.iqmod_mfb_lpf_pex_ota_core_hybrid_bm_half_0.iqmod_mfb_lpf_pex_ota_core_tg$1_0.v_b.n3 iqmod_mfb_lpf_pex_half_1.iqmod_mfb_lpf_pex_ota_core_hybrid_bm_half_0.iqmod_mfb_lpf_pex_ota_core_tg$1_0.v_b.n21 0.254024
R8216 iqmod_mfb_lpf_pex_half_1.iqmod_mfb_lpf_pex_ota_core_hybrid_bm_half_0.iqmod_mfb_lpf_pex_ota_core_tg$1_0.v_b.n2 iqmod_mfb_lpf_pex_half_1.iqmod_mfb_lpf_pex_ota_core_hybrid_bm_half_0.iqmod_mfb_lpf_pex_ota_core_tg$1_0.v_b.n20 0.254024
R8217 iqmod_mfb_lpf_pex_half_1.iqmod_mfb_lpf_pex_ota_core_hybrid_bm_half_0.iqmod_mfb_lpf_pex_ota_core_tg$1_0.v_b.n20 iqmod_mfb_lpf_pex_half_1.iqmod_mfb_lpf_pex_ota_core_hybrid_bm_half_0.iqmod_mfb_lpf_pex_ota_core_tg$1_0.v_b.n1 0.83231
R8218 iqmod_mfb_lpf_pex_half_1.iqmod_mfb_lpf_pex_ota_core_hybrid_bm_half_0.iqmod_mfb_lpf_pex_ota_core_tg$1_0.v_b.n10 iqmod_mfb_lpf_pex_half_1.iqmod_mfb_lpf_pex_ota_core_hybrid_bm_half_0.iqmod_mfb_lpf_pex_ota_core_tg$1_0.v_b.n19 0.254024
R8219 iqmod_mfb_lpf_pex_half_1.iqmod_mfb_lpf_pex_ota_core_hybrid_bm_half_0.iqmod_mfb_lpf_pex_ota_core_tg$1_0.v_b.n19 iqmod_mfb_lpf_pex_half_1.iqmod_mfb_lpf_pex_ota_core_hybrid_bm_half_0.iqmod_mfb_lpf_pex_ota_core_tg$1_0.v_b.t36 0.994013
R8220 iqmod_mfb_lpf_pex_half_1.iqmod_mfb_lpf_pex_ota_core_hybrid_bm_half_0.iqmod_mfb_lpf_pex_ota_core_tg$1_0.v_b.n0 iqmod_mfb_lpf_pex_half_1.iqmod_mfb_lpf_pex_ota_core_hybrid_bm_half_0.iqmod_mfb_lpf_pex_ota_core_tg$1_0.v_b.t14 2.0693
R8221 iqmod_mfb_lpf_pex_half_1.iqmod_mfb_lpf_pex_ota_core_hybrid_bm_half_0.iqmod_mfb_lpf_pex_ota_core_tg$1_0.v_a.t1 iqmod_mfb_lpf_pex_half_1.iqmod_mfb_lpf_pex_ota_core_hybrid_bm_half_0.iqmod_mfb_lpf_pex_ota_core_tg$1_0.v_a.t0 27.484
R8222 iqmod_mfb_lpf_pex_half_0.iqmod_mfb_lpf_pex_ota_core_hybrid_bm_half_0.iqmod_mfb_lpf_pex_ota_core_inv_NF20$1_1.vin.t1 iqmod_mfb_lpf_pex_half_0.iqmod_mfb_lpf_pex_ota_core_hybrid_bm_half_0.iqmod_mfb_lpf_pex_ota_core_inv_NF20$1_1.vin.t0 30.5857
R8223 iqmod_mfb_lpf_pex_half_0.iqmod_mfb_lpf_pex_ota_core_hybrid_bm_half_0.iqmod_mfb_lpf_pex_ota_core_spdt_switch$1_0.iqmod_mfb_lpf_pex_ota_core_spdt_switch_inv$2_0.vout.t1 iqmod_mfb_lpf_pex_half_0.iqmod_mfb_lpf_pex_ota_core_hybrid_bm_half_0.iqmod_mfb_lpf_pex_ota_core_spdt_switch$1_0.iqmod_mfb_lpf_pex_ota_core_spdt_switch_inv$2_0.vout 14.9798
R8224 iqmod_mfb_lpf_pex_half_0.iqmod_mfb_lpf_pex_ota_core_hybrid_bm_half_0.iqmod_mfb_lpf_pex_ota_core_spdt_switch$1_0.iqmod_mfb_lpf_pex_ota_core_spdt_switch_inv$2_0.vout iqmod_mfb_lpf_pex_half_0.iqmod_mfb_lpf_pex_ota_core_hybrid_bm_half_0.iqmod_mfb_lpf_pex_ota_core_spdt_switch$1_0.iqmod_mfb_lpf_pex_ota_core_spdt_switch_inv$2_0.vout.n3 0.17034
R8225 iqmod_mfb_lpf_pex_half_0.iqmod_mfb_lpf_pex_ota_core_hybrid_bm_half_0.iqmod_mfb_lpf_pex_ota_core_spdt_switch$1_0.iqmod_mfb_lpf_pex_ota_core_spdt_switch_inv$2_0.vout iqmod_mfb_lpf_pex_half_0.iqmod_mfb_lpf_pex_ota_core_hybrid_bm_half_0.iqmod_mfb_lpf_pex_ota_core_spdt_switch$1_0.iqmod_mfb_lpf_pex_ota_core_spdt_switch_inv$2_0.vout.t0 3.25207
R8226 iqmod_mfb_lpf_pex_half_0.iqmod_mfb_lpf_pex_ota_core_hybrid_bm_half_0.iqmod_mfb_lpf_pex_ota_core_spdt_switch$1_0.iqmod_mfb_lpf_pex_ota_core_spdt_switch_inv$2_0.vout.n3 iqmod_mfb_lpf_pex_half_0.iqmod_mfb_lpf_pex_ota_core_hybrid_bm_half_0.iqmod_mfb_lpf_pex_ota_core_spdt_switch$1_0.iqmod_mfb_lpf_pex_ota_core_spdt_switch_inv$2_0.vout.n0 13.3461
R8227 iqmod_mfb_lpf_pex_half_0.iqmod_mfb_lpf_pex_ota_core_hybrid_bm_half_0.iqmod_mfb_lpf_pex_ota_core_spdt_switch$1_0.iqmod_mfb_lpf_pex_ota_core_spdt_switch_inv$2_0.vout.n3 iqmod_mfb_lpf_pex_half_0.iqmod_mfb_lpf_pex_ota_core_hybrid_bm_half_0.iqmod_mfb_lpf_pex_ota_core_spdt_switch$1_0.iqmod_mfb_lpf_pex_ota_core_spdt_switch_inv$2_0.vout.n2 3.2859
R8228 iqmod_mfb_lpf_pex_half_0.iqmod_mfb_lpf_pex_ota_core_hybrid_bm_half_0.iqmod_mfb_lpf_pex_ota_core_spdt_switch$1_0.iqmod_mfb_lpf_pex_ota_core_spdt_switch_inv$2_0.vout iqmod_mfb_lpf_pex_half_0.iqmod_mfb_lpf_pex_ota_core_hybrid_bm_half_0.iqmod_mfb_lpf_pex_ota_core_spdt_switch$1_0.iqmod_mfb_lpf_pex_ota_core_spdt_switch_inv$2_0.vout.n2 0.0335
R8229 iqmod_mfb_lpf_pex_half_0.iqmod_mfb_lpf_pex_ota_core_hybrid_bm_half_0.iqmod_mfb_lpf_pex_ota_core_spdt_switch$1_0.iqmod_mfb_lpf_pex_ota_core_spdt_switch_inv$2_0.vout.n2 iqmod_mfb_lpf_pex_half_0.iqmod_mfb_lpf_pex_ota_core_hybrid_bm_half_0.iqmod_mfb_lpf_pex_ota_core_spdt_switch$1_0.iqmod_mfb_lpf_pex_ota_core_spdt_switch_inv$2_0.vout.t2 3.12406
R8230 iqmod_mfb_lpf_pex_half_0.iqmod_mfb_lpf_pex_ota_core_hybrid_bm_half_0.iqmod_mfb_lpf_pex_ota_core_spdt_switch$1_0.iqmod_mfb_lpf_pex_ota_core_spdt_switch_inv$2_0.vout iqmod_mfb_lpf_pex_half_0.iqmod_mfb_lpf_pex_ota_core_hybrid_bm_half_0.iqmod_mfb_lpf_pex_ota_core_spdt_switch$1_0.iqmod_mfb_lpf_pex_ota_core_spdt_switch_inv$2_0.vout.n0 0.0335
R8231 iqmod_mfb_lpf_pex_half_0.iqmod_mfb_lpf_pex_ota_core_hybrid_bm_half_0.iqmod_mfb_lpf_pex_ota_core_spdt_switch$1_0.iqmod_mfb_lpf_pex_ota_core_spdt_switch_inv$2_0.vout.n1 iqmod_mfb_lpf_pex_half_0.iqmod_mfb_lpf_pex_ota_core_hybrid_bm_half_0.iqmod_mfb_lpf_pex_ota_core_spdt_switch$1_0.iqmod_mfb_lpf_pex_ota_core_spdt_switch_inv$2_0.vout.t4 0.00137204
R8232 iqmod_mfb_lpf_pex_half_0.iqmod_mfb_lpf_pex_ota_core_hybrid_bm_half_0.iqmod_mfb_lpf_pex_ota_core_spdt_switch$1_0.iqmod_mfb_lpf_pex_ota_core_spdt_switch_inv$2_0.vout.n0 iqmod_mfb_lpf_pex_half_0.iqmod_mfb_lpf_pex_ota_core_hybrid_bm_half_0.iqmod_mfb_lpf_pex_ota_core_spdt_switch$1_0.iqmod_mfb_lpf_pex_ota_core_spdt_switch_inv$2_0.vout.n1 3.12245
R8233 iqmod_mfb_lpf_pex_half_0.iqmod_mfb_lpf_pex_ota_core_hybrid_bm_half_0.iqmod_mfb_lpf_pex_ota_core_spdt_switch$1_0.iqmod_mfb_lpf_pex_ota_core_spdt_switch_inv$2_0.vout.n1 iqmod_mfb_lpf_pex_half_0.iqmod_mfb_lpf_pex_ota_core_hybrid_bm_half_0.iqmod_mfb_lpf_pex_ota_core_spdt_switch$1_0.iqmod_mfb_lpf_pex_ota_core_spdt_switch_inv$2_0.vout.t3 0.00262788
R8234 iqmod_mfb_lpf_pex_half_0.iqmod_mfb_lpf_pex_ota_core_hybrid_bm_half_0.iqmod_mfb_lpf_pex_ota_core_tg$1_0.di_tg_ctrl_n.t0 iqmod_mfb_lpf_pex_half_0.iqmod_mfb_lpf_pex_ota_core_hybrid_bm_half_0.iqmod_mfb_lpf_pex_ota_core_tg$1_0.di_tg_ctrl_n 14.9798
R8235 iqmod_mfb_lpf_pex_half_0.iqmod_mfb_lpf_pex_ota_core_hybrid_bm_half_0.iqmod_mfb_lpf_pex_ota_core_tg$1_0.di_tg_ctrl_n iqmod_mfb_lpf_pex_half_0.iqmod_mfb_lpf_pex_ota_core_hybrid_bm_half_0.iqmod_mfb_lpf_pex_ota_core_tg$1_0.di_tg_ctrl_n.n8 0.17914
R8236 iqmod_mfb_lpf_pex_half_0.iqmod_mfb_lpf_pex_ota_core_hybrid_bm_half_0.iqmod_mfb_lpf_pex_ota_core_tg$1_0.di_tg_ctrl_n iqmod_mfb_lpf_pex_half_0.iqmod_mfb_lpf_pex_ota_core_hybrid_bm_half_0.iqmod_mfb_lpf_pex_ota_core_tg$1_0.di_tg_ctrl_n.t1 3.25207
R8237 iqmod_mfb_lpf_pex_half_0.iqmod_mfb_lpf_pex_ota_core_hybrid_bm_half_0.iqmod_mfb_lpf_pex_ota_core_tg$1_0.di_tg_ctrl_n.n8 iqmod_mfb_lpf_pex_half_0.iqmod_mfb_lpf_pex_ota_core_hybrid_bm_half_0.iqmod_mfb_lpf_pex_ota_core_tg$1_0.di_tg_ctrl_n.n1 1.5493
R8238 iqmod_mfb_lpf_pex_half_0.iqmod_mfb_lpf_pex_ota_core_hybrid_bm_half_0.iqmod_mfb_lpf_pex_ota_core_tg$1_0.di_tg_ctrl_n.n8 iqmod_mfb_lpf_pex_half_0.iqmod_mfb_lpf_pex_ota_core_hybrid_bm_half_0.iqmod_mfb_lpf_pex_ota_core_tg$1_0.di_tg_ctrl_n.n7 12.8885
R8239 iqmod_mfb_lpf_pex_half_0.iqmod_mfb_lpf_pex_ota_core_hybrid_bm_half_0.iqmod_mfb_lpf_pex_ota_core_tg$1_0.di_tg_ctrl_n iqmod_mfb_lpf_pex_half_0.iqmod_mfb_lpf_pex_ota_core_hybrid_bm_half_0.iqmod_mfb_lpf_pex_ota_core_tg$1_0.di_tg_ctrl_n.n7 0.0335
R8240 iqmod_mfb_lpf_pex_half_0.iqmod_mfb_lpf_pex_ota_core_hybrid_bm_half_0.iqmod_mfb_lpf_pex_ota_core_tg$1_0.di_tg_ctrl_n.n7 iqmod_mfb_lpf_pex_half_0.iqmod_mfb_lpf_pex_ota_core_hybrid_bm_half_0.iqmod_mfb_lpf_pex_ota_core_tg$1_0.di_tg_ctrl_n.t2 3.12406
R8241 iqmod_mfb_lpf_pex_half_0.iqmod_mfb_lpf_pex_ota_core_hybrid_bm_half_0.iqmod_mfb_lpf_pex_ota_core_tg$1_0.di_tg_ctrl_n.n1 iqmod_mfb_lpf_pex_half_0.iqmod_mfb_lpf_pex_ota_core_hybrid_bm_half_0.iqmod_mfb_lpf_pex_ota_core_tg$1_0.di_tg_ctrl_n.n5 5.6795
R8242 iqmod_mfb_lpf_pex_half_0.iqmod_mfb_lpf_pex_ota_core_hybrid_bm_half_0.iqmod_mfb_lpf_pex_ota_core_tg$1_0.di_tg_ctrl_n iqmod_mfb_lpf_pex_half_0.iqmod_mfb_lpf_pex_ota_core_hybrid_bm_half_0.iqmod_mfb_lpf_pex_ota_core_tg$1_0.di_tg_ctrl_n.n5 0.0335
R8243 iqmod_mfb_lpf_pex_half_0.iqmod_mfb_lpf_pex_ota_core_hybrid_bm_half_0.iqmod_mfb_lpf_pex_ota_core_tg$1_0.di_tg_ctrl_n.n6 iqmod_mfb_lpf_pex_half_0.iqmod_mfb_lpf_pex_ota_core_hybrid_bm_half_0.iqmod_mfb_lpf_pex_ota_core_tg$1_0.di_tg_ctrl_n.t7 0.00137204
R8244 iqmod_mfb_lpf_pex_half_0.iqmod_mfb_lpf_pex_ota_core_hybrid_bm_half_0.iqmod_mfb_lpf_pex_ota_core_tg$1_0.di_tg_ctrl_n.n5 iqmod_mfb_lpf_pex_half_0.iqmod_mfb_lpf_pex_ota_core_hybrid_bm_half_0.iqmod_mfb_lpf_pex_ota_core_tg$1_0.di_tg_ctrl_n.n6 3.12245
R8245 iqmod_mfb_lpf_pex_half_0.iqmod_mfb_lpf_pex_ota_core_hybrid_bm_half_0.iqmod_mfb_lpf_pex_ota_core_tg$1_0.di_tg_ctrl_n.n6 iqmod_mfb_lpf_pex_half_0.iqmod_mfb_lpf_pex_ota_core_hybrid_bm_half_0.iqmod_mfb_lpf_pex_ota_core_tg$1_0.di_tg_ctrl_n.t6 0.00262788
R8246 iqmod_mfb_lpf_pex_half_0.iqmod_mfb_lpf_pex_ota_core_hybrid_bm_half_0.iqmod_mfb_lpf_pex_ota_core_tg$1_0.di_tg_ctrl_n.n3 iqmod_mfb_lpf_pex_half_0.iqmod_mfb_lpf_pex_ota_core_hybrid_bm_half_0.iqmod_mfb_lpf_pex_ota_core_tg$1_0.di_tg_ctrl_n.n2 1.1255
R8247 iqmod_mfb_lpf_pex_half_0.iqmod_mfb_lpf_pex_ota_core_hybrid_bm_half_0.iqmod_mfb_lpf_pex_ota_core_tg$1_0.di_tg_ctrl_n.n1 iqmod_mfb_lpf_pex_half_0.iqmod_mfb_lpf_pex_ota_core_hybrid_bm_half_0.iqmod_mfb_lpf_pex_ota_core_tg$1_0.di_tg_ctrl_n.n3 26.9504
R8248 iqmod_mfb_lpf_pex_half_0.iqmod_mfb_lpf_pex_ota_core_hybrid_bm_half_0.iqmod_mfb_lpf_pex_ota_core_tg$1_0.di_tg_ctrl_n.n3 iqmod_mfb_lpf_pex_half_0.iqmod_mfb_lpf_pex_ota_core_hybrid_bm_half_0.iqmod_mfb_lpf_pex_ota_core_tg$1_0.di_tg_ctrl_n.n4 49.0109
R8249 iqmod_mfb_lpf_pex_half_0.iqmod_mfb_lpf_pex_ota_core_hybrid_bm_half_0.iqmod_mfb_lpf_pex_ota_core_tg$1_0.di_tg_ctrl_n iqmod_mfb_lpf_pex_half_0.iqmod_mfb_lpf_pex_ota_core_hybrid_bm_half_0.iqmod_mfb_lpf_pex_ota_core_tg$1_0.di_tg_ctrl_n.n4 0.0335
R8250 iqmod_mfb_lpf_pex_half_0.iqmod_mfb_lpf_pex_ota_core_hybrid_bm_half_0.iqmod_mfb_lpf_pex_ota_core_tg$1_0.di_tg_ctrl_n.n4 iqmod_mfb_lpf_pex_half_0.iqmod_mfb_lpf_pex_ota_core_hybrid_bm_half_0.iqmod_mfb_lpf_pex_ota_core_tg$1_0.di_tg_ctrl_n.t4 3.12406
R8251 iqmod_mfb_lpf_pex_half_0.iqmod_mfb_lpf_pex_ota_core_hybrid_bm_half_0.iqmod_mfb_lpf_pex_ota_core_tg$1_0.di_tg_ctrl_n iqmod_mfb_lpf_pex_half_0.iqmod_mfb_lpf_pex_ota_core_hybrid_bm_half_0.iqmod_mfb_lpf_pex_ota_core_tg$1_0.di_tg_ctrl_n.n2 0.0335
R8252 iqmod_mfb_lpf_pex_half_0.iqmod_mfb_lpf_pex_ota_core_hybrid_bm_half_0.iqmod_mfb_lpf_pex_ota_core_tg$1_0.di_tg_ctrl_n.n2 iqmod_mfb_lpf_pex_half_0.iqmod_mfb_lpf_pex_ota_core_hybrid_bm_half_0.iqmod_mfb_lpf_pex_ota_core_tg$1_0.di_tg_ctrl_n.t5 3.12406
R8253 iqmod_mfb_lpf_pex_half_0.iqmod_mfb_lpf_pex_ota_core_hybrid_bm_half_0.iqmod_mfb_lpf_pex_ota_core_tg$1_0.di_tg_ctrl_n.n8 iqmod_mfb_lpf_pex_half_0.iqmod_mfb_lpf_pex_ota_core_hybrid_bm_half_0.iqmod_mfb_lpf_pex_ota_core_tg$1_0.di_tg_ctrl_n 4.55638
R8254 iqmod_mfb_lpf_pex_half_0.iqmod_mfb_lpf_pex_ota_core_hybrid_bm_half_0.iqmod_mfb_lpf_pex_ota_core_tg$1_0.di_tg_ctrl_n iqmod_mfb_lpf_pex_half_0.iqmod_mfb_lpf_pex_ota_core_hybrid_bm_half_0.iqmod_mfb_lpf_pex_ota_core_tg$1_0.di_tg_ctrl_n.n0 0.03174
R8255 iqmod_mfb_lpf_pex_half_0.iqmod_mfb_lpf_pex_ota_core_hybrid_bm_half_0.iqmod_mfb_lpf_pex_ota_core_tg$1_0.di_tg_ctrl_n.t8 iqmod_mfb_lpf_pex_half_0.iqmod_mfb_lpf_pex_ota_core_hybrid_bm_half_0.iqmod_mfb_lpf_pex_ota_core_tg$1_0.di_tg_ctrl_n.n0 12.3425
R8256 iqmod_mfb_lpf_pex_half_0.iqmod_mfb_lpf_pex_ota_core_hybrid_bm_half_0.iqmod_mfb_lpf_pex_ota_core_tg$1_0.di_tg_ctrl_n.t3 iqmod_mfb_lpf_pex_half_0.iqmod_mfb_lpf_pex_ota_core_hybrid_bm_half_0.iqmod_mfb_lpf_pex_ota_core_tg$1_0.di_tg_ctrl_n.n0 12.3425
R8257 a_37874_3903.t0 a_37874_3903.t1 30.6351
R8258 iqmod_mfb_lpf_pex_half_1.C2_half.t3 iqmod_mfb_lpf_pex_half_1.C2_half.n5 17.2505
R8259 iqmod_mfb_lpf_pex_half_1.C2_half.n3 iqmod_mfb_lpf_pex_half_1.C2_half 6.07889
R8260 iqmod_mfb_lpf_pex_half_1.C2_half iqmod_mfb_lpf_pex_half_1.C2_half.n5 0.0161129
R8261 iqmod_mfb_lpf_pex_half_1.C2_half iqmod_mfb_lpf_pex_half_1.C2_half.n5 0.319855
R8262 iqmod_mfb_lpf_pex_half_1.C2_half.n3 iqmod_mfb_lpf_pex_half_1.C2_half.n4 7.38463
R8263 iqmod_mfb_lpf_pex_half_1.C2_half.t1 iqmod_mfb_lpf_pex_half_1.C2_half.n4 0.0237435
R8264 iqmod_mfb_lpf_pex_half_1.C2_half.n4 iqmod_mfb_lpf_pex_half_1.C2_half.t2 0.109257
R8265 iqmod_mfb_lpf_pex_half_1.C2_half.t0 iqmod_mfb_lpf_pex_half_1.C2_half.t1 0.1325
R8266 iqmod_mfb_lpf_pex_half_1.C2_half.n2 iqmod_mfb_lpf_pex_half_1.C2_half 26.995
R8267 iqmod_mfb_lpf_pex_half_1.C2_half iqmod_mfb_lpf_pex_half_1.C2_half.n0 0.0161129
R8268 iqmod_mfb_lpf_pex_half_1.C2_half.n0 iqmod_mfb_lpf_pex_half_1.C2_half.n3 2.48792
R8269 iqmod_mfb_lpf_pex_half_1.C2_half iqmod_mfb_lpf_pex_half_1.C2_half.n2 0.00371429
R8270 iqmod_mfb_lpf_pex_half_1.C2_half.n2 iqmod_mfb_lpf_pex_half_1.C2_half.n1 0.0221
R8271 iqmod_mfb_lpf_pex_half_1.C2_half.n1 iqmod_mfb_lpf_pex_half_1.C2_half.t7 0.00628571
R8272 iqmod_mfb_lpf_pex_half_1.C2_half.t7 iqmod_mfb_lpf_pex_half_1.C2_half.t6 0.04226
R8273 iqmod_mfb_lpf_pex_half_1.C2_half.t8 iqmod_mfb_lpf_pex_half_1.C2_half.n1 0.0364743
R8274 iqmod_mfb_lpf_pex_half_1.C2_half.t4 iqmod_mfb_lpf_pex_half_1.C2_half.n0 17.2505
R8275 iqmod_mfb_lpf_pex_half_1.C2_half iqmod_mfb_lpf_pex_half_1.C2_half.t5 17.2661
R8276 a_13404_3903.t0 a_13404_3903.t1 30.6351
R8277 a_25788_4203.t0 a_25788_4203.t1 30.6351
R8278 a_6620_3903.t0 a_6620_3903.t1 30.6351
R8279 a_25290_4203.t0 a_25290_4203.t1 30.6351
R8280 iqmod_mfb_lpf_pex_half_0.vinp.t7 iqmod_mfb_lpf_pex_half_0.vinp.n0 10.8541
R8281 iqmod_mfb_lpf_pex_half_0.iqmod_mfb_lpf_pex_ota_core_hybrid_bm_half_0.vinp iqmod_mfb_lpf_pex_half_0.iqmod_mfb_lpf_pex_ota_core_hybrid_bm_half_0.iqmod_mfb_lpf_pex_ota_core_spdt_switch$1_0.iqmod_mfb_lpf_pex_ota_core_spdt_switch_tg$2_1.v_a 5.2969
R8282 iqmod_mfb_lpf_pex_half_0.iqmod_mfb_lpf_pex_ota_core_hybrid_bm_half_0.iqmod_mfb_lpf_pex_ota_core_spdt_switch$1_0.iqmod_mfb_lpf_pex_ota_core_spdt_switch_tg$2_1.v_a iqmod_mfb_lpf_pex_half_0.vinp.n4 0.00974
R8283 iqmod_mfb_lpf_pex_half_0.vinp.n4 iqmod_mfb_lpf_pex_half_0.vinp.n3 0.09026
R8284 iqmod_mfb_lpf_pex_half_0.vinp.n3 iqmod_mfb_lpf_pex_half_0.vinp.n2 0.09026
R8285 iqmod_mfb_lpf_pex_half_0.vinp.n2 iqmod_mfb_lpf_pex_half_0.vinp.n0 0.09026
R8286 iqmod_mfb_lpf_pex_half_0.vinp.n4 iqmod_mfb_lpf_pex_half_0.vinp.t0 3.59068
R8287 iqmod_mfb_lpf_pex_half_0.vinp.n4 iqmod_mfb_lpf_pex_half_0.vinp.t4 10.8541
R8288 iqmod_mfb_lpf_pex_half_0.vinp.n3 iqmod_mfb_lpf_pex_half_0.vinp.t1 3.59112
R8289 iqmod_mfb_lpf_pex_half_0.vinp.n3 iqmod_mfb_lpf_pex_half_0.vinp.t5 10.8541
R8290 iqmod_mfb_lpf_pex_half_0.vinp.n2 iqmod_mfb_lpf_pex_half_0.vinp.t2 3.59112
R8291 iqmod_mfb_lpf_pex_half_0.vinp.n2 iqmod_mfb_lpf_pex_half_0.vinp.t6 10.8541
R8292 iqmod_mfb_lpf_pex_half_0.iqmod_mfb_lpf_pex_ota_core_hybrid_bm_half_0.iqmod_mfb_lpf_pex_ota_core_spdt_switch$1_0.v_a iqmod_mfb_lpf_pex_half_0.iqmod_mfb_lpf_pex_ota_core_hybrid_bm_half_0.vinp 0.0115
R8293 iqmod_mfb_lpf_pex_half_0.iqmod_mfb_lpf_pex_ota_core_hybrid_bm_half_0.iqmod_mfb_lpf_pex_ota_core_spdt_switch$1_0.v_a iqmod_mfb_lpf_pex_half_0.vinp.n1 14.3466
R8294 iqmod_mfb_lpf_pex_half_0.vinp.n1 iqmod_mfb_lpf_pex_half_0.vinp.t9 7.24781
R8295 iqmod_mfb_lpf_pex_half_0.vinp.n1 iqmod_mfb_lpf_pex_half_0.iqmod_mfb_lpf_pex_R3_0.v_b 1.2105
R8296 iqmod_mfb_lpf_pex_half_0.vinp.t8 iqmod_mfb_lpf_pex_half_0.iqmod_mfb_lpf_pex_R3_0.v_b 17.2661
R8297 iqmod_mfb_lpf_pex_half_0.vinp.n0 iqmod_mfb_lpf_pex_half_0.vinp.t3 3.59068
R8298 a_6122_3903.t0 a_6122_3903.t1 30.6351
R8299 a_12906_4203.t0 a_12906_4203.t1 30.6351
R8300 iqmod_mfb_lpf_pex_half_1.C1_half iqmod_mfb_lpf_pex_half_1.C1_half.n1 0.0487581
R8301 iqmod_mfb_lpf_pex_half_1.C1_half iqmod_mfb_lpf_pex_half_1.C1_half.t5 17.2661
R8302 iqmod_mfb_lpf_pex_half_1.C1_half.n1 iqmod_mfb_lpf_pex_half_1.C1_half.n4 7.20381
R8303 iqmod_mfb_lpf_pex_half_1.C1_half.n4 iqmod_mfb_lpf_pex_half_1.C1_half.t2 0.0237913
R8304 iqmod_mfb_lpf_pex_half_1.C1_half.n4 iqmod_mfb_lpf_pex_half_1.C1_half.t3 0.109209
R8305 iqmod_mfb_lpf_pex_half_1.C1_half.t3 iqmod_mfb_lpf_pex_half_1.C1_half.t4 0.1325
R8306 iqmod_mfb_lpf_pex_half_1.C1_half.t2 iqmod_mfb_lpf_pex_half_1.C1_half.t1 0.1325
R8307 iqmod_mfb_lpf_pex_half_1.C1_half.t1 iqmod_mfb_lpf_pex_half_1.C1_half.t0 0.1325
R8308 iqmod_mfb_lpf_pex_half_1.C1_half.n1 iqmod_mfb_lpf_pex_half_1.C1_half.n3 19.9373
R8309 iqmod_mfb_lpf_pex_half_1.C1_half iqmod_mfb_lpf_pex_half_1.C1_half.n3 0.00371429
R8310 iqmod_mfb_lpf_pex_half_1.C1_half.n3 iqmod_mfb_lpf_pex_half_1.C1_half.n2 0.0221
R8311 iqmod_mfb_lpf_pex_half_1.C1_half.n2 iqmod_mfb_lpf_pex_half_1.C1_half.t9 0.00628571
R8312 iqmod_mfb_lpf_pex_half_1.C1_half.t9 iqmod_mfb_lpf_pex_half_1.C1_half.t8 0.04226
R8313 iqmod_mfb_lpf_pex_half_1.C1_half.t8 iqmod_mfb_lpf_pex_half_1.C1_half.t7 0.04226
R8314 iqmod_mfb_lpf_pex_half_1.C1_half.n2 iqmod_mfb_lpf_pex_half_1.C1_half.t10 0.0364743
R8315 iqmod_mfb_lpf_pex_half_1.C1_half.t10 iqmod_mfb_lpf_pex_half_1.C1_half.t11 0.04226
R8316 iqmod_mfb_lpf_pex_half_1.C1_half iqmod_mfb_lpf_pex_half_1.C1_half.n0 0.0161129
R8317 iqmod_mfb_lpf_pex_half_1.C1_half.n1 iqmod_mfb_lpf_pex_half_1.C1_half.n0 0.064371
R8318 iqmod_mfb_lpf_pex_half_1.C1_half.n0 iqmod_mfb_lpf_pex_half_1.C1_half.t6 17.2505
R8319 a_636_4203.t0 a_636_4203.t1 30.6351
C0 a_25874_n4003# VDD 0.12803f
C1 a_13490_3603# iqmod_mfb_lpf_pex_half_1.iqmod_mfb_lpf_pex_ota_core_hybrid_bm_half_0.iqmod_mfb_lpf_pex_ota_core_tg$1_0.v_b 0.04647f
C2 iqmod_mfb_lpf_pex_half_1.C2_half a_6706_n3703# 0.02394f
C3 a_25874_n4303# voutp 0.01719f
C4 a_13490_4803# iqmod_mfb_lpf_pex_half_1.C2_half 0.25837f
C5 iqmod_mfb_lpf_pex_half_1.C1_half a_722_n4603# 0.0172f
C6 iqmod_mfb_lpf_pex_half_1.iqmod_mfb_lpf_pex_ota_core_hybrid_bm_half_0.iqmod_mfb_lpf_pex_ota_core_tg$1_0.v_b iqmod_mfb_lpf_pex_half_1.iqmod_mfb_lpf_pex_ota_core_hybrid_bm_half_0.iqmod_mfb_lpf_pex_ota_core_tg$1_0.di_tg_ctrl_n 1.96204f
C7 iqmod_mfb_lpf_pex_half_1.iqmod_mfb_lpf_pex_ota_core_hybrid_bm_half_0.iqmod_mfb_lpf_pex_ota_core_spdt_switch$1_0.iqmod_mfb_lpf_pex_ota_core_spdt_switch_inv$2_0.vout VDD 7.58236f
C8 iqmod_mfb_lpf_pex_half_1.C2_half voutp 0.99383f
C9 iqmod_mfb_lpf_pex_half_1.C1_half VDD 2.91238f
C10 iqmod_mfb_lpf_pex_half_1.C1_half a_6706_4203# 0.1078f
C11 VDD di_filter_en 2.24075f
C12 iqmod_mfb_lpf_pex_half_1.iqmod_mfb_lpf_pex_ota_core_hybrid_bm_half_0.iqmod_mfb_lpf_pex_ota_core_tg$1_0.v_b iqmod_mfb_lpf_pex_half_1.iqmod_mfb_lpf_pex_R2_0.v_a 1.1806f
C13 iqmod_mfb_lpf_pex_half_1.C1_half a_6706_3603# 0.1132f
C14 iqmod_mfb_lpf_pex_half_0.iqmod_mfb_lpf_pex_ota_core_hybrid_bm_half_0.iqmod_mfb_lpf_pex_ota_core_tg$1_0.di_tg_ctrl_n iqmod_mfb_lpf_pex_half_1.iqmod_mfb_lpf_pex_ota_core_hybrid_bm_half_0.iqmod_mfb_lpf_pex_ota_core_tg$1_0.di_tg_ctrl_n 0.15543f
C15 iqmod_mfb_lpf_pex_half_1.iqmod_mfb_lpf_pex_R2_0.v_a a_6706_n4303# 0.0556f
C16 a_722_n4003# iqmod_mfb_lpf_pex_half_1.iqmod_mfb_lpf_pex_R1_0.v_b 0.07082f
C17 a_13490_4503# a_13490_4203# 0.70571f
C18 a_722_n4003# a_722_n4303# 0.32295f
C19 iqmod_mfb_lpf_pex_half_1.iqmod_mfb_lpf_pex_ota_core_hybrid_bm_half_0.iqmod_mfb_lpf_pex_ota_core_tg$1_0.v_b iqmod_mfb_lpf_pex_half_1.iqmod_mfb_lpf_pex_R1_0.v_b 0.02501f
C20 iqmod_mfb_lpf_pex_half_0.iqmod_mfb_lpf_pex_ota_core_hybrid_bm_half_0.iqmod_mfb_lpf_pex_ota_core_tg$1_0.di_tg_ctrl_n iqmod_mfb_lpf_pex_half_1.iqmod_mfb_lpf_pex_R2_0.v_a 0.10115f
C21 a_6706_n4303# iqmod_mfb_lpf_pex_half_1.iqmod_mfb_lpf_pex_R1_0.v_b 0.09927f
C22 a_722_3903# a_722_3603# 0.32295f
C23 iqmod_mfb_lpf_pex_half_1.iqmod_mfb_lpf_pex_ota_core_hybrid_bm_half_0.iqmod_mfb_lpf_pex_ota_core_tg$1_0.v_b iqmod_mfb_lpf_pex_half_1.iqmod_mfb_lpf_pex_ota_core_hybrid_bm_half_0.iqmod_mfb_lpf_pex_ota_core_inv_NF20$1_0.vout 0.01573f
C24 a_25874_n3703# a_25874_n4003# 0.71767f
C25 iqmod_mfb_lpf_pex_half_0.iqmod_mfb_lpf_pex_ota_core_hybrid_bm_half_0.iqmod_mfb_lpf_pex_ota_core_tg$1_0.di_tg_ctrl_n iqmod_mfb_lpf_pex_half_1.iqmod_mfb_lpf_pex_R1_0.v_b 0.13043f
C26 iqmod_mfb_lpf_pex_half_1.C1_half a_722_4203# 0.12777f
C27 iqmod_mfb_lpf_pex_half_1.iqmod_mfb_lpf_pex_R1_0.v_b a_722_n4903# 0.1399f
C28 a_6706_4803# iqmod_mfb_lpf_pex_half_1.iqmod_mfb_lpf_pex_R2_0.v_a 0.06322f
C29 iqmod_mfb_lpf_pex_half_0.iqmod_mfb_lpf_pex_ota_core_hybrid_bm_half_0.iqmod_mfb_lpf_pex_ota_core_tg$1_0.di_tg_ctrl_n iqmod_mfb_lpf_pex_half_1.iqmod_mfb_lpf_pex_ota_core_hybrid_bm_half_0.iqmod_mfb_lpf_pex_ota_core_inv_NF20$1_0.vout 0.77311f
C30 a_6706_n4303# a_6706_n4603# 0.3708f
C31 a_13490_4503# VDD 0.03006f
C32 iqmod_mfb_lpf_pex_half_1.C1_half iqmod_mfb_lpf_pex_half_0.iqmod_mfb_lpf_pex_ota_core_hybrid_bm_half_0.iqmod_mfb_lpf_pex_ota_core_spdt_switch$1_0.iqmod_mfb_lpf_pex_ota_core_spdt_switch_inv$2_0.vout 0.03798f
C33 iqmod_mfb_lpf_pex_half_0.iqmod_mfb_lpf_pex_ota_core_hybrid_bm_half_0.iqmod_mfb_lpf_pex_ota_core_spdt_switch$1_0.iqmod_mfb_lpf_pex_ota_core_spdt_switch_inv$2_0.vout di_filter_en 0.0847f
C34 a_13490_n4603# VDD 0.03006f
C35 a_13490_n4603# a_13490_n4903# 0.70571f
C36 a_6706_4803# iqmod_mfb_lpf_pex_half_1.iqmod_mfb_lpf_pex_R1_0.v_b 0.01165f
C37 a_6706_n3703# iqmod_mfb_lpf_pex_half_1.iqmod_mfb_lpf_pex_R2_0.v_a 0.07442f
C38 iqmod_mfb_lpf_pex_half_1.iqmod_mfb_lpf_pex_ota_core_hybrid_bm_half_0.iqmod_mfb_lpf_pex_ota_core_tg$1_0.di_tg_ctrl_n voutp 2.50645f
C39 a_722_4803# iqmod_mfb_lpf_pex_half_1.C1_half 0.13325f
C40 iqmod_mfb_lpf_pex_half_1.iqmod_mfb_lpf_pex_ota_core_hybrid_bm_half_0.iqmod_mfb_lpf_pex_ota_core_tg$1_0.v_b iqmod_mfb_lpf_pex_half_1.iqmod_mfb_lpf_pex_ota_core_hybrid_bm_half_0.iqmod_mfb_lpf_pex_ota_core_inv_NF6$1_1.vout 11.0111f
C41 a_13490_4803# iqmod_mfb_lpf_pex_half_1.iqmod_mfb_lpf_pex_R2_0.v_a 0.0673f
C42 iqmod_mfb_lpf_pex_half_1.C2_half m3_16084_n5108# 0.03248f
C43 iqmod_mfb_lpf_pex_half_1.iqmod_mfb_lpf_pex_R2_0.v_a a_13490_n4003# 0.82887f
C44 a_6706_n4003# a_6706_n4303# 0.3708f
C45 a_6706_n3703# iqmod_mfb_lpf_pex_half_1.iqmod_mfb_lpf_pex_R1_0.v_b 0.09628f
C46 iqmod_mfb_lpf_pex_half_1.C2_half a_13490_3603# 0.35902f
C47 iqmod_mfb_lpf_pex_half_1.iqmod_mfb_lpf_pex_R2_0.v_a voutp 4.73469f
C48 iqmod_mfb_lpf_pex_half_0.iqmod_mfb_lpf_pex_ota_core_hybrid_bm_half_0.iqmod_mfb_lpf_pex_ota_core_tg$1_0.di_tg_ctrl_n iqmod_mfb_lpf_pex_half_1.iqmod_mfb_lpf_pex_ota_core_hybrid_bm_half_0.iqmod_mfb_lpf_pex_ota_core_inv_NF6$1_1.vout 1.43086f
C49 iqmod_mfb_lpf_pex_half_1.C1_half voutn 0.03953f
C50 voutn di_filter_en 2.37508f
C51 a_722_n4003# VDD 0.01323f
C52 iqmod_mfb_lpf_pex_half_1.iqmod_mfb_lpf_pex_R1_0.v_b voutp 0.03916f
C53 a_6706_4503# a_6706_4203# 0.3708f
C54 iqmod_mfb_lpf_pex_half_1.C2_half iqmod_mfb_lpf_pex_half_1.iqmod_mfb_lpf_pex_ota_core_hybrid_bm_half_0.iqmod_mfb_lpf_pex_ota_core_tg$1_0.di_tg_ctrl_n 0.09776f
C55 a_6706_3903# iqmod_mfb_lpf_pex_half_1.C2_half 0.16562f
C56 iqmod_mfb_lpf_pex_half_1.iqmod_mfb_lpf_pex_ota_core_hybrid_bm_half_0.iqmod_mfb_lpf_pex_ota_core_tg$1_0.v_b VDD 75.8581f
C57 iqmod_mfb_lpf_pex_half_1.iqmod_mfb_lpf_pex_ota_core_hybrid_bm_half_0.iqmod_mfb_lpf_pex_ota_core_inv_NF20$1_0.vout voutp 22.0658f
C58 a_6706_n4303# VDD 0.02451f
C59 iqmod_mfb_lpf_pex_half_1.C2_half iqmod_mfb_lpf_pex_half_1.iqmod_mfb_lpf_pex_R2_0.v_a 8.20896f
C60 a_722_n4603# a_722_n4903# 0.32295f
C61 a_25874_3603# iqmod_mfb_lpf_pex_half_1.iqmod_mfb_lpf_pex_ota_core_hybrid_bm_half_0.iqmod_mfb_lpf_pex_ota_core_inv_NF20$1_0.vout 0.01652f
C62 iqmod_mfb_lpf_pex_half_0.iqmod_mfb_lpf_pex_ota_core_hybrid_bm_half_0.iqmod_mfb_lpf_pex_ota_core_tg$1_0.di_tg_ctrl_n VDD 32.2565f
C63 iqmod_mfb_lpf_pex_half_1.C2_half iqmod_mfb_lpf_pex_half_1.iqmod_mfb_lpf_pex_R1_0.v_b 0.06519f
C64 a_25874_3903# a_25874_3603# 0.71767f
C65 a_6706_n3703# a_6706_n4003# 0.3708f
C66 a_13490_n4303# a_13490_n4603# 0.70571f
C67 a_13490_4503# voutn 0.03036f
C68 iqmod_mfb_lpf_pex_half_1.iqmod_mfb_lpf_pex_ota_core_hybrid_bm_half_0.iqmod_mfb_lpf_pex_ota_core_inv_NF6$1_1.vout voutp 1.83884f
C69 iqmod_mfb_lpf_pex_half_1.C1_half a_6706_n4903# 0.03425f
C70 iqmod_mfb_lpf_pex_half_1.C1_half iqmod_mfb_lpf_pex_half_1.iqmod_mfb_lpf_pex_ota_core_hybrid_bm_half_0.iqmod_mfb_lpf_pex_ota_core_spdt_switch$1_0.iqmod_mfb_lpf_pex_ota_core_spdt_switch_inv$2_0.vout 0.0237f
C71 iqmod_mfb_lpf_pex_half_1.iqmod_mfb_lpf_pex_ota_core_hybrid_bm_half_0.iqmod_mfb_lpf_pex_ota_core_spdt_switch$1_0.iqmod_mfb_lpf_pex_ota_core_spdt_switch_inv$2_0.vout di_filter_en 0.0847f
C72 a_722_n3703# iqmod_mfb_lpf_pex_half_1.iqmod_mfb_lpf_pex_R1_0.v_b 0.13998f
C73 iqmod_mfb_lpf_pex_half_1.C2_half a_25874_3903# 0.04232f
C74 a_722_3603# iqmod_mfb_lpf_pex_half_1.iqmod_mfb_lpf_pex_R1_0.v_b 0.03281f
C75 a_25874_3603# iqmod_mfb_lpf_pex_half_1.iqmod_mfb_lpf_pex_ota_core_hybrid_bm_half_0.iqmod_mfb_lpf_pex_ota_core_inv_NF6$1_1.vout 0.01424f
C76 iqmod_mfb_lpf_pex_half_1.C1_half di_filter_en 0.15881f
C77 iqmod_mfb_lpf_pex_half_1.iqmod_mfb_lpf_pex_R2_0.v_a m3_16084_n5108# 0.22787f
C78 a_6706_n3703# VDD 0.21216f
C79 a_13490_3603# iqmod_mfb_lpf_pex_half_1.iqmod_mfb_lpf_pex_R2_0.v_a 0.02113f
C80 a_13490_4203# iqmod_mfb_lpf_pex_half_1.C2_half 0.46468f
C81 iqmod_mfb_lpf_pex_half_0.iqmod_mfb_lpf_pex_ota_core_hybrid_bm_half_0.iqmod_mfb_lpf_pex_ota_core_tg$1_0.di_tg_ctrl_n iqmod_mfb_lpf_pex_half_0.iqmod_mfb_lpf_pex_ota_core_hybrid_bm_half_0.iqmod_mfb_lpf_pex_ota_core_spdt_switch$1_0.iqmod_mfb_lpf_pex_ota_core_spdt_switch_inv$2_0.vout 1.34626f
C82 VDD voutp 63.88231f
C83 iqmod_mfb_lpf_pex_half_1.iqmod_mfb_lpf_pex_ota_core_hybrid_bm_half_0.iqmod_mfb_lpf_pex_ota_core_tg$1_0.di_tg_ctrl_n iqmod_mfb_lpf_pex_half_1.iqmod_mfb_lpf_pex_R2_0.v_a 0.10091f
C84 a_6706_3903# iqmod_mfb_lpf_pex_half_1.iqmod_mfb_lpf_pex_R2_0.v_a 0.01928f
C85 a_13490_n4903# voutp 0.02318f
C86 a_722_3903# VDD 0.01323f
C87 iqmod_mfb_lpf_pex_half_1.iqmod_mfb_lpf_pex_ota_core_hybrid_bm_half_0.iqmod_mfb_lpf_pex_ota_core_tg$1_0.v_b voutn 24.245f
C88 a_25874_3603# VDD 0.40064f
C89 iqmod_mfb_lpf_pex_half_1.iqmod_mfb_lpf_pex_ota_core_hybrid_bm_half_0.iqmod_mfb_lpf_pex_ota_core_tg$1_0.di_tg_ctrl_n iqmod_mfb_lpf_pex_half_1.iqmod_mfb_lpf_pex_R1_0.v_b 0.13553f
C90 a_25874_n4303# VDD 0.08194f
C91 iqmod_mfb_lpf_pex_half_1.iqmod_mfb_lpf_pex_ota_core_hybrid_bm_half_0.iqmod_mfb_lpf_pex_ota_core_inv_NF20$1_0.vout iqmod_mfb_lpf_pex_half_1.iqmod_mfb_lpf_pex_ota_core_hybrid_bm_half_0.iqmod_mfb_lpf_pex_ota_core_tg$1_0.di_tg_ctrl_n 0.77311f
C92 iqmod_mfb_lpf_pex_half_0.iqmod_mfb_lpf_pex_ota_core_hybrid_bm_half_0.iqmod_mfb_lpf_pex_ota_core_tg$1_0.di_tg_ctrl_n voutn 2.50644f
C93 iqmod_mfb_lpf_pex_half_1.iqmod_mfb_lpf_pex_R2_0.v_a iqmod_mfb_lpf_pex_half_1.iqmod_mfb_lpf_pex_R1_0.v_b 0.54843f
C94 iqmod_mfb_lpf_pex_half_1.C2_half VDD 2.6398f
C95 iqmod_mfb_lpf_pex_half_1.iqmod_mfb_lpf_pex_ota_core_hybrid_bm_half_0.iqmod_mfb_lpf_pex_ota_core_tg$1_0.v_b a_13490_n3703# 0.04647f
C96 a_6706_4203# iqmod_mfb_lpf_pex_half_1.C2_half 0.04272f
C97 iqmod_mfb_lpf_pex_half_1.C2_half a_13490_n4903# 0.0673f
C98 iqmod_mfb_lpf_pex_half_1.C2_half a_6706_3603# 0.05899f
C99 a_722_4203# a_722_3903# 0.32295f
C100 a_722_4503# iqmod_mfb_lpf_pex_half_1.iqmod_mfb_lpf_pex_R1_0.v_b 0.03249f
C101 a_722_n3703# VDD 0.1667f
C102 a_722_n4303# iqmod_mfb_lpf_pex_half_1.iqmod_mfb_lpf_pex_R1_0.v_b 0.14136f
C103 a_722_3603# VDD 0.17025f
C104 a_6706_4803# voutn 0.02162f
C105 a_25874_4503# a_25874_4203# 0.71767f
C106 a_25874_n3703# voutp 0.063f
C107 iqmod_mfb_lpf_pex_half_1.iqmod_mfb_lpf_pex_ota_core_hybrid_bm_half_0.iqmod_mfb_lpf_pex_ota_core_inv_NF6$1_1.vout iqmod_mfb_lpf_pex_half_1.iqmod_mfb_lpf_pex_ota_core_hybrid_bm_half_0.iqmod_mfb_lpf_pex_ota_core_tg$1_0.di_tg_ctrl_n 1.43086f
C108 a_13490_4203# iqmod_mfb_lpf_pex_half_1.iqmod_mfb_lpf_pex_R2_0.v_a 0.02756f
C109 iqmod_mfb_lpf_pex_half_1.C1_half a_6706_4503# 0.13974f
C110 iqmod_mfb_lpf_pex_half_1.iqmod_mfb_lpf_pex_R1_0.v_b a_6706_n4603# 0.1281f
C111 a_25874_n4603# voutp 0.07087f
C112 a_13490_4803# voutn 0.02318f
C113 a_25874_4503# VDD 0.05607f
C114 iqmod_mfb_lpf_pex_half_1.C1_half iqmod_mfb_lpf_pex_half_1.iqmod_mfb_lpf_pex_ota_core_hybrid_bm_half_0.iqmod_mfb_lpf_pex_ota_core_tg$1_0.v_b 0.02501f
C115 iqmod_mfb_lpf_pex_half_1.iqmod_mfb_lpf_pex_ota_core_hybrid_bm_half_0.iqmod_mfb_lpf_pex_ota_core_tg$1_0.v_b di_filter_en 7.27796f
C116 a_13490_n4003# a_13490_n4303# 0.70571f
C117 a_13490_n4303# voutp 0.04019f
C118 a_13490_3603# VDD 0.38425f
C119 iqmod_mfb_lpf_pex_half_1.C1_half a_6706_n4303# 0.02356f
C120 a_6706_n4003# iqmod_mfb_lpf_pex_half_1.iqmod_mfb_lpf_pex_R2_0.v_a 0.20092f
C121 voutn voutp 0.05785f
C122 a_25874_n4303# a_25874_n4603# 0.71767f
C123 iqmod_mfb_lpf_pex_half_1.C1_half iqmod_mfb_lpf_pex_half_0.iqmod_mfb_lpf_pex_ota_core_hybrid_bm_half_0.iqmod_mfb_lpf_pex_ota_core_tg$1_0.di_tg_ctrl_n 0.11862f
C124 iqmod_mfb_lpf_pex_half_0.iqmod_mfb_lpf_pex_ota_core_hybrid_bm_half_0.iqmod_mfb_lpf_pex_ota_core_tg$1_0.di_tg_ctrl_n di_filter_en 1.12955f
C125 iqmod_mfb_lpf_pex_half_1.iqmod_mfb_lpf_pex_ota_core_hybrid_bm_half_0.iqmod_mfb_lpf_pex_ota_core_tg$1_0.di_tg_ctrl_n VDD 32.2565f
C126 a_25874_3603# voutn 0.063f
C127 a_6706_n4003# iqmod_mfb_lpf_pex_half_1.iqmod_mfb_lpf_pex_R1_0.v_b 0.03057f
C128 a_6706_3903# VDD 0.01411f
C129 a_6706_4203# a_6706_3903# 0.3708f
C130 iqmod_mfb_lpf_pex_half_1.iqmod_mfb_lpf_pex_ota_core_hybrid_bm_half_0.iqmod_mfb_lpf_pex_ota_core_inv_NF6$1_1.vout iqmod_mfb_lpf_pex_half_1.iqmod_mfb_lpf_pex_ota_core_hybrid_bm_half_0.iqmod_mfb_lpf_pex_ota_core_inv_NF20$1_0.vout 37.0719f
C131 iqmod_mfb_lpf_pex_half_1.C1_half a_722_n4903# 0.02288f
C132 a_722_3603# iqmod_mfb_lpf_pex_half_0.iqmod_mfb_lpf_pex_ota_core_hybrid_bm_half_0.iqmod_mfb_lpf_pex_ota_core_spdt_switch$1_0.iqmod_mfb_lpf_pex_ota_core_spdt_switch_inv$2_0.vout 0.01232f
C133 a_13490_n3703# a_13490_n4003# 0.70571f
C134 a_13490_n3703# voutp 0.12245f
C135 iqmod_mfb_lpf_pex_half_1.C2_half a_13490_3903# 0.82887f
C136 a_6706_3903# a_6706_3603# 0.3708f
C137 iqmod_mfb_lpf_pex_half_1.C2_half a_13490_n4303# 0.02756f
C138 iqmod_mfb_lpf_pex_half_1.iqmod_mfb_lpf_pex_R2_0.v_a VDD 2.64269f
C139 a_6706_4203# iqmod_mfb_lpf_pex_half_1.iqmod_mfb_lpf_pex_R2_0.v_a 0.04268f
C140 a_722_n4603# iqmod_mfb_lpf_pex_half_1.iqmod_mfb_lpf_pex_R1_0.v_b 0.19074f
C141 iqmod_mfb_lpf_pex_half_1.C2_half voutn 4.80131f
C142 iqmod_mfb_lpf_pex_half_1.iqmod_mfb_lpf_pex_R2_0.v_a a_13490_n4903# 0.25811f
C143 a_6706_3603# iqmod_mfb_lpf_pex_half_1.iqmod_mfb_lpf_pex_R2_0.v_a 0.02784f
C144 a_6706_4803# iqmod_mfb_lpf_pex_half_1.C1_half 0.11143f
C145 a_722_n4303# a_722_n4603# 0.32295f
C146 a_25874_n4003# voutp 0.0164f
C147 iqmod_mfb_lpf_pex_half_1.iqmod_mfb_lpf_pex_R1_0.v_b VDD 3.19397f
C148 a_25874_4203# a_25874_3903# 0.71767f
C149 a_722_4503# VDD 0.01337f
C150 a_6706_3603# iqmod_mfb_lpf_pex_half_1.iqmod_mfb_lpf_pex_R1_0.v_b 0.01023f
C151 a_722_n4303# VDD 0.01914f
C152 iqmod_mfb_lpf_pex_half_1.C1_half a_6706_n3703# 0.03215f
C153 iqmod_mfb_lpf_pex_half_1.iqmod_mfb_lpf_pex_ota_core_hybrid_bm_half_0.iqmod_mfb_lpf_pex_ota_core_inv_NF20$1_0.vout VDD 51.8859f
C154 iqmod_mfb_lpf_pex_half_1.C2_half a_13490_n3703# 0.02113f
C155 a_25874_n4003# a_25874_n4303# 0.71767f
C156 a_6706_n4903# voutp 0.01957f
C157 a_25874_3903# VDD 0.12803f
C158 iqmod_mfb_lpf_pex_half_1.C1_half voutp 0.41142f
C159 di_filter_en voutp 2.37508f
C160 a_13490_3903# a_13490_3603# 0.70571f
C161 iqmod_mfb_lpf_pex_half_1.C1_half a_722_3903# 0.07002f
C162 a_25874_4503# voutn 0.07087f
C163 a_13490_3603# voutn 0.12245f
C164 a_13490_4203# VDD 0.04299f
C165 a_722_4203# iqmod_mfb_lpf_pex_half_1.iqmod_mfb_lpf_pex_R1_0.v_b 0.02351f
C166 iqmod_mfb_lpf_pex_half_1.C2_half a_6706_n4903# 0.04852f
C167 a_722_4503# a_722_4203# 0.32295f
C168 iqmod_mfb_lpf_pex_half_1.iqmod_mfb_lpf_pex_ota_core_hybrid_bm_half_0.iqmod_mfb_lpf_pex_ota_core_inv_NF6$1_1.vout VDD 26.3329f
C169 iqmod_mfb_lpf_pex_half_0.iqmod_mfb_lpf_pex_ota_core_hybrid_bm_half_0.iqmod_mfb_lpf_pex_ota_core_spdt_switch$1_0.iqmod_mfb_lpf_pex_ota_core_spdt_switch_inv$2_0.vout iqmod_mfb_lpf_pex_half_1.iqmod_mfb_lpf_pex_R1_0.v_b 0.03067f
C170 a_25874_4803# a_25874_4503# 0.71767f
C171 iqmod_mfb_lpf_pex_half_1.C1_half iqmod_mfb_lpf_pex_half_1.C2_half 0.01071f
C172 iqmod_mfb_lpf_pex_half_1.C2_half di_filter_en 0.15146f
C173 a_25874_4203# VDD 0.08194f
C174 a_13490_4803# a_13490_4503# 0.70571f
C175 a_722_4803# iqmod_mfb_lpf_pex_half_1.iqmod_mfb_lpf_pex_R1_0.v_b 0.0329f
C176 iqmod_mfb_lpf_pex_half_1.iqmod_mfb_lpf_pex_R2_0.v_a a_13490_n4303# 0.46468f
C177 iqmod_mfb_lpf_pex_half_1.iqmod_mfb_lpf_pex_ota_core_hybrid_bm_half_0.iqmod_mfb_lpf_pex_ota_core_spdt_switch$1_0.iqmod_mfb_lpf_pex_ota_core_spdt_switch_inv$2_0.vout a_722_n3703# 0.01232f
C178 a_722_n4603# VDD 0.01337f
C179 a_722_4803# a_722_4503# 0.32295f
C180 iqmod_mfb_lpf_pex_half_0.iqmod_mfb_lpf_pex_ota_core_hybrid_bm_half_0.iqmod_mfb_lpf_pex_ota_core_tg$1_0.di_tg_ctrl_n iqmod_mfb_lpf_pex_half_1.iqmod_mfb_lpf_pex_ota_core_hybrid_bm_half_0.iqmod_mfb_lpf_pex_ota_core_tg$1_0.v_b 1.96204f
C181 iqmod_mfb_lpf_pex_half_1.iqmod_mfb_lpf_pex_R2_0.v_a voutn 0.91842f
C182 iqmod_mfb_lpf_pex_half_1.iqmod_mfb_lpf_pex_ota_core_hybrid_bm_half_0.iqmod_mfb_lpf_pex_ota_core_inv_NF20$1_0.vout a_25874_n3703# 0.01652f
C183 iqmod_mfb_lpf_pex_half_1.C1_half a_722_n3703# 0.01294f
C184 iqmod_mfb_lpf_pex_half_1.C1_half a_722_3603# 0.12216f
C185 a_13490_n4603# voutp 0.03036f
C186 a_6706_4203# VDD 0.02615f
C187 iqmod_mfb_lpf_pex_half_1.iqmod_mfb_lpf_pex_R1_0.v_b voutn 0.41142f
C188 a_6706_4803# a_6706_4503# 0.3708f
C189 a_6706_3603# VDD 0.21216f
C190 a_25874_n4603# a_25874_n4903# 0.71767f
C191 a_13490_n3703# iqmod_mfb_lpf_pex_half_1.iqmod_mfb_lpf_pex_R2_0.v_a 0.35902f
C192 iqmod_mfb_lpf_pex_half_1.iqmod_mfb_lpf_pex_ota_core_hybrid_bm_half_0.iqmod_mfb_lpf_pex_ota_core_inv_NF20$1_0.vout voutn 22.0658f
C193 a_25874_3903# voutn 0.0164f
C194 iqmod_mfb_lpf_pex_half_1.iqmod_mfb_lpf_pex_R2_0.v_a a_25874_n4003# 0.04232f
C195 a_13490_4503# iqmod_mfb_lpf_pex_half_1.C2_half 0.3204f
C196 iqmod_mfb_lpf_pex_half_1.iqmod_mfb_lpf_pex_ota_core_hybrid_bm_half_0.iqmod_mfb_lpf_pex_ota_core_inv_NF6$1_1.vout a_25874_n3703# 0.01424f
C197 iqmod_mfb_lpf_pex_half_1.iqmod_mfb_lpf_pex_ota_core_hybrid_bm_half_0.iqmod_mfb_lpf_pex_ota_core_tg$1_0.di_tg_ctrl_n iqmod_mfb_lpf_pex_half_1.iqmod_mfb_lpf_pex_ota_core_hybrid_bm_half_0.iqmod_mfb_lpf_pex_ota_core_spdt_switch$1_0.iqmod_mfb_lpf_pex_ota_core_spdt_switch_inv$2_0.vout 1.34626f
C198 iqmod_mfb_lpf_pex_half_1.C2_half a_13490_n4603# 0.04612f
C199 a_13490_4203# a_13490_3903# 0.70571f
C200 iqmod_mfb_lpf_pex_half_1.C1_half iqmod_mfb_lpf_pex_half_1.iqmod_mfb_lpf_pex_ota_core_hybrid_bm_half_0.iqmod_mfb_lpf_pex_ota_core_tg$1_0.di_tg_ctrl_n 0.11362f
C201 a_722_4203# VDD 0.01914f
C202 iqmod_mfb_lpf_pex_half_1.iqmod_mfb_lpf_pex_ota_core_hybrid_bm_half_0.iqmod_mfb_lpf_pex_ota_core_tg$1_0.v_b voutp 24.245f
C203 iqmod_mfb_lpf_pex_half_1.iqmod_mfb_lpf_pex_ota_core_hybrid_bm_half_0.iqmod_mfb_lpf_pex_ota_core_tg$1_0.di_tg_ctrl_n di_filter_en 1.12955f
C204 iqmod_mfb_lpf_pex_half_1.C1_half a_6706_3903# 0.03319f
C205 a_13490_4203# voutn 0.04019f
C206 a_6706_n4303# voutp 0.02251f
C207 iqmod_mfb_lpf_pex_half_1.iqmod_mfb_lpf_pex_ota_core_hybrid_bm_half_0.iqmod_mfb_lpf_pex_ota_core_inv_NF6$1_1.vout voutn 1.83884f
C208 iqmod_mfb_lpf_pex_half_0.iqmod_mfb_lpf_pex_ota_core_hybrid_bm_half_0.iqmod_mfb_lpf_pex_ota_core_spdt_switch$1_0.iqmod_mfb_lpf_pex_ota_core_spdt_switch_inv$2_0.vout VDD 7.58236f
C209 iqmod_mfb_lpf_pex_half_1.C1_half iqmod_mfb_lpf_pex_half_1.iqmod_mfb_lpf_pex_R2_0.v_a 1.12599f
C210 iqmod_mfb_lpf_pex_half_1.iqmod_mfb_lpf_pex_R2_0.v_a di_filter_en 0.15668f
C211 iqmod_mfb_lpf_pex_half_1.iqmod_mfb_lpf_pex_R1_0.v_b a_6706_n4903# 0.10934f
C212 iqmod_mfb_lpf_pex_half_1.iqmod_mfb_lpf_pex_ota_core_hybrid_bm_half_0.iqmod_mfb_lpf_pex_ota_core_spdt_switch$1_0.iqmod_mfb_lpf_pex_ota_core_spdt_switch_inv$2_0.vout iqmod_mfb_lpf_pex_half_1.iqmod_mfb_lpf_pex_R1_0.v_b 0.04495f
C213 a_25874_n3703# VDD 0.40064f
C214 a_25874_4203# voutn 0.01719f
C215 iqmod_mfb_lpf_pex_half_1.C1_half iqmod_mfb_lpf_pex_half_1.iqmod_mfb_lpf_pex_R1_0.v_b 13.2125f
C216 iqmod_mfb_lpf_pex_half_1.iqmod_mfb_lpf_pex_R1_0.v_b di_filter_en 0.18801f
C217 a_25874_n4603# VDD 0.05607f
C218 a_722_4503# iqmod_mfb_lpf_pex_half_1.C1_half 0.17855f
C219 iqmod_mfb_lpf_pex_half_1.C2_half iqmod_mfb_lpf_pex_half_1.iqmod_mfb_lpf_pex_ota_core_hybrid_bm_half_0.iqmod_mfb_lpf_pex_ota_core_tg$1_0.v_b 1.29189f
C220 iqmod_mfb_lpf_pex_half_1.iqmod_mfb_lpf_pex_ota_core_hybrid_bm_half_0.iqmod_mfb_lpf_pex_ota_core_inv_NF20$1_0.vout di_filter_en 0.95997f
C221 a_13490_n4303# VDD 0.04299f
C222 iqmod_mfb_lpf_pex_half_1.C2_half a_6706_n4303# 0.03659f
C223 a_6706_n4603# a_6706_n4903# 0.3708f
C224 VDD voutn 63.8822f
C225 a_6706_4203# voutn 0.02469f
C226 a_722_n3703# a_722_n4003# 0.32295f
C227 a_6706_3603# voutn 0.02468f
C228 iqmod_mfb_lpf_pex_half_1.C2_half iqmod_mfb_lpf_pex_half_0.iqmod_mfb_lpf_pex_ota_core_hybrid_bm_half_0.iqmod_mfb_lpf_pex_ota_core_tg$1_0.di_tg_ctrl_n 0.09751f
C229 iqmod_mfb_lpf_pex_half_1.C1_half a_6706_n4603# 0.0315f
C230 a_6706_n3703# voutp 0.02469f
C231 a_13490_n3703# VDD 0.38425f
C232 a_13490_4503# iqmod_mfb_lpf_pex_half_1.iqmod_mfb_lpf_pex_R2_0.v_a 0.04612f
C233 iqmod_mfb_lpf_pex_half_1.iqmod_mfb_lpf_pex_R2_0.v_a a_13490_n4603# 0.3204f
C234 iqmod_mfb_lpf_pex_half_1.iqmod_mfb_lpf_pex_ota_core_hybrid_bm_half_0.iqmod_mfb_lpf_pex_ota_core_inv_NF6$1_1.vout di_filter_en 2.54867f
C235 voutp VSS 29.52372f
C236 di_filter_en VSS 43.20427f
C237 voutn VSS 29.54302f
C238 VDD VSS 38.66426f
C239 m3_16084_n5108# VSS 0.16484f $ **FLOATING
C240 a_25874_n4903# VSS 7.87022f $ **FLOATING
C241 a_13490_n4903# VSS 7.73096f $ **FLOATING
C242 a_25874_n4603# VSS 6.2999f $ **FLOATING
C243 a_6706_n4903# VSS 4.08028f $ **FLOATING
C244 a_13490_n4603# VSS 6.1949f $ **FLOATING
C245 a_722_n4903# VSS 3.56763f $ **FLOATING
C246 a_25874_n4303# VSS 6.27738f $ **FLOATING
C247 a_6706_n4603# VSS 3.25499f $ **FLOATING
C248 a_13490_n4303# VSS 6.16404f $ **FLOATING
C249 iqmod_mfb_lpf_pex_half_1.iqmod_mfb_lpf_pex_R1_0.v_b VSS 14.43876f
C250 a_722_n4603# VSS 2.84388f $ **FLOATING
C251 a_25874_n4003# VSS 6.30877f $ **FLOATING
C252 a_6706_n4303# VSS 3.23892f $ **FLOATING
C253 a_13490_n4003# VSS 6.1949f $ **FLOATING
C254 a_722_n4303# VSS 2.82992f $ **FLOATING
C255 a_25874_n3703# VSS 7.40475f $ **FLOATING
C256 iqmod_mfb_lpf_pex_half_1.iqmod_mfb_lpf_pex_R2_0.v_a VSS 18.63867f
C257 a_6706_n4003# VSS 3.25499f $ **FLOATING
C258 a_13490_n3703# VSS 7.26941f $ **FLOATING
C259 a_722_n4003# VSS 2.83501f $ **FLOATING
C260 a_6706_n3703# VSS 3.84371f $ **FLOATING
C261 a_722_n3703# VSS 3.39002f $ **FLOATING
C262 iqmod_mfb_lpf_pex_half_1.iqmod_mfb_lpf_pex_ota_core_hybrid_bm_half_0.iqmod_mfb_lpf_pex_ota_core_spdt_switch$1_0.iqmod_mfb_lpf_pex_ota_core_spdt_switch_inv$2_0.vout VSS 5.85785f
C263 iqmod_mfb_lpf_pex_half_1.iqmod_mfb_lpf_pex_ota_core_hybrid_bm_half_0.iqmod_mfb_lpf_pex_ota_core_tg$1_0.di_tg_ctrl_n VSS 9.94337f
C264 iqmod_mfb_lpf_pex_half_1.iqmod_mfb_lpf_pex_ota_core_hybrid_bm_half_0.iqmod_mfb_lpf_pex_ota_core_inv_NF20$1_0.vout VSS 21.76029f
C265 iqmod_mfb_lpf_pex_half_1.iqmod_mfb_lpf_pex_ota_core_hybrid_bm_half_0.iqmod_mfb_lpf_pex_ota_core_inv_NF6$1_1.vout VSS 16.65929f
C266 iqmod_mfb_lpf_pex_half_1.iqmod_mfb_lpf_pex_ota_core_hybrid_bm_half_0.iqmod_mfb_lpf_pex_ota_core_tg$1_0.v_b VSS 47.88036f
C267 iqmod_mfb_lpf_pex_half_0.iqmod_mfb_lpf_pex_ota_core_hybrid_bm_half_0.iqmod_mfb_lpf_pex_ota_core_spdt_switch$1_0.iqmod_mfb_lpf_pex_ota_core_spdt_switch_inv$2_0.vout VSS 5.85785f
C268 iqmod_mfb_lpf_pex_half_0.iqmod_mfb_lpf_pex_ota_core_hybrid_bm_half_0.iqmod_mfb_lpf_pex_ota_core_tg$1_0.di_tg_ctrl_n VSS 9.94335f
C269 a_25874_3603# VSS 7.40475f $ **FLOATING
C270 a_13490_3603# VSS 7.26941f $ **FLOATING
C271 a_25874_3903# VSS 6.30877f $ **FLOATING
C272 a_6706_3603# VSS 3.84371f $ **FLOATING
C273 a_13490_3903# VSS 6.1949f $ **FLOATING
C274 a_722_3603# VSS 3.39635f $ **FLOATING
C275 a_25874_4203# VSS 6.27738f $ **FLOATING
C276 iqmod_mfb_lpf_pex_half_1.C2_half VSS 16.32865f
C277 a_6706_3903# VSS 3.25499f $ **FLOATING
C278 a_13490_4203# VSS 6.16404f $ **FLOATING
C279 a_722_3903# VSS 2.83501f $ **FLOATING
C280 a_25874_4503# VSS 6.2999f $ **FLOATING
C281 a_6706_4203# VSS 3.23892f $ **FLOATING
C282 a_13490_4503# VSS 6.1949f $ **FLOATING
C283 a_722_4203# VSS 2.82992f $ **FLOATING
C284 a_25874_4803# VSS 7.87022f $ **FLOATING
C285 a_6706_4503# VSS 3.25499f $ **FLOATING
C286 a_13490_4803# VSS 7.73096f $ **FLOATING
C287 iqmod_mfb_lpf_pex_half_1.C1_half VSS 13.97848f
C288 a_722_4503# VSS 2.84388f $ **FLOATING
C289 a_6706_4803# VSS 4.08028f $ **FLOATING
C290 a_722_4803# VSS 3.56763f $ **FLOATING
C291 a_636_4203.t0 VSS 0.03908f
C292 a_636_4203.t1 VSS 0.03908f
C293 iqmod_mfb_lpf_pex_half_1.C1_half.n0 VSS 0.01155f
C294 iqmod_mfb_lpf_pex_half_1.C1_half.n1 VSS 0.9287f
C295 iqmod_mfb_lpf_pex_half_1.C1_half.t9 VSS 2.18905f
C296 iqmod_mfb_lpf_pex_half_1.C1_half.t10 VSS 2.5767f
C297 iqmod_mfb_lpf_pex_half_1.C1_half.t11 VSS 2.59564f
C298 iqmod_mfb_lpf_pex_half_1.C1_half.t8 VSS 2.65099f
C299 iqmod_mfb_lpf_pex_half_1.C1_half.t7 VSS 2.59564f
C300 iqmod_mfb_lpf_pex_half_1.C1_half.n2 VSS 0.59172f
C301 iqmod_mfb_lpf_pex_half_1.C1_half.n3 VSS 0.84069f
C302 iqmod_mfb_lpf_pex_half_1.C1_half.t0 VSS 1.79565f
C303 iqmod_mfb_lpf_pex_half_1.C1_half.t1 VSS 1.81662f
C304 iqmod_mfb_lpf_pex_half_1.C1_half.t4 VSS 1.79565f
C305 iqmod_mfb_lpf_pex_half_1.C1_half.t3 VSS 1.67233f
C306 iqmod_mfb_lpf_pex_half_1.C1_half.t2 VSS 1.14317f
C307 iqmod_mfb_lpf_pex_half_1.C1_half.n4 VSS 1.03066f
C308 a_12906_4203.t0 VSS 0.06703f
C309 a_12906_4203.t1 VSS 0.06703f
C310 a_6122_3903.t0 VSS 0.06686f
C311 a_6122_3903.t1 VSS 0.06686f
C312 iqmod_mfb_lpf_pex_half_0.vinp.t7 VSS 0.06763f
C313 iqmod_mfb_lpf_pex_half_0.vinp.t3 VSS 0.51073f
C314 iqmod_mfb_lpf_pex_half_0.vinp.n0 VSS 0.3663f
C315 iqmod_mfb_lpf_pex_half_0.vinp.t8 VSS 0.04035f
C316 iqmod_mfb_lpf_pex_half_0.iqmod_mfb_lpf_pex_R3_0.v_b VSS 0.48996f
C317 iqmod_mfb_lpf_pex_half_0.vinp.n1 VSS 6.67279f
C318 iqmod_mfb_lpf_pex_half_0.vinp.t9 VSS 14.0258f
C319 iqmod_mfb_lpf_pex_half_0.iqmod_mfb_lpf_pex_ota_core_hybrid_bm_half_0.iqmod_mfb_lpf_pex_ota_core_spdt_switch$1_0.v_a VSS 2.7285f
C320 iqmod_mfb_lpf_pex_half_0.iqmod_mfb_lpf_pex_ota_core_hybrid_bm_half_0.vinp VSS 1.30522f
C321 iqmod_mfb_lpf_pex_half_0.vinp.t6 VSS 0.07356f
C322 iqmod_mfb_lpf_pex_half_0.vinp.t2 VSS 0.5463f
C323 iqmod_mfb_lpf_pex_half_0.vinp.n2 VSS 0.42636f
C324 iqmod_mfb_lpf_pex_half_0.vinp.t5 VSS 0.07356f
C325 iqmod_mfb_lpf_pex_half_0.vinp.t1 VSS 0.5463f
C326 iqmod_mfb_lpf_pex_half_0.vinp.n3 VSS 0.42636f
C327 iqmod_mfb_lpf_pex_half_0.vinp.t4 VSS 0.06763f
C328 iqmod_mfb_lpf_pex_half_0.vinp.t0 VSS 0.51073f
C329 iqmod_mfb_lpf_pex_half_0.vinp.n4 VSS 0.35852f
C330 iqmod_mfb_lpf_pex_half_0.iqmod_mfb_lpf_pex_ota_core_hybrid_bm_half_0.iqmod_mfb_lpf_pex_ota_core_spdt_switch$1_0.iqmod_mfb_lpf_pex_ota_core_spdt_switch_tg$2_1.v_a VSS 0.26112f
C331 a_25290_4203.t0 VSS 0.03193f
C332 a_25290_4203.t1 VSS 0.03193f
C333 a_6620_3903.t0 VSS 0.0666f
C334 a_6620_3903.t1 VSS 0.0666f
C335 a_25788_4203.t0 VSS 0.03193f
C336 a_25788_4203.t1 VSS 0.03193f
C337 a_13404_3903.t0 VSS 0.06652f
C338 a_13404_3903.t1 VSS 0.06652f
C339 iqmod_mfb_lpf_pex_half_1.C2_half.n0 VSS 0.19027f
C340 iqmod_mfb_lpf_pex_half_1.C2_half.t7 VSS 3.39907f
C341 iqmod_mfb_lpf_pex_half_1.C2_half.t8 VSS 3.91505f
C342 iqmod_mfb_lpf_pex_half_1.C2_half.t6 VSS 4.03041f
C343 iqmod_mfb_lpf_pex_half_1.C2_half.n1 VSS 0.91879f
C344 iqmod_mfb_lpf_pex_half_1.C2_half.n2 VSS 1.55942f
C345 iqmod_mfb_lpf_pex_half_1.C2_half.n3 VSS 1.15067f
C346 iqmod_mfb_lpf_pex_half_1.C2_half.t0 VSS 2.78822f
C347 iqmod_mfb_lpf_pex_half_1.C2_half.t2 VSS 2.56457f
C348 iqmod_mfb_lpf_pex_half_1.C2_half.t1 VSS 1.77432f
C349 iqmod_mfb_lpf_pex_half_1.C2_half.n4 VSS 1.61216f
C350 iqmod_mfb_lpf_pex_half_1.C2_half.n5 VSS 0.03611f
C351 a_37874_3903.t0 VSS 0.03601f
C352 a_37874_3903.t1 VSS 0.03601f
C353 iqmod_mfb_lpf_pex_half_0.iqmod_mfb_lpf_pex_ota_core_hybrid_bm_half_0.iqmod_mfb_lpf_pex_ota_core_tg$1_0.di_tg_ctrl_n.t0 VSS 0.35561f
C354 iqmod_mfb_lpf_pex_half_0.iqmod_mfb_lpf_pex_ota_core_hybrid_bm_half_0.iqmod_mfb_lpf_pex_ota_core_tg$1_0.di_tg_ctrl_n.t3 VSS 0.30765f
C355 iqmod_mfb_lpf_pex_half_0.iqmod_mfb_lpf_pex_ota_core_hybrid_bm_half_0.iqmod_mfb_lpf_pex_ota_core_tg$1_0.di_tg_ctrl_n.t8 VSS 1.09265f
C356 iqmod_mfb_lpf_pex_half_0.iqmod_mfb_lpf_pex_ota_core_hybrid_bm_half_0.iqmod_mfb_lpf_pex_ota_core_tg$1_0.di_tg_ctrl_n.n0 VSS 0.36577f
C357 iqmod_mfb_lpf_pex_half_0.iqmod_mfb_lpf_pex_ota_core_hybrid_bm_half_0.iqmod_mfb_lpf_pex_ota_core_tg$1_0.di_tg_ctrl_n.n1 VSS 2.92856f
C358 iqmod_mfb_lpf_pex_half_0.iqmod_mfb_lpf_pex_ota_core_hybrid_bm_half_0.iqmod_mfb_lpf_pex_ota_core_tg$1_0.di_tg_ctrl_n.n2 VSS 0.43542f
C359 iqmod_mfb_lpf_pex_half_0.iqmod_mfb_lpf_pex_ota_core_hybrid_bm_half_0.iqmod_mfb_lpf_pex_ota_core_tg$1_0.di_tg_ctrl_n.t5 VSS 3.47212f
C360 iqmod_mfb_lpf_pex_half_0.iqmod_mfb_lpf_pex_ota_core_hybrid_bm_half_0.iqmod_mfb_lpf_pex_ota_core_tg$1_0.di_tg_ctrl_n.n3 VSS 9.82414f
C361 iqmod_mfb_lpf_pex_half_0.iqmod_mfb_lpf_pex_ota_core_hybrid_bm_half_0.iqmod_mfb_lpf_pex_ota_core_tg$1_0.di_tg_ctrl_n.n4 VSS 7.0751f
C362 iqmod_mfb_lpf_pex_half_0.iqmod_mfb_lpf_pex_ota_core_hybrid_bm_half_0.iqmod_mfb_lpf_pex_ota_core_tg$1_0.di_tg_ctrl_n.t4 VSS 3.47212f
C363 iqmod_mfb_lpf_pex_half_0.iqmod_mfb_lpf_pex_ota_core_hybrid_bm_half_0.iqmod_mfb_lpf_pex_ota_core_tg$1_0.di_tg_ctrl_n.n5 VSS 1.09311f
C364 iqmod_mfb_lpf_pex_half_0.iqmod_mfb_lpf_pex_ota_core_hybrid_bm_half_0.iqmod_mfb_lpf_pex_ota_core_tg$1_0.di_tg_ctrl_n.n6 VSS 0.1407f
C365 iqmod_mfb_lpf_pex_half_0.iqmod_mfb_lpf_pex_ota_core_hybrid_bm_half_0.iqmod_mfb_lpf_pex_ota_core_tg$1_0.di_tg_ctrl_n.t7 VSS 2.79522f
C366 iqmod_mfb_lpf_pex_half_0.iqmod_mfb_lpf_pex_ota_core_hybrid_bm_half_0.iqmod_mfb_lpf_pex_ota_core_tg$1_0.di_tg_ctrl_n.t6 VSS 0.53622f
C367 iqmod_mfb_lpf_pex_half_0.iqmod_mfb_lpf_pex_ota_core_hybrid_bm_half_0.iqmod_mfb_lpf_pex_ota_core_tg$1_0.di_tg_ctrl_n.n7 VSS 1.89832f
C368 iqmod_mfb_lpf_pex_half_0.iqmod_mfb_lpf_pex_ota_core_hybrid_bm_half_0.iqmod_mfb_lpf_pex_ota_core_tg$1_0.di_tg_ctrl_n.t2 VSS 1.11712f
C369 iqmod_mfb_lpf_pex_half_0.iqmod_mfb_lpf_pex_ota_core_hybrid_bm_half_0.iqmod_mfb_lpf_pex_ota_core_tg$1_0.di_tg_ctrl_n.n8 VSS 1.81606f
C370 iqmod_mfb_lpf_pex_half_0.iqmod_mfb_lpf_pex_ota_core_hybrid_bm_half_0.iqmod_mfb_lpf_pex_ota_core_tg$1_0.di_tg_ctrl_n.t1 VSS 2.55096f
C371 iqmod_mfb_lpf_pex_half_0.iqmod_mfb_lpf_pex_ota_core_hybrid_bm_half_0.iqmod_mfb_lpf_pex_ota_core_spdt_switch$1_0.iqmod_mfb_lpf_pex_ota_core_spdt_switch_inv$2_0.vout.t1 VSS 0.26351f
C372 iqmod_mfb_lpf_pex_half_0.iqmod_mfb_lpf_pex_ota_core_hybrid_bm_half_0.iqmod_mfb_lpf_pex_ota_core_spdt_switch$1_0.iqmod_mfb_lpf_pex_ota_core_spdt_switch_inv$2_0.vout.n0 VSS 1.34422f
C373 iqmod_mfb_lpf_pex_half_0.iqmod_mfb_lpf_pex_ota_core_hybrid_bm_half_0.iqmod_mfb_lpf_pex_ota_core_spdt_switch$1_0.iqmod_mfb_lpf_pex_ota_core_spdt_switch_inv$2_0.vout.n1 VSS 0.10426f
C374 iqmod_mfb_lpf_pex_half_0.iqmod_mfb_lpf_pex_ota_core_hybrid_bm_half_0.iqmod_mfb_lpf_pex_ota_core_spdt_switch$1_0.iqmod_mfb_lpf_pex_ota_core_spdt_switch_inv$2_0.vout.t4 VSS 2.07127f
C375 iqmod_mfb_lpf_pex_half_0.iqmod_mfb_lpf_pex_ota_core_hybrid_bm_half_0.iqmod_mfb_lpf_pex_ota_core_spdt_switch$1_0.iqmod_mfb_lpf_pex_ota_core_spdt_switch_inv$2_0.vout.t3 VSS 0.39734f
C376 iqmod_mfb_lpf_pex_half_0.iqmod_mfb_lpf_pex_ota_core_hybrid_bm_half_0.iqmod_mfb_lpf_pex_ota_core_spdt_switch$1_0.iqmod_mfb_lpf_pex_ota_core_spdt_switch_inv$2_0.vout.n2 VSS 0.56282f
C377 iqmod_mfb_lpf_pex_half_0.iqmod_mfb_lpf_pex_ota_core_hybrid_bm_half_0.iqmod_mfb_lpf_pex_ota_core_spdt_switch$1_0.iqmod_mfb_lpf_pex_ota_core_spdt_switch_inv$2_0.vout.t2 VSS 0.82779f
C378 iqmod_mfb_lpf_pex_half_0.iqmod_mfb_lpf_pex_ota_core_hybrid_bm_half_0.iqmod_mfb_lpf_pex_ota_core_spdt_switch$1_0.iqmod_mfb_lpf_pex_ota_core_spdt_switch_inv$2_0.vout.n3 VSS 1.57913f
C379 iqmod_mfb_lpf_pex_half_0.iqmod_mfb_lpf_pex_ota_core_hybrid_bm_half_0.iqmod_mfb_lpf_pex_ota_core_spdt_switch$1_0.iqmod_mfb_lpf_pex_ota_core_spdt_switch_inv$2_0.vout.t0 VSS 1.89027f
C380 iqmod_mfb_lpf_pex_half_0.iqmod_mfb_lpf_pex_ota_core_hybrid_bm_half_0.iqmod_mfb_lpf_pex_ota_core_inv_NF20$1_1.vin.t0 VSS 54.0671f
C381 iqmod_mfb_lpf_pex_half_0.iqmod_mfb_lpf_pex_ota_core_hybrid_bm_half_0.iqmod_mfb_lpf_pex_ota_core_inv_NF20$1_1.vin.t1 VSS 55.9658f
C382 iqmod_mfb_lpf_pex_half_1.iqmod_mfb_lpf_pex_ota_core_hybrid_bm_half_0.iqmod_mfb_lpf_pex_ota_core_tg$1_0.v_a.t0 VSS 52.9283f
C383 iqmod_mfb_lpf_pex_half_1.iqmod_mfb_lpf_pex_ota_core_hybrid_bm_half_0.iqmod_mfb_lpf_pex_ota_core_tg$1_0.v_a.t1 VSS 48.6978f
C384 iqmod_mfb_lpf_pex_half_1.iqmod_mfb_lpf_pex_ota_core_hybrid_bm_half_0.iqmod_mfb_lpf_pex_ota_core_tg$1_0.v_b.t8 VSS 0.1721f
C385 iqmod_mfb_lpf_pex_half_1.iqmod_mfb_lpf_pex_ota_core_hybrid_bm_half_0.iqmod_mfb_lpf_pex_ota_core_tg$1_0.v_b.t14 VSS 1.22202f
C386 iqmod_mfb_lpf_pex_half_1.iqmod_mfb_lpf_pex_ota_core_hybrid_bm_half_0.iqmod_mfb_lpf_pex_ota_core_tg$1_0.v_b.n0 VSS 3.03522f
C387 iqmod_mfb_lpf_pex_half_1.iqmod_mfb_lpf_pex_ota_core_hybrid_bm_half_0.iqmod_mfb_lpf_pex_ota_core_tg$1_0.v_b.n1 VSS 0.77715f
C388 iqmod_mfb_lpf_pex_half_1.iqmod_mfb_lpf_pex_ota_core_hybrid_bm_half_0.iqmod_mfb_lpf_pex_ota_core_tg$1_0.v_b.n2 VSS 0.29884f
C389 iqmod_mfb_lpf_pex_half_1.iqmod_mfb_lpf_pex_ota_core_hybrid_bm_half_0.iqmod_mfb_lpf_pex_ota_core_tg$1_0.v_b.n3 VSS 0.29884f
C390 iqmod_mfb_lpf_pex_half_1.iqmod_mfb_lpf_pex_ota_core_hybrid_bm_half_0.iqmod_mfb_lpf_pex_ota_core_tg$1_0.v_b.n4 VSS 0.29884f
C391 iqmod_mfb_lpf_pex_half_1.iqmod_mfb_lpf_pex_ota_core_hybrid_bm_half_0.iqmod_mfb_lpf_pex_ota_core_tg$1_0.v_b.n5 VSS 0.29884f
C392 iqmod_mfb_lpf_pex_half_1.iqmod_mfb_lpf_pex_ota_core_hybrid_bm_half_0.iqmod_mfb_lpf_pex_ota_core_tg$1_0.v_b.n6 VSS 0.29884f
C393 iqmod_mfb_lpf_pex_half_1.iqmod_mfb_lpf_pex_ota_core_hybrid_bm_half_0.iqmod_mfb_lpf_pex_ota_core_tg$1_0.v_b.n7 VSS 0.29884f
C394 iqmod_mfb_lpf_pex_half_1.iqmod_mfb_lpf_pex_ota_core_hybrid_bm_half_0.iqmod_mfb_lpf_pex_ota_core_tg$1_0.v_b.n8 VSS 0.29884f
C395 iqmod_mfb_lpf_pex_half_1.iqmod_mfb_lpf_pex_ota_core_hybrid_bm_half_0.iqmod_mfb_lpf_pex_ota_core_tg$1_0.v_b.n9 VSS 0.29884f
C396 iqmod_mfb_lpf_pex_half_1.iqmod_mfb_lpf_pex_ota_core_hybrid_bm_half_0.iqmod_mfb_lpf_pex_ota_core_tg$1_0.v_b.n10 VSS 0.29884f
C397 iqmod_mfb_lpf_pex_half_1.iqmod_mfb_lpf_pex_ota_core_hybrid_bm_half_0.iqmod_mfb_lpf_pex_ota_core_tg$1_0.v_b.n11 VSS 0.29884f
C398 iqmod_mfb_lpf_pex_half_1.iqmod_mfb_lpf_pex_ota_core_hybrid_bm_half_0.iqmod_mfb_lpf_pex_ota_core_tg$1_0.v_b.n12 VSS 0.29884f
C399 iqmod_mfb_lpf_pex_half_1.iqmod_mfb_lpf_pex_ota_core_hybrid_bm_half_0.iqmod_mfb_lpf_pex_ota_core_tg$1_0.v_b.n13 VSS 0.29884f
C400 iqmod_mfb_lpf_pex_half_1.iqmod_mfb_lpf_pex_ota_core_hybrid_bm_half_0.iqmod_mfb_lpf_pex_ota_core_tg$1_0.v_b.n14 VSS 0.29884f
C401 iqmod_mfb_lpf_pex_half_1.iqmod_mfb_lpf_pex_ota_core_hybrid_bm_half_0.iqmod_mfb_lpf_pex_ota_core_tg$1_0.v_b.n15 VSS 0.29884f
C402 iqmod_mfb_lpf_pex_half_1.iqmod_mfb_lpf_pex_ota_core_hybrid_bm_half_0.iqmod_mfb_lpf_pex_ota_core_tg$1_0.v_b.n16 VSS 0.29884f
C403 iqmod_mfb_lpf_pex_half_1.iqmod_mfb_lpf_pex_ota_core_hybrid_bm_half_0.iqmod_mfb_lpf_pex_ota_core_tg$1_0.v_b.n17 VSS 0.29884f
C404 iqmod_mfb_lpf_pex_half_1.iqmod_mfb_lpf_pex_ota_core_hybrid_bm_half_0.iqmod_mfb_lpf_pex_ota_core_tg$1_0.v_b.n18 VSS 0.29884f
C405 iqmod_mfb_lpf_pex_half_1.iqmod_mfb_lpf_pex_ota_core_hybrid_bm_half_0.iqmod_mfb_lpf_pex_ota_core_tg$1_0.v_b.t36 VSS 26.2882f
C406 iqmod_mfb_lpf_pex_half_1.iqmod_mfb_lpf_pex_ota_core_hybrid_bm_half_0.iqmod_mfb_lpf_pex_ota_core_tg$1_0.v_b.n19 VSS 0.29709f
C407 iqmod_mfb_lpf_pex_half_1.iqmod_mfb_lpf_pex_ota_core_hybrid_bm_half_0.iqmod_mfb_lpf_pex_ota_core_tg$1_0.v_b.n20 VSS 0.09281f
C408 iqmod_mfb_lpf_pex_half_1.iqmod_mfb_lpf_pex_ota_core_hybrid_bm_half_0.iqmod_mfb_lpf_pex_ota_core_tg$1_0.v_b.n21 VSS 0.07006f
C409 iqmod_mfb_lpf_pex_half_1.iqmod_mfb_lpf_pex_ota_core_hybrid_bm_half_0.iqmod_mfb_lpf_pex_ota_core_tg$1_0.v_b.n22 VSS 0.07006f
C410 iqmod_mfb_lpf_pex_half_1.iqmod_mfb_lpf_pex_ota_core_hybrid_bm_half_0.iqmod_mfb_lpf_pex_ota_core_tg$1_0.v_b.n23 VSS 0.07006f
C411 iqmod_mfb_lpf_pex_half_1.iqmod_mfb_lpf_pex_ota_core_hybrid_bm_half_0.iqmod_mfb_lpf_pex_ota_core_tg$1_0.v_b.n24 VSS 0.07006f
C412 iqmod_mfb_lpf_pex_half_1.iqmod_mfb_lpf_pex_ota_core_hybrid_bm_half_0.iqmod_mfb_lpf_pex_ota_core_tg$1_0.v_b.n25 VSS 0.07006f
C413 iqmod_mfb_lpf_pex_half_1.iqmod_mfb_lpf_pex_ota_core_hybrid_bm_half_0.iqmod_mfb_lpf_pex_ota_core_tg$1_0.v_b.n26 VSS 0.07006f
C414 iqmod_mfb_lpf_pex_half_1.iqmod_mfb_lpf_pex_ota_core_hybrid_bm_half_0.iqmod_mfb_lpf_pex_ota_core_tg$1_0.v_b.n27 VSS 0.07006f
C415 iqmod_mfb_lpf_pex_half_1.iqmod_mfb_lpf_pex_ota_core_hybrid_bm_half_0.iqmod_mfb_lpf_pex_ota_core_tg$1_0.v_b.n28 VSS 0.07006f
C416 iqmod_mfb_lpf_pex_half_1.iqmod_mfb_lpf_pex_ota_core_hybrid_bm_half_0.iqmod_mfb_lpf_pex_ota_core_tg$1_0.v_b.n29 VSS 0.07006f
C417 iqmod_mfb_lpf_pex_half_1.iqmod_mfb_lpf_pex_ota_core_hybrid_bm_half_0.iqmod_mfb_lpf_pex_ota_core_tg$1_0.v_b.n30 VSS 0.07006f
C418 iqmod_mfb_lpf_pex_half_1.iqmod_mfb_lpf_pex_ota_core_hybrid_bm_half_0.iqmod_mfb_lpf_pex_ota_core_tg$1_0.v_b.n31 VSS 0.07006f
C419 iqmod_mfb_lpf_pex_half_1.iqmod_mfb_lpf_pex_ota_core_hybrid_bm_half_0.iqmod_mfb_lpf_pex_ota_core_tg$1_0.v_b.n32 VSS 0.07006f
C420 iqmod_mfb_lpf_pex_half_1.iqmod_mfb_lpf_pex_ota_core_hybrid_bm_half_0.iqmod_mfb_lpf_pex_ota_core_tg$1_0.v_b.n33 VSS 0.07006f
C421 iqmod_mfb_lpf_pex_half_1.iqmod_mfb_lpf_pex_ota_core_hybrid_bm_half_0.iqmod_mfb_lpf_pex_ota_core_tg$1_0.v_b.n34 VSS 0.07006f
C422 iqmod_mfb_lpf_pex_half_1.iqmod_mfb_lpf_pex_ota_core_hybrid_bm_half_0.iqmod_mfb_lpf_pex_ota_core_tg$1_0.v_b.n35 VSS 0.09281f
C423 iqmod_mfb_lpf_pex_half_1.iqmod_mfb_lpf_pex_ota_core_hybrid_bm_half_0.iqmod_mfb_lpf_pex_ota_core_tg$1_0.v_b.t37 VSS 6.45905f
C424 iqmod_mfb_lpf_pex_half_1.iqmod_mfb_lpf_pex_ota_core_hybrid_bm_half_0.iqmod_mfb_lpf_pex_ota_core_tg$1_0.v_b.n36 VSS 0.29709f
C425 iqmod_mfb_lpf_pex_half_1.iqmod_mfb_lpf_pex_ota_core_hybrid_bm_half_0.iqmod_mfb_lpf_pex_ota_core_tg$1_0.v_b.n37 VSS 0.07123f
C426 iqmod_mfb_lpf_pex_half_1.iqmod_mfb_lpf_pex_ota_core_hybrid_bm_half_0.iqmod_mfb_lpf_pex_ota_core_tg$1_0.v_b.n38 VSS 0.09165f
C427 iqmod_mfb_lpf_pex_half_1.iqmod_mfb_lpf_pex_ota_core_hybrid_bm_half_0.iqmod_mfb_lpf_pex_ota_core_tg$1_0.v_b.n39 VSS 0.07006f
C428 iqmod_mfb_lpf_pex_half_1.iqmod_mfb_lpf_pex_ota_core_hybrid_bm_half_0.iqmod_mfb_lpf_pex_ota_core_tg$1_0.v_b.n40 VSS 0.07006f
C429 iqmod_mfb_lpf_pex_half_1.iqmod_mfb_lpf_pex_ota_core_hybrid_bm_half_0.iqmod_mfb_lpf_pex_ota_core_tg$1_0.v_b.n41 VSS 0.07006f
C430 iqmod_mfb_lpf_pex_half_1.iqmod_mfb_lpf_pex_ota_core_hybrid_bm_half_0.iqmod_mfb_lpf_pex_ota_core_tg$1_0.v_b.n42 VSS 0.07006f
C431 iqmod_mfb_lpf_pex_half_1.iqmod_mfb_lpf_pex_ota_core_hybrid_bm_half_0.iqmod_mfb_lpf_pex_ota_core_tg$1_0.v_b.n43 VSS 0.07006f
C432 iqmod_mfb_lpf_pex_half_1.iqmod_mfb_lpf_pex_ota_core_hybrid_bm_half_0.iqmod_mfb_lpf_pex_ota_core_tg$1_0.v_b.n44 VSS 0.07006f
C433 iqmod_mfb_lpf_pex_half_1.iqmod_mfb_lpf_pex_ota_core_hybrid_bm_half_0.iqmod_mfb_lpf_pex_ota_core_tg$1_0.v_b.n45 VSS 0.07006f
C434 iqmod_mfb_lpf_pex_half_1.iqmod_mfb_lpf_pex_ota_core_hybrid_bm_half_0.iqmod_mfb_lpf_pex_ota_core_tg$1_0.v_b.n46 VSS 0.07006f
C435 iqmod_mfb_lpf_pex_half_1.iqmod_mfb_lpf_pex_ota_core_hybrid_bm_half_0.iqmod_mfb_lpf_pex_ota_core_tg$1_0.v_b.n47 VSS 0.07006f
C436 iqmod_mfb_lpf_pex_half_1.iqmod_mfb_lpf_pex_ota_core_hybrid_bm_half_0.iqmod_mfb_lpf_pex_ota_core_tg$1_0.v_b.n48 VSS 0.07006f
C437 iqmod_mfb_lpf_pex_half_1.iqmod_mfb_lpf_pex_ota_core_hybrid_bm_half_0.iqmod_mfb_lpf_pex_ota_core_tg$1_0.v_b.n49 VSS 0.07006f
C438 iqmod_mfb_lpf_pex_half_1.iqmod_mfb_lpf_pex_ota_core_hybrid_bm_half_0.iqmod_mfb_lpf_pex_ota_core_tg$1_0.v_b.n50 VSS 0.07006f
C439 iqmod_mfb_lpf_pex_half_1.iqmod_mfb_lpf_pex_ota_core_hybrid_bm_half_0.iqmod_mfb_lpf_pex_ota_core_tg$1_0.v_b.n51 VSS 0.09165f
C440 iqmod_mfb_lpf_pex_half_1.iqmod_mfb_lpf_pex_ota_core_hybrid_bm_half_0.iqmod_mfb_lpf_pex_ota_core_tg$1_0.v_b.n52 VSS 0.07123f
C441 iqmod_mfb_lpf_pex_half_1.iqmod_mfb_lpf_pex_ota_core_hybrid_bm_half_0.iqmod_mfb_lpf_pex_ota_core_tg$1_0.v_b.n53 VSS 0.27621f
C442 iqmod_mfb_lpf_pex_half_1.iqmod_mfb_lpf_pex_ota_core_hybrid_bm_half_0.iqmod_mfb_lpf_pex_ota_core_tg$1_0.v_b.n54 VSS 0.70516f
C443 iqmod_mfb_lpf_pex_half_1.iqmod_mfb_lpf_pex_ota_core_hybrid_bm_half_0.iqmod_mfb_lpf_pex_ota_core_tg$1_0.v_b.n55 VSS 0.70516f
C444 iqmod_mfb_lpf_pex_half_1.iqmod_mfb_lpf_pex_ota_core_hybrid_bm_half_0.iqmod_mfb_lpf_pex_ota_core_tg$1_0.v_b.n56 VSS 0.77715f
C445 iqmod_mfb_lpf_pex_half_1.iqmod_mfb_lpf_pex_ota_core_hybrid_bm_half_0.iqmod_mfb_lpf_pex_ota_core_tg$1_0.v_b.n57 VSS 0.29884f
C446 iqmod_mfb_lpf_pex_half_1.iqmod_mfb_lpf_pex_ota_core_hybrid_bm_half_0.iqmod_mfb_lpf_pex_ota_core_tg$1_0.v_b.n58 VSS 0.29884f
C447 iqmod_mfb_lpf_pex_half_1.iqmod_mfb_lpf_pex_ota_core_hybrid_bm_half_0.iqmod_mfb_lpf_pex_ota_core_tg$1_0.v_b.n59 VSS 0.29884f
C448 iqmod_mfb_lpf_pex_half_1.iqmod_mfb_lpf_pex_ota_core_hybrid_bm_half_0.iqmod_mfb_lpf_pex_ota_core_tg$1_0.v_b.n60 VSS 0.29884f
C449 iqmod_mfb_lpf_pex_half_1.iqmod_mfb_lpf_pex_ota_core_hybrid_bm_half_0.iqmod_mfb_lpf_pex_ota_core_tg$1_0.v_b.n61 VSS 0.29884f
C450 iqmod_mfb_lpf_pex_half_1.iqmod_mfb_lpf_pex_ota_core_hybrid_bm_half_0.iqmod_mfb_lpf_pex_ota_core_tg$1_0.v_b.n62 VSS 0.29884f
C451 iqmod_mfb_lpf_pex_half_1.iqmod_mfb_lpf_pex_ota_core_hybrid_bm_half_0.iqmod_mfb_lpf_pex_ota_core_tg$1_0.v_b.n63 VSS 0.29884f
C452 iqmod_mfb_lpf_pex_half_1.iqmod_mfb_lpf_pex_ota_core_hybrid_bm_half_0.iqmod_mfb_lpf_pex_ota_core_tg$1_0.v_b.n64 VSS 0.29884f
C453 iqmod_mfb_lpf_pex_half_1.iqmod_mfb_lpf_pex_ota_core_hybrid_bm_half_0.iqmod_mfb_lpf_pex_ota_core_tg$1_0.v_b.n65 VSS 0.29884f
C454 iqmod_mfb_lpf_pex_half_1.iqmod_mfb_lpf_pex_ota_core_hybrid_bm_half_0.iqmod_mfb_lpf_pex_ota_core_tg$1_0.v_b.n66 VSS 0.29884f
C455 iqmod_mfb_lpf_pex_half_1.iqmod_mfb_lpf_pex_ota_core_hybrid_bm_half_0.iqmod_mfb_lpf_pex_ota_core_tg$1_0.v_b.n67 VSS 0.29884f
C456 iqmod_mfb_lpf_pex_half_1.iqmod_mfb_lpf_pex_ota_core_hybrid_bm_half_0.iqmod_mfb_lpf_pex_ota_core_tg$1_0.v_b.n68 VSS 0.29884f
C457 iqmod_mfb_lpf_pex_half_1.iqmod_mfb_lpf_pex_ota_core_hybrid_bm_half_0.iqmod_mfb_lpf_pex_ota_core_tg$1_0.v_b.n69 VSS 0.29884f
C458 iqmod_mfb_lpf_pex_half_1.iqmod_mfb_lpf_pex_ota_core_hybrid_bm_half_0.iqmod_mfb_lpf_pex_ota_core_tg$1_0.v_b.n70 VSS 0.29884f
C459 iqmod_mfb_lpf_pex_half_1.iqmod_mfb_lpf_pex_ota_core_hybrid_bm_half_0.iqmod_mfb_lpf_pex_ota_core_tg$1_0.v_b.n71 VSS 0.29884f
C460 iqmod_mfb_lpf_pex_half_1.iqmod_mfb_lpf_pex_ota_core_hybrid_bm_half_0.iqmod_mfb_lpf_pex_ota_core_tg$1_0.v_b.n72 VSS 0.29884f
C461 iqmod_mfb_lpf_pex_half_1.iqmod_mfb_lpf_pex_ota_core_hybrid_bm_half_0.iqmod_mfb_lpf_pex_ota_core_tg$1_0.v_b.n73 VSS 0.29884f
C462 iqmod_mfb_lpf_pex_half_1.iqmod_mfb_lpf_pex_ota_core_hybrid_bm_half_0.iqmod_mfb_lpf_pex_ota_core_tg$1_0.v_b.t38 VSS 6.45905f
C463 iqmod_mfb_lpf_pex_half_1.iqmod_mfb_lpf_pex_ota_core_hybrid_bm_half_0.iqmod_mfb_lpf_pex_ota_core_tg$1_0.v_b.n74 VSS 0.29709f
C464 iqmod_mfb_lpf_pex_half_1.iqmod_mfb_lpf_pex_ota_core_hybrid_bm_half_0.iqmod_mfb_lpf_pex_ota_core_tg$1_0.v_b.n75 VSS 0.09281f
C465 iqmod_mfb_lpf_pex_half_1.iqmod_mfb_lpf_pex_ota_core_hybrid_bm_half_0.iqmod_mfb_lpf_pex_ota_core_tg$1_0.v_b.n76 VSS 0.07006f
C466 iqmod_mfb_lpf_pex_half_1.iqmod_mfb_lpf_pex_ota_core_hybrid_bm_half_0.iqmod_mfb_lpf_pex_ota_core_tg$1_0.v_b.n77 VSS 0.07006f
C467 iqmod_mfb_lpf_pex_half_1.iqmod_mfb_lpf_pex_ota_core_hybrid_bm_half_0.iqmod_mfb_lpf_pex_ota_core_tg$1_0.v_b.n78 VSS 0.07006f
C468 iqmod_mfb_lpf_pex_half_1.iqmod_mfb_lpf_pex_ota_core_hybrid_bm_half_0.iqmod_mfb_lpf_pex_ota_core_tg$1_0.v_b.n79 VSS 0.07006f
C469 iqmod_mfb_lpf_pex_half_1.iqmod_mfb_lpf_pex_ota_core_hybrid_bm_half_0.iqmod_mfb_lpf_pex_ota_core_tg$1_0.v_b.n80 VSS 0.07006f
C470 iqmod_mfb_lpf_pex_half_1.iqmod_mfb_lpf_pex_ota_core_hybrid_bm_half_0.iqmod_mfb_lpf_pex_ota_core_tg$1_0.v_b.n81 VSS 0.07006f
C471 iqmod_mfb_lpf_pex_half_1.iqmod_mfb_lpf_pex_ota_core_hybrid_bm_half_0.iqmod_mfb_lpf_pex_ota_core_tg$1_0.v_b.n82 VSS 0.07006f
C472 iqmod_mfb_lpf_pex_half_1.iqmod_mfb_lpf_pex_ota_core_hybrid_bm_half_0.iqmod_mfb_lpf_pex_ota_core_tg$1_0.v_b.n83 VSS 0.07006f
C473 iqmod_mfb_lpf_pex_half_1.iqmod_mfb_lpf_pex_ota_core_hybrid_bm_half_0.iqmod_mfb_lpf_pex_ota_core_tg$1_0.v_b.n84 VSS 0.07006f
C474 iqmod_mfb_lpf_pex_half_1.iqmod_mfb_lpf_pex_ota_core_hybrid_bm_half_0.iqmod_mfb_lpf_pex_ota_core_tg$1_0.v_b.n85 VSS 0.07006f
C475 iqmod_mfb_lpf_pex_half_1.iqmod_mfb_lpf_pex_ota_core_hybrid_bm_half_0.iqmod_mfb_lpf_pex_ota_core_tg$1_0.v_b.n86 VSS 0.07006f
C476 iqmod_mfb_lpf_pex_half_1.iqmod_mfb_lpf_pex_ota_core_hybrid_bm_half_0.iqmod_mfb_lpf_pex_ota_core_tg$1_0.v_b.n87 VSS 0.07006f
C477 iqmod_mfb_lpf_pex_half_1.iqmod_mfb_lpf_pex_ota_core_hybrid_bm_half_0.iqmod_mfb_lpf_pex_ota_core_tg$1_0.v_b.n88 VSS 0.07006f
C478 iqmod_mfb_lpf_pex_half_1.iqmod_mfb_lpf_pex_ota_core_hybrid_bm_half_0.iqmod_mfb_lpf_pex_ota_core_tg$1_0.v_b.n89 VSS 0.07006f
C479 iqmod_mfb_lpf_pex_half_1.iqmod_mfb_lpf_pex_ota_core_hybrid_bm_half_0.iqmod_mfb_lpf_pex_ota_core_tg$1_0.v_b.n90 VSS 0.09281f
C480 iqmod_mfb_lpf_pex_half_1.iqmod_mfb_lpf_pex_ota_core_hybrid_bm_half_0.iqmod_mfb_lpf_pex_ota_core_tg$1_0.v_b.t39 VSS 26.2882f
C481 iqmod_mfb_lpf_pex_half_1.iqmod_mfb_lpf_pex_ota_core_hybrid_bm_half_0.iqmod_mfb_lpf_pex_ota_core_tg$1_0.v_b.n91 VSS 0.29709f
C482 iqmod_mfb_lpf_pex_half_1.iqmod_mfb_lpf_pex_ota_core_hybrid_bm_half_0.iqmod_mfb_lpf_pex_ota_core_tg$1_0.v_b.n92 VSS 0.07123f
C483 iqmod_mfb_lpf_pex_half_1.iqmod_mfb_lpf_pex_ota_core_hybrid_bm_half_0.iqmod_mfb_lpf_pex_ota_core_tg$1_0.v_b.n93 VSS 0.09165f
C484 iqmod_mfb_lpf_pex_half_1.iqmod_mfb_lpf_pex_ota_core_hybrid_bm_half_0.iqmod_mfb_lpf_pex_ota_core_tg$1_0.v_b.n94 VSS 0.07006f
C485 iqmod_mfb_lpf_pex_half_1.iqmod_mfb_lpf_pex_ota_core_hybrid_bm_half_0.iqmod_mfb_lpf_pex_ota_core_tg$1_0.v_b.n95 VSS 0.07006f
C486 iqmod_mfb_lpf_pex_half_1.iqmod_mfb_lpf_pex_ota_core_hybrid_bm_half_0.iqmod_mfb_lpf_pex_ota_core_tg$1_0.v_b.n96 VSS 0.07006f
C487 iqmod_mfb_lpf_pex_half_1.iqmod_mfb_lpf_pex_ota_core_hybrid_bm_half_0.iqmod_mfb_lpf_pex_ota_core_tg$1_0.v_b.n97 VSS 0.07006f
C488 iqmod_mfb_lpf_pex_half_1.iqmod_mfb_lpf_pex_ota_core_hybrid_bm_half_0.iqmod_mfb_lpf_pex_ota_core_tg$1_0.v_b.n98 VSS 0.07006f
C489 iqmod_mfb_lpf_pex_half_1.iqmod_mfb_lpf_pex_ota_core_hybrid_bm_half_0.iqmod_mfb_lpf_pex_ota_core_tg$1_0.v_b.n99 VSS 0.07006f
C490 iqmod_mfb_lpf_pex_half_1.iqmod_mfb_lpf_pex_ota_core_hybrid_bm_half_0.iqmod_mfb_lpf_pex_ota_core_tg$1_0.v_b.n100 VSS 0.07006f
C491 iqmod_mfb_lpf_pex_half_1.iqmod_mfb_lpf_pex_ota_core_hybrid_bm_half_0.iqmod_mfb_lpf_pex_ota_core_tg$1_0.v_b.n101 VSS 0.07006f
C492 iqmod_mfb_lpf_pex_half_1.iqmod_mfb_lpf_pex_ota_core_hybrid_bm_half_0.iqmod_mfb_lpf_pex_ota_core_tg$1_0.v_b.n102 VSS 0.07006f
C493 iqmod_mfb_lpf_pex_half_1.iqmod_mfb_lpf_pex_ota_core_hybrid_bm_half_0.iqmod_mfb_lpf_pex_ota_core_tg$1_0.v_b.n103 VSS 0.07006f
C494 iqmod_mfb_lpf_pex_half_1.iqmod_mfb_lpf_pex_ota_core_hybrid_bm_half_0.iqmod_mfb_lpf_pex_ota_core_tg$1_0.v_b.n104 VSS 0.07006f
C495 iqmod_mfb_lpf_pex_half_1.iqmod_mfb_lpf_pex_ota_core_hybrid_bm_half_0.iqmod_mfb_lpf_pex_ota_core_tg$1_0.v_b.n105 VSS 0.07006f
C496 iqmod_mfb_lpf_pex_half_1.iqmod_mfb_lpf_pex_ota_core_hybrid_bm_half_0.iqmod_mfb_lpf_pex_ota_core_tg$1_0.v_b.n106 VSS 0.09165f
C497 iqmod_mfb_lpf_pex_half_1.iqmod_mfb_lpf_pex_ota_core_hybrid_bm_half_0.iqmod_mfb_lpf_pex_ota_core_tg$1_0.v_b.n107 VSS 0.07123f
C498 iqmod_mfb_lpf_pex_half_1.iqmod_mfb_lpf_pex_ota_core_hybrid_bm_half_0.iqmod_mfb_lpf_pex_ota_core_tg$1_0.v_b.n108 VSS 0.27621f
C499 iqmod_mfb_lpf_pex_half_1.iqmod_mfb_lpf_pex_ota_core_hybrid_bm_half_0.iqmod_mfb_lpf_pex_ota_core_tg$1_0.v_b.t5 VSS 0.1721f
C500 iqmod_mfb_lpf_pex_half_1.iqmod_mfb_lpf_pex_ota_core_hybrid_bm_half_0.iqmod_mfb_lpf_pex_ota_core_tg$1_0.v_b.t11 VSS 1.22202f
C501 iqmod_mfb_lpf_pex_half_1.iqmod_mfb_lpf_pex_ota_core_hybrid_bm_half_0.iqmod_mfb_lpf_pex_ota_core_tg$1_0.v_b.n109 VSS 3.03522f
C502 iqmod_mfb_lpf_pex_half_1.iqmod_mfb_lpf_pex_ota_core_hybrid_bm_half_0.iqmod_mfb_lpf_pex_ota_core_tg$1_0.v_b.t4 VSS 0.1721f
C503 iqmod_mfb_lpf_pex_half_1.iqmod_mfb_lpf_pex_ota_core_hybrid_bm_half_0.iqmod_mfb_lpf_pex_ota_core_tg$1_0.v_b.t10 VSS 1.22202f
C504 iqmod_mfb_lpf_pex_half_1.iqmod_mfb_lpf_pex_ota_core_hybrid_bm_half_0.iqmod_mfb_lpf_pex_ota_core_tg$1_0.v_b.n110 VSS 3.4085f
C505 iqmod_mfb_lpf_pex_half_1.iqmod_mfb_lpf_pex_ota_core_hybrid_bm_half_0.iqmod_mfb_lpf_pex_ota_core_tg$1_0.v_b.t3 VSS 0.1721f
C506 iqmod_mfb_lpf_pex_half_1.iqmod_mfb_lpf_pex_ota_core_hybrid_bm_half_0.iqmod_mfb_lpf_pex_ota_core_tg$1_0.v_b.t9 VSS 1.22202f
C507 iqmod_mfb_lpf_pex_half_1.iqmod_mfb_lpf_pex_ota_core_hybrid_bm_half_0.iqmod_mfb_lpf_pex_ota_core_tg$1_0.v_b.n111 VSS 3.58942f
C508 iqmod_mfb_lpf_pex_half_1.iqmod_mfb_lpf_pex_ota_core_hybrid_bm_half_0.iqmod_mfb_lpf_pex_ota_core_tg$1_0.v_b.n112 VSS 8.11671f
C509 iqmod_mfb_lpf_pex_half_1.iqmod_mfb_lpf_pex_ota_core_hybrid_bm_half_0.iqmod_mfb_lpf_pex_ota_core_tg$1_0.v_b.t25 VSS 0.11678f
C510 iqmod_mfb_lpf_pex_half_1.iqmod_mfb_lpf_pex_ota_core_hybrid_bm_half_0.iqmod_mfb_lpf_pex_ota_core_tg$1_0.v_b.t1 VSS 0.83769f
C511 iqmod_mfb_lpf_pex_half_1.iqmod_mfb_lpf_pex_ota_core_hybrid_bm_half_0.iqmod_mfb_lpf_pex_ota_core_tg$1_0.v_b.n113 VSS 1.25847f
C512 iqmod_mfb_lpf_pex_half_1.iqmod_mfb_lpf_pex_ota_core_hybrid_bm_half_0.iqmod_mfb_lpf_pex_ota_core_tg$1_0.v_b.t24 VSS 0.11678f
C513 iqmod_mfb_lpf_pex_half_1.iqmod_mfb_lpf_pex_ota_core_hybrid_bm_half_0.iqmod_mfb_lpf_pex_ota_core_tg$1_0.v_b.t0 VSS 0.83786f
C514 iqmod_mfb_lpf_pex_half_1.iqmod_mfb_lpf_pex_ota_core_hybrid_bm_half_0.iqmod_mfb_lpf_pex_ota_core_tg$1_0.v_b.n114 VSS 1.20675f
C515 iqmod_mfb_lpf_pex_half_1.iqmod_mfb_lpf_pex_ota_core_hybrid_bm_half_0.iqmod_mfb_lpf_pex_ota_core_tg$1_0.v_b.t26 VSS 0.11678f
C516 iqmod_mfb_lpf_pex_half_1.iqmod_mfb_lpf_pex_ota_core_hybrid_bm_half_0.iqmod_mfb_lpf_pex_ota_core_tg$1_0.v_b.t2 VSS 0.83769f
C517 iqmod_mfb_lpf_pex_half_1.iqmod_mfb_lpf_pex_ota_core_hybrid_bm_half_0.iqmod_mfb_lpf_pex_ota_core_tg$1_0.v_b.t32 VSS 0.1721f
C518 iqmod_mfb_lpf_pex_half_1.iqmod_mfb_lpf_pex_ota_core_hybrid_bm_half_0.iqmod_mfb_lpf_pex_ota_core_tg$1_0.v_b.t35 VSS 1.22202f
C519 iqmod_mfb_lpf_pex_half_1.iqmod_mfb_lpf_pex_ota_core_hybrid_bm_half_0.iqmod_mfb_lpf_pex_ota_core_tg$1_0.v_b.n115 VSS 3.03522f
C520 iqmod_mfb_lpf_pex_half_1.iqmod_mfb_lpf_pex_ota_core_hybrid_bm_half_0.iqmod_mfb_lpf_pex_ota_core_tg$1_0.v_b.t31 VSS 0.1721f
C521 iqmod_mfb_lpf_pex_half_1.iqmod_mfb_lpf_pex_ota_core_hybrid_bm_half_0.iqmod_mfb_lpf_pex_ota_core_tg$1_0.v_b.t34 VSS 1.22202f
C522 iqmod_mfb_lpf_pex_half_1.iqmod_mfb_lpf_pex_ota_core_hybrid_bm_half_0.iqmod_mfb_lpf_pex_ota_core_tg$1_0.v_b.n116 VSS 3.4085f
C523 iqmod_mfb_lpf_pex_half_1.iqmod_mfb_lpf_pex_ota_core_hybrid_bm_half_0.iqmod_mfb_lpf_pex_ota_core_tg$1_0.v_b.t30 VSS 0.1721f
C524 iqmod_mfb_lpf_pex_half_1.iqmod_mfb_lpf_pex_ota_core_hybrid_bm_half_0.iqmod_mfb_lpf_pex_ota_core_tg$1_0.v_b.t33 VSS 1.22202f
C525 iqmod_mfb_lpf_pex_half_1.iqmod_mfb_lpf_pex_ota_core_hybrid_bm_half_0.iqmod_mfb_lpf_pex_ota_core_tg$1_0.v_b.n117 VSS 3.58593f
C526 iqmod_mfb_lpf_pex_half_1.iqmod_mfb_lpf_pex_ota_core_hybrid_bm_half_0.iqmod_mfb_lpf_pex_ota_core_tg$1_0.v_b.t28 VSS 0.83769f
C527 iqmod_mfb_lpf_pex_half_1.iqmod_mfb_lpf_pex_ota_core_hybrid_bm_half_0.iqmod_mfb_lpf_pex_ota_core_tg$1_0.v_b.t22 VSS 0.11678f
C528 iqmod_mfb_lpf_pex_half_1.iqmod_mfb_lpf_pex_ota_core_hybrid_bm_half_0.iqmod_mfb_lpf_pex_ota_core_tg$1_0.v_b.n118 VSS 1.25847f
C529 iqmod_mfb_lpf_pex_half_1.iqmod_mfb_lpf_pex_ota_core_hybrid_bm_half_0.iqmod_mfb_lpf_pex_ota_core_tg$1_0.v_b.t27 VSS 0.83769f
C530 iqmod_mfb_lpf_pex_half_1.iqmod_mfb_lpf_pex_ota_core_hybrid_bm_half_0.iqmod_mfb_lpf_pex_ota_core_tg$1_0.v_b.t21 VSS 0.11678f
C531 iqmod_mfb_lpf_pex_half_1.iqmod_mfb_lpf_pex_ota_core_hybrid_bm_half_0.iqmod_mfb_lpf_pex_ota_core_tg$1_0.v_b.n119 VSS 1.20691f
C532 iqmod_mfb_lpf_pex_half_1.iqmod_mfb_lpf_pex_ota_core_hybrid_bm_half_0.iqmod_mfb_lpf_pex_ota_core_tg$1_0.v_b.t29 VSS 0.83769f
C533 iqmod_mfb_lpf_pex_half_1.iqmod_mfb_lpf_pex_ota_core_hybrid_bm_half_0.iqmod_mfb_lpf_pex_ota_core_tg$1_0.v_b.t23 VSS 0.11678f
C534 iqmod_mfb_lpf_pex_half_1.iqmod_mfb_lpf_pex_ota_core_hybrid_bm_half_0.iqmod_mfb_lpf_pex_ota_core_tg$1_0.v_b.t20 VSS 1.22202f
C535 iqmod_mfb_lpf_pex_half_1.iqmod_mfb_lpf_pex_ota_core_hybrid_bm_half_0.iqmod_mfb_lpf_pex_ota_core_tg$1_0.v_b.t17 VSS 0.1721f
C536 iqmod_mfb_lpf_pex_half_1.iqmod_mfb_lpf_pex_ota_core_hybrid_bm_half_0.iqmod_mfb_lpf_pex_ota_core_tg$1_0.v_b.n120 VSS 3.03522f
C537 iqmod_mfb_lpf_pex_half_1.iqmod_mfb_lpf_pex_ota_core_hybrid_bm_half_0.iqmod_mfb_lpf_pex_ota_core_tg$1_0.v_b.t19 VSS 1.22202f
C538 iqmod_mfb_lpf_pex_half_1.iqmod_mfb_lpf_pex_ota_core_hybrid_bm_half_0.iqmod_mfb_lpf_pex_ota_core_tg$1_0.v_b.t16 VSS 0.1721f
C539 iqmod_mfb_lpf_pex_half_1.iqmod_mfb_lpf_pex_ota_core_hybrid_bm_half_0.iqmod_mfb_lpf_pex_ota_core_tg$1_0.v_b.n121 VSS 3.4085f
C540 iqmod_mfb_lpf_pex_half_1.iqmod_mfb_lpf_pex_ota_core_hybrid_bm_half_0.iqmod_mfb_lpf_pex_ota_core_tg$1_0.v_b.t18 VSS 1.22202f
C541 iqmod_mfb_lpf_pex_half_1.iqmod_mfb_lpf_pex_ota_core_hybrid_bm_half_0.iqmod_mfb_lpf_pex_ota_core_tg$1_0.v_b.t15 VSS 0.1721f
C542 iqmod_mfb_lpf_pex_half_1.iqmod_mfb_lpf_pex_ota_core_hybrid_bm_half_0.iqmod_mfb_lpf_pex_ota_core_tg$1_0.v_b.n122 VSS 3.58593f
C543 iqmod_mfb_lpf_pex_half_1.iqmod_mfb_lpf_pex_ota_core_hybrid_bm_half_0.iqmod_mfb_lpf_pex_ota_core_tg$1_0.v_b.n123 VSS 8.15696f
C544 iqmod_mfb_lpf_pex_half_1.iqmod_mfb_lpf_pex_ota_core_hybrid_bm_half_0.iqmod_mfb_lpf_pex_ota_core_tg$1_0.v_b.n124 VSS 8.15696f
C545 iqmod_mfb_lpf_pex_half_1.iqmod_mfb_lpf_pex_ota_core_hybrid_bm_half_0.iqmod_mfb_lpf_pex_ota_core_tg$1_0.v_b.n125 VSS 8.11671f
C546 iqmod_mfb_lpf_pex_half_1.iqmod_mfb_lpf_pex_ota_core_hybrid_bm_half_0.iqmod_mfb_lpf_pex_ota_core_tg$1_0.v_b.t13 VSS 1.22202f
C547 iqmod_mfb_lpf_pex_half_1.iqmod_mfb_lpf_pex_ota_core_hybrid_bm_half_0.iqmod_mfb_lpf_pex_ota_core_tg$1_0.v_b.t7 VSS 0.1721f
C548 iqmod_mfb_lpf_pex_half_1.iqmod_mfb_lpf_pex_ota_core_hybrid_bm_half_0.iqmod_mfb_lpf_pex_ota_core_tg$1_0.v_b.n126 VSS 3.4085f
C549 iqmod_mfb_lpf_pex_half_1.iqmod_mfb_lpf_pex_ota_core_hybrid_bm_half_0.iqmod_mfb_lpf_pex_ota_core_tg$1_0.v_b.t12 VSS 1.22202f
C550 iqmod_mfb_lpf_pex_half_1.iqmod_mfb_lpf_pex_ota_core_hybrid_bm_half_0.iqmod_mfb_lpf_pex_ota_core_tg$1_0.v_b.t6 VSS 0.1721f
C551 iqmod_mfb_lpf_pex_half_1.iqmod_mfb_lpf_pex_ota_core_hybrid_bm_half_0.iqmod_mfb_lpf_pex_ota_core_tg$1_0.v_b.n127 VSS 3.58942f
C552 iqmod_mfb_lpf_pex_half_1.iqmod_mfb_lpf_pex_ota_core_hybrid_bm_half_0.iqmod_mfb_lpf_pex_ota_core_inv_NF6$1_1.vout.t8 VSS 0.13545f
C553 iqmod_mfb_lpf_pex_half_1.iqmod_mfb_lpf_pex_ota_core_hybrid_bm_half_0.iqmod_mfb_lpf_pex_ota_core_inv_NF6$1_1.vout.n0 VSS 0.86038f
C554 iqmod_mfb_lpf_pex_half_1.iqmod_mfb_lpf_pex_ota_core_hybrid_bm_half_0.iqmod_mfb_lpf_pex_ota_core_inv_NF6$1_1.vout.n1 VSS 0.34661f
C555 iqmod_mfb_lpf_pex_half_1.iqmod_mfb_lpf_pex_ota_core_hybrid_bm_half_0.iqmod_mfb_lpf_pex_ota_core_inv_NF6$1_1.vout.n2 VSS 0.34661f
C556 iqmod_mfb_lpf_pex_half_1.iqmod_mfb_lpf_pex_ota_core_hybrid_bm_half_0.iqmod_mfb_lpf_pex_ota_core_inv_NF6$1_1.vout.n3 VSS 0.34661f
C557 iqmod_mfb_lpf_pex_half_1.iqmod_mfb_lpf_pex_ota_core_hybrid_bm_half_0.iqmod_mfb_lpf_pex_ota_core_inv_NF6$1_1.vout.t24 VSS 9.00639f
C558 iqmod_mfb_lpf_pex_half_1.iqmod_mfb_lpf_pex_ota_core_hybrid_bm_half_0.iqmod_mfb_lpf_pex_ota_core_inv_NF6$1_1.vout.n4 VSS 0.24077f
C559 iqmod_mfb_lpf_pex_half_1.iqmod_mfb_lpf_pex_ota_core_hybrid_bm_half_0.iqmod_mfb_lpf_pex_ota_core_inv_NF6$1_1.vout.n5 VSS 0.10721f
C560 iqmod_mfb_lpf_pex_half_1.iqmod_mfb_lpf_pex_ota_core_hybrid_bm_half_0.iqmod_mfb_lpf_pex_ota_core_inv_NF6$1_1.vout.n6 VSS 0.10721f
C561 iqmod_mfb_lpf_pex_half_1.iqmod_mfb_lpf_pex_ota_core_hybrid_bm_half_0.iqmod_mfb_lpf_pex_ota_core_inv_NF6$1_1.vout.t25 VSS 2.10654f
C562 iqmod_mfb_lpf_pex_half_1.iqmod_mfb_lpf_pex_ota_core_hybrid_bm_half_0.iqmod_mfb_lpf_pex_ota_core_inv_NF6$1_1.vout.n7 VSS 0.29064f
C563 iqmod_mfb_lpf_pex_half_1.iqmod_mfb_lpf_pex_ota_core_hybrid_bm_half_0.iqmod_mfb_lpf_pex_ota_core_inv_NF6$1_1.vout.n8 VSS 0.08228f
C564 iqmod_mfb_lpf_pex_half_1.iqmod_mfb_lpf_pex_ota_core_hybrid_bm_half_0.iqmod_mfb_lpf_pex_ota_core_inv_NF6$1_1.vout.n9 VSS 0.08228f
C565 iqmod_mfb_lpf_pex_half_1.iqmod_mfb_lpf_pex_ota_core_hybrid_bm_half_0.iqmod_mfb_lpf_pex_ota_core_inv_NF6$1_1.vout.n10 VSS 0.31835f
C566 iqmod_mfb_lpf_pex_half_1.iqmod_mfb_lpf_pex_ota_core_hybrid_bm_half_0.iqmod_mfb_lpf_pex_ota_core_inv_NF6$1_1.vout.n11 VSS 2.24722f
C567 iqmod_mfb_lpf_pex_half_1.iqmod_mfb_lpf_pex_ota_core_hybrid_bm_half_0.iqmod_mfb_lpf_pex_ota_core_inv_NF6$1_1.vout.n12 VSS 2.24722f
C568 iqmod_mfb_lpf_pex_half_1.iqmod_mfb_lpf_pex_ota_core_hybrid_bm_half_0.iqmod_mfb_lpf_pex_ota_core_inv_NF6$1_1.vout.n13 VSS 0.86038f
C569 iqmod_mfb_lpf_pex_half_1.iqmod_mfb_lpf_pex_ota_core_hybrid_bm_half_0.iqmod_mfb_lpf_pex_ota_core_inv_NF6$1_1.vout.n14 VSS 0.34661f
C570 iqmod_mfb_lpf_pex_half_1.iqmod_mfb_lpf_pex_ota_core_hybrid_bm_half_0.iqmod_mfb_lpf_pex_ota_core_inv_NF6$1_1.vout.n15 VSS 0.34661f
C571 iqmod_mfb_lpf_pex_half_1.iqmod_mfb_lpf_pex_ota_core_hybrid_bm_half_0.iqmod_mfb_lpf_pex_ota_core_inv_NF6$1_1.vout.n16 VSS 0.34661f
C572 iqmod_mfb_lpf_pex_half_1.iqmod_mfb_lpf_pex_ota_core_hybrid_bm_half_0.iqmod_mfb_lpf_pex_ota_core_inv_NF6$1_1.vout.t26 VSS 2.10654f
C573 iqmod_mfb_lpf_pex_half_1.iqmod_mfb_lpf_pex_ota_core_hybrid_bm_half_0.iqmod_mfb_lpf_pex_ota_core_inv_NF6$1_1.vout.n17 VSS 0.24077f
C574 iqmod_mfb_lpf_pex_half_1.iqmod_mfb_lpf_pex_ota_core_hybrid_bm_half_0.iqmod_mfb_lpf_pex_ota_core_inv_NF6$1_1.vout.n18 VSS 0.10721f
C575 iqmod_mfb_lpf_pex_half_1.iqmod_mfb_lpf_pex_ota_core_hybrid_bm_half_0.iqmod_mfb_lpf_pex_ota_core_inv_NF6$1_1.vout.n19 VSS 0.10721f
C576 iqmod_mfb_lpf_pex_half_1.iqmod_mfb_lpf_pex_ota_core_hybrid_bm_half_0.iqmod_mfb_lpf_pex_ota_core_inv_NF6$1_1.vout.t27 VSS 9.00639f
C577 iqmod_mfb_lpf_pex_half_1.iqmod_mfb_lpf_pex_ota_core_hybrid_bm_half_0.iqmod_mfb_lpf_pex_ota_core_inv_NF6$1_1.vout.n20 VSS 0.29064f
C578 iqmod_mfb_lpf_pex_half_1.iqmod_mfb_lpf_pex_ota_core_hybrid_bm_half_0.iqmod_mfb_lpf_pex_ota_core_inv_NF6$1_1.vout.n21 VSS 0.08228f
C579 iqmod_mfb_lpf_pex_half_1.iqmod_mfb_lpf_pex_ota_core_hybrid_bm_half_0.iqmod_mfb_lpf_pex_ota_core_inv_NF6$1_1.vout.n22 VSS 0.08228f
C580 iqmod_mfb_lpf_pex_half_1.iqmod_mfb_lpf_pex_ota_core_hybrid_bm_half_0.iqmod_mfb_lpf_pex_ota_core_inv_NF6$1_1.vout.n23 VSS 0.31835f
C581 iqmod_mfb_lpf_pex_half_1.iqmod_mfb_lpf_pex_ota_core_hybrid_bm_half_0.iqmod_mfb_lpf_pex_ota_core_inv_NF6$1_1.vout.t4 VSS 0.13545f
C582 iqmod_mfb_lpf_pex_half_1.iqmod_mfb_lpf_pex_ota_core_hybrid_bm_half_0.iqmod_mfb_lpf_pex_ota_core_inv_NF6$1_1.vout.t1 VSS 0.97162f
C583 iqmod_mfb_lpf_pex_half_1.iqmod_mfb_lpf_pex_ota_core_hybrid_bm_half_0.iqmod_mfb_lpf_pex_ota_core_inv_NF6$1_1.vout.n24 VSS 1.45968f
C584 iqmod_mfb_lpf_pex_half_1.iqmod_mfb_lpf_pex_ota_core_hybrid_bm_half_0.iqmod_mfb_lpf_pex_ota_core_inv_NF6$1_1.vout.t3 VSS 0.13545f
C585 iqmod_mfb_lpf_pex_half_1.iqmod_mfb_lpf_pex_ota_core_hybrid_bm_half_0.iqmod_mfb_lpf_pex_ota_core_inv_NF6$1_1.vout.t0 VSS 0.97162f
C586 iqmod_mfb_lpf_pex_half_1.iqmod_mfb_lpf_pex_ota_core_hybrid_bm_half_0.iqmod_mfb_lpf_pex_ota_core_inv_NF6$1_1.vout.n25 VSS 1.91319f
C587 iqmod_mfb_lpf_pex_half_1.iqmod_mfb_lpf_pex_ota_core_hybrid_bm_half_0.iqmod_mfb_lpf_pex_ota_core_inv_NF6$1_1.vout.t5 VSS 0.13545f
C588 iqmod_mfb_lpf_pex_half_1.iqmod_mfb_lpf_pex_ota_core_hybrid_bm_half_0.iqmod_mfb_lpf_pex_ota_core_inv_NF6$1_1.vout.t2 VSS 0.97162f
C589 iqmod_mfb_lpf_pex_half_1.iqmod_mfb_lpf_pex_ota_core_hybrid_bm_half_0.iqmod_mfb_lpf_pex_ota_core_inv_NF6$1_1.vout.t11 VSS 0.19962f
C590 iqmod_mfb_lpf_pex_half_1.iqmod_mfb_lpf_pex_ota_core_hybrid_bm_half_0.iqmod_mfb_lpf_pex_ota_core_inv_NF6$1_1.vout.t17 VSS 1.4174f
C591 iqmod_mfb_lpf_pex_half_1.iqmod_mfb_lpf_pex_ota_core_hybrid_bm_half_0.iqmod_mfb_lpf_pex_ota_core_inv_NF6$1_1.vout.n26 VSS 3.52049f
C592 iqmod_mfb_lpf_pex_half_1.iqmod_mfb_lpf_pex_ota_core_hybrid_bm_half_0.iqmod_mfb_lpf_pex_ota_core_inv_NF6$1_1.vout.t10 VSS 0.19962f
C593 iqmod_mfb_lpf_pex_half_1.iqmod_mfb_lpf_pex_ota_core_hybrid_bm_half_0.iqmod_mfb_lpf_pex_ota_core_inv_NF6$1_1.vout.t16 VSS 1.4174f
C594 iqmod_mfb_lpf_pex_half_1.iqmod_mfb_lpf_pex_ota_core_hybrid_bm_half_0.iqmod_mfb_lpf_pex_ota_core_inv_NF6$1_1.vout.n27 VSS 3.95346f
C595 iqmod_mfb_lpf_pex_half_1.iqmod_mfb_lpf_pex_ota_core_hybrid_bm_half_0.iqmod_mfb_lpf_pex_ota_core_inv_NF6$1_1.vout.t9 VSS 0.19962f
C596 iqmod_mfb_lpf_pex_half_1.iqmod_mfb_lpf_pex_ota_core_hybrid_bm_half_0.iqmod_mfb_lpf_pex_ota_core_inv_NF6$1_1.vout.t15 VSS 1.41797f
C597 iqmod_mfb_lpf_pex_half_1.iqmod_mfb_lpf_pex_ota_core_hybrid_bm_half_0.iqmod_mfb_lpf_pex_ota_core_inv_NF6$1_1.vout.n28 VSS 4.18527f
C598 iqmod_mfb_lpf_pex_half_1.iqmod_mfb_lpf_pex_ota_core_hybrid_bm_half_0.iqmod_mfb_lpf_pex_ota_core_inv_NF6$1_1.vout.t20 VSS 1.4174f
C599 iqmod_mfb_lpf_pex_half_1.iqmod_mfb_lpf_pex_ota_core_hybrid_bm_half_0.iqmod_mfb_lpf_pex_ota_core_inv_NF6$1_1.vout.t14 VSS 0.19962f
C600 iqmod_mfb_lpf_pex_half_1.iqmod_mfb_lpf_pex_ota_core_hybrid_bm_half_0.iqmod_mfb_lpf_pex_ota_core_inv_NF6$1_1.vout.n29 VSS 3.52049f
C601 iqmod_mfb_lpf_pex_half_1.iqmod_mfb_lpf_pex_ota_core_hybrid_bm_half_0.iqmod_mfb_lpf_pex_ota_core_inv_NF6$1_1.vout.t19 VSS 1.4174f
C602 iqmod_mfb_lpf_pex_half_1.iqmod_mfb_lpf_pex_ota_core_hybrid_bm_half_0.iqmod_mfb_lpf_pex_ota_core_inv_NF6$1_1.vout.t13 VSS 0.19962f
C603 iqmod_mfb_lpf_pex_half_1.iqmod_mfb_lpf_pex_ota_core_hybrid_bm_half_0.iqmod_mfb_lpf_pex_ota_core_inv_NF6$1_1.vout.n30 VSS 3.95346f
C604 iqmod_mfb_lpf_pex_half_1.iqmod_mfb_lpf_pex_ota_core_hybrid_bm_half_0.iqmod_mfb_lpf_pex_ota_core_inv_NF6$1_1.vout.t18 VSS 1.4174f
C605 iqmod_mfb_lpf_pex_half_1.iqmod_mfb_lpf_pex_ota_core_hybrid_bm_half_0.iqmod_mfb_lpf_pex_ota_core_inv_NF6$1_1.vout.t12 VSS 0.19962f
C606 iqmod_mfb_lpf_pex_half_1.iqmod_mfb_lpf_pex_ota_core_hybrid_bm_half_0.iqmod_mfb_lpf_pex_ota_core_inv_NF6$1_1.vout.n31 VSS 4.18584f
C607 iqmod_mfb_lpf_pex_half_1.iqmod_mfb_lpf_pex_ota_core_hybrid_bm_half_0.iqmod_mfb_lpf_pex_ota_core_inv_NF6$1_1.vout.t22 VSS 0.97162f
C608 iqmod_mfb_lpf_pex_half_1.iqmod_mfb_lpf_pex_ota_core_hybrid_bm_half_0.iqmod_mfb_lpf_pex_ota_core_inv_NF6$1_1.vout.t7 VSS 0.13545f
C609 iqmod_mfb_lpf_pex_half_1.iqmod_mfb_lpf_pex_ota_core_hybrid_bm_half_0.iqmod_mfb_lpf_pex_ota_core_inv_NF6$1_1.vout.n32 VSS 1.45968f
C610 iqmod_mfb_lpf_pex_half_1.iqmod_mfb_lpf_pex_ota_core_hybrid_bm_half_0.iqmod_mfb_lpf_pex_ota_core_inv_NF6$1_1.vout.t21 VSS 0.97162f
C611 iqmod_mfb_lpf_pex_half_1.iqmod_mfb_lpf_pex_ota_core_hybrid_bm_half_0.iqmod_mfb_lpf_pex_ota_core_inv_NF6$1_1.vout.t6 VSS 0.13545f
C612 iqmod_mfb_lpf_pex_half_1.iqmod_mfb_lpf_pex_ota_core_hybrid_bm_half_0.iqmod_mfb_lpf_pex_ota_core_inv_NF6$1_1.vout.n33 VSS 1.91319f
C613 iqmod_mfb_lpf_pex_half_1.iqmod_mfb_lpf_pex_ota_core_hybrid_bm_half_0.iqmod_mfb_lpf_pex_ota_core_inv_NF6$1_1.vout.t23 VSS 0.97162f
C614 iqmod_mfb_lpf_pex_half_1.iqmod_mfb_lpf_pex_ota_core_hybrid_bm_half_0.iqmod_mfb_lpf_pex_ota_core_inv_NF20$1_0.vout.t21 VSS 0.17197f
C615 iqmod_mfb_lpf_pex_half_1.iqmod_mfb_lpf_pex_ota_core_hybrid_bm_half_0.iqmod_mfb_lpf_pex_ota_core_inv_NF20$1_0.vout.t31 VSS 1.23102f
C616 iqmod_mfb_lpf_pex_half_1.iqmod_mfb_lpf_pex_ota_core_hybrid_bm_half_0.iqmod_mfb_lpf_pex_ota_core_inv_NF20$1_0.vout.n0 VSS 3.02285f
C617 iqmod_mfb_lpf_pex_half_1.iqmod_mfb_lpf_pex_ota_core_hybrid_bm_half_0.iqmod_mfb_lpf_pex_ota_core_inv_NF20$1_0.vout.t11 VSS 0.09039f
C618 iqmod_mfb_lpf_pex_half_1.iqmod_mfb_lpf_pex_ota_core_hybrid_bm_half_0.iqmod_mfb_lpf_pex_ota_core_inv_NF20$1_0.vout.t3 VSS 0.68255f
C619 iqmod_mfb_lpf_pex_half_1.iqmod_mfb_lpf_pex_ota_core_hybrid_bm_half_0.iqmod_mfb_lpf_pex_ota_core_inv_NF20$1_0.vout.n1 VSS 0.94694f
C620 iqmod_mfb_lpf_pex_half_1.iqmod_mfb_lpf_pex_ota_core_hybrid_bm_half_0.iqmod_mfb_lpf_pex_ota_core_inv_NF20$1_0.vout.t10 VSS 0.09831f
C621 iqmod_mfb_lpf_pex_half_1.iqmod_mfb_lpf_pex_ota_core_hybrid_bm_half_0.iqmod_mfb_lpf_pex_ota_core_inv_NF20$1_0.vout.t2 VSS 0.73009f
C622 iqmod_mfb_lpf_pex_half_1.iqmod_mfb_lpf_pex_ota_core_hybrid_bm_half_0.iqmod_mfb_lpf_pex_ota_core_inv_NF20$1_0.vout.n2 VSS 0.5698f
C623 iqmod_mfb_lpf_pex_half_1.iqmod_mfb_lpf_pex_ota_core_hybrid_bm_half_0.iqmod_mfb_lpf_pex_ota_core_inv_NF20$1_0.vout.t9 VSS 0.09831f
C624 iqmod_mfb_lpf_pex_half_1.iqmod_mfb_lpf_pex_ota_core_hybrid_bm_half_0.iqmod_mfb_lpf_pex_ota_core_inv_NF20$1_0.vout.t1 VSS 0.73009f
C625 iqmod_mfb_lpf_pex_half_1.iqmod_mfb_lpf_pex_ota_core_hybrid_bm_half_0.iqmod_mfb_lpf_pex_ota_core_inv_NF20$1_0.vout.n3 VSS 0.5698f
C626 iqmod_mfb_lpf_pex_half_1.iqmod_mfb_lpf_pex_ota_core_hybrid_bm_half_0.iqmod_mfb_lpf_pex_ota_core_inv_NF20$1_0.vout.t8 VSS 0.09039f
C627 iqmod_mfb_lpf_pex_half_1.iqmod_mfb_lpf_pex_ota_core_hybrid_bm_half_0.iqmod_mfb_lpf_pex_ota_core_inv_NF20$1_0.vout.t0 VSS 0.68264f
C628 iqmod_mfb_lpf_pex_half_1.iqmod_mfb_lpf_pex_ota_core_hybrid_bm_half_0.iqmod_mfb_lpf_pex_ota_core_inv_NF20$1_0.vout.n4 VSS 0.47905f
C629 iqmod_mfb_lpf_pex_half_1.iqmod_mfb_lpf_pex_ota_core_hybrid_bm_half_0.iqmod_mfb_lpf_pex_ota_core_inv_NF20$1_0.vout.n5 VSS 0.72699f
C630 iqmod_mfb_lpf_pex_half_1.iqmod_mfb_lpf_pex_ota_core_hybrid_bm_half_0.iqmod_mfb_lpf_pex_ota_core_inv_NF20$1_0.vout.n6 VSS 0.2986f
C631 iqmod_mfb_lpf_pex_half_1.iqmod_mfb_lpf_pex_ota_core_hybrid_bm_half_0.iqmod_mfb_lpf_pex_ota_core_inv_NF20$1_0.vout.n7 VSS 0.2986f
C632 iqmod_mfb_lpf_pex_half_1.iqmod_mfb_lpf_pex_ota_core_hybrid_bm_half_0.iqmod_mfb_lpf_pex_ota_core_inv_NF20$1_0.vout.n8 VSS 0.2986f
C633 iqmod_mfb_lpf_pex_half_1.iqmod_mfb_lpf_pex_ota_core_hybrid_bm_half_0.iqmod_mfb_lpf_pex_ota_core_inv_NF20$1_0.vout.t58 VSS 1.81473f
C634 iqmod_mfb_lpf_pex_half_1.iqmod_mfb_lpf_pex_ota_core_hybrid_bm_half_0.iqmod_mfb_lpf_pex_ota_core_inv_NF20$1_0.vout.n9 VSS 0.20742f
C635 iqmod_mfb_lpf_pex_half_1.iqmod_mfb_lpf_pex_ota_core_hybrid_bm_half_0.iqmod_mfb_lpf_pex_ota_core_inv_NF20$1_0.vout.n10 VSS 0.09236f
C636 iqmod_mfb_lpf_pex_half_1.iqmod_mfb_lpf_pex_ota_core_hybrid_bm_half_0.iqmod_mfb_lpf_pex_ota_core_inv_NF20$1_0.vout.n11 VSS 0.09236f
C637 iqmod_mfb_lpf_pex_half_1.iqmod_mfb_lpf_pex_ota_core_hybrid_bm_half_0.iqmod_mfb_lpf_pex_ota_core_inv_NF20$1_0.vout.t59 VSS 7.75877f
C638 iqmod_mfb_lpf_pex_half_1.iqmod_mfb_lpf_pex_ota_core_hybrid_bm_half_0.iqmod_mfb_lpf_pex_ota_core_inv_NF20$1_0.vout.n12 VSS 0.25038f
C639 iqmod_mfb_lpf_pex_half_1.iqmod_mfb_lpf_pex_ota_core_hybrid_bm_half_0.iqmod_mfb_lpf_pex_ota_core_inv_NF20$1_0.vout.n13 VSS 0.07088f
C640 iqmod_mfb_lpf_pex_half_1.iqmod_mfb_lpf_pex_ota_core_hybrid_bm_half_0.iqmod_mfb_lpf_pex_ota_core_inv_NF20$1_0.vout.n14 VSS 0.07088f
C641 iqmod_mfb_lpf_pex_half_1.iqmod_mfb_lpf_pex_ota_core_hybrid_bm_half_0.iqmod_mfb_lpf_pex_ota_core_inv_NF20$1_0.vout.n15 VSS 0.27426f
C642 iqmod_mfb_lpf_pex_half_1.iqmod_mfb_lpf_pex_ota_core_hybrid_bm_half_0.iqmod_mfb_lpf_pex_ota_core_inv_NF20$1_0.vout.n16 VSS 1.66488f
C643 iqmod_mfb_lpf_pex_half_1.iqmod_mfb_lpf_pex_ota_core_hybrid_bm_half_0.iqmod_mfb_lpf_pex_ota_core_inv_NF20$1_0.vout.n17 VSS 1.66488f
C644 iqmod_mfb_lpf_pex_half_1.iqmod_mfb_lpf_pex_ota_core_hybrid_bm_half_0.iqmod_mfb_lpf_pex_ota_core_inv_NF20$1_0.vout.t35 VSS 0.68255f
C645 iqmod_mfb_lpf_pex_half_1.iqmod_mfb_lpf_pex_ota_core_hybrid_bm_half_0.iqmod_mfb_lpf_pex_ota_core_inv_NF20$1_0.vout.t5 VSS 0.09039f
C646 iqmod_mfb_lpf_pex_half_1.iqmod_mfb_lpf_pex_ota_core_hybrid_bm_half_0.iqmod_mfb_lpf_pex_ota_core_inv_NF20$1_0.vout.n18 VSS 0.94694f
C647 iqmod_mfb_lpf_pex_half_1.iqmod_mfb_lpf_pex_ota_core_hybrid_bm_half_0.iqmod_mfb_lpf_pex_ota_core_inv_NF20$1_0.vout.t33 VSS 0.73009f
C648 iqmod_mfb_lpf_pex_half_1.iqmod_mfb_lpf_pex_ota_core_hybrid_bm_half_0.iqmod_mfb_lpf_pex_ota_core_inv_NF20$1_0.vout.t4 VSS 0.09831f
C649 iqmod_mfb_lpf_pex_half_1.iqmod_mfb_lpf_pex_ota_core_hybrid_bm_half_0.iqmod_mfb_lpf_pex_ota_core_inv_NF20$1_0.vout.n19 VSS 0.5698f
C650 iqmod_mfb_lpf_pex_half_1.iqmod_mfb_lpf_pex_ota_core_hybrid_bm_half_0.iqmod_mfb_lpf_pex_ota_core_inv_NF20$1_0.vout.t32 VSS 0.73009f
C651 iqmod_mfb_lpf_pex_half_1.iqmod_mfb_lpf_pex_ota_core_hybrid_bm_half_0.iqmod_mfb_lpf_pex_ota_core_inv_NF20$1_0.vout.t7 VSS 0.09831f
C652 iqmod_mfb_lpf_pex_half_1.iqmod_mfb_lpf_pex_ota_core_hybrid_bm_half_0.iqmod_mfb_lpf_pex_ota_core_inv_NF20$1_0.vout.n20 VSS 0.5698f
C653 iqmod_mfb_lpf_pex_half_1.iqmod_mfb_lpf_pex_ota_core_hybrid_bm_half_0.iqmod_mfb_lpf_pex_ota_core_inv_NF20$1_0.vout.t34 VSS 0.68255f
C654 iqmod_mfb_lpf_pex_half_1.iqmod_mfb_lpf_pex_ota_core_hybrid_bm_half_0.iqmod_mfb_lpf_pex_ota_core_inv_NF20$1_0.vout.t6 VSS 0.09039f
C655 iqmod_mfb_lpf_pex_half_1.iqmod_mfb_lpf_pex_ota_core_hybrid_bm_half_0.iqmod_mfb_lpf_pex_ota_core_inv_NF20$1_0.vout.n21 VSS 0.47913f
C656 iqmod_mfb_lpf_pex_half_1.iqmod_mfb_lpf_pex_ota_core_hybrid_bm_half_0.iqmod_mfb_lpf_pex_ota_core_inv_NF20$1_0.vout.n22 VSS 0.72699f
C657 iqmod_mfb_lpf_pex_half_1.iqmod_mfb_lpf_pex_ota_core_hybrid_bm_half_0.iqmod_mfb_lpf_pex_ota_core_inv_NF20$1_0.vout.n23 VSS 0.2986f
C658 iqmod_mfb_lpf_pex_half_1.iqmod_mfb_lpf_pex_ota_core_hybrid_bm_half_0.iqmod_mfb_lpf_pex_ota_core_inv_NF20$1_0.vout.n24 VSS 0.2986f
C659 iqmod_mfb_lpf_pex_half_1.iqmod_mfb_lpf_pex_ota_core_hybrid_bm_half_0.iqmod_mfb_lpf_pex_ota_core_inv_NF20$1_0.vout.n25 VSS 0.2986f
C660 iqmod_mfb_lpf_pex_half_1.iqmod_mfb_lpf_pex_ota_core_hybrid_bm_half_0.iqmod_mfb_lpf_pex_ota_core_inv_NF20$1_0.vout.t56 VSS 7.75877f
C661 iqmod_mfb_lpf_pex_half_1.iqmod_mfb_lpf_pex_ota_core_hybrid_bm_half_0.iqmod_mfb_lpf_pex_ota_core_inv_NF20$1_0.vout.n26 VSS 0.20742f
C662 iqmod_mfb_lpf_pex_half_1.iqmod_mfb_lpf_pex_ota_core_hybrid_bm_half_0.iqmod_mfb_lpf_pex_ota_core_inv_NF20$1_0.vout.n27 VSS 0.09236f
C663 iqmod_mfb_lpf_pex_half_1.iqmod_mfb_lpf_pex_ota_core_hybrid_bm_half_0.iqmod_mfb_lpf_pex_ota_core_inv_NF20$1_0.vout.n28 VSS 0.09236f
C664 iqmod_mfb_lpf_pex_half_1.iqmod_mfb_lpf_pex_ota_core_hybrid_bm_half_0.iqmod_mfb_lpf_pex_ota_core_inv_NF20$1_0.vout.t57 VSS 1.81473f
C665 iqmod_mfb_lpf_pex_half_1.iqmod_mfb_lpf_pex_ota_core_hybrid_bm_half_0.iqmod_mfb_lpf_pex_ota_core_inv_NF20$1_0.vout.n29 VSS 0.25038f
C666 iqmod_mfb_lpf_pex_half_1.iqmod_mfb_lpf_pex_ota_core_hybrid_bm_half_0.iqmod_mfb_lpf_pex_ota_core_inv_NF20$1_0.vout.n30 VSS 0.07088f
C667 iqmod_mfb_lpf_pex_half_1.iqmod_mfb_lpf_pex_ota_core_hybrid_bm_half_0.iqmod_mfb_lpf_pex_ota_core_inv_NF20$1_0.vout.n31 VSS 0.07088f
C668 iqmod_mfb_lpf_pex_half_1.iqmod_mfb_lpf_pex_ota_core_hybrid_bm_half_0.iqmod_mfb_lpf_pex_ota_core_inv_NF20$1_0.vout.n32 VSS 0.27426f
C669 iqmod_mfb_lpf_pex_half_1.iqmod_mfb_lpf_pex_ota_core_hybrid_bm_half_0.iqmod_mfb_lpf_pex_ota_core_inv_NF20$1_0.vout.t55 VSS 1.23112f
C670 iqmod_mfb_lpf_pex_half_1.iqmod_mfb_lpf_pex_ota_core_hybrid_bm_half_0.iqmod_mfb_lpf_pex_ota_core_inv_NF20$1_0.vout.t45 VSS 0.17197f
C671 iqmod_mfb_lpf_pex_half_1.iqmod_mfb_lpf_pex_ota_core_hybrid_bm_half_0.iqmod_mfb_lpf_pex_ota_core_inv_NF20$1_0.vout.n33 VSS 3.02275f
C672 iqmod_mfb_lpf_pex_half_1.iqmod_mfb_lpf_pex_ota_core_hybrid_bm_half_0.iqmod_mfb_lpf_pex_ota_core_inv_NF20$1_0.vout.t54 VSS 1.23112f
C673 iqmod_mfb_lpf_pex_half_1.iqmod_mfb_lpf_pex_ota_core_hybrid_bm_half_0.iqmod_mfb_lpf_pex_ota_core_inv_NF20$1_0.vout.t44 VSS 0.17197f
C674 iqmod_mfb_lpf_pex_half_1.iqmod_mfb_lpf_pex_ota_core_hybrid_bm_half_0.iqmod_mfb_lpf_pex_ota_core_inv_NF20$1_0.vout.n34 VSS 3.39574f
C675 iqmod_mfb_lpf_pex_half_1.iqmod_mfb_lpf_pex_ota_core_hybrid_bm_half_0.iqmod_mfb_lpf_pex_ota_core_inv_NF20$1_0.vout.t53 VSS 1.23112f
C676 iqmod_mfb_lpf_pex_half_1.iqmod_mfb_lpf_pex_ota_core_hybrid_bm_half_0.iqmod_mfb_lpf_pex_ota_core_inv_NF20$1_0.vout.t43 VSS 0.17197f
C677 iqmod_mfb_lpf_pex_half_1.iqmod_mfb_lpf_pex_ota_core_hybrid_bm_half_0.iqmod_mfb_lpf_pex_ota_core_inv_NF20$1_0.vout.n35 VSS 3.39574f
C678 iqmod_mfb_lpf_pex_half_1.iqmod_mfb_lpf_pex_ota_core_hybrid_bm_half_0.iqmod_mfb_lpf_pex_ota_core_inv_NF20$1_0.vout.t52 VSS 1.23112f
C679 iqmod_mfb_lpf_pex_half_1.iqmod_mfb_lpf_pex_ota_core_hybrid_bm_half_0.iqmod_mfb_lpf_pex_ota_core_inv_NF20$1_0.vout.t42 VSS 0.17197f
C680 iqmod_mfb_lpf_pex_half_1.iqmod_mfb_lpf_pex_ota_core_hybrid_bm_half_0.iqmod_mfb_lpf_pex_ota_core_inv_NF20$1_0.vout.n36 VSS 3.39574f
C681 iqmod_mfb_lpf_pex_half_1.iqmod_mfb_lpf_pex_ota_core_hybrid_bm_half_0.iqmod_mfb_lpf_pex_ota_core_inv_NF20$1_0.vout.t51 VSS 1.23112f
C682 iqmod_mfb_lpf_pex_half_1.iqmod_mfb_lpf_pex_ota_core_hybrid_bm_half_0.iqmod_mfb_lpf_pex_ota_core_inv_NF20$1_0.vout.t41 VSS 0.17197f
C683 iqmod_mfb_lpf_pex_half_1.iqmod_mfb_lpf_pex_ota_core_hybrid_bm_half_0.iqmod_mfb_lpf_pex_ota_core_inv_NF20$1_0.vout.n37 VSS 3.39574f
C684 iqmod_mfb_lpf_pex_half_1.iqmod_mfb_lpf_pex_ota_core_hybrid_bm_half_0.iqmod_mfb_lpf_pex_ota_core_inv_NF20$1_0.vout.t50 VSS 1.22106f
C685 iqmod_mfb_lpf_pex_half_1.iqmod_mfb_lpf_pex_ota_core_hybrid_bm_half_0.iqmod_mfb_lpf_pex_ota_core_inv_NF20$1_0.vout.t40 VSS 0.17197f
C686 iqmod_mfb_lpf_pex_half_1.iqmod_mfb_lpf_pex_ota_core_hybrid_bm_half_0.iqmod_mfb_lpf_pex_ota_core_inv_NF20$1_0.vout.n38 VSS 3.4058f
C687 iqmod_mfb_lpf_pex_half_1.iqmod_mfb_lpf_pex_ota_core_hybrid_bm_half_0.iqmod_mfb_lpf_pex_ota_core_inv_NF20$1_0.vout.t49 VSS 1.22106f
C688 iqmod_mfb_lpf_pex_half_1.iqmod_mfb_lpf_pex_ota_core_hybrid_bm_half_0.iqmod_mfb_lpf_pex_ota_core_inv_NF20$1_0.vout.t39 VSS 0.17197f
C689 iqmod_mfb_lpf_pex_half_1.iqmod_mfb_lpf_pex_ota_core_hybrid_bm_half_0.iqmod_mfb_lpf_pex_ota_core_inv_NF20$1_0.vout.n39 VSS 3.4058f
C690 iqmod_mfb_lpf_pex_half_1.iqmod_mfb_lpf_pex_ota_core_hybrid_bm_half_0.iqmod_mfb_lpf_pex_ota_core_inv_NF20$1_0.vout.t48 VSS 1.22106f
C691 iqmod_mfb_lpf_pex_half_1.iqmod_mfb_lpf_pex_ota_core_hybrid_bm_half_0.iqmod_mfb_lpf_pex_ota_core_inv_NF20$1_0.vout.t38 VSS 0.17197f
C692 iqmod_mfb_lpf_pex_half_1.iqmod_mfb_lpf_pex_ota_core_hybrid_bm_half_0.iqmod_mfb_lpf_pex_ota_core_inv_NF20$1_0.vout.n40 VSS 3.4058f
C693 iqmod_mfb_lpf_pex_half_1.iqmod_mfb_lpf_pex_ota_core_hybrid_bm_half_0.iqmod_mfb_lpf_pex_ota_core_inv_NF20$1_0.vout.t47 VSS 1.22106f
C694 iqmod_mfb_lpf_pex_half_1.iqmod_mfb_lpf_pex_ota_core_hybrid_bm_half_0.iqmod_mfb_lpf_pex_ota_core_inv_NF20$1_0.vout.t37 VSS 0.17197f
C695 iqmod_mfb_lpf_pex_half_1.iqmod_mfb_lpf_pex_ota_core_hybrid_bm_half_0.iqmod_mfb_lpf_pex_ota_core_inv_NF20$1_0.vout.n41 VSS 3.4058f
C696 iqmod_mfb_lpf_pex_half_1.iqmod_mfb_lpf_pex_ota_core_hybrid_bm_half_0.iqmod_mfb_lpf_pex_ota_core_inv_NF20$1_0.vout.t46 VSS 1.22106f
C697 iqmod_mfb_lpf_pex_half_1.iqmod_mfb_lpf_pex_ota_core_hybrid_bm_half_0.iqmod_mfb_lpf_pex_ota_core_inv_NF20$1_0.vout.t36 VSS 0.17197f
C698 iqmod_mfb_lpf_pex_half_1.iqmod_mfb_lpf_pex_ota_core_hybrid_bm_half_0.iqmod_mfb_lpf_pex_ota_core_inv_NF20$1_0.vout.n42 VSS 3.32932f
C699 iqmod_mfb_lpf_pex_half_1.iqmod_mfb_lpf_pex_ota_core_hybrid_bm_half_0.iqmod_mfb_lpf_pex_ota_core_inv_NF20$1_0.vout.t20 VSS 0.17197f
C700 iqmod_mfb_lpf_pex_half_1.iqmod_mfb_lpf_pex_ota_core_hybrid_bm_half_0.iqmod_mfb_lpf_pex_ota_core_inv_NF20$1_0.vout.t30 VSS 1.23102f
C701 iqmod_mfb_lpf_pex_half_1.iqmod_mfb_lpf_pex_ota_core_hybrid_bm_half_0.iqmod_mfb_lpf_pex_ota_core_inv_NF20$1_0.vout.n43 VSS 3.39584f
C702 iqmod_mfb_lpf_pex_half_1.iqmod_mfb_lpf_pex_ota_core_hybrid_bm_half_0.iqmod_mfb_lpf_pex_ota_core_inv_NF20$1_0.vout.t19 VSS 0.17197f
C703 iqmod_mfb_lpf_pex_half_1.iqmod_mfb_lpf_pex_ota_core_hybrid_bm_half_0.iqmod_mfb_lpf_pex_ota_core_inv_NF20$1_0.vout.t29 VSS 1.23102f
C704 iqmod_mfb_lpf_pex_half_1.iqmod_mfb_lpf_pex_ota_core_hybrid_bm_half_0.iqmod_mfb_lpf_pex_ota_core_inv_NF20$1_0.vout.n44 VSS 3.39584f
C705 iqmod_mfb_lpf_pex_half_1.iqmod_mfb_lpf_pex_ota_core_hybrid_bm_half_0.iqmod_mfb_lpf_pex_ota_core_inv_NF20$1_0.vout.t18 VSS 0.17197f
C706 iqmod_mfb_lpf_pex_half_1.iqmod_mfb_lpf_pex_ota_core_hybrid_bm_half_0.iqmod_mfb_lpf_pex_ota_core_inv_NF20$1_0.vout.t28 VSS 1.23102f
C707 iqmod_mfb_lpf_pex_half_1.iqmod_mfb_lpf_pex_ota_core_hybrid_bm_half_0.iqmod_mfb_lpf_pex_ota_core_inv_NF20$1_0.vout.n45 VSS 3.39584f
C708 iqmod_mfb_lpf_pex_half_1.iqmod_mfb_lpf_pex_ota_core_hybrid_bm_half_0.iqmod_mfb_lpf_pex_ota_core_inv_NF20$1_0.vout.t17 VSS 0.17197f
C709 iqmod_mfb_lpf_pex_half_1.iqmod_mfb_lpf_pex_ota_core_hybrid_bm_half_0.iqmod_mfb_lpf_pex_ota_core_inv_NF20$1_0.vout.t27 VSS 1.23102f
C710 iqmod_mfb_lpf_pex_half_1.iqmod_mfb_lpf_pex_ota_core_hybrid_bm_half_0.iqmod_mfb_lpf_pex_ota_core_inv_NF20$1_0.vout.n46 VSS 3.39584f
C711 iqmod_mfb_lpf_pex_half_1.iqmod_mfb_lpf_pex_ota_core_hybrid_bm_half_0.iqmod_mfb_lpf_pex_ota_core_inv_NF20$1_0.vout.t16 VSS 0.17197f
C712 iqmod_mfb_lpf_pex_half_1.iqmod_mfb_lpf_pex_ota_core_hybrid_bm_half_0.iqmod_mfb_lpf_pex_ota_core_inv_NF20$1_0.vout.t26 VSS 1.22106f
C713 iqmod_mfb_lpf_pex_half_1.iqmod_mfb_lpf_pex_ota_core_hybrid_bm_half_0.iqmod_mfb_lpf_pex_ota_core_inv_NF20$1_0.vout.n47 VSS 3.4058f
C714 iqmod_mfb_lpf_pex_half_1.iqmod_mfb_lpf_pex_ota_core_hybrid_bm_half_0.iqmod_mfb_lpf_pex_ota_core_inv_NF20$1_0.vout.t15 VSS 0.17197f
C715 iqmod_mfb_lpf_pex_half_1.iqmod_mfb_lpf_pex_ota_core_hybrid_bm_half_0.iqmod_mfb_lpf_pex_ota_core_inv_NF20$1_0.vout.t25 VSS 1.22106f
C716 iqmod_mfb_lpf_pex_half_1.iqmod_mfb_lpf_pex_ota_core_hybrid_bm_half_0.iqmod_mfb_lpf_pex_ota_core_inv_NF20$1_0.vout.n48 VSS 3.4058f
C717 iqmod_mfb_lpf_pex_half_1.iqmod_mfb_lpf_pex_ota_core_hybrid_bm_half_0.iqmod_mfb_lpf_pex_ota_core_inv_NF20$1_0.vout.t14 VSS 0.17197f
C718 iqmod_mfb_lpf_pex_half_1.iqmod_mfb_lpf_pex_ota_core_hybrid_bm_half_0.iqmod_mfb_lpf_pex_ota_core_inv_NF20$1_0.vout.t24 VSS 1.22106f
C719 iqmod_mfb_lpf_pex_half_1.iqmod_mfb_lpf_pex_ota_core_hybrid_bm_half_0.iqmod_mfb_lpf_pex_ota_core_inv_NF20$1_0.vout.n49 VSS 3.4058f
C720 iqmod_mfb_lpf_pex_half_1.iqmod_mfb_lpf_pex_ota_core_hybrid_bm_half_0.iqmod_mfb_lpf_pex_ota_core_inv_NF20$1_0.vout.t13 VSS 0.17197f
C721 iqmod_mfb_lpf_pex_half_1.iqmod_mfb_lpf_pex_ota_core_hybrid_bm_half_0.iqmod_mfb_lpf_pex_ota_core_inv_NF20$1_0.vout.t23 VSS 1.22106f
C722 iqmod_mfb_lpf_pex_half_1.iqmod_mfb_lpf_pex_ota_core_hybrid_bm_half_0.iqmod_mfb_lpf_pex_ota_core_inv_NF20$1_0.vout.n50 VSS 3.4058f
C723 iqmod_mfb_lpf_pex_half_1.iqmod_mfb_lpf_pex_ota_core_hybrid_bm_half_0.iqmod_mfb_lpf_pex_ota_core_inv_NF20$1_0.vout.t12 VSS 0.17197f
C724 iqmod_mfb_lpf_pex_half_1.iqmod_mfb_lpf_pex_ota_core_hybrid_bm_half_0.iqmod_mfb_lpf_pex_ota_core_inv_NF20$1_0.vout.t22 VSS 1.22106f
C725 iqmod_mfb_lpf_pex_half_1.iqmod_mfb_lpf_pex_ota_core_hybrid_bm_half_0.iqmod_mfb_lpf_pex_ota_core_inv_NF20$1_0.vout.n51 VSS 3.32932f
C726 iqmod_mfb_lpf_pex_half_1.iqmod_mfb_lpf_pex_ota_core_hybrid_bm_half_0.iqmod_mfb_lpf_pex_ota_core_tg$1_0.di_tg_ctrl_n.t0 VSS 0.35561f
C727 iqmod_mfb_lpf_pex_half_1.iqmod_mfb_lpf_pex_ota_core_hybrid_bm_half_0.iqmod_mfb_lpf_pex_ota_core_tg$1_0.di_tg_ctrl_n.t5 VSS 1.09265f
C728 iqmod_mfb_lpf_pex_half_1.iqmod_mfb_lpf_pex_ota_core_hybrid_bm_half_0.iqmod_mfb_lpf_pex_ota_core_tg$1_0.di_tg_ctrl_n.t8 VSS 0.30765f
C729 iqmod_mfb_lpf_pex_half_1.iqmod_mfb_lpf_pex_ota_core_hybrid_bm_half_0.iqmod_mfb_lpf_pex_ota_core_tg$1_0.di_tg_ctrl_n.n0 VSS 0.36577f
C730 iqmod_mfb_lpf_pex_half_1.iqmod_mfb_lpf_pex_ota_core_hybrid_bm_half_0.iqmod_mfb_lpf_pex_ota_core_tg$1_0.di_tg_ctrl_n.n1 VSS 1.89831f
C731 iqmod_mfb_lpf_pex_half_1.iqmod_mfb_lpf_pex_ota_core_hybrid_bm_half_0.iqmod_mfb_lpf_pex_ota_core_tg$1_0.di_tg_ctrl_n.n2 VSS 0.1407f
C732 iqmod_mfb_lpf_pex_half_1.iqmod_mfb_lpf_pex_ota_core_hybrid_bm_half_0.iqmod_mfb_lpf_pex_ota_core_tg$1_0.di_tg_ctrl_n.t7 VSS 0.83273f
C733 iqmod_mfb_lpf_pex_half_1.iqmod_mfb_lpf_pex_ota_core_hybrid_bm_half_0.iqmod_mfb_lpf_pex_ota_core_tg$1_0.di_tg_ctrl_n.t6 VSS 0.14372f
C734 iqmod_mfb_lpf_pex_half_1.iqmod_mfb_lpf_pex_ota_core_hybrid_bm_half_0.iqmod_mfb_lpf_pex_ota_core_tg$1_0.di_tg_ctrl_n.n3 VSS 2.92857f
C735 iqmod_mfb_lpf_pex_half_1.iqmod_mfb_lpf_pex_ota_core_hybrid_bm_half_0.iqmod_mfb_lpf_pex_ota_core_tg$1_0.di_tg_ctrl_n.n4 VSS 0.43542f
C736 iqmod_mfb_lpf_pex_half_1.iqmod_mfb_lpf_pex_ota_core_hybrid_bm_half_0.iqmod_mfb_lpf_pex_ota_core_tg$1_0.di_tg_ctrl_n.t3 VSS 3.47213f
C737 iqmod_mfb_lpf_pex_half_1.iqmod_mfb_lpf_pex_ota_core_hybrid_bm_half_0.iqmod_mfb_lpf_pex_ota_core_tg$1_0.di_tg_ctrl_n.n5 VSS 9.82417f
C738 iqmod_mfb_lpf_pex_half_1.iqmod_mfb_lpf_pex_ota_core_hybrid_bm_half_0.iqmod_mfb_lpf_pex_ota_core_tg$1_0.di_tg_ctrl_n.n6 VSS 7.07512f
C739 iqmod_mfb_lpf_pex_half_1.iqmod_mfb_lpf_pex_ota_core_hybrid_bm_half_0.iqmod_mfb_lpf_pex_ota_core_tg$1_0.di_tg_ctrl_n.t2 VSS 3.47213f
C740 iqmod_mfb_lpf_pex_half_1.iqmod_mfb_lpf_pex_ota_core_hybrid_bm_half_0.iqmod_mfb_lpf_pex_ota_core_tg$1_0.di_tg_ctrl_n.n7 VSS 1.09312f
C741 iqmod_mfb_lpf_pex_half_1.iqmod_mfb_lpf_pex_ota_core_hybrid_bm_half_0.iqmod_mfb_lpf_pex_ota_core_tg$1_0.di_tg_ctrl_n.t4 VSS 3.47213f
C742 iqmod_mfb_lpf_pex_half_1.iqmod_mfb_lpf_pex_ota_core_hybrid_bm_half_0.iqmod_mfb_lpf_pex_ota_core_tg$1_0.di_tg_ctrl_n.n8 VSS 1.81606f
C743 iqmod_mfb_lpf_pex_half_1.iqmod_mfb_lpf_pex_ota_core_hybrid_bm_half_0.iqmod_mfb_lpf_pex_ota_core_tg$1_0.di_tg_ctrl_n.t1 VSS 2.55097f
C744 iqmod_mfb_lpf_pex_half_1.iqmod_mfb_lpf_pex_ota_core_hybrid_bm_half_0.iqmod_mfb_lpf_pex_ota_core_spdt_switch$1_0.iqmod_mfb_lpf_pex_ota_core_spdt_switch_inv$2_0.vout.t1 VSS 0.26351f
C745 iqmod_mfb_lpf_pex_half_1.iqmod_mfb_lpf_pex_ota_core_hybrid_bm_half_0.iqmod_mfb_lpf_pex_ota_core_spdt_switch$1_0.iqmod_mfb_lpf_pex_ota_core_spdt_switch_inv$2_0.vout.n0 VSS 0.56281f
C746 iqmod_mfb_lpf_pex_half_1.iqmod_mfb_lpf_pex_ota_core_hybrid_bm_half_0.iqmod_mfb_lpf_pex_ota_core_spdt_switch$1_0.iqmod_mfb_lpf_pex_ota_core_spdt_switch_inv$2_0.vout.n1 VSS 0.10426f
C747 iqmod_mfb_lpf_pex_half_1.iqmod_mfb_lpf_pex_ota_core_hybrid_bm_half_0.iqmod_mfb_lpf_pex_ota_core_spdt_switch$1_0.iqmod_mfb_lpf_pex_ota_core_spdt_switch_inv$2_0.vout.t4 VSS 0.61705f
C748 iqmod_mfb_lpf_pex_half_1.iqmod_mfb_lpf_pex_ota_core_hybrid_bm_half_0.iqmod_mfb_lpf_pex_ota_core_spdt_switch$1_0.iqmod_mfb_lpf_pex_ota_core_spdt_switch_inv$2_0.vout.t3 VSS 0.10649f
C749 iqmod_mfb_lpf_pex_half_1.iqmod_mfb_lpf_pex_ota_core_hybrid_bm_half_0.iqmod_mfb_lpf_pex_ota_core_spdt_switch$1_0.iqmod_mfb_lpf_pex_ota_core_spdt_switch_inv$2_0.vout.n2 VSS 1.34423f
C750 iqmod_mfb_lpf_pex_half_1.iqmod_mfb_lpf_pex_ota_core_hybrid_bm_half_0.iqmod_mfb_lpf_pex_ota_core_spdt_switch$1_0.iqmod_mfb_lpf_pex_ota_core_spdt_switch_inv$2_0.vout.t2 VSS 2.57285f
C751 iqmod_mfb_lpf_pex_half_1.iqmod_mfb_lpf_pex_ota_core_hybrid_bm_half_0.iqmod_mfb_lpf_pex_ota_core_spdt_switch$1_0.iqmod_mfb_lpf_pex_ota_core_spdt_switch_inv$2_0.vout.n3 VSS 1.57913f
C752 iqmod_mfb_lpf_pex_half_1.iqmod_mfb_lpf_pex_ota_core_hybrid_bm_half_0.iqmod_mfb_lpf_pex_ota_core_spdt_switch$1_0.iqmod_mfb_lpf_pex_ota_core_spdt_switch_inv$2_0.vout.t0 VSS 1.89027f
C753 iqmod_mfb_lpf_pex_half_1.vinp.t6 VSS 0.07482f
C754 iqmod_mfb_lpf_pex_half_1.vinp.t2 VSS 0.55567f
C755 iqmod_mfb_lpf_pex_half_1.vinp.n0 VSS 0.43368f
C756 iqmod_mfb_lpf_pex_half_1.vinp.t8 VSS 0.04104f
C757 iqmod_mfb_lpf_pex_half_1.iqmod_mfb_lpf_pex_R3_0.v_b VSS 0.49836f
C758 iqmod_mfb_lpf_pex_half_1.vinp.n1 VSS 6.78729f
C759 iqmod_mfb_lpf_pex_half_1.vinp.t9 VSS 14.2665f
C760 iqmod_mfb_lpf_pex_half_1.iqmod_mfb_lpf_pex_ota_core_hybrid_bm_half_0.iqmod_mfb_lpf_pex_ota_core_spdt_switch$1_0.v_a VSS 2.77532f
C761 iqmod_mfb_lpf_pex_half_1.iqmod_mfb_lpf_pex_ota_core_hybrid_bm_half_0.vinp VSS 1.32761f
C762 iqmod_mfb_lpf_pex_half_1.vinp.t3 VSS 0.51949f
C763 iqmod_mfb_lpf_pex_half_1.vinp.t7 VSS 0.06879f
C764 iqmod_mfb_lpf_pex_half_1.vinp.n2 VSS 0.37259f
C765 iqmod_mfb_lpf_pex_half_1.vinp.t1 VSS 0.55567f
C766 iqmod_mfb_lpf_pex_half_1.vinp.t5 VSS 0.07482f
C767 iqmod_mfb_lpf_pex_half_1.vinp.n3 VSS 0.43368f
C768 iqmod_mfb_lpf_pex_half_1.vinp.t0 VSS 0.51949f
C769 iqmod_mfb_lpf_pex_half_1.vinp.t4 VSS 0.06879f
C770 iqmod_mfb_lpf_pex_half_1.vinp.n4 VSS 0.36467f
C771 iqmod_mfb_lpf_pex_half_1.iqmod_mfb_lpf_pex_ota_core_hybrid_bm_half_0.iqmod_mfb_lpf_pex_ota_core_spdt_switch$1_0.iqmod_mfb_lpf_pex_ota_core_spdt_switch_tg$2_1.v_a VSS 0.2656f
C772 iqmod_mfb_lpf_pex_half_1.iqmod_mfb_lpf_pex_ota_core_hybrid_bm_half_0.iqmod_mfb_lpf_pex_ota_core_inv_NF20$1_1.vin.t0 VSS 54.0789f
C773 iqmod_mfb_lpf_pex_half_1.iqmod_mfb_lpf_pex_ota_core_hybrid_bm_half_0.iqmod_mfb_lpf_pex_ota_core_inv_NF20$1_1.vin.t1 VSS 55.9611f
C774 a_6122_n4303.t0 VSS 0.06732f
C775 a_6122_n4303.t1 VSS 0.06732f
C776 a_6620_n4303.t0 VSS 0.06778f
C777 a_6620_n4303.t1 VSS 0.06778f
C778 iqmod_mfb_lpf_pex_half_1.iqmod_mfb_lpf_pex_R2_0.v_a.t7 VSS 3.40999f
C779 iqmod_mfb_lpf_pex_half_1.iqmod_mfb_lpf_pex_R2_0.v_a.t8 VSS 3.92762f
C780 iqmod_mfb_lpf_pex_half_1.iqmod_mfb_lpf_pex_R2_0.v_a.t6 VSS 4.04336f
C781 iqmod_mfb_lpf_pex_half_1.iqmod_mfb_lpf_pex_R2_0.v_a.n0 VSS 0.90889f
C782 iqmod_mfb_lpf_pex_half_1.iqmod_mfb_lpf_pex_R2_0.v_a.n1 VSS 0.03622f
C783 iqmod_mfb_lpf_pex_half_1.iqmod_mfb_lpf_pex_R2_0.v_a.n2 VSS 1.15436f
C784 iqmod_mfb_lpf_pex_half_1.iqmod_mfb_lpf_pex_R2_0.v_a.t2 VSS 2.79718f
C785 iqmod_mfb_lpf_pex_half_1.iqmod_mfb_lpf_pex_R2_0.v_a.t3 VSS 2.57281f
C786 iqmod_mfb_lpf_pex_half_1.iqmod_mfb_lpf_pex_R2_0.v_a.t0 VSS 1.78002f
C787 iqmod_mfb_lpf_pex_half_1.iqmod_mfb_lpf_pex_R2_0.v_a.n3 VSS 1.61734f
C788 iqmod_mfb_lpf_pex_half_1.iqmod_mfb_lpf_pex_R2_0.v_a.n4 VSS 0.19088f
C789 a_636_n4603.t0 VSS 0.03908f
C790 a_636_n4603.t1 VSS 0.03908f
C791 a_13404_n4303.t0 VSS 0.06652f
C792 a_13404_n4303.t1 VSS 0.06652f
C793 a_12906_n4603.t0 VSS 0.06704f
C794 a_12906_n4603.t1 VSS 0.06704f
C795 a_37874_n4303.t0 VSS 0.03601f
C796 a_37874_n4303.t1 VSS 0.03601f
C797 iqmod_mfb_lpf_pex_half_1.iqmod_mfb_lpf_pex_R1_0.v_b.n0 VSS 0.01118f
C798 iqmod_mfb_lpf_pex_half_1.iqmod_mfb_lpf_pex_R1_0.v_b.n1 VSS 0.86933f
C799 iqmod_mfb_lpf_pex_half_1.iqmod_mfb_lpf_pex_R1_0.v_b.t5 VSS 1.73797f
C800 iqmod_mfb_lpf_pex_half_1.iqmod_mfb_lpf_pex_R1_0.v_b.t4 VSS 1.75826f
C801 iqmod_mfb_lpf_pex_half_1.iqmod_mfb_lpf_pex_R1_0.v_b.t6 VSS 1.73797f
C802 iqmod_mfb_lpf_pex_half_1.iqmod_mfb_lpf_pex_R1_0.v_b.t3 VSS 1.61861f
C803 iqmod_mfb_lpf_pex_half_1.iqmod_mfb_lpf_pex_R1_0.v_b.t1 VSS 1.10644f
C804 iqmod_mfb_lpf_pex_half_1.iqmod_mfb_lpf_pex_R1_0.v_b.n2 VSS 0.99755f
C805 iqmod_mfb_lpf_pex_half_1.iqmod_mfb_lpf_pex_R1_0.v_b.t9 VSS 2.11872f
C806 iqmod_mfb_lpf_pex_half_1.iqmod_mfb_lpf_pex_R1_0.v_b.t10 VSS 2.49392f
C807 iqmod_mfb_lpf_pex_half_1.iqmod_mfb_lpf_pex_R1_0.v_b.t11 VSS 2.51225f
C808 iqmod_mfb_lpf_pex_half_1.iqmod_mfb_lpf_pex_R1_0.v_b.t8 VSS 2.56583f
C809 iqmod_mfb_lpf_pex_half_1.iqmod_mfb_lpf_pex_R1_0.v_b.t7 VSS 2.51225f
C810 iqmod_mfb_lpf_pex_half_1.iqmod_mfb_lpf_pex_R1_0.v_b.n3 VSS 0.56472f
C811 a_25290_n4603.t0 VSS 0.03193f
C812 a_25290_n4603.t1 VSS 0.03193f
C813 a_25788_n4603.t0 VSS 0.03193f
C814 a_25788_n4603.t1 VSS 0.03193f
C815 VDD.n0 VSS 0.44524f
C816 VDD.t58 VSS 0.06217f
C817 VDD.t57 VSS 0.37884f
C818 VDD.t38 VSS 0.19766f
C819 VDD.t60 VSS 0.18115f
C820 VDD.n1 VSS 1.2263f
C821 VDD.t56 VSS 0.06217f
C822 VDD.n2 VSS 0.53982f
C823 VDD.n3 VSS 0.36931f
C824 VDD.n4 VSS 0.09556f
C825 VDD.n5 VSS 0.14302f
C826 VDD.n6 VSS 0.05787f
C827 VDD.n7 VSS 0.03073f
C828 VDD.n8 VSS 0.10019f
C829 VDD.n9 VSS 0.11025f
C830 VDD.n10 VSS 0.05787f
C831 VDD.n11 VSS 0.2459f
C832 VDD.n12 VSS 0.10019f
C833 VDD.n13 VSS 0.09748f
C834 VDD.n14 VSS 0.12884f
C835 VDD.n15 VSS 0.14728f
C836 VDD.n16 VSS 0.03936f
C837 VDD.n17 VSS 0.10703f
C838 VDD.n18 VSS 0.05787f
C839 VDD.n19 VSS 0.21788f
C840 VDD.n20 VSS 0.09556f
C841 VDD.n21 VSS 0.20387f
C842 VDD.n22 VSS 0.08602f
C843 VDD.n31 VSS 0.01403f
C844 VDD.n32 VSS 0.04367f
C845 VDD.n33 VSS 0.03184f
C846 VDD.n34 VSS 0.24376f
C847 VDD.n35 VSS 0.10958f
C848 VDD.n36 VSS 0.2673f
C849 VDD.n37 VSS 0.42172f
C850 VDD.n38 VSS 0.10664f
C851 VDD.n39 VSS 0.11499f
C852 VDD.n40 VSS 0.04819f
C853 VDD.n41 VSS 0.0575f
C854 VDD.n42 VSS 0.11427f
C855 VDD.n43 VSS 0.10587f
C856 VDD.n44 VSS 0.11012f
C857 VDD.n45 VSS 0.51537f
C858 VDD.n47 VSS 0.03229f
C859 VDD.n48 VSS 0.03229f
C860 VDD.n49 VSS 0.03275f
C861 VDD.n50 VSS 0.03229f
C862 VDD.n51 VSS 0.03229f
C863 VDD.n52 VSS 0.06102f
C864 VDD.n53 VSS 0.03229f
C865 VDD.n54 VSS 0.03229f
C866 VDD.n55 VSS 0.03229f
C867 VDD.n56 VSS 0.03275f
C868 VDD.n57 VSS 0.03229f
C869 VDD.n58 VSS 0.03229f
C870 VDD.n59 VSS 0.03229f
C871 VDD.n61 VSS 0.04367f
C872 VDD.n62 VSS 0.21329f
C873 VDD.n65 VSS 0.03229f
C874 VDD.n66 VSS 0.03229f
C875 VDD.n67 VSS 0.03275f
C876 VDD.n68 VSS 0.03229f
C877 VDD.n69 VSS 0.03229f
C878 VDD.n70 VSS 0.03229f
C879 VDD.n71 VSS 0.03229f
C880 VDD.n72 VSS 0.03229f
C881 VDD.n73 VSS 0.03229f
C882 VDD.n74 VSS 0.03275f
C883 VDD.n75 VSS 0.03229f
C884 VDD.n76 VSS 0.03229f
C885 VDD.n77 VSS 0.03229f
C886 VDD.n79 VSS 0.04367f
C887 VDD.n80 VSS 0.12457f
C888 VDD.n81 VSS 0.03936f
C889 VDD.n84 VSS 0.03229f
C890 VDD.n85 VSS 0.03229f
C891 VDD.n86 VSS 0.03275f
C892 VDD.n87 VSS 0.03229f
C893 VDD.n88 VSS 0.03229f
C894 VDD.n89 VSS 0.06102f
C895 VDD.n90 VSS 0.03229f
C896 VDD.n91 VSS 0.03229f
C897 VDD.n92 VSS 0.03229f
C898 VDD.n93 VSS 0.03275f
C899 VDD.n94 VSS 0.03229f
C900 VDD.n95 VSS 0.03229f
C901 VDD.n96 VSS 0.03229f
C902 VDD.n98 VSS 0.04367f
C903 VDD.n99 VSS 0.10377f
C904 VDD.n100 VSS 0.13644f
C905 VDD.n103 VSS 0.06093f
C906 VDD.n104 VSS 0.06093f
C907 VDD.n105 VSS 0.06179f
C908 VDD.n106 VSS 0.06093f
C909 VDD.n107 VSS 0.06093f
C910 VDD.n108 VSS 0.06093f
C911 VDD.n109 VSS 0.06093f
C912 VDD.n110 VSS 0.06093f
C913 VDD.n111 VSS 0.06093f
C914 VDD.n112 VSS 0.06179f
C915 VDD.n113 VSS 0.06093f
C916 VDD.n114 VSS 0.06093f
C917 VDD.n115 VSS 0.06093f
C918 VDD.n117 VSS 0.08238f
C919 VDD.n118 VSS 0.13762f
C920 VDD.n119 VSS 0.13644f
C921 VDD.n122 VSS 0.06093f
C922 VDD.n123 VSS 0.06093f
C923 VDD.n124 VSS 0.06179f
C924 VDD.n125 VSS 0.06093f
C925 VDD.n126 VSS 0.06093f
C926 VDD.n127 VSS 0.06093f
C927 VDD.n128 VSS 0.06093f
C928 VDD.n129 VSS 0.06093f
C929 VDD.n130 VSS 0.06093f
C930 VDD.n131 VSS 0.06179f
C931 VDD.n132 VSS 0.06093f
C932 VDD.n133 VSS 0.06093f
C933 VDD.n134 VSS 0.06093f
C934 VDD.n136 VSS 0.08238f
C935 VDD.n137 VSS 0.20481f
C936 VDD.n138 VSS 0.10558f
C937 VDD.n139 VSS 0.04804f
C938 VDD.n140 VSS 0.05792f
C939 VDD.n141 VSS 0.10683f
C940 VDD.n142 VSS 0.20324f
C941 VDD.n143 VSS 0.68253f
C942 VDD.n144 VSS 0.10558f
C943 VDD.n145 VSS 0.04804f
C944 VDD.n146 VSS 0.05792f
C945 VDD.n147 VSS 0.10683f
C946 VDD.n148 VSS 0.11001f
C947 VDD.n149 VSS 0.43856f
C948 VDD.n150 VSS 0.08863f
C949 VDD.n151 VSS 0.09827f
C950 VDD.n152 VSS 0.10947f
C951 VDD.n153 VSS 0.45412f
C952 VDD.n154 VSS 0.10558f
C953 VDD.n155 VSS 0.11396f
C954 VDD.n156 VSS 0.11419f
C955 VDD.n157 VSS 0.11433f
C956 VDD.n158 VSS 0.10419f
C957 VDD.n159 VSS 0.11433f
C958 VDD.n160 VSS 0.11439f
C959 VDD.n161 VSS 0.11437f
C960 VDD.n162 VSS 0.11427f
C961 VDD.n163 VSS 0.68038f
C962 VDD.n164 VSS 0.10662f
C963 VDD.n165 VSS 0.11498f
C964 VDD.n166 VSS 0.11512f
C965 VDD.n167 VSS 0.11518f
C966 VDD.n168 VSS 0.11516f
C967 VDD.n169 VSS 0.10509f
C968 VDD.n170 VSS 0.11516f
C969 VDD.n171 VSS 0.11506f
C970 VDD.n172 VSS 0.11488f
C971 VDD.n173 VSS 0.10652f
C972 VDD.n174 VSS 0.20481f
C973 VDD.n175 VSS 0.08238f
C974 VDD.n177 VSS 0.06093f
C975 VDD.n178 VSS 0.06093f
C976 VDD.n179 VSS 0.06093f
C977 VDD.n180 VSS 0.06179f
C978 VDD.n181 VSS 0.06093f
C979 VDD.n182 VSS 0.06093f
C980 VDD.n183 VSS 0.06093f
C981 VDD.n184 VSS 0.06093f
C982 VDD.n185 VSS 0.06093f
C983 VDD.n186 VSS 0.06093f
C984 VDD.n187 VSS 0.06179f
C985 VDD.n188 VSS 0.06093f
C986 VDD.n189 VSS 0.06093f
C987 VDD.n192 VSS 0.1528f
C988 VDD.n193 VSS 0.49954f
C989 VDD.n194 VSS 0.17323f
C990 VDD.n195 VSS 0.49954f
C991 VDD.n198 VSS 0.06093f
C992 VDD.n199 VSS 0.06093f
C993 VDD.n200 VSS 0.06179f
C994 VDD.n201 VSS 0.06093f
C995 VDD.n202 VSS 0.06093f
C996 VDD.n203 VSS 0.06093f
C997 VDD.n204 VSS 0.06093f
C998 VDD.n205 VSS 0.06093f
C999 VDD.n206 VSS 0.06093f
C1000 VDD.n207 VSS 0.06179f
C1001 VDD.n208 VSS 0.06093f
C1002 VDD.n209 VSS 0.06093f
C1003 VDD.n210 VSS 0.06093f
C1004 VDD.n212 VSS 0.08238f
C1005 VDD.n213 VSS 0.15806f
C1006 VDD.n214 VSS 0.13644f
C1007 VDD.n217 VSS 0.03229f
C1008 VDD.n218 VSS 0.03229f
C1009 VDD.n219 VSS 0.03275f
C1010 VDD.n220 VSS 0.03229f
C1011 VDD.n221 VSS 0.03229f
C1012 VDD.n222 VSS 0.03229f
C1013 VDD.n223 VSS 0.03229f
C1014 VDD.n224 VSS 0.03229f
C1015 VDD.n225 VSS 0.03229f
C1016 VDD.n226 VSS 0.03275f
C1017 VDD.n227 VSS 0.03229f
C1018 VDD.n228 VSS 0.03229f
C1019 VDD.n229 VSS 0.03229f
C1020 VDD.n231 VSS 0.04367f
C1021 VDD.n232 VSS 0.10388f
C1022 VDD.n233 VSS 0.03936f
C1023 VDD.n234 VSS 0.11492f
C1024 VDD.n237 VSS 0.03229f
C1025 VDD.n238 VSS 0.03229f
C1026 VDD.n239 VSS 0.03275f
C1027 VDD.n240 VSS 0.03229f
C1028 VDD.n241 VSS 0.03229f
C1029 VDD.n242 VSS 0.06102f
C1030 VDD.n243 VSS 0.03229f
C1031 VDD.n244 VSS 0.03229f
C1032 VDD.n245 VSS 0.03229f
C1033 VDD.n246 VSS 0.03275f
C1034 VDD.n247 VSS 0.03229f
C1035 VDD.n248 VSS 0.03229f
C1036 VDD.n249 VSS 0.03229f
C1037 VDD.n251 VSS 0.04367f
C1038 VDD.n252 VSS 0.43899f
C1039 VDD.n253 VSS 0.08863f
C1040 VDD.n254 VSS 0.09827f
C1041 VDD.n255 VSS 0.10947f
C1042 VDD.n256 VSS 0.45412f
C1043 VDD.n257 VSS 0.10558f
C1044 VDD.n258 VSS 0.04804f
C1045 VDD.n259 VSS 0.05792f
C1046 VDD.n260 VSS 0.10683f
C1047 VDD.n261 VSS 0.20324f
C1048 VDD.n262 VSS 0.68253f
C1049 VDD.n263 VSS 0.10558f
C1050 VDD.n264 VSS 0.11396f
C1051 VDD.n265 VSS 0.11419f
C1052 VDD.n266 VSS 0.11433f
C1053 VDD.n267 VSS 0.10419f
C1054 VDD.n268 VSS 0.11433f
C1055 VDD.n269 VSS 0.11439f
C1056 VDD.n270 VSS 0.11437f
C1057 VDD.n271 VSS 0.11427f
C1058 VDD.n272 VSS 0.68082f
C1059 VDD.n273 VSS 0.39924f
C1060 VDD.n274 VSS 0.29395f
C1061 VDD.t32 VSS 0.16721f
C1062 VDD.n275 VSS 0.30538f
C1063 VDD.n276 VSS 0.29389f
C1064 VDD.t30 VSS 0.16721f
C1065 VDD.n277 VSS 0.30538f
C1066 VDD.n278 VSS 0.29391f
C1067 VDD.t28 VSS 0.16721f
C1068 VDD.n279 VSS 0.30538f
C1069 VDD.t26 VSS 0.24564f
C1070 VDD.n280 VSS 0.19027f
C1071 VDD.n281 VSS 0.22696f
C1072 VDD.n282 VSS 0.29391f
C1073 VDD.t24 VSS 0.16721f
C1074 VDD.n283 VSS 0.30538f
C1075 VDD.n284 VSS 0.48589f
C1076 VDD.n285 VSS 1.84596f
C1077 VDD.n286 VSS 0.29309f
C1078 VDD.t195 VSS 0.16721f
C1079 VDD.n287 VSS 0.30538f
C1080 VDD.n288 VSS 0.29311f
C1081 VDD.t197 VSS 0.16721f
C1082 VDD.n289 VSS 0.30538f
C1083 VDD.n290 VSS 0.29321f
C1084 VDD.t199 VSS 0.16721f
C1085 VDD.n291 VSS 0.30538f
C1086 VDD.n292 VSS 0.2934f
C1087 VDD.t201 VSS 0.16721f
C1088 VDD.n293 VSS 0.30538f
C1089 VDD.n294 VSS 0.87829f
C1090 VDD.t85 VSS 0.14033f
C1091 VDD.t41 VSS 0.15684f
C1092 VDD.n295 VSS 0.63769f
C1093 VDD.n296 VSS 0.05835f
C1094 VDD.n297 VSS 0.05835f
C1095 VDD.n298 VSS 0.05835f
C1096 VDD.n299 VSS 0.05835f
C1097 VDD.n300 VSS 0.05835f
C1098 VDD.n301 VSS 0.05835f
C1099 VDD.n302 VSS 0.11546f
C1100 VDD.n303 VSS 0.11546f
C1101 VDD.n304 VSS 0.05835f
C1102 VDD.n305 VSS 0.05835f
C1103 VDD.n306 VSS 0.05835f
C1104 VDD.n307 VSS 0.05835f
C1105 VDD.n308 VSS 0.05835f
C1106 VDD.n309 VSS 0.11607f
C1107 VDD.n310 VSS 0.11563f
C1108 VDD.t82 VSS 0.29717f
C1109 VDD.n311 VSS 0.07895f
C1110 VDD.n313 VSS 0.22386f
C1111 VDD.t40 VSS 0.16721f
C1112 VDD.n314 VSS 0.30538f
C1113 VDD.n315 VSS 0.2366f
C1114 VDD.t43 VSS 0.16721f
C1115 VDD.n316 VSS 0.30538f
C1116 VDD.n317 VSS 0.87829f
C1117 VDD.n318 VSS 0.63769f
C1118 VDD.t89 VSS 0.15684f
C1119 VDD.n320 VSS 0.11546f
C1120 VDD.n321 VSS 0.05835f
C1121 VDD.n322 VSS 0.05835f
C1122 VDD.n323 VSS 0.05835f
C1123 VDD.n324 VSS 0.07895f
C1124 VDD.n325 VSS 0.05835f
C1125 VDD.n326 VSS 0.05835f
C1126 VDD.n327 VSS 0.11607f
C1127 VDD.n328 VSS 0.11563f
C1128 VDD.n329 VSS 0.05835f
C1129 VDD.n330 VSS 0.05835f
C1130 VDD.n331 VSS 0.05835f
C1131 VDD.n332 VSS 0.05835f
C1132 VDD.n333 VSS 0.05835f
C1133 VDD.n334 VSS 0.05835f
C1134 VDD.t45 VSS 0.29717f
C1135 VDD.n335 VSS 0.11546f
C1136 VDD.t90 VSS 0.14033f
C1137 VDD.n336 VSS 0.22386f
C1138 VDD.t155 VSS 0.16721f
C1139 VDD.n337 VSS 0.30538f
C1140 VDD.n338 VSS 0.2366f
C1141 VDD.t157 VSS 0.16721f
C1142 VDD.n339 VSS 0.30538f
C1143 VDD.n340 VSS 0.40927f
C1144 VDD.n341 VSS 0.06983f
C1145 VDD.n342 VSS 1.43425f
C1146 VDD.n343 VSS 0.48589f
C1147 VDD.t239 VSS 0.24564f
C1148 VDD.n344 VSS 0.22696f
C1149 VDD.t234 VSS 0.16721f
C1150 VDD.n345 VSS 0.30538f
C1151 VDD.t236 VSS 0.16721f
C1152 VDD.n346 VSS 0.30538f
C1153 VDD.t233 VSS 0.16721f
C1154 VDD.n347 VSS 0.30538f
C1155 VDD.n348 VSS 0.52683f
C1156 VDD.n349 VSS 0.11488f
C1157 VDD.n350 VSS 6.90052f
C1158 VDD.n351 VSS 0.09893f
C1159 VDD.n352 VSS 0.04367f
C1160 VDD.t138 VSS 0.43337f
C1161 VDD.n354 VSS 0.03229f
C1162 VDD.n356 VSS 0.01312f
C1163 VDD.n357 VSS 0.01608f
C1164 VDD.n358 VSS 0.06147f
C1165 VDD.n359 VSS 0.03229f
C1166 VDD.n360 VSS 0.03093f
C1167 VDD.n361 VSS 0.03229f
C1168 VDD.n362 VSS 0.03093f
C1169 VDD.n363 VSS 0.03275f
C1170 VDD.n364 VSS 0.03093f
C1171 VDD.n365 VSS 0.03229f
C1172 VDD.n366 VSS 0.03093f
C1173 VDD.n367 VSS 0.03229f
C1174 VDD.n368 VSS 0.06102f
C1175 VDD.n369 VSS 0.03093f
C1176 VDD.n370 VSS 0.03093f
C1177 VDD.n371 VSS 0.03229f
C1178 VDD.n372 VSS 0.03093f
C1179 VDD.n373 VSS 0.03229f
C1180 VDD.n374 VSS 0.03093f
C1181 VDD.n375 VSS 0.03275f
C1182 VDD.n376 VSS 0.03093f
C1183 VDD.n377 VSS 0.03229f
C1184 VDD.n378 VSS 0.03093f
C1185 VDD.n379 VSS 0.03229f
C1186 VDD.t141 VSS 0.43337f
C1187 VDD.n380 VSS 0.20953f
C1188 VDD.n381 VSS 0.03229f
C1189 VDD.n382 VSS 0.33294f
C1190 VDD.t243 VSS 0.16721f
C1191 VDD.n383 VSS 0.30538f
C1192 VDD.t246 VSS 0.16721f
C1193 VDD.n384 VSS 0.30538f
C1194 VDD.n385 VSS 0.38382f
C1195 VDD.n386 VSS 0.11498f
C1196 VDD.n387 VSS 0.29321f
C1197 VDD.n388 VSS 0.11512f
C1198 VDD.t241 VSS 0.16721f
C1199 VDD.n389 VSS 0.30538f
C1200 VDD.n390 VSS 0.2933f
C1201 VDD.n391 VSS 0.11506f
C1202 VDD.n392 VSS 0.29315f
C1203 VDD.n393 VSS 0.11516f
C1204 VDD.n394 VSS 0.29309f
C1205 VDD.n395 VSS 0.10509f
C1206 VDD.n396 VSS 0.1901f
C1207 VDD.n397 VSS 0.11516f
C1208 VDD.n398 VSS 0.29309f
C1209 VDD.n399 VSS 0.11518f
C1210 VDD.n400 VSS 0.29311f
C1211 VDD.t244 VSS 0.16721f
C1212 VDD.n401 VSS 0.30538f
C1213 VDD.n402 VSS 0.48589f
C1214 VDD.n403 VSS 0.48589f
C1215 VDD.n404 VSS 0.57489f
C1216 VDD.n405 VSS 1.30165f
C1217 VDD.n406 VSS 0.33191f
C1218 VDD.n407 VSS 0.04367f
C1219 VDD.n408 VSS 0.06111f
C1220 VDD.n410 VSS 0.06111f
C1221 VDD.n411 VSS 0.03229f
C1222 VDD.n412 VSS 0.03093f
C1223 VDD.t142 VSS 0.28109f
C1224 VDD.n413 VSS 0.14158f
C1225 VDD.n414 VSS 0.5156f
C1226 VDD.n420 VSS 0.03423f
C1227 VDD.t115 VSS 0.14033f
C1228 VDD.n422 VSS 0.03093f
C1229 VDD.n423 VSS 0.03093f
C1230 VDD.n424 VSS 0.03093f
C1231 VDD.n425 VSS 0.03093f
C1232 VDD.n426 VSS 0.03093f
C1233 VDD.n427 VSS 0.03093f
C1234 VDD.n428 VSS 0.03093f
C1235 VDD.n429 VSS 0.03093f
C1236 VDD.n430 VSS 0.33294f
C1237 VDD.n432 VSS 0.04185f
C1238 VDD.n433 VSS 0.03093f
C1239 VDD.n434 VSS 0.03093f
C1240 VDD.n435 VSS 0.03093f
C1241 VDD.n436 VSS 0.03093f
C1242 VDD.n437 VSS 0.03093f
C1243 VDD.n438 VSS 0.03229f
C1244 VDD.n440 VSS 0.01403f
C1245 VDD.n444 VSS 0.03229f
C1246 VDD.n445 VSS 0.03275f
C1247 VDD.n446 VSS 0.01403f
C1248 VDD.n448 VSS 0.03229f
C1249 VDD.n449 VSS 0.03229f
C1250 VDD.n450 VSS 0.01651f
C1251 VDD.n452 VSS 0.03229f
C1252 VDD.n453 VSS 0.03229f
C1253 VDD.n454 VSS 0.01651f
C1254 VDD.n456 VSS 0.03275f
C1255 VDD.n457 VSS 0.03229f
C1256 VDD.n458 VSS 0.01403f
C1257 VDD.n460 VSS 0.03229f
C1258 VDD.n461 VSS 0.03229f
C1259 VDD.n462 VSS 0.01403f
C1260 VDD.n466 VSS 1.53249f
C1261 VDD.n468 VSS 0.4458f
C1262 VDD.n469 VSS 0.03229f
C1263 VDD.n470 VSS 0.01403f
C1264 VDD.n471 VSS 0.03184f
C1265 VDD.n472 VSS 0.03184f
C1266 VDD.n473 VSS 0.01403f
C1267 VDD.n474 VSS 0.04367f
C1268 VDD.t113 VSS 0.43337f
C1269 VDD.n475 VSS 0.05777f
C1270 VDD.n476 VSS 0.09893f
C1271 VDD.n477 VSS 0.08863f
C1272 VDD.n478 VSS 0.11001f
C1273 VDD.n479 VSS 0.04367f
C1274 VDD.n481 VSS 0.03229f
C1275 VDD.n482 VSS 0.03229f
C1276 VDD.n483 VSS 0.03229f
C1277 VDD.n484 VSS 0.03275f
C1278 VDD.n485 VSS 0.03229f
C1279 VDD.n486 VSS 0.03229f
C1280 VDD.n487 VSS 0.03229f
C1281 VDD.n488 VSS 0.06102f
C1282 VDD.n489 VSS 0.03229f
C1283 VDD.n490 VSS 0.03229f
C1284 VDD.n491 VSS 0.03275f
C1285 VDD.n492 VSS 0.03229f
C1286 VDD.n493 VSS 0.03229f
C1287 VDD.n495 VSS 0.43853f
C1288 VDD.n496 VSS 0.10662f
C1289 VDD.n497 VSS 0.11498f
C1290 VDD.n498 VSS 0.0574f
C1291 VDD.n499 VSS 0.04819f
C1292 VDD.n500 VSS 0.11499f
C1293 VDD.n501 VSS 0.10664f
C1294 VDD.n502 VSS 0.10947f
C1295 VDD.n503 VSS 0.04367f
C1296 VDD.n505 VSS 0.03229f
C1297 VDD.n506 VSS 0.03229f
C1298 VDD.n507 VSS 0.03229f
C1299 VDD.n508 VSS 0.03275f
C1300 VDD.n509 VSS 0.03229f
C1301 VDD.n510 VSS 0.03229f
C1302 VDD.n511 VSS 0.03229f
C1303 VDD.n512 VSS 0.03229f
C1304 VDD.n513 VSS 0.03229f
C1305 VDD.n514 VSS 0.03229f
C1306 VDD.n515 VSS 0.03275f
C1307 VDD.n516 VSS 0.03229f
C1308 VDD.n517 VSS 0.03229f
C1309 VDD.n519 VSS 0.24388f
C1310 VDD.n520 VSS 0.11601f
C1311 VDD.n521 VSS 0.24661f
C1312 VDD.n522 VSS 0.2934f
C1313 VDD.t263 VSS 0.16721f
C1314 VDD.n523 VSS 0.30538f
C1315 VDD.n524 VSS 0.23687f
C1316 VDD.t261 VSS 0.16721f
C1317 VDD.n525 VSS 0.30538f
C1318 VDD.n526 VSS 0.07198f
C1319 VDD.n527 VSS 0.22266f
C1320 VDD.t259 VSS 0.16721f
C1321 VDD.n528 VSS 0.30538f
C1322 VDD.n529 VSS 0.41469f
C1323 VDD.n530 VSS 2.84271f
C1324 VDD.n531 VSS 0.41043f
C1325 VDD.t50 VSS 0.16721f
C1326 VDD.n532 VSS 0.30538f
C1327 VDD.n533 VSS 0.20481f
C1328 VDD.n534 VSS 0.11488f
C1329 VDD.t269 VSS 0.16721f
C1330 VDD.n535 VSS 0.30538f
C1331 VDD.t271 VSS 0.16721f
C1332 VDD.n536 VSS 0.30538f
C1333 VDD.t273 VSS 0.16721f
C1334 VDD.n537 VSS 0.30538f
C1335 VDD.n538 VSS 0.48589f
C1336 VDD.t277 VSS 0.16721f
C1337 VDD.n539 VSS 0.30538f
C1338 VDD.t279 VSS 0.16721f
C1339 VDD.n540 VSS 0.30538f
C1340 VDD.t281 VSS 0.16721f
C1341 VDD.n541 VSS 0.30538f
C1342 VDD.t283 VSS 0.16721f
C1343 VDD.n542 VSS 0.30538f
C1344 VDD.n543 VSS 0.20481f
C1345 VDD.n544 VSS 0.11396f
C1346 VDD.t167 VSS 0.16721f
C1347 VDD.n545 VSS 0.30538f
C1348 VDD.t169 VSS 0.16721f
C1349 VDD.n546 VSS 0.30538f
C1350 VDD.t171 VSS 0.16721f
C1351 VDD.n547 VSS 0.30538f
C1352 VDD.n548 VSS 0.48589f
C1353 VDD.t173 VSS 0.24564f
C1354 VDD.n549 VSS 0.22696f
C1355 VDD.n550 VSS 1.14173f
C1356 VDD.n551 VSS 0.41043f
C1357 VDD.t207 VSS 0.16721f
C1358 VDD.n552 VSS 0.30538f
C1359 VDD.n553 VSS 0.20324f
C1360 VDD.t150 VSS 0.16721f
C1361 VDD.n554 VSS 0.30538f
C1362 VDD.n555 VSS 0.05792f
C1363 VDD.t148 VSS 0.16721f
C1364 VDD.n556 VSS 0.30538f
C1365 VDD.n557 VSS 0.99254f
C1366 VDD.n558 VSS 0.2366f
C1367 VDD.n559 VSS 0.10683f
C1368 VDD.t137 VSS 0.28109f
C1369 VDD.n561 VSS 0.06362f
C1370 VDD.n563 VSS 0.06147f
C1371 VDD.n564 VSS 0.03229f
C1372 VDD.n565 VSS 0.03093f
C1373 VDD.n566 VSS 0.03229f
C1374 VDD.n567 VSS 0.03093f
C1375 VDD.n568 VSS 0.03275f
C1376 VDD.n569 VSS 0.03093f
C1377 VDD.n570 VSS 0.03229f
C1378 VDD.n571 VSS 0.03093f
C1379 VDD.n572 VSS 0.03229f
C1380 VDD.n573 VSS 0.03093f
C1381 VDD.n574 VSS 0.06102f
C1382 VDD.n575 VSS 0.01312f
C1383 VDD.n576 VSS 0.33294f
C1384 VDD.n577 VSS 0.03229f
C1385 VDD.n578 VSS 0.03093f
C1386 VDD.n579 VSS 0.03229f
C1387 VDD.n580 VSS 0.03093f
C1388 VDD.n581 VSS 0.03229f
C1389 VDD.n582 VSS 0.03093f
C1390 VDD.n583 VSS 0.03275f
C1391 VDD.n584 VSS 0.03093f
C1392 VDD.n585 VSS 0.03229f
C1393 VDD.n586 VSS 0.03093f
C1394 VDD.n587 VSS 0.03229f
C1395 VDD.n588 VSS 0.03093f
C1396 VDD.n589 VSS 0.03229f
C1397 VDD.n590 VSS 0.06111f
C1398 VDD.n591 VSS 0.01608f
C1399 VDD.n592 VSS 0.06111f
C1400 VDD.n593 VSS 0.04367f
C1401 VDD.t136 VSS 0.43337f
C1402 VDD.n594 VSS 0.06167f
C1403 VDD.n595 VSS 0.11001f
C1404 VDD.n596 VSS 0.43856f
C1405 VDD.n597 VSS 0.08863f
C1406 VDD.n598 VSS 0.11601f
C1407 VDD.n599 VSS 0.24661f
C1408 VDD.n600 VSS 0.52683f
C1409 VDD.n601 VSS 0.40927f
C1410 VDD.n602 VSS 0.87829f
C1411 VDD.n604 VSS 0.63769f
C1412 VDD.t134 VSS 0.15684f
C1413 VDD.n605 VSS 0.06093f
C1414 VDD.t135 VSS 0.14033f
C1415 VDD.n607 VSS 0.07895f
C1416 VDD.n608 VSS 0.06093f
C1417 VDD.n609 VSS 0.05835f
C1418 VDD.n610 VSS 0.06093f
C1419 VDD.n611 VSS 0.05835f
C1420 VDD.n612 VSS 0.06093f
C1421 VDD.n613 VSS 0.05835f
C1422 VDD.n614 VSS 0.06179f
C1423 VDD.n615 VSS 0.05835f
C1424 VDD.n616 VSS 0.06093f
C1425 VDD.n617 VSS 0.05835f
C1426 VDD.n618 VSS 0.06093f
C1427 VDD.n619 VSS 0.11607f
C1428 VDD.n621 VSS 0.11563f
C1429 VDD.n622 VSS 0.05835f
C1430 VDD.n623 VSS 0.06093f
C1431 VDD.n624 VSS 0.05835f
C1432 VDD.n625 VSS 0.06093f
C1433 VDD.n626 VSS 0.05835f
C1434 VDD.n627 VSS 0.06179f
C1435 VDD.n628 VSS 0.05835f
C1436 VDD.n629 VSS 0.06093f
C1437 VDD.n630 VSS 0.05835f
C1438 VDD.n631 VSS 0.06093f
C1439 VDD.n632 VSS 0.05835f
C1440 VDD.n633 VSS 0.06093f
C1441 VDD.n634 VSS 0.11546f
C1442 VDD.t132 VSS 0.29717f
C1443 VDD.n635 VSS 0.11546f
C1444 VDD.n636 VSS 0.08238f
C1445 VDD.t133 VSS 0.43337f
C1446 VDD.t131 VSS 0.43337f
C1447 VDD.n637 VSS 0.1182f
C1448 VDD.n638 VSS 0.87829f
C1449 VDD.n639 VSS 0.39924f
C1450 VDD.n640 VSS 0.08238f
C1451 VDD.n641 VSS 0.39924f
C1452 VDD.n642 VSS 0.41043f
C1453 VDD.n643 VSS 0.14239f
C1454 VDD.n644 VSS 0.06983f
C1455 VDD.n645 VSS 0.04804f
C1456 VDD.n646 VSS 0.22309f
C1457 VDD.n647 VSS 0.10652f
C1458 VDD.n648 VSS 0.68235f
C1459 VDD.n649 VSS 0.10683f
C1460 VDD.n650 VSS 0.2366f
C1461 VDD.n651 VSS 0.05792f
C1462 VDD.n652 VSS 0.06983f
C1463 VDD.t205 VSS 0.16721f
C1464 VDD.n653 VSS 0.30538f
C1465 VDD.n654 VSS 0.87829f
C1466 VDD.t130 VSS 0.14033f
C1467 VDD.n656 VSS 0.39924f
C1468 VDD.t129 VSS 0.15684f
C1469 VDD.n657 VSS 0.06093f
C1470 VDD.n659 VSS 0.07895f
C1471 VDD.n660 VSS 0.06093f
C1472 VDD.n661 VSS 0.05835f
C1473 VDD.n662 VSS 0.06093f
C1474 VDD.n663 VSS 0.05835f
C1475 VDD.n664 VSS 0.06093f
C1476 VDD.n665 VSS 0.05835f
C1477 VDD.n666 VSS 0.06179f
C1478 VDD.n667 VSS 0.05835f
C1479 VDD.n668 VSS 0.06093f
C1480 VDD.n669 VSS 0.05835f
C1481 VDD.n670 VSS 0.06093f
C1482 VDD.n671 VSS 0.11607f
C1483 VDD.n673 VSS 0.11563f
C1484 VDD.n674 VSS 0.05835f
C1485 VDD.n675 VSS 0.06093f
C1486 VDD.n676 VSS 0.05835f
C1487 VDD.n677 VSS 0.06093f
C1488 VDD.n678 VSS 0.05835f
C1489 VDD.n679 VSS 0.06179f
C1490 VDD.n680 VSS 0.05835f
C1491 VDD.n681 VSS 0.06093f
C1492 VDD.n682 VSS 0.05835f
C1493 VDD.n683 VSS 0.06093f
C1494 VDD.n684 VSS 0.05835f
C1495 VDD.n685 VSS 0.06093f
C1496 VDD.n686 VSS 0.11546f
C1497 VDD.t127 VSS 0.29717f
C1498 VDD.n687 VSS 0.11546f
C1499 VDD.n688 VSS 0.08238f
C1500 VDD.t128 VSS 0.43337f
C1501 VDD.t181 VSS 0.16721f
C1502 VDD.n689 VSS 0.30538f
C1503 VDD.t179 VSS 0.16721f
C1504 VDD.n690 VSS 0.30538f
C1505 VDD.n691 VSS 0.48163f
C1506 VDD.n692 VSS 0.48589f
C1507 VDD.n693 VSS 0.48589f
C1508 VDD.t177 VSS 0.16721f
C1509 VDD.n694 VSS 0.30538f
C1510 VDD.t175 VSS 0.16721f
C1511 VDD.n695 VSS 0.30538f
C1512 VDD.n696 VSS 0.29421f
C1513 VDD.n697 VSS 0.11419f
C1514 VDD.n698 VSS 0.29402f
C1515 VDD.n699 VSS 0.11433f
C1516 VDD.n700 VSS 0.29391f
C1517 VDD.n701 VSS 0.10419f
C1518 VDD.n702 VSS 0.19027f
C1519 VDD.n703 VSS 0.11433f
C1520 VDD.n704 VSS 0.29391f
C1521 VDD.n705 VSS 0.11439f
C1522 VDD.n706 VSS 0.29389f
C1523 VDD.n707 VSS 0.11437f
C1524 VDD.n708 VSS 0.29395f
C1525 VDD.n709 VSS 0.11427f
C1526 VDD.n710 VSS 0.2941f
C1527 VDD.n711 VSS 0.10587f
C1528 VDD.n712 VSS 0.04804f
C1529 VDD.n713 VSS 0.22309f
C1530 VDD.n714 VSS 0.10652f
C1531 VDD.n715 VSS 0.68082f
C1532 VDD.n716 VSS 0.20481f
C1533 VDD.t126 VSS 0.43337f
C1534 VDD.n717 VSS 0.11875f
C1535 VDD.n718 VSS 0.87829f
C1536 VDD.n719 VSS 0.63769f
C1537 VDD.n720 VSS 0.08238f
C1538 VDD.n721 VSS 0.39924f
C1539 VDD.n722 VSS 0.41043f
C1540 VDD.n723 VSS 0.14239f
C1541 VDD.n724 VSS 1.84596f
C1542 VDD.n725 VSS 2.84271f
C1543 VDD.n726 VSS 0.48589f
C1544 VDD.n727 VSS 0.48589f
C1545 VDD.n728 VSS 0.48589f
C1546 VDD.n729 VSS 0.48589f
C1547 VDD.n730 VSS 0.87829f
C1548 VDD.t125 VSS 0.14033f
C1549 VDD.n732 VSS 0.48589f
C1550 VDD.n733 VSS 0.48589f
C1551 VDD.n734 VSS 0.48163f
C1552 VDD.n735 VSS 0.39924f
C1553 VDD.t124 VSS 0.15684f
C1554 VDD.n736 VSS 0.06093f
C1555 VDD.n738 VSS 0.07895f
C1556 VDD.n739 VSS 0.06093f
C1557 VDD.n740 VSS 0.05835f
C1558 VDD.n741 VSS 0.06093f
C1559 VDD.n742 VSS 0.05835f
C1560 VDD.n743 VSS 0.06093f
C1561 VDD.n744 VSS 0.05835f
C1562 VDD.n745 VSS 0.06179f
C1563 VDD.n746 VSS 0.05835f
C1564 VDD.n747 VSS 0.06093f
C1565 VDD.n748 VSS 0.05835f
C1566 VDD.n749 VSS 0.06093f
C1567 VDD.n750 VSS 0.11607f
C1568 VDD.n752 VSS 0.11563f
C1569 VDD.n753 VSS 0.05835f
C1570 VDD.n754 VSS 0.06093f
C1571 VDD.n755 VSS 0.05835f
C1572 VDD.n756 VSS 0.06093f
C1573 VDD.n757 VSS 0.05835f
C1574 VDD.n758 VSS 0.06179f
C1575 VDD.n759 VSS 0.05835f
C1576 VDD.n760 VSS 0.06093f
C1577 VDD.n761 VSS 0.05835f
C1578 VDD.n762 VSS 0.06093f
C1579 VDD.n763 VSS 0.05835f
C1580 VDD.n764 VSS 0.06093f
C1581 VDD.n765 VSS 0.11546f
C1582 VDD.t122 VSS 0.29717f
C1583 VDD.n766 VSS 0.11546f
C1584 VDD.n767 VSS 0.08238f
C1585 VDD.t123 VSS 0.43337f
C1586 VDD.t121 VSS 0.43337f
C1587 VDD.n768 VSS 0.11875f
C1588 VDD.n769 VSS 0.87829f
C1589 VDD.n770 VSS 0.63769f
C1590 VDD.n771 VSS 0.08238f
C1591 VDD.n772 VSS 0.39924f
C1592 VDD.n773 VSS 0.48163f
C1593 VDD.t165 VSS 0.16721f
C1594 VDD.n774 VSS 0.30538f
C1595 VDD.n775 VSS 0.29448f
C1596 VDD.n776 VSS 0.10558f
C1597 VDD.n777 VSS 0.68038f
C1598 VDD.n778 VSS 0.10662f
C1599 VDD.n779 VSS 0.2934f
C1600 VDD.n780 VSS 0.11498f
C1601 VDD.n781 VSS 0.29321f
C1602 VDD.n782 VSS 0.11512f
C1603 VDD.n783 VSS 0.29311f
C1604 VDD.n784 VSS 0.11518f
C1605 VDD.n785 VSS 0.29309f
C1606 VDD.n786 VSS 0.11516f
C1607 VDD.n787 VSS 0.2933f
C1608 VDD.n788 VSS 0.11506f
C1609 VDD.n789 VSS 0.29315f
C1610 VDD.n790 VSS 0.11516f
C1611 VDD.n791 VSS 0.29309f
C1612 VDD.n792 VSS 0.10509f
C1613 VDD.n793 VSS 0.1901f
C1614 VDD.t275 VSS 0.24564f
C1615 VDD.n794 VSS 0.22696f
C1616 VDD.n795 VSS 0.48589f
C1617 VDD.n796 VSS 0.48589f
C1618 VDD.n797 VSS 0.48589f
C1619 VDD.n798 VSS 0.48589f
C1620 VDD.n799 VSS 0.87829f
C1621 VDD.t120 VSS 0.14033f
C1622 VDD.n801 VSS 0.39924f
C1623 VDD.t119 VSS 0.15684f
C1624 VDD.n802 VSS 0.06093f
C1625 VDD.n804 VSS 0.07895f
C1626 VDD.n805 VSS 0.06093f
C1627 VDD.n806 VSS 0.05835f
C1628 VDD.n807 VSS 0.06093f
C1629 VDD.n808 VSS 0.05835f
C1630 VDD.n809 VSS 0.06093f
C1631 VDD.n810 VSS 0.05835f
C1632 VDD.n811 VSS 0.06179f
C1633 VDD.n812 VSS 0.05835f
C1634 VDD.n813 VSS 0.06093f
C1635 VDD.n814 VSS 0.05835f
C1636 VDD.n815 VSS 0.06093f
C1637 VDD.n816 VSS 0.11607f
C1638 VDD.n818 VSS 0.11563f
C1639 VDD.n819 VSS 0.05835f
C1640 VDD.n820 VSS 0.06093f
C1641 VDD.n821 VSS 0.05835f
C1642 VDD.n822 VSS 0.06093f
C1643 VDD.n823 VSS 0.05835f
C1644 VDD.n824 VSS 0.06179f
C1645 VDD.n825 VSS 0.05835f
C1646 VDD.n826 VSS 0.06093f
C1647 VDD.n827 VSS 0.05835f
C1648 VDD.n828 VSS 0.06093f
C1649 VDD.n829 VSS 0.05835f
C1650 VDD.n830 VSS 0.06093f
C1651 VDD.n831 VSS 0.11546f
C1652 VDD.t52 VSS 0.29717f
C1653 VDD.n832 VSS 0.11546f
C1654 VDD.n833 VSS 0.08238f
C1655 VDD.t118 VSS 0.43337f
C1656 VDD.t116 VSS 0.43337f
C1657 VDD.n834 VSS 0.11875f
C1658 VDD.n835 VSS 0.87829f
C1659 VDD.n836 VSS 0.63769f
C1660 VDD.n837 VSS 0.08238f
C1661 VDD.n838 VSS 0.39924f
C1662 VDD.n839 VSS 0.48163f
C1663 VDD.t267 VSS 0.16721f
C1664 VDD.n840 VSS 0.30538f
C1665 VDD.n841 VSS 0.29352f
C1666 VDD.n842 VSS 0.10652f
C1667 VDD.n843 VSS 0.6802f
C1668 VDD.n844 VSS 0.10662f
C1669 VDD.n845 VSS 0.23715f
C1670 VDD.n846 VSS 0.05701f
C1671 VDD.n847 VSS 0.07043f
C1672 VDD.n848 VSS 0.04785f
C1673 VDD.n849 VSS 0.10664f
C1674 VDD.n850 VSS 0.22305f
C1675 VDD.t48 VSS 0.16721f
C1676 VDD.n851 VSS 0.30538f
C1677 VDD.n852 VSS 0.99254f
C1678 VDD.n853 VSS 0.52683f
C1679 VDD.n854 VSS 0.40927f
C1680 VDD.n855 VSS 0.14239f
C1681 VDD.n856 VSS 1.64011f
C1682 VDD.n857 VSS 1.07827f
C1683 VDD.n858 VSS 0.49786f
C1684 VDD.n860 VSS 0.13836f
C1685 VDD.n861 VSS 0.06111f
C1686 VDD.n862 VSS 0.06111f
C1687 VDD.n863 VSS 0.03093f
C1688 VDD.n864 VSS 0.03093f
C1689 VDD.n865 VSS 0.03093f
C1690 VDD.n866 VSS 0.03093f
C1691 VDD.n867 VSS 0.03093f
C1692 VDD.n868 VSS 0.03093f
C1693 VDD.n869 VSS 0.04185f
C1694 VDD.n870 VSS 0.03093f
C1695 VDD.n871 VSS 0.03093f
C1696 VDD.n872 VSS 0.03093f
C1697 VDD.n873 VSS 0.03093f
C1698 VDD.n874 VSS 0.03093f
C1699 VDD.t110 VSS 0.14033f
C1700 VDD.n875 VSS 0.06147f
C1701 VDD.t109 VSS 0.15684f
C1702 VDD.n876 VSS 0.33294f
C1703 VDD.t108 VSS 0.43337f
C1704 VDD.n877 VSS 0.06144f
C1705 VDD.n878 VSS 0.99254f
C1706 VDD.n879 VSS 0.29342f
C1707 VDD.t257 VSS 0.16721f
C1708 VDD.n880 VSS 0.30538f
C1709 VDD.n881 VSS 0.48047f
C1710 VDD.n882 VSS 0.61557f
C1711 VDD.n883 VSS 0.11601f
C1712 VDD.n884 VSS 0.11601f
C1713 VDD.t2 VSS 0.47678f
C1714 VDD.t106 VSS 0.06217f
C1715 VDD.n885 VSS 0.8578f
C1716 VDD.n886 VSS 0.08539f
C1717 VDD.t102 VSS 0.37884f
C1718 VDD.t1 VSS 0.19766f
C1719 VDD.t105 VSS 0.18115f
C1720 VDD.n887 VSS 1.2263f
C1721 VDD.t103 VSS 0.06217f
C1722 VDD.t101 VSS 0.06217f
C1723 VDD.n888 VSS 0.53982f
C1724 VDD.n889 VSS 0.36931f
C1725 VDD.t46 VSS 0.03138f
C1726 VDD.t295 VSS 0.23697f
C1727 VDD.t3 VSS 0.03413f
C1728 VDD.t293 VSS 0.25347f
C1729 VDD.t5 VSS 0.03413f
C1730 VDD.t291 VSS 0.25347f
C1731 VDD.t4 VSS 0.03138f
C1732 VDD.t290 VSS 0.23697f
C1733 VDD.n890 VSS 0.16635f
C1734 VDD.n891 VSS 0.19783f
C1735 VDD.n892 VSS 0.19783f
C1736 VDD.n893 VSS 0.63881f
C1737 VDD.n894 VSS 1.18779f
C1738 VDD.t99 VSS 0.19766f
C1739 VDD.t100 VSS 0.18115f
C1740 VDD.n895 VSS 0.66992f
C1741 VDD.t98 VSS 0.06217f
C1742 VDD.n896 VSS 0.34461f
C1743 VDD.n897 VSS 0.09556f
C1744 VDD.n898 VSS 0.08602f
C1745 VDD.n899 VSS 0.20385f
C1746 VDD.n900 VSS 0.05787f
C1747 VDD.n901 VSS 0.10012f
C1748 VDD.n902 VSS 0.09556f
C1749 VDD.n903 VSS 0.21774f
C1750 VDD.n904 VSS 0.05787f
C1751 VDD.n905 VSS 0.10012f
C1752 VDD.n906 VSS 0.11056f
C1753 VDD.n907 VSS 0.24425f
C1754 VDD.n908 VSS 0.05938f
C1755 VDD.n909 VSS 0.42188f
C1756 VDD.n910 VSS 0.11056f
C1757 VDD.n911 VSS 0.26853f
C1758 VDD.n912 VSS 0.12832f
C1759 VDD.n913 VSS 0.14792f
C1760 VDD.n914 VSS 0.0373f
C1761 VDD.n915 VSS 0.10911f
C1762 VDD.n916 VSS 0.03073f
C1763 VDD.n917 VSS 0.14287f
C1764 VDD.n918 VSS 0.13103f
C1765 VDD.n919 VSS 0.08539f
C1766 VDD.n920 VSS 0.19142f
C1767 VDD.n921 VSS 0.30362f
C1768 VDD.n922 VSS 0.44524f
C1769 VDD.n923 VSS 0.04179f
C1770 VDD.n924 VSS 0.32308f
C1771 VDD.n925 VSS 0.38539f
C1772 VDD.n926 VSS 0.47413f
C1773 VDD.n927 VSS 0.96116f
C1774 VDD.n928 VSS 1.3094f
C1775 VDD.n929 VSS 0.14239f
C1776 VDD.n930 VSS 0.41469f
C1777 VDD.n931 VSS 0.48047f
C1778 VDD.n932 VSS 0.52683f
C1779 VDD.t111 VSS 0.43337f
C1780 VDD.n933 VSS 0.06167f
C1781 VDD.n934 VSS 0.99254f
C1782 VDD.n935 VSS 0.33294f
C1783 VDD.n936 VSS 0.01312f
C1784 VDD.n937 VSS 0.06111f
C1785 VDD.n938 VSS 0.03093f
C1786 VDD.n939 VSS 0.03093f
C1787 VDD.n940 VSS 0.03093f
C1788 VDD.n941 VSS 0.03093f
C1789 VDD.n942 VSS 0.03093f
C1790 VDD.n943 VSS 0.03093f
C1791 VDD.n944 VSS 0.03093f
C1792 VDD.n945 VSS 0.03093f
C1793 VDD.n946 VSS 0.03093f
C1794 VDD.n947 VSS 0.03093f
C1795 VDD.n948 VSS 0.03093f
C1796 VDD.n949 VSS 0.06111f
C1797 VDD.t112 VSS 0.28121f
C1798 VDD.n950 VSS 0.06148f
C1799 VDD.n951 VSS 0.01596f
C1800 VDD.n952 VSS 0.06361f
C1801 VDD.n954 VSS 0.11258f
C1802 VDD.n955 VSS 0.03639f
C1803 VDD.n956 VSS 1.2964f
C1804 VDD.n957 VSS 0.02138f
C1805 VDD.n958 VSS 0.01403f
C1806 VDD.n959 VSS 0.09916f
C1807 VDD.n960 VSS 0.01403f
C1808 VDD.t0 VSS 0.11161p
C1809 VDD.n963 VSS 0.01403f
C1810 VDD.n964 VSS 0.03229f
C1811 VDD.n965 VSS 0.06147f
C1812 VDD.t47 VSS 0.15684f
C1813 VDD.n966 VSS 0.06202f
C1814 VDD.n968 VSS 0.07477f
C1815 VDD.n969 VSS 0.13549f
C1816 VDD.n970 VSS 0.15895f
C1817 VDD.n971 VSS 0.49954f
C1818 VDD.n972 VSS 0.17321f
C1819 VDD.n973 VSS 0.49954f
C1820 VDD.n974 VSS 0.15282f
C1821 VDD.n975 VSS 0.13636f
C1822 VDD.n976 VSS 0.13769f
C1823 VDD.n977 VSS 0.13636f
C1824 VDD.n978 VSS 0.1038f
C1825 VDD.n979 VSS 0.03932f
C1826 VDD.n980 VSS 0.12437f
C1827 VDD.n982 VSS 0.06362f
C1828 VDD.n983 VSS 0.06111f
C1829 VDD.n985 VSS 0.06111f
C1830 VDD.n986 VSS 0.03229f
C1831 VDD.n987 VSS 0.03093f
C1832 VDD.n988 VSS 0.03229f
C1833 VDD.n989 VSS 0.03093f
C1834 VDD.n990 VSS 0.03229f
C1835 VDD.n991 VSS 0.03093f
C1836 VDD.n992 VSS 0.03275f
C1837 VDD.n993 VSS 0.03093f
C1838 VDD.n994 VSS 0.03229f
C1839 VDD.n995 VSS 0.03093f
C1840 VDD.n996 VSS 0.03229f
C1841 VDD.n997 VSS 0.03093f
C1842 VDD.n998 VSS 0.04185f
C1843 VDD.n999 VSS 0.03229f
C1844 VDD.n1000 VSS 0.03093f
C1845 VDD.n1001 VSS 0.03229f
C1846 VDD.n1002 VSS 0.03093f
C1847 VDD.n1003 VSS 0.03229f
C1848 VDD.n1004 VSS 0.03093f
C1849 VDD.n1005 VSS 0.03275f
C1850 VDD.n1006 VSS 0.03093f
C1851 VDD.n1007 VSS 0.03229f
C1852 VDD.n1008 VSS 0.03093f
C1853 VDD.n1010 VSS 0.03229f
C1854 VDD.t140 VSS 0.14033f
C1855 VDD.n1011 VSS 0.06147f
C1856 VDD.t139 VSS 0.15684f
C1857 VDD.n1012 VSS 0.33294f
C1858 VDD.n1013 VSS 0.99254f
C1859 VDD.n1014 VSS 0.06144f
C1860 VDD.n1015 VSS 0.10947f
C1861 VDD.n1016 VSS 0.45339f
C1862 VDD.n1017 VSS 0.10652f
C1863 VDD.n1018 VSS 0.29352f
C1864 VDD.t230 VSS 0.16721f
C1865 VDD.n1019 VSS 0.30538f
C1866 VDD.n1020 VSS 0.48047f
C1867 VDD.n1021 VSS 0.48589f
C1868 VDD.n1022 VSS 0.48589f
C1869 VDD.n1023 VSS 0.48589f
C1870 VDD.n1024 VSS 0.48589f
C1871 VDD.n1025 VSS 3.87862f
C1872 VDD.n1026 VSS 3.87862f
C1873 VDD.t94 VSS 0.15684f
C1874 VDD.n1027 VSS 0.04185f
C1875 VDD.n1028 VSS 0.06111f
C1876 VDD.n1029 VSS 0.03093f
C1877 VDD.n1030 VSS 0.03093f
C1878 VDD.n1031 VSS 0.03093f
C1879 VDD.n1032 VSS 0.03093f
C1880 VDD.n1033 VSS 0.03093f
C1881 VDD.n1034 VSS 0.06147f
C1882 VDD.n1035 VSS 0.06361f
C1883 VDD.n1036 VSS 0.03093f
C1884 VDD.n1037 VSS 0.03093f
C1885 VDD.n1038 VSS 0.03093f
C1886 VDD.n1039 VSS 0.03093f
C1887 VDD.n1040 VSS 0.03093f
C1888 VDD.n1041 VSS 0.03093f
C1889 VDD.n1042 VSS 0.06111f
C1890 VDD.t95 VSS 0.14033f
C1891 VDD.n1044 VSS 0.33294f
C1892 VDD.t93 VSS 0.43337f
C1893 VDD.n1045 VSS 0.06144f
C1894 VDD.n1046 VSS 0.99254f
C1895 VDD.n1047 VSS 0.29448f
C1896 VDD.t211 VSS 0.16721f
C1897 VDD.n1048 VSS 0.30538f
C1898 VDD.n1049 VSS 0.29421f
C1899 VDD.t212 VSS 0.16721f
C1900 VDD.n1050 VSS 0.30538f
C1901 VDD.n1051 VSS 0.29402f
C1902 VDD.t215 VSS 0.16721f
C1903 VDD.n1052 VSS 0.30538f
C1904 VDD.n1053 VSS 0.29391f
C1905 VDD.t218 VSS 0.16721f
C1906 VDD.n1054 VSS 0.30538f
C1907 VDD.n1055 VSS 0.29391f
C1908 VDD.t217 VSS 0.16721f
C1909 VDD.n1056 VSS 0.30538f
C1910 VDD.n1057 VSS 0.29389f
C1911 VDD.t223 VSS 0.16721f
C1912 VDD.n1058 VSS 0.30538f
C1913 VDD.n1059 VSS 0.29395f
C1914 VDD.t225 VSS 0.16721f
C1915 VDD.n1060 VSS 0.30538f
C1916 VDD.n1061 VSS 0.1416f
C1917 VDD.n1062 VSS 0.06148f
C1918 VDD.n1063 VSS 0.01596f
C1919 VDD.n1064 VSS 0.06111f
C1920 VDD.n1065 VSS 0.03093f
C1921 VDD.n1066 VSS 0.03093f
C1922 VDD.n1067 VSS 0.03093f
C1923 VDD.n1068 VSS 0.03093f
C1924 VDD.n1069 VSS 0.03093f
C1925 VDD.n1070 VSS 0.03093f
C1926 VDD.n1071 VSS 0.03093f
C1927 VDD.n1072 VSS 0.03093f
C1928 VDD.n1073 VSS 0.03093f
C1929 VDD.n1074 VSS 0.03093f
C1930 VDD.n1075 VSS 0.03093f
C1931 VDD.n1076 VSS 0.06111f
C1932 VDD.t97 VSS 0.28121f
C1933 VDD.n1077 VSS 0.01312f
C1934 VDD.n1078 VSS 0.33294f
C1935 VDD.t96 VSS 0.43337f
C1936 VDD.n1079 VSS 0.32848f
C1937 VDD.n1080 VSS 1.30165f
C1938 VDD.n1081 VSS 0.38406f
C1939 VDD.t227 VSS 0.16721f
C1940 VDD.n1082 VSS 0.30538f
C1941 VDD.n1083 VSS 0.57489f
C1942 VDD.n1084 VSS 0.48589f
C1943 VDD.n1085 VSS 0.48589f
C1944 VDD.n1086 VSS 0.48589f
C1945 VDD.t220 VSS 0.24564f
C1946 VDD.n1087 VSS 0.19027f
C1947 VDD.n1088 VSS 0.22696f
C1948 VDD.n1089 VSS 0.48589f
C1949 VDD.n1090 VSS 0.48589f
C1950 VDD.n1091 VSS 0.48589f
C1951 VDD.n1092 VSS 0.48589f
C1952 VDD.n1093 VSS 0.48047f
C1953 VDD.n1094 VSS 0.52683f
C1954 VDD.n1095 VSS 0.11611f
C1955 VDD.n1096 VSS 0.06361f
C1956 VDD.n1097 VSS 0.06148f
C1957 VDD.n1098 VSS 0.01596f
C1958 VDD.n1099 VSS 0.06111f
C1959 VDD.n1100 VSS 0.03093f
C1960 VDD.n1101 VSS 0.03093f
C1961 VDD.n1102 VSS 0.03093f
C1962 VDD.n1103 VSS 0.03093f
C1963 VDD.n1104 VSS 0.03093f
C1964 VDD.n1105 VSS 0.03093f
C1965 VDD.n1106 VSS 0.03093f
C1966 VDD.n1107 VSS 0.03093f
C1967 VDD.n1108 VSS 0.03093f
C1968 VDD.n1109 VSS 0.03093f
C1969 VDD.n1110 VSS 0.03093f
C1970 VDD.n1111 VSS 0.06111f
C1971 VDD.t92 VSS 0.28121f
C1972 VDD.n1112 VSS 0.01312f
C1973 VDD.n1113 VSS 0.33294f
C1974 VDD.t91 VSS 0.43337f
C1975 VDD.n1114 VSS 0.06167f
C1976 VDD.n1115 VSS 0.99254f
C1977 VDD.n1116 VSS 0.52683f
C1978 VDD.n1117 VSS 0.24661f
C1979 VDD.n1118 VSS 1.43425f
C1980 VDD.n1119 VSS 1.14173f
C1981 VDD.n1120 VSS 0.14239f
C1982 VDD.n1121 VSS 0.41043f
C1983 VDD.t88 VSS 0.43337f
C1984 VDD.t86 VSS 0.43337f
C1985 VDD.n1122 VSS 0.1182f
C1986 VDD.n1123 VSS 0.87829f
C1987 VDD.n1124 VSS 0.39924f
C1988 VDD.n1125 VSS 0.08238f
C1989 VDD.n1126 VSS 0.39924f
C1990 VDD.n1127 VSS 0.41043f
C1991 VDD.n1128 VSS 0.06983f
C1992 VDD.n1129 VSS 0.14239f
C1993 VDD.n1130 VSS 0.41043f
C1994 VDD.t83 VSS 0.43337f
C1995 VDD.t81 VSS 0.43337f
C1996 VDD.n1131 VSS 0.11875f
C1997 VDD.n1132 VSS 0.87829f
C1998 VDD.n1133 VSS 0.39924f
C1999 VDD.n1134 VSS 0.08238f
C2000 VDD.n1135 VSS 0.39924f
C2001 VDD.n1136 VSS 0.48163f
C2002 VDD.n1137 VSS 0.48589f
C2003 VDD.n1138 VSS 0.48589f
C2004 VDD.n1139 VSS 0.48589f
C2005 VDD.t193 VSS 0.24564f
C2006 VDD.n1140 VSS 0.1901f
C2007 VDD.n1141 VSS 0.22696f
C2008 VDD.n1142 VSS 0.29309f
C2009 VDD.t191 VSS 0.16721f
C2010 VDD.n1143 VSS 0.30538f
C2011 VDD.n1144 VSS 0.29315f
C2012 VDD.t189 VSS 0.16721f
C2013 VDD.n1145 VSS 0.30538f
C2014 VDD.n1146 VSS 0.2933f
C2015 VDD.t187 VSS 0.16721f
C2016 VDD.n1147 VSS 0.30538f
C2017 VDD.n1148 VSS 0.29352f
C2018 VDD.t185 VSS 0.16721f
C2019 VDD.n1149 VSS 0.30538f
C2020 VDD.n1150 VSS 0.87829f
C2021 VDD.t80 VSS 0.14033f
C2022 VDD.t79 VSS 0.15684f
C2023 VDD.t78 VSS 0.43337f
C2024 VDD.t76 VSS 0.43337f
C2025 VDD.n1151 VSS 0.11875f
C2026 VDD.n1152 VSS 0.87829f
C2027 VDD.n1153 VSS 0.63769f
C2028 VDD.n1154 VSS 0.05835f
C2029 VDD.n1155 VSS 0.05835f
C2030 VDD.n1156 VSS 0.05835f
C2031 VDD.n1157 VSS 0.05835f
C2032 VDD.n1158 VSS 0.05835f
C2033 VDD.n1159 VSS 0.05835f
C2034 VDD.n1160 VSS 0.11546f
C2035 VDD.n1161 VSS 0.11546f
C2036 VDD.n1162 VSS 0.05835f
C2037 VDD.n1163 VSS 0.05835f
C2038 VDD.n1164 VSS 0.05835f
C2039 VDD.n1165 VSS 0.05835f
C2040 VDD.n1166 VSS 0.05835f
C2041 VDD.n1167 VSS 0.11607f
C2042 VDD.n1168 VSS 0.11563f
C2043 VDD.t36 VSS 0.29717f
C2044 VDD.n1169 VSS 0.07895f
C2045 VDD.n1171 VSS 0.08238f
C2046 VDD.n1172 VSS 0.39924f
C2047 VDD.n1173 VSS 0.48163f
C2048 VDD.n1174 VSS 0.48589f
C2049 VDD.n1175 VSS 0.48589f
C2050 VDD.n1176 VSS 0.48589f
C2051 VDD.n1177 VSS 0.48589f
C2052 VDD.n1178 VSS 2.84271f
C2053 VDD.n1179 VSS 1.07827f
C2054 VDD.n1180 VSS 0.2366f
C2055 VDD.t253 VSS 0.16721f
C2056 VDD.n1181 VSS 0.30538f
C2057 VDD.n1182 VSS 0.87829f
C2058 VDD.t75 VSS 0.14033f
C2059 VDD.t7 VSS 0.15684f
C2060 VDD.n1183 VSS 0.63769f
C2061 VDD.n1184 VSS 0.05835f
C2062 VDD.n1185 VSS 0.05835f
C2063 VDD.n1186 VSS 0.05835f
C2064 VDD.n1187 VSS 0.05835f
C2065 VDD.n1188 VSS 0.05835f
C2066 VDD.n1189 VSS 0.05835f
C2067 VDD.n1190 VSS 0.11546f
C2068 VDD.n1191 VSS 0.11546f
C2069 VDD.n1192 VSS 0.05835f
C2070 VDD.n1193 VSS 0.05835f
C2071 VDD.n1194 VSS 0.05835f
C2072 VDD.n1195 VSS 0.05835f
C2073 VDD.n1196 VSS 0.05835f
C2074 VDD.n1197 VSS 0.11607f
C2075 VDD.n1198 VSS 0.11563f
C2076 VDD.t72 VSS 0.29717f
C2077 VDD.n1199 VSS 0.07895f
C2078 VDD.n1201 VSS 0.29448f
C2079 VDD.t18 VSS 0.16721f
C2080 VDD.n1202 VSS 0.30538f
C2081 VDD.n1203 VSS 0.29421f
C2082 VDD.t20 VSS 0.16721f
C2083 VDD.n1204 VSS 0.30538f
C2084 VDD.n1205 VSS 0.29402f
C2085 VDD.t22 VSS 0.16721f
C2086 VDD.n1206 VSS 0.30538f
C2087 VDD.n1207 VSS 0.48589f
C2088 VDD.n1208 VSS 0.48589f
C2089 VDD.n1209 VSS 0.48163f
C2090 VDD.t73 VSS 0.43337f
C2091 VDD.t71 VSS 0.43337f
C2092 VDD.n1210 VSS 0.1182f
C2093 VDD.n1211 VSS 0.87829f
C2094 VDD.n1212 VSS 0.39924f
C2095 VDD.n1213 VSS 0.08238f
C2096 VDD.n1214 VSS 0.39924f
C2097 VDD.n1215 VSS 0.41043f
C2098 VDD.n1216 VSS 0.06983f
C2099 VDD.n1217 VSS 0.22386f
C2100 VDD.t251 VSS 0.16721f
C2101 VDD.n1218 VSS 0.30538f
C2102 VDD.n1219 VSS 0.03093f
C2103 VDD.n1220 VSS 0.03093f
C2104 VDD.n1221 VSS 0.03093f
C2105 VDD.n1222 VSS 0.03093f
C2106 VDD.n1223 VSS 0.03093f
C2107 VDD.n1224 VSS 0.03093f
C2108 VDD.n1225 VSS 0.03093f
C2109 VDD.n1226 VSS 0.03093f
C2110 VDD.n1227 VSS 0.03093f
C2111 VDD.n1228 VSS 0.03093f
C2112 VDD.n1229 VSS 0.03093f
C2113 VDD.n1230 VSS 0.06111f
C2114 VDD.n1231 VSS 0.06361f
C2115 VDD.n1232 VSS 0.06148f
C2116 VDD.n1233 VSS 0.01596f
C2117 VDD.n1234 VSS 0.06111f
C2118 VDD.t17 VSS 0.28121f
C2119 VDD.n1235 VSS 0.01312f
C2120 VDD.n1236 VSS 0.33294f
C2121 VDD.t66 VSS 0.43337f
C2122 VDD.n1237 VSS 0.06171f
C2123 VDD.n1238 VSS 0.99254f
C2124 VDD.n1239 VSS 0.23713f
C2125 VDD.t13 VSS 0.16721f
C2126 VDD.n1240 VSS 0.30538f
C2127 VDD.n1241 VSS 0.07176f
C2128 VDD.n1242 VSS 0.22266f
C2129 VDD.t11 VSS 0.16721f
C2130 VDD.n1243 VSS 0.30538f
C2131 VDD.n1244 VSS 0.41469f
C2132 VDD.n1245 VSS 0.49786f
C2133 VDD.n1246 VSS 0.29342f
C2134 VDD.t9 VSS 0.16721f
C2135 VDD.n1247 VSS 0.30538f
C2136 VDD.n1248 VSS 0.48047f
C2137 VDD.n1249 VSS 0.03229f
C2138 VDD.n1251 VSS 0.06111f
C2139 VDD.n1252 VSS 0.10808f
C2140 VDD.n1253 VSS 0.03093f
C2141 VDD.n1254 VSS 0.03139f
C2142 VDD.n1255 VSS 0.01403f
C2143 VDD.n1256 VSS 0.03229f
C2144 VDD.n1257 VSS 0.03093f
C2145 VDD.n1258 VSS 0.03093f
C2146 VDD.n1259 VSS 0.03229f
C2147 VDD.n1260 VSS 0.01403f
C2148 VDD.n1261 VSS 0.03275f
C2149 VDD.n1262 VSS 0.03093f
C2150 VDD.n1263 VSS 0.03093f
C2151 VDD.n1264 VSS 0.03229f
C2152 VDD.n1265 VSS 0.01403f
C2153 VDD.n1266 VSS 0.03229f
C2154 VDD.n1267 VSS 0.03093f
C2155 VDD.n1268 VSS 0.01899f
C2156 VDD.n1269 VSS 0.03229f
C2157 VDD.n1270 VSS 0.04185f
C2158 VDD.n1271 VSS 0.03093f
C2159 VDD.n1272 VSS 0.03093f
C2160 VDD.n1273 VSS 0.03229f
C2161 VDD.n1274 VSS 0.01403f
C2162 VDD.n1275 VSS 0.03229f
C2163 VDD.n1276 VSS 0.03093f
C2164 VDD.n1277 VSS 0.03093f
C2165 VDD.n1278 VSS 0.03275f
C2166 VDD.n1279 VSS 0.01403f
C2167 VDD.n1280 VSS 0.03229f
C2168 VDD.n1281 VSS 0.03093f
C2169 VDD.n1282 VSS 0.03093f
C2170 VDD.n1284 VSS 0.03229f
C2171 VDD.n1285 VSS 0.01403f
C2172 VDD.n1286 VSS 0.03229f
C2173 VDD.t65 VSS 0.14033f
C2174 VDD.n1287 VSS 0.06111f
C2175 VDD.t8 VSS 0.15684f
C2176 VDD.n1288 VSS 0.33294f
C2177 VDD.t63 VSS 0.43337f
C2178 VDD.n1289 VSS 0.06149f
C2179 VDD.n1290 VSS 0.99254f
C2180 VDD.n1291 VSS 0.61557f
C2181 VDD.n1292 VSS 0.13039f
C2182 VDD.n1293 VSS 0.11636f
C2183 VDD.t39 VSS 0.47678f
C2184 VDD.t61 VSS 0.06217f
C2185 VDD.n1294 VSS 0.8578f
C2186 VDD.n1295 VSS 0.08539f
C2187 VDD.n1296 VSS 0.04179f
C2188 VDD.n1297 VSS 0.32308f
C2189 VDD.n1298 VSS 0.38539f
C2190 VDD.n1299 VSS 0.47413f
C2191 VDD.n1300 VSS 0.96116f
C2192 VDD.n1301 VSS 1.3094f
C2193 VDD.n1302 VSS 0.14239f
C2194 VDD.n1303 VSS 0.41469f
C2195 VDD.n1304 VSS 0.2941f
C2196 VDD.t15 VSS 0.16721f
C2197 VDD.n1305 VSS 0.30538f
C2198 VDD.n1306 VSS 0.48047f
C2199 VDD.n1307 VSS 0.52683f
C2200 VDD.n1308 VSS 0.11611f
C2201 VDD.n1309 VSS 0.24661f
C2202 VDD.n1311 VSS 0.06111f
C2203 VDD.n1312 VSS 0.06361f
C2204 VDD.n1313 VSS 0.06147f
C2205 VDD.n1314 VSS 0.03093f
C2206 VDD.n1315 VSS 0.03093f
C2207 VDD.n1316 VSS 0.03093f
C2208 VDD.n1317 VSS 0.03093f
C2209 VDD.n1318 VSS 0.03093f
C2210 VDD.n1319 VSS 0.04185f
C2211 VDD.n1320 VSS 0.03093f
C2212 VDD.n1321 VSS 0.03093f
C2213 VDD.n1322 VSS 0.03093f
C2214 VDD.n1323 VSS 0.03093f
C2215 VDD.n1324 VSS 0.03093f
C2216 VDD.n1325 VSS 0.03093f
C2217 VDD.t70 VSS 0.14033f
C2218 VDD.n1326 VSS 0.06111f
C2219 VDD.t69 VSS 0.15684f
C2220 VDD.n1327 VSS 0.33294f
C2221 VDD.t68 VSS 0.43337f
C2222 VDD.n1328 VSS 0.06144f
C2223 VDD.n1329 VSS 0.99254f
C2224 VDD.n1330 VSS 0.52683f
C2225 VDD.n1331 VSS 0.40927f
C2226 VDD.n1332 VSS 0.14239f
C2227 VDD.n1333 VSS 1.64011f
C2228 VDD.n1334 VSS 2.84271f
C2229 VDD.n1335 VSS 0.48589f
C2230 VDD.n1336 VSS 0.48589f
C2231 VDD.n1337 VSS 0.48589f
C2232 VDD.n1338 VSS 0.48589f
C2233 VDD.n1339 VSS 0.48163f
C2234 VDD.t34 VSS 0.16721f
C2235 VDD.n1340 VSS 0.30538f
C2236 VDD.n1341 VSS 0.2941f
C2237 VDD.n1342 VSS 0.10587f
C2238 VDD.n1343 VSS 8.23902f
C2239 VDD.t6 VSS 0.1116p
C2240 VDD.n1345 VSS 1.5349f
C2241 VDD.n1346 VSS 0.13049f
C2242 VDD.n1347 VSS 0.08539f
C2243 VDD.t54 VSS 0.19766f
C2244 VDD.t37 VSS 0.23697f
C2245 VDD.t289 VSS 0.03138f
C2246 VDD.t146 VSS 0.25347f
C2247 VDD.t288 VSS 0.03413f
C2248 VDD.t144 VSS 0.25347f
C2249 VDD.t287 VSS 0.03413f
C2250 VDD.t143 VSS 0.23697f
C2251 VDD.t286 VSS 0.03138f
C2252 VDD.n1348 VSS 0.16635f
C2253 VDD.n1349 VSS 0.19783f
C2254 VDD.n1350 VSS 0.19783f
C2255 VDD.n1351 VSS 0.63881f
C2256 VDD.n1352 VSS 1.18779f
C2257 VDD.t55 VSS 0.18115f
C2258 VDD.n1353 VSS 0.66992f
C2259 VDD.t53 VSS 0.06217f
C2260 VDD.n1354 VSS 0.34461f
C2261 VDD.n1355 VSS 0.19142f
C2262 VDD.n1356 VSS 0.30362f
C2263 voutn.t20 VSS 0.03692f
C2264 voutn.n0 VSS 0.34542f
C2265 voutn.n1 VSS 0.06362f
C2266 voutn.n2 VSS 0.20484f
C2267 voutn.n3 VSS 0.20484f
C2268 voutn.n4 VSS 0.20484f
C2269 voutn.n5 VSS 0.20484f
C2270 voutn.n6 VSS 0.20484f
C2271 voutn.n7 VSS 0.20484f
C2272 voutn.n8 VSS 0.20484f
C2273 voutn.n9 VSS 0.20484f
C2274 voutn.n10 VSS 0.20484f
C2275 voutn.n11 VSS 0.20484f
C2276 voutn.n12 VSS 0.20484f
C2277 voutn.n13 VSS 0.20484f
C2278 voutn.n14 VSS 0.20484f
C2279 voutn.n15 VSS 0.20484f
C2280 voutn.n16 VSS 0.20484f
C2281 voutn.n17 VSS 0.20484f
C2282 voutn.n18 VSS 0.20484f
C2283 voutn.n19 VSS 0.04802f
C2284 voutn.n20 VSS 0.04802f
C2285 voutn.n21 VSS 0.04802f
C2286 voutn.n22 VSS 0.04802f
C2287 voutn.n23 VSS 0.04802f
C2288 voutn.n24 VSS 0.04802f
C2289 voutn.n25 VSS 0.04802f
C2290 voutn.t42 VSS 4.42733f
C2291 voutn.n26 VSS 0.20364f
C2292 voutn.n27 VSS 0.04802f
C2293 voutn.n28 VSS 0.04802f
C2294 voutn.n29 VSS 0.04802f
C2295 voutn.n30 VSS 0.04802f
C2296 voutn.n31 VSS 0.04802f
C2297 voutn.n32 VSS 0.04802f
C2298 voutn.n33 VSS 0.04802f
C2299 voutn.n34 VSS 0.06362f
C2300 voutn.n35 VSS 0.18933f
C2301 voutn.n36 VSS 0.04882f
C2302 voutn.n37 VSS 0.06282f
C2303 voutn.n38 VSS 0.04802f
C2304 voutn.n39 VSS 0.04802f
C2305 voutn.n40 VSS 0.04802f
C2306 voutn.n41 VSS 0.04802f
C2307 voutn.n42 VSS 0.04802f
C2308 voutn.n43 VSS 0.04802f
C2309 voutn.t43 VSS 18.0192f
C2310 voutn.n44 VSS 0.20364f
C2311 voutn.n45 VSS 0.04802f
C2312 voutn.n46 VSS 0.04802f
C2313 voutn.n47 VSS 0.04802f
C2314 voutn.n48 VSS 0.04802f
C2315 voutn.n49 VSS 0.04802f
C2316 voutn.n50 VSS 0.04802f
C2317 voutn.n51 VSS 0.06282f
C2318 voutn.n52 VSS 0.04882f
C2319 voutn.n53 VSS 0.60772f
C2320 voutn.t35 VSS 0.83763f
C2321 voutn.t25 VSS 0.11797f
C2322 voutn.t36 VSS 0.83763f
C2323 voutn.t21 VSS 0.11797f
C2324 voutn.t31 VSS 0.83763f
C2325 voutn.t22 VSS 0.11797f
C2326 voutn.t32 VSS 0.83763f
C2327 voutn.t29 VSS 0.11797f
C2328 voutn.t38 VSS 0.83763f
C2329 voutn.t30 VSS 0.11797f
C2330 voutn.t39 VSS 0.84447f
C2331 voutn.t28 VSS 0.11797f
C2332 voutn.t40 VSS 0.84447f
C2333 voutn.t23 VSS 0.11797f
C2334 voutn.t33 VSS 0.84447f
C2335 voutn.t24 VSS 0.11797f
C2336 voutn.t34 VSS 0.84447f
C2337 voutn.t27 VSS 0.11797f
C2338 voutn.t37 VSS 0.84447f
C2339 voutn.t26 VSS 0.11797f
C2340 voutn.n54 VSS 2.07364f
C2341 voutn.n55 VSS 2.32951f
C2342 voutn.n56 VSS 2.32951f
C2343 voutn.n57 VSS 2.32951f
C2344 voutn.n58 VSS 2.32951f
C2345 voutn.n59 VSS 2.33634f
C2346 voutn.n60 VSS 2.33634f
C2347 voutn.n61 VSS 2.33634f
C2348 voutn.n62 VSS 2.33634f
C2349 voutn.n63 VSS 2.43879f
C2350 voutn.t8 VSS 0.84447f
C2351 voutn.t16 VSS 0.11797f
C2352 voutn.t7 VSS 0.84447f
C2353 voutn.t10 VSS 0.11797f
C2354 voutn.t6 VSS 0.84447f
C2355 voutn.t9 VSS 0.11797f
C2356 voutn.t12 VSS 0.84447f
C2357 voutn.t5 VSS 0.11797f
C2358 voutn.t11 VSS 0.84447f
C2359 voutn.t4 VSS 0.11797f
C2360 voutn.t18 VSS 0.83763f
C2361 voutn.t2 VSS 0.11797f
C2362 voutn.t19 VSS 0.83763f
C2363 voutn.t1 VSS 0.11797f
C2364 voutn.t17 VSS 0.83763f
C2365 voutn.t14 VSS 0.11797f
C2366 voutn.t13 VSS 0.83763f
C2367 voutn.t15 VSS 0.11797f
C2368 voutn.t3 VSS 0.83763f
C2369 voutn.t0 VSS 0.11797f
C2370 voutn.n64 VSS 2.15693f
C2371 voutn.n65 VSS 2.33634f
C2372 voutn.n66 VSS 2.33634f
C2373 voutn.n67 VSS 2.33634f
C2374 voutn.n68 VSS 2.33634f
C2375 voutn.n69 VSS 2.32951f
C2376 voutn.n70 VSS 2.32951f
C2377 voutn.n71 VSS 2.32951f
C2378 voutn.n72 VSS 2.32951f
C2379 voutn.n73 VSS 2.07364f
C2380 voutn.n74 VSS 0.77709f
C2381 voutn.t41 VSS 20.2052f
C2382 voutn.n75 VSS 17.705f
C2383 voutn.n76 VSS 11.2011f
C2384 vinp.t0 VSS 0.01135f
C2385 vinp.n0 VSS 0.03514f
C2386 di_filter_en.t4 VSS 0.5267f
C2387 di_filter_en.n0 VSS 3.34071f
C2388 di_filter_en.t5 VSS 0.5267f
C2389 di_filter_en.n1 VSS 0.20529f
C2390 di_filter_en.n2 VSS 4.4629f
C2391 di_filter_en.t7 VSS 0.51516f
C2392 di_filter_en.t6 VSS 0.14505f
C2393 di_filter_en.n3 VSS 0.17245f
C2394 di_filter_en.n4 VSS 0.31162f
C2395 di_filter_en.n5 VSS 0.1642f
C2396 di_filter_en.n6 VSS 1.84492f
C2397 di_filter_en.t1 VSS 0.5267f
C2398 di_filter_en.n7 VSS 3.34071f
C2399 di_filter_en.t2 VSS 0.5267f
C2400 di_filter_en.n8 VSS 0.20529f
C2401 di_filter_en.n9 VSS 4.4629f
C2402 di_filter_en.t3 VSS 0.14505f
C2403 di_filter_en.t0 VSS 0.51516f
C2404 di_filter_en.n10 VSS 0.17245f
C2405 di_filter_en.n11 VSS 0.60569f
C2406 di_filter_en.n12 VSS 1.72939f
C2407 di_filter_en.n13 VSS 0.55332f
C2408 voutp.n0 VSS 0.06362f
C2409 voutp.n1 VSS 0.20484f
C2410 voutp.n2 VSS 0.20484f
C2411 voutp.n3 VSS 0.20484f
C2412 voutp.n4 VSS 0.20484f
C2413 voutp.n5 VSS 0.20484f
C2414 voutp.n6 VSS 0.20484f
C2415 voutp.n7 VSS 0.20484f
C2416 voutp.n8 VSS 0.20484f
C2417 voutp.n9 VSS 0.20484f
C2418 voutp.n10 VSS 0.20484f
C2419 voutp.n11 VSS 0.20484f
C2420 voutp.n12 VSS 0.20484f
C2421 voutp.n13 VSS 0.20484f
C2422 voutp.n14 VSS 0.20484f
C2423 voutp.n15 VSS 0.20484f
C2424 voutp.n16 VSS 0.20484f
C2425 voutp.n17 VSS 0.20484f
C2426 voutp.n18 VSS 0.04802f
C2427 voutp.n19 VSS 0.04802f
C2428 voutp.n20 VSS 0.04802f
C2429 voutp.n21 VSS 0.04802f
C2430 voutp.n22 VSS 0.04802f
C2431 voutp.n23 VSS 0.04802f
C2432 voutp.n24 VSS 0.04802f
C2433 voutp.t42 VSS 18.0192f
C2434 voutp.n25 VSS 0.20364f
C2435 voutp.n26 VSS 0.04802f
C2436 voutp.n27 VSS 0.04802f
C2437 voutp.n28 VSS 0.04802f
C2438 voutp.n29 VSS 0.04802f
C2439 voutp.n30 VSS 0.04802f
C2440 voutp.n31 VSS 0.04802f
C2441 voutp.n32 VSS 0.04802f
C2442 voutp.n33 VSS 0.06362f
C2443 voutp.n34 VSS 0.18933f
C2444 voutp.n35 VSS 0.04882f
C2445 voutp.n36 VSS 0.06282f
C2446 voutp.n37 VSS 0.04802f
C2447 voutp.n38 VSS 0.04802f
C2448 voutp.n39 VSS 0.04802f
C2449 voutp.n40 VSS 0.04802f
C2450 voutp.n41 VSS 0.04802f
C2451 voutp.n42 VSS 0.04802f
C2452 voutp.t43 VSS 4.42734f
C2453 voutp.n43 VSS 0.20364f
C2454 voutp.n44 VSS 0.04802f
C2455 voutp.n45 VSS 0.04802f
C2456 voutp.n46 VSS 0.04802f
C2457 voutp.n47 VSS 0.04802f
C2458 voutp.n48 VSS 0.04802f
C2459 voutp.n49 VSS 0.04802f
C2460 voutp.n50 VSS 0.06282f
C2461 voutp.n51 VSS 0.04882f
C2462 voutp.n52 VSS 0.60772f
C2463 voutp.t0 VSS 0.03692f
C2464 voutp.n53 VSS 0.34542f
C2465 voutp.t11 VSS 0.11797f
C2466 voutp.t10 VSS 0.83763f
C2467 voutp.t12 VSS 0.11797f
C2468 voutp.t1 VSS 0.83763f
C2469 voutp.t19 VSS 0.11797f
C2470 voutp.t2 VSS 0.83763f
C2471 voutp.t16 VSS 0.11797f
C2472 voutp.t7 VSS 0.83763f
C2473 voutp.t17 VSS 0.11797f
C2474 voutp.t9 VSS 0.83763f
C2475 voutp.t15 VSS 0.11797f
C2476 voutp.t5 VSS 0.84454f
C2477 voutp.t13 VSS 0.11797f
C2478 voutp.t6 VSS 0.84454f
C2479 voutp.t14 VSS 0.11797f
C2480 voutp.t3 VSS 0.84454f
C2481 voutp.t20 VSS 0.11797f
C2482 voutp.t4 VSS 0.84454f
C2483 voutp.t18 VSS 0.11797f
C2484 voutp.t8 VSS 0.84454f
C2485 voutp.n54 VSS 2.07358f
C2486 voutp.n55 VSS 2.32944f
C2487 voutp.n56 VSS 2.32944f
C2488 voutp.n57 VSS 2.32944f
C2489 voutp.n58 VSS 2.32944f
C2490 voutp.n59 VSS 2.33635f
C2491 voutp.n60 VSS 2.33635f
C2492 voutp.n61 VSS 2.33635f
C2493 voutp.n62 VSS 2.33635f
C2494 voutp.n63 VSS 2.4388f
C2495 voutp.t35 VSS 0.11797f
C2496 voutp.t31 VSS 0.84454f
C2497 voutp.t34 VSS 0.11797f
C2498 voutp.t40 VSS 0.84454f
C2499 voutp.t30 VSS 0.11797f
C2500 voutp.t22 VSS 0.84454f
C2501 voutp.t28 VSS 0.11797f
C2502 voutp.t21 VSS 0.84454f
C2503 voutp.t27 VSS 0.11797f
C2504 voutp.t33 VSS 0.84454f
C2505 voutp.t29 VSS 0.11797f
C2506 voutp.t32 VSS 0.83763f
C2507 voutp.t38 VSS 0.11797f
C2508 voutp.t39 VSS 0.83763f
C2509 voutp.t26 VSS 0.11797f
C2510 voutp.t24 VSS 0.83763f
C2511 voutp.t25 VSS 0.11797f
C2512 voutp.t23 VSS 0.83763f
C2513 voutp.t36 VSS 0.11797f
C2514 voutp.t37 VSS 0.83763f
C2515 voutp.n64 VSS 2.15693f
C2516 voutp.n65 VSS 2.33635f
C2517 voutp.n66 VSS 2.33635f
C2518 voutp.n67 VSS 2.33635f
C2519 voutp.n68 VSS 2.33635f
C2520 voutp.n69 VSS 2.32944f
C2521 voutp.n70 VSS 2.32944f
C2522 voutp.n71 VSS 2.32944f
C2523 voutp.n72 VSS 2.32944f
C2524 voutp.n73 VSS 2.07358f
C2525 voutp.n74 VSS 0.7771f
C2526 voutp.t41 VSS 20.2053f
C2527 voutp.n75 VSS 17.705f
C2528 voutp.n76 VSS 11.2012f
C2529 vinn.t0 VSS 0.01135f
C2530 vinn.n0 VSS 0.03514f
.ends
