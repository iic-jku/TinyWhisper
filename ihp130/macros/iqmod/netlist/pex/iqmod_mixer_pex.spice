* PEX produced on Sat Mar 28 07:07:32 PM CET 2026 using /foss/tools/sak/sak-pex.sh with m=1 and s=1
* NGSPICE file created from iqmod_mixer_pex.ext - technology: ihp-sg13g2

.subckt iqmod_mixer_pex vinp_IF VDD vinp_LO vinn_IF VSS vinn_LO voutp_RF
+ voutn_RF
X0 VSS iqmod_mixer_pex_half_1.iqmod_mixer_pex_se2diff_0.iqmod_mixer_pex_se2diff_half_tg$1_0.iqmod_mixer_pex_se2diff_inv_NF18$4_0.vout iqmod_mixer_pex_half_1.iqmod_mixer_pex_tg_0.di_tg_ctrl_n VSS sg13_lv_nmos ad=0.19p pd=1.38u as=0.19p ps=1.38u w=1u l=0.13u
X1 voutp_RF iqmod_mixer_pex_half_1.iqmod_mixer_pex_tg_0.di_tg_ctrl_n voutp_RF VSS sg13_lv_nmos ad=0.57p pd=3.38u as=93.24p ps=0.91908m w=3u l=0.13u
X2 iqmod_mixer_pex_half_1.iqmod_mixer_pex_tg_0.di_tg_ctrl iqmod_mixer_pex_half_1.iqmod_mixer_pex_se2diff_0.iqmod_mixer_pex_se2diff_half_inv$1_0.iqmod_mixer_pex_se2diff_inv_NF18$5_0.vout VDD VDD sg13_lv_pmos ad=0.57p pd=3.38u as=0.57p ps=3.38u w=3u l=0.13u
X3 iqmod_mixer_pex_half_1.iqmod_mixer_pex_tg_0.di_tg_ctrl_n iqmod_mixer_pex_half_1.iqmod_mixer_pex_se2diff_0.iqmod_mixer_pex_se2diff_half_tg$1_0.iqmod_mixer_pex_se2diff_inv_NF18$4_0.vout VSS VSS sg13_lv_nmos ad=0.19p pd=1.38u as=0.19p ps=1.38u w=1u l=0.13u
X4 iqmod_mixer_pex_half_1.iqmod_mixer_pex_tg_0.di_tg_ctrl_n iqmod_mixer_pex_half_1.iqmod_mixer_pex_se2diff_0.iqmod_mixer_pex_se2diff_half_tg$1_0.iqmod_mixer_pex_se2diff_inv_NF18$4_0.vout VSS VSS sg13_lv_nmos ad=0.19p pd=1.38u as=0.19p ps=1.38u w=1u l=0.13u
X5 VDD iqmod_mixer_pex_half_0.iqmod_mixer_pex_se2diff_0.iqmod_mixer_pex_se2diff_half_inv$1_0.iqmod_mixer_pex_se2diff_inv_NF6$5_2.vin iqmod_mixer_pex_half_0.iqmod_mixer_pex_se2diff_0.iqmod_mixer_pex_se2diff_half_inv$1_0.iqmod_mixer_pex_se2diff_inv_NF6$5_2.vout VDD sg13_lv_pmos ad=0.57p pd=3.38u as=0.57p ps=3.38u w=3u l=0.13u
X6 VDD iqmod_mixer_pex_half_1.iqmod_mixer_pex_se2diff_0.iqmod_mixer_pex_se2diff_half_tg$1_0.iqmod_mixer_pex_se2diff_inv_NF6$4_0.vout iqmod_mixer_pex_half_1.iqmod_mixer_pex_se2diff_0.iqmod_mixer_pex_se2diff_half_tg$1_0.iqmod_mixer_pex_se2diff_inv_NF18$4_0.vout VDD sg13_lv_pmos ad=0.57p pd=3.38u as=0.57p ps=3.38u w=3u l=0.13u
X7 iqmod_mixer_pex_half_0.iqmod_mixer_pex_se2diff_0.iqmod_mixer_pex_se2diff_half_inv$1_0.iqmod_mixer_pex_se2diff_inv_NF2$5_0.vout VDD iqmod_mixer_pex_half_0.iqmod_mixer_pex_se2diff_0.iqmod_mixer_pex_se2diff_half_tg$1_0.iqmod_mixer_pex_se2diff_tg_NF6$2_0.v_b VSS sg13_lv_nmos ad=0.19p pd=1.38u as=0.19p ps=1.38u w=1u l=0.13u
X8 VDD VDD VDD VDD sg13_lv_pmos ad=0.57p pd=3.38u as=1.02028n ps=2.72164m w=3u l=0.13u
X9 VSS iqmod_mixer_pex_half_1.iqmod_mixer_pex_se2diff_0.iqmod_mixer_pex_se2diff_half_tg$1_0.iqmod_mixer_pex_se2diff_inv_NF18$4_0.vout iqmod_mixer_pex_half_1.iqmod_mixer_pex_tg_0.di_tg_ctrl_n VSS sg13_lv_nmos ad=0.19p pd=1.38u as=0.19p ps=1.38u w=1u l=0.13u
X10 iqmod_mixer_pex_half_1.iqmod_mixer_pex_se2diff_0.iqmod_mixer_pex_se2diff_half_inv$1_0.iqmod_mixer_pex_se2diff_inv_NF2$5_0.vout vinp_LO VDD VDD sg13_lv_pmos ad=0.57p pd=3.38u as=0.57p ps=3.38u w=3u l=0.13u
X11 iqmod_mixer_pex_half_1.iqmod_mixer_pex_se2diff_0.iqmod_mixer_pex_se2diff_half_tg$1_0.iqmod_mixer_pex_se2diff_inv_NF18$4_0.vout iqmod_mixer_pex_half_1.iqmod_mixer_pex_se2diff_0.iqmod_mixer_pex_se2diff_half_tg$1_0.iqmod_mixer_pex_se2diff_inv_NF6$4_0.vout VDD VDD sg13_lv_pmos ad=0.57p pd=3.38u as=0.57p ps=3.38u w=3u l=0.13u
X12 iqmod_mixer_pex_half_1.iqmod_mixer_pex_tg_0.di_tg_ctrl_n iqmod_mixer_pex_half_1.iqmod_mixer_pex_se2diff_0.iqmod_mixer_pex_se2diff_half_tg$1_0.iqmod_mixer_pex_se2diff_inv_NF18$4_0.vout VDD VDD sg13_lv_pmos ad=0.57p pd=3.38u as=0.57p ps=3.38u w=3u l=0.13u
X13 iqmod_mixer_pex_half_0.iqmod_mixer_pex_se2diff_0.iqmod_mixer_pex_se2diff_half_inv$1_0.iqmod_mixer_pex_se2diff_inv_NF2$5_1.vout iqmod_mixer_pex_half_0.iqmod_mixer_pex_se2diff_0.iqmod_mixer_pex_se2diff_half_inv$1_0.iqmod_mixer_pex_se2diff_inv_NF6$5_2.vout VDD VDD sg13_lv_pmos ad=0.57p pd=3.38u as=0.57p ps=3.38u w=3u l=0.13u
X14 voutn_RF iqmod_mixer_pex_half_0.iqmod_mixer_pex_tg_0.di_tg_ctrl_n voutn_RF VSS sg13_lv_nmos ad=0.57p pd=3.38u as=93.24p ps=0.91908m w=3u l=0.13u
X15 VDD iqmod_mixer_pex_half_1.iqmod_mixer_pex_se2diff_0.iqmod_mixer_pex_se2diff_half_tg$1_0.iqmod_mixer_pex_se2diff_inv_NF18$4_0.vout iqmod_mixer_pex_half_1.iqmod_mixer_pex_tg_0.di_tg_ctrl_n VDD sg13_lv_pmos ad=0.57p pd=3.38u as=0.57p ps=3.38u w=3u l=0.13u
X16 VDD iqmod_mixer_pex_half_0.iqmod_mixer_pex_se2diff_0.iqmod_mixer_pex_se2diff_half_inv$1_0.iqmod_mixer_pex_se2diff_inv_NF6$5_2.vin iqmod_mixer_pex_half_0.iqmod_mixer_pex_se2diff_0.iqmod_mixer_pex_se2diff_half_inv$1_0.iqmod_mixer_pex_se2diff_inv_NF6$5_2.vout VDD sg13_lv_pmos ad=0.57p pd=3.38u as=0.57p ps=3.38u w=3u l=0.13u
X17 iqmod_mixer_pex_half_0.iqmod_mixer_pex_se2diff_0.iqmod_mixer_pex_se2diff_half_inv$1_0.iqmod_mixer_pex_se2diff_inv_NF6$5_2.vin iqmod_mixer_pex_half_0.iqmod_mixer_pex_se2diff_0.iqmod_mixer_pex_se2diff_half_inv$1_0.iqmod_mixer_pex_se2diff_inv_NF2$5_0.vout VDD VDD sg13_lv_pmos ad=0.57p pd=3.38u as=0.57p ps=3.38u w=3u l=0.13u
X18 voutp_RF iqmod_mixer_pex_half_1.iqmod_mixer_pex_tg_0.di_tg_ctrl_n voutp_RF VSS sg13_lv_nmos ad=0.57p pd=3.38u as=0 ps=0 w=3u l=0.13u
X19 iqmod_mixer_pex_half_1.iqmod_mixer_pex_se2diff_0.iqmod_mixer_pex_se2diff_half_inv$1_0.iqmod_mixer_pex_se2diff_inv_NF18$5_0.vout iqmod_mixer_pex_half_1.iqmod_mixer_pex_se2diff_0.iqmod_mixer_pex_se2diff_half_inv$1_0.iqmod_mixer_pex_se2diff_inv_NF6$5_1.vout VSS VSS sg13_lv_nmos ad=0.19p pd=1.38u as=0.19p ps=1.38u w=1u l=0.13u
X20 VSS iqmod_mixer_pex_half_1.iqmod_mixer_pex_se2diff_0.iqmod_mixer_pex_se2diff_half_inv$1_0.iqmod_mixer_pex_se2diff_inv_NF18$5_0.vout iqmod_mixer_pex_half_1.iqmod_mixer_pex_tg_0.di_tg_ctrl VSS sg13_lv_nmos ad=0.19p pd=1.38u as=0.19p ps=1.38u w=1u l=0.13u
X21 voutp_RF iqmod_mixer_pex_half_1.iqmod_mixer_pex_tg_0.di_tg_ctrl vinp_IF VSS sg13_lv_nmos ad=0.57p pd=3.38u as=0.57p ps=3.38u w=3u l=0.13u
X22 voutn_RF iqmod_mixer_pex_half_0.iqmod_mixer_pex_tg_0.di_tg_ctrl_n voutn_RF VSS sg13_lv_nmos ad=0.57p pd=3.38u as=0 ps=0 w=3u l=0.13u
X23 vinn_IF iqmod_mixer_pex_half_0.iqmod_mixer_pex_tg_0.di_tg_ctrl voutn_RF VSS sg13_lv_nmos ad=0.57p pd=3.38u as=0.57p ps=3.38u w=3u l=0.13u
X24 iqmod_mixer_pex_half_1.iqmod_mixer_pex_tg_0.di_tg_ctrl_n iqmod_mixer_pex_half_1.iqmod_mixer_pex_se2diff_0.iqmod_mixer_pex_se2diff_half_tg$1_0.iqmod_mixer_pex_se2diff_inv_NF18$4_0.vout VSS VSS sg13_lv_nmos ad=0.19p pd=1.38u as=0.19p ps=1.38u w=1u l=0.13u
X25 VDD iqmod_mixer_pex_half_0.iqmod_mixer_pex_se2diff_0.iqmod_mixer_pex_se2diff_half_inv$1_0.iqmod_mixer_pex_se2diff_inv_NF2$5_1.vout iqmod_mixer_pex_half_0.iqmod_mixer_pex_se2diff_0.iqmod_mixer_pex_se2diff_half_inv$1_0.iqmod_mixer_pex_se2diff_inv_NF6$5_2.vout VDD sg13_lv_pmos ad=0.57p pd=3.38u as=0.57p ps=3.38u w=3u l=0.13u
X26 iqmod_mixer_pex_half_0.iqmod_mixer_pex_se2diff_0.iqmod_mixer_pex_se2diff_half_inv$1_0.iqmod_mixer_pex_se2diff_inv_NF2$5_1.vout iqmod_mixer_pex_half_0.iqmod_mixer_pex_se2diff_0.iqmod_mixer_pex_se2diff_half_tg$1_0.iqmod_mixer_pex_se2diff_tg_NF6$2_0.v_b VDD VDD sg13_lv_pmos ad=0.57p pd=3.38u as=0.57p ps=3.38u w=3u l=0.13u
X27 iqmod_mixer_pex_half_1.iqmod_mixer_pex_tg_0.di_tg_ctrl iqmod_mixer_pex_half_1.iqmod_mixer_pex_se2diff_0.iqmod_mixer_pex_se2diff_half_inv$1_0.iqmod_mixer_pex_se2diff_inv_NF18$5_0.vout VSS VSS sg13_lv_nmos ad=0.19p pd=1.38u as=0.19p ps=1.38u w=1u l=0.13u
X28 voutn_RF iqmod_mixer_pex_half_0.iqmod_mixer_pex_tg_0.di_tg_ctrl vinn_IF VSS sg13_lv_nmos ad=0.57p pd=3.38u as=0.57p ps=3.38u w=3u l=0.13u
X29 vinn_IF iqmod_mixer_pex_half_0.iqmod_mixer_pex_tg_0.di_tg_ctrl voutn_RF VSS sg13_lv_nmos ad=0.57p pd=3.38u as=0.57p ps=3.38u w=3u l=0.13u
X30 iqmod_mixer_pex_half_0.iqmod_mixer_pex_tg_0.di_tg_ctrl iqmod_mixer_pex_half_0.iqmod_mixer_pex_se2diff_0.iqmod_mixer_pex_se2diff_half_inv$1_0.iqmod_mixer_pex_se2diff_inv_NF18$5_0.vout VDD VDD sg13_lv_pmos ad=0.57p pd=3.38u as=0.57p ps=3.38u w=3u l=0.13u
X31 VDD iqmod_mixer_pex_half_0.iqmod_mixer_pex_se2diff_0.iqmod_mixer_pex_se2diff_half_inv$1_0.iqmod_mixer_pex_se2diff_inv_NF6$5_1.vout iqmod_mixer_pex_half_0.iqmod_mixer_pex_se2diff_0.iqmod_mixer_pex_se2diff_half_inv$1_0.iqmod_mixer_pex_se2diff_inv_NF18$5_0.vout VDD sg13_lv_pmos ad=0.57p pd=3.38u as=0.57p ps=3.38u w=3u l=0.13u
X32 iqmod_mixer_pex_half_1.iqmod_mixer_pex_tg_0.di_tg_ctrl_n iqmod_mixer_pex_half_1.iqmod_mixer_pex_se2diff_0.iqmod_mixer_pex_se2diff_half_tg$1_0.iqmod_mixer_pex_se2diff_inv_NF18$4_0.vout VDD VDD sg13_lv_pmos ad=0.57p pd=3.38u as=0.57p ps=3.38u w=3u l=0.13u
X33 VDD iqmod_mixer_pex_half_1.iqmod_mixer_pex_se2diff_0.iqmod_mixer_pex_se2diff_half_inv$1_0.iqmod_mixer_pex_se2diff_inv_NF6$5_2.vout iqmod_mixer_pex_half_1.iqmod_mixer_pex_se2diff_0.iqmod_mixer_pex_se2diff_half_inv$1_0.iqmod_mixer_pex_se2diff_inv_NF6$5_1.vout VDD sg13_lv_pmos ad=0.57p pd=3.38u as=0.57p ps=3.38u w=3u l=0.13u
X34 iqmod_mixer_pex_half_1.iqmod_mixer_pex_se2diff_0.iqmod_mixer_pex_se2diff_half_inv$1_0.iqmod_mixer_pex_se2diff_inv_NF18$5_0.vout iqmod_mixer_pex_half_1.iqmod_mixer_pex_se2diff_0.iqmod_mixer_pex_se2diff_half_inv$1_0.iqmod_mixer_pex_se2diff_inv_NF6$5_1.vout VDD VDD sg13_lv_pmos ad=0.57p pd=3.38u as=0.57p ps=3.38u w=3u l=0.13u
X35 VDD iqmod_mixer_pex_half_1.iqmod_mixer_pex_se2diff_0.iqmod_mixer_pex_se2diff_half_tg$1_0.iqmod_mixer_pex_se2diff_inv_NF18$4_0.vout iqmod_mixer_pex_half_1.iqmod_mixer_pex_tg_0.di_tg_ctrl_n VDD sg13_lv_pmos ad=0.57p pd=3.38u as=0.57p ps=3.38u w=3u l=0.13u
X36 iqmod_mixer_pex_half_0.iqmod_mixer_pex_tg_0.di_tg_ctrl iqmod_mixer_pex_half_0.iqmod_mixer_pex_se2diff_0.iqmod_mixer_pex_se2diff_half_inv$1_0.iqmod_mixer_pex_se2diff_inv_NF18$5_0.vout VDD VDD sg13_lv_pmos ad=0.57p pd=3.38u as=0.57p ps=3.38u w=3u l=0.13u
X37 vinn_IF iqmod_mixer_pex_half_0.iqmod_mixer_pex_tg_0.di_tg_ctrl voutn_RF VSS sg13_lv_nmos ad=0.57p pd=3.38u as=0.57p ps=3.38u w=3u l=0.13u
X38 vinn_IF iqmod_mixer_pex_half_0.iqmod_mixer_pex_tg_0.di_tg_ctrl voutn_RF VSS sg13_lv_nmos ad=0.57p pd=3.38u as=0.57p ps=3.38u w=3u l=0.13u
X39 VDD iqmod_mixer_pex_half_1.iqmod_mixer_pex_se2diff_0.iqmod_mixer_pex_se2diff_half_inv$1_0.iqmod_mixer_pex_se2diff_inv_NF18$5_0.vout iqmod_mixer_pex_half_1.iqmod_mixer_pex_tg_0.di_tg_ctrl VDD sg13_lv_pmos ad=0.57p pd=3.38u as=0.57p ps=3.38u w=3u l=0.13u
X40 iqmod_mixer_pex_half_1.iqmod_mixer_pex_se2diff_0.iqmod_mixer_pex_se2diff_half_inv$1_0.iqmod_mixer_pex_se2diff_inv_NF2$5_1.vout iqmod_mixer_pex_half_1.iqmod_mixer_pex_se2diff_0.iqmod_mixer_pex_se2diff_half_tg$1_0.iqmod_mixer_pex_se2diff_tg_NF6$2_0.v_b VDD VDD sg13_lv_pmos ad=0.57p pd=3.38u as=0.57p ps=3.38u w=3u l=0.13u
X41 VDD VDD VDD VDD sg13_lv_pmos ad=0.57p pd=3.38u as=0 ps=0 w=3u l=0.13u
X42 VDD iqmod_mixer_pex_half_0.iqmod_mixer_pex_se2diff_0.iqmod_mixer_pex_se2diff_half_tg$1_0.iqmod_mixer_pex_se2diff_inv_NF18$4_0.vout iqmod_mixer_pex_half_0.iqmod_mixer_pex_tg_0.di_tg_ctrl_n VDD sg13_lv_pmos ad=0.57p pd=3.38u as=0.57p ps=3.38u w=3u l=0.13u
X43 VDD iqmod_mixer_pex_half_0.iqmod_mixer_pex_se2diff_0.iqmod_mixer_pex_se2diff_half_tg$1_0.iqmod_mixer_pex_se2diff_inv_NF18$4_0.vout iqmod_mixer_pex_half_0.iqmod_mixer_pex_tg_0.di_tg_ctrl_n VDD sg13_lv_pmos ad=0.57p pd=3.38u as=0.57p ps=3.38u w=3u l=0.13u
X44 VDD iqmod_mixer_pex_half_0.iqmod_mixer_pex_se2diff_0.iqmod_mixer_pex_se2diff_half_inv$1_0.iqmod_mixer_pex_se2diff_inv_NF6$5_1.vout iqmod_mixer_pex_half_0.iqmod_mixer_pex_se2diff_0.iqmod_mixer_pex_se2diff_half_inv$1_0.iqmod_mixer_pex_se2diff_inv_NF18$5_0.vout VDD sg13_lv_pmos ad=0.57p pd=3.38u as=0.57p ps=3.38u w=3u l=0.13u
X45 iqmod_mixer_pex_half_0.iqmod_mixer_pex_se2diff_0.iqmod_mixer_pex_se2diff_half_inv$1_0.iqmod_mixer_pex_se2diff_inv_NF6$5_1.vout iqmod_mixer_pex_half_0.iqmod_mixer_pex_se2diff_0.iqmod_mixer_pex_se2diff_half_inv$1_0.iqmod_mixer_pex_se2diff_inv_NF6$5_2.vout VDD VDD sg13_lv_pmos ad=0.57p pd=3.38u as=0.57p ps=3.38u w=3u l=0.13u
X46 iqmod_mixer_pex_half_1.iqmod_mixer_pex_tg_0.di_tg_ctrl iqmod_mixer_pex_half_1.iqmod_mixer_pex_se2diff_0.iqmod_mixer_pex_se2diff_half_inv$1_0.iqmod_mixer_pex_se2diff_inv_NF18$5_0.vout VDD VDD sg13_lv_pmos ad=0.57p pd=3.38u as=0.57p ps=3.38u w=3u l=0.13u
X47 iqmod_mixer_pex_half_1.iqmod_mixer_pex_tg_0.di_tg_ctrl iqmod_mixer_pex_half_1.iqmod_mixer_pex_se2diff_0.iqmod_mixer_pex_se2diff_half_inv$1_0.iqmod_mixer_pex_se2diff_inv_NF18$5_0.vout VSS VSS sg13_lv_nmos ad=0.19p pd=1.38u as=0.19p ps=1.38u w=1u l=0.13u
X48 VSS iqmod_mixer_pex_half_1.iqmod_mixer_pex_se2diff_0.iqmod_mixer_pex_se2diff_half_tg$1_0.iqmod_mixer_pex_se2diff_inv_NF6$4_0.vout iqmod_mixer_pex_half_1.iqmod_mixer_pex_se2diff_0.iqmod_mixer_pex_se2diff_half_tg$1_0.iqmod_mixer_pex_se2diff_inv_NF18$4_0.vout VSS sg13_lv_nmos ad=0.19p pd=1.38u as=0.19p ps=1.38u w=1u l=0.13u
X49 voutp_RF iqmod_mixer_pex_half_1.iqmod_mixer_pex_tg_0.di_tg_ctrl_n vinp_IF VDD sg13_lv_pmos ad=1.71p pd=9.38u as=1.71p ps=9.38u w=9u l=0.13u
X50 VSS iqmod_mixer_pex_half_0.iqmod_mixer_pex_se2diff_0.iqmod_mixer_pex_se2diff_half_inv$1_0.iqmod_mixer_pex_se2diff_inv_NF18$5_0.vout iqmod_mixer_pex_half_0.iqmod_mixer_pex_tg_0.di_tg_ctrl VSS sg13_lv_nmos ad=0.19p pd=1.38u as=0.19p ps=1.38u w=1u l=0.13u
X51 vinn_IF iqmod_mixer_pex_half_0.iqmod_mixer_pex_tg_0.di_tg_ctrl voutn_RF VSS sg13_lv_nmos ad=0.57p pd=3.38u as=0.57p ps=3.38u w=3u l=0.13u
X52 VDD iqmod_mixer_pex_half_0.iqmod_mixer_pex_se2diff_0.iqmod_mixer_pex_se2diff_half_tg$1_0.iqmod_mixer_pex_se2diff_inv_NF18$4_0.vout iqmod_mixer_pex_half_0.iqmod_mixer_pex_tg_0.di_tg_ctrl_n VDD sg13_lv_pmos ad=0.57p pd=3.38u as=0.57p ps=3.38u w=3u l=0.13u
X53 iqmod_mixer_pex_half_0.iqmod_mixer_pex_tg_0.di_tg_ctrl iqmod_mixer_pex_half_0.iqmod_mixer_pex_se2diff_0.iqmod_mixer_pex_se2diff_half_inv$1_0.iqmod_mixer_pex_se2diff_inv_NF18$5_0.vout VDD VDD sg13_lv_pmos ad=0.57p pd=3.38u as=0.57p ps=3.38u w=3u l=0.13u
X54 VSS iqmod_mixer_pex_half_0.iqmod_mixer_pex_se2diff_0.iqmod_mixer_pex_se2diff_half_inv$1_0.iqmod_mixer_pex_se2diff_inv_NF18$5_0.vout iqmod_mixer_pex_half_0.iqmod_mixer_pex_tg_0.di_tg_ctrl VSS sg13_lv_nmos ad=0.19p pd=1.38u as=0.19p ps=1.38u w=1u l=0.13u
X55 VDD iqmod_mixer_pex_half_1.iqmod_mixer_pex_se2diff_0.iqmod_mixer_pex_se2diff_half_inv$1_0.iqmod_mixer_pex_se2diff_inv_NF6$5_2.vin iqmod_mixer_pex_half_1.iqmod_mixer_pex_se2diff_0.iqmod_mixer_pex_se2diff_half_inv$1_0.iqmod_mixer_pex_se2diff_inv_NF6$5_2.vout VDD sg13_lv_pmos ad=0.57p pd=3.38u as=0.57p ps=3.38u w=3u l=0.13u
X56 vinp_IF iqmod_mixer_pex_half_1.iqmod_mixer_pex_tg_0.di_tg_ctrl_n voutp_RF VDD sg13_lv_pmos ad=1.71p pd=9.38u as=1.71p ps=9.38u w=9u l=0.13u
X57 VDD iqmod_mixer_pex_half_0.iqmod_mixer_pex_se2diff_0.iqmod_mixer_pex_se2diff_half_inv$1_0.iqmod_mixer_pex_se2diff_inv_NF2$5_1.vout iqmod_mixer_pex_half_0.iqmod_mixer_pex_se2diff_0.iqmod_mixer_pex_se2diff_half_tg$1_0.iqmod_mixer_pex_se2diff_inv_NF6$4_0.vout VDD sg13_lv_pmos ad=0.57p pd=3.38u as=0.57p ps=3.38u w=3u l=0.13u
X58 iqmod_mixer_pex_half_0.iqmod_mixer_pex_se2diff_0.iqmod_mixer_pex_se2diff_half_tg$1_0.iqmod_mixer_pex_se2diff_inv_NF18$4_0.vout iqmod_mixer_pex_half_0.iqmod_mixer_pex_se2diff_0.iqmod_mixer_pex_se2diff_half_tg$1_0.iqmod_mixer_pex_se2diff_inv_NF6$4_0.vout VDD VDD sg13_lv_pmos ad=0.57p pd=3.38u as=0.57p ps=3.38u w=3u l=0.13u
X59 iqmod_mixer_pex_half_0.iqmod_mixer_pex_se2diff_0.iqmod_mixer_pex_se2diff_half_tg$1_0.iqmod_mixer_pex_se2diff_inv_NF18$4_0.vout iqmod_mixer_pex_half_0.iqmod_mixer_pex_se2diff_0.iqmod_mixer_pex_se2diff_half_tg$1_0.iqmod_mixer_pex_se2diff_inv_NF6$4_0.vout VDD VDD sg13_lv_pmos ad=0.57p pd=3.38u as=0.57p ps=3.38u w=3u l=0.13u
X60 VDD iqmod_mixer_pex_half_0.iqmod_mixer_pex_se2diff_0.iqmod_mixer_pex_se2diff_half_tg$1_0.iqmod_mixer_pex_se2diff_inv_NF18$4_0.vout iqmod_mixer_pex_half_0.iqmod_mixer_pex_tg_0.di_tg_ctrl_n VDD sg13_lv_pmos ad=0.57p pd=3.38u as=0.57p ps=3.38u w=3u l=0.13u
X61 iqmod_mixer_pex_half_1.iqmod_mixer_pex_tg_0.di_tg_ctrl iqmod_mixer_pex_half_1.iqmod_mixer_pex_se2diff_0.iqmod_mixer_pex_se2diff_half_inv$1_0.iqmod_mixer_pex_se2diff_inv_NF18$5_0.vout VDD VDD sg13_lv_pmos ad=0.57p pd=3.38u as=0.57p ps=3.38u w=3u l=0.13u
X62 iqmod_mixer_pex_half_1.iqmod_mixer_pex_se2diff_0.iqmod_mixer_pex_se2diff_half_inv$1_0.iqmod_mixer_pex_se2diff_inv_NF6$5_2.vout iqmod_mixer_pex_half_1.iqmod_mixer_pex_se2diff_0.iqmod_mixer_pex_se2diff_half_inv$1_0.iqmod_mixer_pex_se2diff_inv_NF6$5_2.vin VDD VDD sg13_lv_pmos ad=0.57p pd=3.38u as=0.57p ps=3.38u w=3u l=0.13u
X63 iqmod_mixer_pex_half_1.iqmod_mixer_pex_se2diff_0.iqmod_mixer_pex_se2diff_half_inv$1_0.iqmod_mixer_pex_se2diff_inv_NF6$5_1.vout iqmod_mixer_pex_half_1.iqmod_mixer_pex_se2diff_0.iqmod_mixer_pex_se2diff_half_inv$1_0.iqmod_mixer_pex_se2diff_inv_NF6$5_2.vout VSS VSS sg13_lv_nmos ad=0.19p pd=1.38u as=0.19p ps=1.38u w=1u l=0.13u
X64 voutp_RF iqmod_mixer_pex_half_1.iqmod_mixer_pex_tg_0.di_tg_ctrl_n vinp_IF VDD sg13_lv_pmos ad=1.71p pd=9.38u as=1.71p ps=9.38u w=9u l=0.13u
X65 VSS iqmod_mixer_pex_half_0.iqmod_mixer_pex_se2diff_0.iqmod_mixer_pex_se2diff_half_inv$1_0.iqmod_mixer_pex_se2diff_inv_NF18$5_0.vout iqmod_mixer_pex_half_0.iqmod_mixer_pex_tg_0.di_tg_ctrl VSS sg13_lv_nmos ad=0.19p pd=1.38u as=0.19p ps=1.38u w=1u l=0.13u
X66 VSS iqmod_mixer_pex_half_0.iqmod_mixer_pex_se2diff_0.iqmod_mixer_pex_se2diff_half_inv$1_0.iqmod_mixer_pex_se2diff_inv_NF18$5_0.vout iqmod_mixer_pex_half_0.iqmod_mixer_pex_tg_0.di_tg_ctrl VSS sg13_lv_nmos ad=0.19p pd=1.38u as=0.19p ps=1.38u w=1u l=0.13u
X67 VSS iqmod_mixer_pex_half_0.iqmod_mixer_pex_se2diff_0.iqmod_mixer_pex_se2diff_half_inv$1_0.iqmod_mixer_pex_se2diff_inv_NF18$5_0.vout iqmod_mixer_pex_half_0.iqmod_mixer_pex_tg_0.di_tg_ctrl VSS sg13_lv_nmos ad=0.19p pd=1.38u as=0.19p ps=1.38u w=1u l=0.13u
X68 iqmod_mixer_pex_half_0.iqmod_mixer_pex_se2diff_0.iqmod_mixer_pex_se2diff_half_inv$1_0.iqmod_mixer_pex_se2diff_inv_NF18$5_0.vout iqmod_mixer_pex_half_0.iqmod_mixer_pex_se2diff_0.iqmod_mixer_pex_se2diff_half_inv$1_0.iqmod_mixer_pex_se2diff_inv_NF6$5_1.vout VSS VSS sg13_lv_nmos ad=0.19p pd=1.38u as=0.19p ps=1.38u w=1u l=0.13u
X69 VDD iqmod_mixer_pex_half_1.iqmod_mixer_pex_se2diff_0.iqmod_mixer_pex_se2diff_half_tg$1_0.iqmod_mixer_pex_se2diff_tg_NF6$2_0.v_b iqmod_mixer_pex_half_1.iqmod_mixer_pex_se2diff_0.iqmod_mixer_pex_se2diff_half_inv$1_0.iqmod_mixer_pex_se2diff_inv_NF2$5_1.vout VDD sg13_lv_pmos ad=0.57p pd=3.38u as=0.57p ps=3.38u w=3u l=0.13u
X70 VDD VDD VDD VDD sg13_lv_pmos ad=1.02p pd=6.68u as=0 ps=0 w=3u l=0.13u
X71 VDD iqmod_mixer_pex_half_0.iqmod_mixer_pex_se2diff_0.iqmod_mixer_pex_se2diff_half_tg$1_0.iqmod_mixer_pex_se2diff_inv_NF18$4_0.vout iqmod_mixer_pex_half_0.iqmod_mixer_pex_tg_0.di_tg_ctrl_n VDD sg13_lv_pmos ad=0.57p pd=3.38u as=0.57p ps=3.38u w=3u l=0.13u
X72 VSS iqmod_mixer_pex_half_1.iqmod_mixer_pex_se2diff_0.iqmod_mixer_pex_se2diff_half_inv$1_0.iqmod_mixer_pex_se2diff_inv_NF6$5_2.vout iqmod_mixer_pex_half_1.iqmod_mixer_pex_se2diff_0.iqmod_mixer_pex_se2diff_half_inv$1_0.iqmod_mixer_pex_se2diff_inv_NF6$5_1.vout VSS sg13_lv_nmos ad=0.19p pd=1.38u as=0.19p ps=1.38u w=1u l=0.13u
X73 iqmod_mixer_pex_half_1.iqmod_mixer_pex_tg_0.di_tg_ctrl iqmod_mixer_pex_half_1.iqmod_mixer_pex_se2diff_0.iqmod_mixer_pex_se2diff_half_inv$1_0.iqmod_mixer_pex_se2diff_inv_NF18$5_0.vout VDD VDD sg13_lv_pmos ad=0.57p pd=3.38u as=0.57p ps=3.38u w=3u l=0.13u
X74 VSS iqmod_mixer_pex_half_1.iqmod_mixer_pex_se2diff_0.iqmod_mixer_pex_se2diff_half_tg$1_0.iqmod_mixer_pex_se2diff_inv_NF6$4_0.vout iqmod_mixer_pex_half_1.iqmod_mixer_pex_se2diff_0.iqmod_mixer_pex_se2diff_half_tg$1_0.iqmod_mixer_pex_se2diff_inv_NF18$4_0.vout VSS sg13_lv_nmos ad=0.19p pd=1.38u as=0.19p ps=1.38u w=1u l=0.13u
X75 VDD iqmod_mixer_pex_half_1.iqmod_mixer_pex_se2diff_0.iqmod_mixer_pex_se2diff_half_tg$1_0.iqmod_mixer_pex_se2diff_inv_NF6$4_0.vout iqmod_mixer_pex_half_1.iqmod_mixer_pex_se2diff_0.iqmod_mixer_pex_se2diff_half_tg$1_0.iqmod_mixer_pex_se2diff_inv_NF18$4_0.vout VDD sg13_lv_pmos ad=0.57p pd=3.38u as=0.57p ps=3.38u w=3u l=0.13u
X76 iqmod_mixer_pex_half_1.iqmod_mixer_pex_tg_0.di_tg_ctrl iqmod_mixer_pex_half_1.iqmod_mixer_pex_se2diff_0.iqmod_mixer_pex_se2diff_half_inv$1_0.iqmod_mixer_pex_se2diff_inv_NF18$5_0.vout VDD VDD sg13_lv_pmos ad=0.57p pd=3.38u as=0.57p ps=3.38u w=3u l=0.13u
X77 voutp_RF iqmod_mixer_pex_half_1.iqmod_mixer_pex_tg_0.di_tg_ctrl vinp_IF VSS sg13_lv_nmos ad=0.57p pd=3.38u as=0.57p ps=3.38u w=3u l=0.13u
X78 VSS VSS VSS VSS sg13_lv_nmos ad=0.34p pd=2.68u as=0.98653n ps=1.83112m w=1u l=0.13u
X79 iqmod_mixer_pex_half_0.iqmod_mixer_pex_se2diff_0.iqmod_mixer_pex_se2diff_half_inv$1_0.iqmod_mixer_pex_se2diff_inv_NF18$5_0.vout iqmod_mixer_pex_half_0.iqmod_mixer_pex_se2diff_0.iqmod_mixer_pex_se2diff_half_inv$1_0.iqmod_mixer_pex_se2diff_inv_NF6$5_1.vout VSS VSS sg13_lv_nmos ad=0.19p pd=1.38u as=0.19p ps=1.38u w=1u l=0.13u
X80 VDD iqmod_mixer_pex_half_1.iqmod_mixer_pex_se2diff_0.iqmod_mixer_pex_se2diff_half_inv$1_0.iqmod_mixer_pex_se2diff_inv_NF18$5_0.vout iqmod_mixer_pex_half_1.iqmod_mixer_pex_tg_0.di_tg_ctrl VDD sg13_lv_pmos ad=0.57p pd=3.38u as=0.57p ps=3.38u w=3u l=0.13u
X81 iqmod_mixer_pex_half_1.iqmod_mixer_pex_se2diff_0.iqmod_mixer_pex_se2diff_half_tg$1_0.iqmod_mixer_pex_se2diff_inv_NF18$4_0.vout iqmod_mixer_pex_half_1.iqmod_mixer_pex_se2diff_0.iqmod_mixer_pex_se2diff_half_tg$1_0.iqmod_mixer_pex_se2diff_inv_NF6$4_0.vout VDD VDD sg13_lv_pmos ad=0.57p pd=3.38u as=0.57p ps=3.38u w=3u l=0.13u
X82 VSS iqmod_mixer_pex_half_0.iqmod_mixer_pex_se2diff_0.iqmod_mixer_pex_se2diff_half_inv$1_0.iqmod_mixer_pex_se2diff_inv_NF18$5_0.vout iqmod_mixer_pex_half_0.iqmod_mixer_pex_tg_0.di_tg_ctrl VSS sg13_lv_nmos ad=0.19p pd=1.38u as=0.19p ps=1.38u w=1u l=0.13u
X83 VSS iqmod_mixer_pex_half_0.iqmod_mixer_pex_se2diff_0.iqmod_mixer_pex_se2diff_half_inv$1_0.iqmod_mixer_pex_se2diff_inv_NF6$5_2.vout iqmod_mixer_pex_half_0.iqmod_mixer_pex_se2diff_0.iqmod_mixer_pex_se2diff_half_inv$1_0.iqmod_mixer_pex_se2diff_inv_NF6$5_1.vout VSS sg13_lv_nmos ad=0.19p pd=1.38u as=0.19p ps=1.38u w=1u l=0.13u
X84 iqmod_mixer_pex_half_1.iqmod_mixer_pex_se2diff_0.iqmod_mixer_pex_se2diff_half_tg$1_0.iqmod_mixer_pex_se2diff_inv_NF18$4_0.vout iqmod_mixer_pex_half_1.iqmod_mixer_pex_se2diff_0.iqmod_mixer_pex_se2diff_half_tg$1_0.iqmod_mixer_pex_se2diff_inv_NF6$4_0.vout VSS VSS sg13_lv_nmos ad=0.19p pd=1.38u as=0.19p ps=1.38u w=1u l=0.13u
X85 vinp_IF iqmod_mixer_pex_half_1.iqmod_mixer_pex_tg_0.di_tg_ctrl voutp_RF VSS sg13_lv_nmos ad=0.57p pd=3.38u as=0.57p ps=3.38u w=3u l=0.13u
X86 VSS iqmod_mixer_pex_half_1.iqmod_mixer_pex_se2diff_0.iqmod_mixer_pex_se2diff_half_tg$1_0.iqmod_mixer_pex_se2diff_inv_NF18$4_0.vout iqmod_mixer_pex_half_1.iqmod_mixer_pex_tg_0.di_tg_ctrl_n VSS sg13_lv_nmos ad=0.19p pd=1.38u as=0.19p ps=1.38u w=1u l=0.13u
X87 VDD iqmod_mixer_pex_half_1.iqmod_mixer_pex_se2diff_0.iqmod_mixer_pex_se2diff_half_tg$1_0.iqmod_mixer_pex_se2diff_inv_NF18$4_0.vout iqmod_mixer_pex_half_1.iqmod_mixer_pex_tg_0.di_tg_ctrl_n VDD sg13_lv_pmos ad=0.57p pd=3.38u as=0.57p ps=3.38u w=3u l=0.13u
X88 iqmod_mixer_pex_half_1.iqmod_mixer_pex_se2diff_0.iqmod_mixer_pex_se2diff_half_inv$1_0.iqmod_mixer_pex_se2diff_inv_NF6$5_2.vin iqmod_mixer_pex_half_1.iqmod_mixer_pex_se2diff_0.iqmod_mixer_pex_se2diff_half_inv$1_0.iqmod_mixer_pex_se2diff_inv_NF2$5_0.vout VSS VSS sg13_lv_nmos ad=0.19p pd=1.38u as=0.19p ps=1.38u w=1u l=0.13u
X89 iqmod_mixer_pex_half_1.iqmod_mixer_pex_tg_0.di_tg_ctrl_n iqmod_mixer_pex_half_1.iqmod_mixer_pex_se2diff_0.iqmod_mixer_pex_se2diff_half_tg$1_0.iqmod_mixer_pex_se2diff_inv_NF18$4_0.vout VDD VDD sg13_lv_pmos ad=0.57p pd=3.38u as=0.57p ps=3.38u w=3u l=0.13u
X90 VSS iqmod_mixer_pex_half_0.iqmod_mixer_pex_se2diff_0.iqmod_mixer_pex_se2diff_half_inv$1_0.iqmod_mixer_pex_se2diff_inv_NF18$5_0.vout iqmod_mixer_pex_half_0.iqmod_mixer_pex_tg_0.di_tg_ctrl VSS sg13_lv_nmos ad=0.19p pd=1.38u as=0.19p ps=1.38u w=1u l=0.13u
X91 iqmod_mixer_pex_half_1.iqmod_mixer_pex_tg_0.di_tg_ctrl_n iqmod_mixer_pex_half_1.iqmod_mixer_pex_se2diff_0.iqmod_mixer_pex_se2diff_half_tg$1_0.iqmod_mixer_pex_se2diff_inv_NF18$4_0.vout VSS VSS sg13_lv_nmos ad=0.19p pd=1.38u as=0.19p ps=1.38u w=1u l=0.13u
X92 VDD iqmod_mixer_pex_half_0.iqmod_mixer_pex_se2diff_0.iqmod_mixer_pex_se2diff_half_inv$1_0.iqmod_mixer_pex_se2diff_inv_NF2$5_0.vout iqmod_mixer_pex_half_0.iqmod_mixer_pex_se2diff_0.iqmod_mixer_pex_se2diff_half_inv$1_0.iqmod_mixer_pex_se2diff_inv_NF6$5_2.vin VDD sg13_lv_pmos ad=0.57p pd=3.38u as=0.57p ps=3.38u w=3u l=0.13u
X93 VSS iqmod_mixer_pex_half_1.iqmod_mixer_pex_se2diff_0.iqmod_mixer_pex_se2diff_half_inv$1_0.iqmod_mixer_pex_se2diff_inv_NF2$5_0.vout iqmod_mixer_pex_half_1.iqmod_mixer_pex_se2diff_0.iqmod_mixer_pex_se2diff_half_inv$1_0.iqmod_mixer_pex_se2diff_inv_NF6$5_2.vin VSS sg13_lv_nmos ad=0.19p pd=1.38u as=0.19p ps=1.38u w=1u l=0.13u
X94 VDD iqmod_mixer_pex_half_0.iqmod_mixer_pex_se2diff_0.iqmod_mixer_pex_se2diff_half_tg$1_0.iqmod_mixer_pex_se2diff_tg_NF6$2_0.v_b iqmod_mixer_pex_half_0.iqmod_mixer_pex_se2diff_0.iqmod_mixer_pex_se2diff_half_inv$1_0.iqmod_mixer_pex_se2diff_inv_NF2$5_1.vout VDD sg13_lv_pmos ad=0.57p pd=3.38u as=0.57p ps=3.38u w=3u l=0.13u
X95 VDD VDD VDD VDD sg13_lv_pmos ad=1.02p pd=6.68u as=0 ps=0 w=3u l=0.13u
X96 iqmod_mixer_pex_half_1.iqmod_mixer_pex_tg_0.di_tg_ctrl iqmod_mixer_pex_half_1.iqmod_mixer_pex_se2diff_0.iqmod_mixer_pex_se2diff_half_inv$1_0.iqmod_mixer_pex_se2diff_inv_NF18$5_0.vout VSS VSS sg13_lv_nmos ad=0.19p pd=1.38u as=0.19p ps=1.38u w=1u l=0.13u
X97 VSS VSS VSS VSS sg13_lv_nmos ad=0.34p pd=2.68u as=0 ps=0 w=1u l=0.13u
X98 iqmod_mixer_pex_half_0.iqmod_mixer_pex_se2diff_0.iqmod_mixer_pex_se2diff_half_tg$1_0.iqmod_mixer_pex_se2diff_tg_NF6$2_0.v_b VSS iqmod_mixer_pex_half_0.iqmod_mixer_pex_se2diff_0.iqmod_mixer_pex_se2diff_half_inv$1_0.iqmod_mixer_pex_se2diff_inv_NF2$5_0.vout VDD sg13_lv_pmos ad=0.57p pd=3.38u as=0.57p ps=3.38u w=3u l=0.13u
X99 iqmod_mixer_pex_half_0.iqmod_mixer_pex_se2diff_0.iqmod_mixer_pex_se2diff_half_inv$1_0.iqmod_mixer_pex_se2diff_inv_NF2$5_0.vout vinn_LO VSS VSS sg13_lv_nmos ad=0.19p pd=1.38u as=0.19p ps=1.38u w=1u l=0.13u
X100 voutn_RF iqmod_mixer_pex_half_0.iqmod_mixer_pex_tg_0.di_tg_ctrl voutn_RF VDD sg13_lv_pmos ad=1.71p pd=9.38u as=0 ps=0 w=9u l=0.13u
X101 iqmod_mixer_pex_half_0.iqmod_mixer_pex_tg_0.di_tg_ctrl_n iqmod_mixer_pex_half_0.iqmod_mixer_pex_se2diff_0.iqmod_mixer_pex_se2diff_half_tg$1_0.iqmod_mixer_pex_se2diff_inv_NF18$4_0.vout VSS VSS sg13_lv_nmos ad=0.19p pd=1.38u as=0.19p ps=1.38u w=1u l=0.13u
X102 iqmod_mixer_pex_half_0.iqmod_mixer_pex_tg_0.di_tg_ctrl_n iqmod_mixer_pex_half_0.iqmod_mixer_pex_se2diff_0.iqmod_mixer_pex_se2diff_half_tg$1_0.iqmod_mixer_pex_se2diff_inv_NF18$4_0.vout VSS VSS sg13_lv_nmos ad=0.19p pd=1.38u as=0.19p ps=1.38u w=1u l=0.13u
X103 iqmod_mixer_pex_half_1.iqmod_mixer_pex_tg_0.di_tg_ctrl iqmod_mixer_pex_half_1.iqmod_mixer_pex_se2diff_0.iqmod_mixer_pex_se2diff_half_inv$1_0.iqmod_mixer_pex_se2diff_inv_NF18$5_0.vout VSS VSS sg13_lv_nmos ad=0.19p pd=1.38u as=0.19p ps=1.38u w=1u l=0.13u
X104 vinp_IF iqmod_mixer_pex_half_1.iqmod_mixer_pex_tg_0.di_tg_ctrl voutp_RF VSS sg13_lv_nmos ad=0.57p pd=3.38u as=0.57p ps=3.38u w=3u l=0.13u
X105 VSS iqmod_mixer_pex_half_1.iqmod_mixer_pex_se2diff_0.iqmod_mixer_pex_se2diff_half_inv$1_0.iqmod_mixer_pex_se2diff_inv_NF18$5_0.vout iqmod_mixer_pex_half_1.iqmod_mixer_pex_tg_0.di_tg_ctrl VSS sg13_lv_nmos ad=0.19p pd=1.38u as=0.19p ps=1.38u w=1u l=0.13u
X106 VDD VDD VDD VDD sg13_lv_pmos ad=1.02p pd=6.68u as=0 ps=0 w=3u l=0.13u
X107 vinn_IF iqmod_mixer_pex_half_0.iqmod_mixer_pex_tg_0.di_tg_ctrl_n voutn_RF VDD sg13_lv_pmos ad=1.71p pd=9.38u as=1.71p ps=9.38u w=9u l=0.13u
X108 VSS iqmod_mixer_pex_half_0.iqmod_mixer_pex_se2diff_0.iqmod_mixer_pex_se2diff_half_inv$1_0.iqmod_mixer_pex_se2diff_inv_NF6$5_2.vin iqmod_mixer_pex_half_0.iqmod_mixer_pex_se2diff_0.iqmod_mixer_pex_se2diff_half_inv$1_0.iqmod_mixer_pex_se2diff_inv_NF6$5_2.vout VSS sg13_lv_nmos ad=0.19p pd=1.38u as=0.19p ps=1.38u w=1u l=0.13u
X109 VSS VSS VSS VSS sg13_lv_nmos ad=0.19p pd=1.38u as=0 ps=0 w=1u l=0.13u
X110 VDD iqmod_mixer_pex_half_1.iqmod_mixer_pex_se2diff_0.iqmod_mixer_pex_se2diff_half_tg$1_0.iqmod_mixer_pex_se2diff_inv_NF18$4_0.vout iqmod_mixer_pex_half_1.iqmod_mixer_pex_tg_0.di_tg_ctrl_n VDD sg13_lv_pmos ad=0.57p pd=3.38u as=0.57p ps=3.38u w=3u l=0.13u
X111 iqmod_mixer_pex_half_0.iqmod_mixer_pex_se2diff_0.iqmod_mixer_pex_se2diff_half_tg$1_0.iqmod_mixer_pex_se2diff_tg_NF6$2_0.v_b VSS iqmod_mixer_pex_half_0.iqmod_mixer_pex_se2diff_0.iqmod_mixer_pex_se2diff_half_inv$1_0.iqmod_mixer_pex_se2diff_inv_NF2$5_0.vout VDD sg13_lv_pmos ad=0.57p pd=3.38u as=1.02p ps=6.68u w=3u l=0.13u
X112 iqmod_mixer_pex_half_1.iqmod_mixer_pex_tg_0.di_tg_ctrl_n iqmod_mixer_pex_half_1.iqmod_mixer_pex_se2diff_0.iqmod_mixer_pex_se2diff_half_tg$1_0.iqmod_mixer_pex_se2diff_inv_NF18$4_0.vout VDD VDD sg13_lv_pmos ad=0.57p pd=3.38u as=0.57p ps=3.38u w=3u l=0.13u
X113 VSS iqmod_mixer_pex_half_0.iqmod_mixer_pex_se2diff_0.iqmod_mixer_pex_se2diff_half_tg$1_0.iqmod_mixer_pex_se2diff_inv_NF6$4_0.vout iqmod_mixer_pex_half_0.iqmod_mixer_pex_se2diff_0.iqmod_mixer_pex_se2diff_half_tg$1_0.iqmod_mixer_pex_se2diff_inv_NF18$4_0.vout VSS sg13_lv_nmos ad=0.19p pd=1.38u as=0.19p ps=1.38u w=1u l=0.13u
X114 voutn_RF iqmod_mixer_pex_half_0.iqmod_mixer_pex_tg_0.di_tg_ctrl voutn_RF VDD sg13_lv_pmos ad=1.71p pd=9.38u as=0 ps=0 w=9u l=0.13u
X115 iqmod_mixer_pex_half_0.iqmod_mixer_pex_tg_0.di_tg_ctrl_n iqmod_mixer_pex_half_0.iqmod_mixer_pex_se2diff_0.iqmod_mixer_pex_se2diff_half_tg$1_0.iqmod_mixer_pex_se2diff_inv_NF18$4_0.vout VSS VSS sg13_lv_nmos ad=0.19p pd=1.38u as=0.19p ps=1.38u w=1u l=0.13u
X116 iqmod_mixer_pex_half_1.iqmod_mixer_pex_se2diff_0.iqmod_mixer_pex_se2diff_half_inv$1_0.iqmod_mixer_pex_se2diff_inv_NF18$5_0.vout iqmod_mixer_pex_half_1.iqmod_mixer_pex_se2diff_0.iqmod_mixer_pex_se2diff_half_inv$1_0.iqmod_mixer_pex_se2diff_inv_NF6$5_1.vout VDD VDD sg13_lv_pmos ad=0.57p pd=3.38u as=0.57p ps=3.38u w=3u l=0.13u
X117 iqmod_mixer_pex_half_0.iqmod_mixer_pex_se2diff_0.iqmod_mixer_pex_se2diff_half_inv$1_0.iqmod_mixer_pex_se2diff_inv_NF2$5_1.vout iqmod_mixer_pex_half_0.iqmod_mixer_pex_se2diff_0.iqmod_mixer_pex_se2diff_half_inv$1_0.iqmod_mixer_pex_se2diff_inv_NF6$5_2.vout VSS VSS sg13_lv_nmos ad=0.19p pd=1.38u as=0.19p ps=1.38u w=1u l=0.13u
X118 vinn_IF iqmod_mixer_pex_half_0.iqmod_mixer_pex_tg_0.di_tg_ctrl_n voutn_RF VDD sg13_lv_pmos ad=1.71p pd=9.38u as=1.71p ps=9.38u w=9u l=0.13u
X119 VSS iqmod_mixer_pex_half_0.iqmod_mixer_pex_se2diff_0.iqmod_mixer_pex_se2diff_half_inv$1_0.iqmod_mixer_pex_se2diff_inv_NF6$5_2.vin iqmod_mixer_pex_half_0.iqmod_mixer_pex_se2diff_0.iqmod_mixer_pex_se2diff_half_inv$1_0.iqmod_mixer_pex_se2diff_inv_NF6$5_2.vout VSS sg13_lv_nmos ad=0.19p pd=1.38u as=0.19p ps=1.38u w=1u l=0.13u
X120 iqmod_mixer_pex_half_0.iqmod_mixer_pex_se2diff_0.iqmod_mixer_pex_se2diff_half_inv$1_0.iqmod_mixer_pex_se2diff_inv_NF6$5_2.vin iqmod_mixer_pex_half_0.iqmod_mixer_pex_se2diff_0.iqmod_mixer_pex_se2diff_half_inv$1_0.iqmod_mixer_pex_se2diff_inv_NF2$5_0.vout VSS VSS sg13_lv_nmos ad=0.19p pd=1.38u as=0.19p ps=1.38u w=1u l=0.13u
X121 VDD iqmod_mixer_pex_half_1.iqmod_mixer_pex_se2diff_0.iqmod_mixer_pex_se2diff_half_inv$1_0.iqmod_mixer_pex_se2diff_inv_NF6$5_1.vout iqmod_mixer_pex_half_1.iqmod_mixer_pex_se2diff_0.iqmod_mixer_pex_se2diff_half_inv$1_0.iqmod_mixer_pex_se2diff_inv_NF18$5_0.vout VDD sg13_lv_pmos ad=0.57p pd=3.38u as=0.57p ps=3.38u w=3u l=0.13u
X122 vinp_IF iqmod_mixer_pex_half_1.iqmod_mixer_pex_tg_0.di_tg_ctrl_n voutp_RF VDD sg13_lv_pmos ad=1.71p pd=9.38u as=1.71p ps=9.38u w=9u l=0.13u
X123 VSS VSS VSS VSS sg13_lv_nmos ad=0.19p pd=1.38u as=0 ps=0 w=1u l=0.13u
X124 VSS iqmod_mixer_pex_half_0.iqmod_mixer_pex_se2diff_0.iqmod_mixer_pex_se2diff_half_tg$1_0.iqmod_mixer_pex_se2diff_inv_NF6$4_0.vout iqmod_mixer_pex_half_0.iqmod_mixer_pex_se2diff_0.iqmod_mixer_pex_se2diff_half_tg$1_0.iqmod_mixer_pex_se2diff_inv_NF18$4_0.vout VSS sg13_lv_nmos ad=0.19p pd=1.38u as=0.19p ps=1.38u w=1u l=0.13u
X125 voutn_RF iqmod_mixer_pex_half_0.iqmod_mixer_pex_tg_0.di_tg_ctrl_n vinn_IF VDD sg13_lv_pmos ad=1.71p pd=9.38u as=1.71p ps=9.38u w=9u l=0.13u
X126 voutn_RF iqmod_mixer_pex_half_0.iqmod_mixer_pex_tg_0.di_tg_ctrl voutn_RF VDD sg13_lv_pmos ad=1.71p pd=9.38u as=0 ps=0 w=9u l=0.13u
X127 iqmod_mixer_pex_half_0.iqmod_mixer_pex_tg_0.di_tg_ctrl_n iqmod_mixer_pex_half_0.iqmod_mixer_pex_se2diff_0.iqmod_mixer_pex_se2diff_half_tg$1_0.iqmod_mixer_pex_se2diff_inv_NF18$4_0.vout VSS VSS sg13_lv_nmos ad=0.19p pd=1.38u as=0.19p ps=1.38u w=1u l=0.13u
X128 iqmod_mixer_pex_half_0.iqmod_mixer_pex_tg_0.di_tg_ctrl_n iqmod_mixer_pex_half_0.iqmod_mixer_pex_se2diff_0.iqmod_mixer_pex_se2diff_half_tg$1_0.iqmod_mixer_pex_se2diff_inv_NF18$4_0.vout VSS VSS sg13_lv_nmos ad=0.19p pd=1.38u as=0.19p ps=1.38u w=1u l=0.13u
X129 VSS VSS VSS VSS sg13_lv_nmos ad=0.19p pd=1.38u as=0 ps=0 w=1u l=0.13u
X130 VSS iqmod_mixer_pex_half_0.iqmod_mixer_pex_se2diff_0.iqmod_mixer_pex_se2diff_half_tg$1_0.iqmod_mixer_pex_se2diff_inv_NF18$4_0.vout iqmod_mixer_pex_half_0.iqmod_mixer_pex_tg_0.di_tg_ctrl_n VSS sg13_lv_nmos ad=0.19p pd=1.38u as=0.19p ps=1.38u w=1u l=0.13u
X131 iqmod_mixer_pex_half_1.iqmod_mixer_pex_se2diff_0.iqmod_mixer_pex_se2diff_half_inv$1_0.iqmod_mixer_pex_se2diff_inv_NF18$5_0.vout iqmod_mixer_pex_half_1.iqmod_mixer_pex_se2diff_0.iqmod_mixer_pex_se2diff_half_inv$1_0.iqmod_mixer_pex_se2diff_inv_NF6$5_1.vout VDD VDD sg13_lv_pmos ad=0.57p pd=3.38u as=0.57p ps=3.38u w=3u l=0.13u
X132 VSS iqmod_mixer_pex_half_1.iqmod_mixer_pex_se2diff_0.iqmod_mixer_pex_se2diff_half_inv$1_0.iqmod_mixer_pex_se2diff_inv_NF18$5_0.vout iqmod_mixer_pex_half_1.iqmod_mixer_pex_tg_0.di_tg_ctrl VSS sg13_lv_nmos ad=0.19p pd=1.38u as=0.19p ps=1.38u w=1u l=0.13u
X133 VDD iqmod_mixer_pex_half_1.iqmod_mixer_pex_se2diff_0.iqmod_mixer_pex_se2diff_half_inv$1_0.iqmod_mixer_pex_se2diff_inv_NF18$5_0.vout iqmod_mixer_pex_half_1.iqmod_mixer_pex_tg_0.di_tg_ctrl VDD sg13_lv_pmos ad=0.57p pd=3.38u as=0.57p ps=3.38u w=3u l=0.13u
X134 iqmod_mixer_pex_half_1.iqmod_mixer_pex_tg_0.di_tg_ctrl_n iqmod_mixer_pex_half_1.iqmod_mixer_pex_se2diff_0.iqmod_mixer_pex_se2diff_half_tg$1_0.iqmod_mixer_pex_se2diff_inv_NF18$4_0.vout VDD VDD sg13_lv_pmos ad=0.57p pd=3.38u as=0.57p ps=3.38u w=3u l=0.13u
X135 voutn_RF iqmod_mixer_pex_half_0.iqmod_mixer_pex_tg_0.di_tg_ctrl_n vinn_IF VDD sg13_lv_pmos ad=1.71p pd=9.38u as=1.71p ps=9.38u w=9u l=0.13u
X136 iqmod_mixer_pex_half_0.iqmod_mixer_pex_tg_0.di_tg_ctrl_n iqmod_mixer_pex_half_0.iqmod_mixer_pex_se2diff_0.iqmod_mixer_pex_se2diff_half_tg$1_0.iqmod_mixer_pex_se2diff_inv_NF18$4_0.vout VSS VSS sg13_lv_nmos ad=0.19p pd=1.38u as=0.19p ps=1.38u w=1u l=0.13u
X137 VDD iqmod_mixer_pex_half_1.iqmod_mixer_pex_se2diff_0.iqmod_mixer_pex_se2diff_half_tg$1_0.iqmod_mixer_pex_se2diff_inv_NF18$4_0.vout iqmod_mixer_pex_half_1.iqmod_mixer_pex_tg_0.di_tg_ctrl_n VDD sg13_lv_pmos ad=0.57p pd=3.38u as=0.57p ps=3.38u w=3u l=0.13u
X138 voutp_RF iqmod_mixer_pex_half_1.iqmod_mixer_pex_tg_0.di_tg_ctrl voutp_RF VDD sg13_lv_pmos ad=1.71p pd=9.38u as=0 ps=0 w=9u l=0.13u
X139 iqmod_mixer_pex_half_1.iqmod_mixer_pex_se2diff_0.iqmod_mixer_pex_se2diff_half_inv$1_0.iqmod_mixer_pex_se2diff_inv_NF2$5_1.vout iqmod_mixer_pex_half_1.iqmod_mixer_pex_se2diff_0.iqmod_mixer_pex_se2diff_half_tg$1_0.iqmod_mixer_pex_se2diff_tg_NF6$2_0.v_b VDD VDD sg13_lv_pmos ad=0.57p pd=3.38u as=0.57p ps=3.38u w=3u l=0.13u
X140 iqmod_mixer_pex_half_0.iqmod_mixer_pex_tg_0.di_tg_ctrl iqmod_mixer_pex_half_0.iqmod_mixer_pex_se2diff_0.iqmod_mixer_pex_se2diff_half_inv$1_0.iqmod_mixer_pex_se2diff_inv_NF18$5_0.vout VSS VSS sg13_lv_nmos ad=0.19p pd=1.38u as=0.19p ps=1.38u w=1u l=0.13u
X141 VSS iqmod_mixer_pex_half_0.iqmod_mixer_pex_se2diff_0.iqmod_mixer_pex_se2diff_half_inv$1_0.iqmod_mixer_pex_se2diff_inv_NF6$5_1.vout iqmod_mixer_pex_half_0.iqmod_mixer_pex_se2diff_0.iqmod_mixer_pex_se2diff_half_inv$1_0.iqmod_mixer_pex_se2diff_inv_NF18$5_0.vout VSS sg13_lv_nmos ad=0.19p pd=1.38u as=0.19p ps=1.38u w=1u l=0.13u
X142 voutp_RF iqmod_mixer_pex_half_1.iqmod_mixer_pex_tg_0.di_tg_ctrl voutp_RF VDD sg13_lv_pmos ad=1.71p pd=9.38u as=0 ps=0 w=9u l=0.13u
X143 iqmod_mixer_pex_half_1.iqmod_mixer_pex_se2diff_0.iqmod_mixer_pex_se2diff_half_tg$1_0.iqmod_mixer_pex_se2diff_inv_NF18$4_0.vout iqmod_mixer_pex_half_1.iqmod_mixer_pex_se2diff_0.iqmod_mixer_pex_se2diff_half_tg$1_0.iqmod_mixer_pex_se2diff_inv_NF6$4_0.vout VDD VDD sg13_lv_pmos ad=0.57p pd=3.38u as=0.57p ps=3.38u w=3u l=0.13u
X144 voutn_RF iqmod_mixer_pex_half_0.iqmod_mixer_pex_tg_0.di_tg_ctrl_n vinn_IF VDD sg13_lv_pmos ad=1.71p pd=9.38u as=1.71p ps=9.38u w=9u l=0.13u
X145 iqmod_mixer_pex_half_0.iqmod_mixer_pex_tg_0.di_tg_ctrl_n iqmod_mixer_pex_half_0.iqmod_mixer_pex_se2diff_0.iqmod_mixer_pex_se2diff_half_tg$1_0.iqmod_mixer_pex_se2diff_inv_NF18$4_0.vout VSS VSS sg13_lv_nmos ad=0.19p pd=1.38u as=0.19p ps=1.38u w=1u l=0.13u
X146 VDD iqmod_mixer_pex_half_1.iqmod_mixer_pex_se2diff_0.iqmod_mixer_pex_se2diff_half_tg$1_0.iqmod_mixer_pex_se2diff_inv_NF6$4_0.vout iqmod_mixer_pex_half_1.iqmod_mixer_pex_se2diff_0.iqmod_mixer_pex_se2diff_half_tg$1_0.iqmod_mixer_pex_se2diff_inv_NF18$4_0.vout VDD sg13_lv_pmos ad=0.57p pd=3.38u as=0.57p ps=3.38u w=3u l=0.13u
X147 VDD VDD VDD VDD sg13_lv_pmos ad=0.57p pd=3.38u as=0 ps=0 w=3u l=0.13u
X148 VDD iqmod_mixer_pex_half_1.iqmod_mixer_pex_se2diff_0.iqmod_mixer_pex_se2diff_half_inv$1_0.iqmod_mixer_pex_se2diff_inv_NF6$5_2.vout iqmod_mixer_pex_half_1.iqmod_mixer_pex_se2diff_0.iqmod_mixer_pex_se2diff_half_inv$1_0.iqmod_mixer_pex_se2diff_inv_NF2$5_1.vout VDD sg13_lv_pmos ad=0.57p pd=3.38u as=0.57p ps=3.38u w=3u l=0.13u
X149 iqmod_mixer_pex_half_0.iqmod_mixer_pex_tg_0.di_tg_ctrl iqmod_mixer_pex_half_0.iqmod_mixer_pex_se2diff_0.iqmod_mixer_pex_se2diff_half_inv$1_0.iqmod_mixer_pex_se2diff_inv_NF18$5_0.vout VSS VSS sg13_lv_nmos ad=0.19p pd=1.38u as=0.19p ps=1.38u w=1u l=0.13u
X150 VSS iqmod_mixer_pex_half_0.iqmod_mixer_pex_se2diff_0.iqmod_mixer_pex_se2diff_half_inv$1_0.iqmod_mixer_pex_se2diff_inv_NF6$5_1.vout iqmod_mixer_pex_half_0.iqmod_mixer_pex_se2diff_0.iqmod_mixer_pex_se2diff_half_inv$1_0.iqmod_mixer_pex_se2diff_inv_NF18$5_0.vout VSS sg13_lv_nmos ad=0.19p pd=1.38u as=0.19p ps=1.38u w=1u l=0.13u
X151 iqmod_mixer_pex_half_0.iqmod_mixer_pex_se2diff_0.iqmod_mixer_pex_se2diff_half_inv$1_0.iqmod_mixer_pex_se2diff_inv_NF6$5_1.vout iqmod_mixer_pex_half_0.iqmod_mixer_pex_se2diff_0.iqmod_mixer_pex_se2diff_half_inv$1_0.iqmod_mixer_pex_se2diff_inv_NF6$5_2.vout VSS VSS sg13_lv_nmos ad=0.19p pd=1.38u as=0.19p ps=1.38u w=1u l=0.13u
X152 iqmod_mixer_pex_half_1.iqmod_mixer_pex_tg_0.di_tg_ctrl_n iqmod_mixer_pex_half_1.iqmod_mixer_pex_se2diff_0.iqmod_mixer_pex_se2diff_half_tg$1_0.iqmod_mixer_pex_se2diff_inv_NF18$4_0.vout VDD VDD sg13_lv_pmos ad=0.57p pd=3.38u as=0.57p ps=3.38u w=3u l=0.13u
X153 vinp_IF iqmod_mixer_pex_half_1.iqmod_mixer_pex_tg_0.di_tg_ctrl voutp_RF VSS sg13_lv_nmos ad=0.57p pd=3.38u as=0.57p ps=3.38u w=3u l=0.13u
X154 VSS iqmod_mixer_pex_half_1.iqmod_mixer_pex_se2diff_0.iqmod_mixer_pex_se2diff_half_tg$1_0.iqmod_mixer_pex_se2diff_inv_NF6$4_0.vout iqmod_mixer_pex_half_1.iqmod_mixer_pex_se2diff_0.iqmod_mixer_pex_se2diff_half_tg$1_0.iqmod_mixer_pex_se2diff_inv_NF18$4_0.vout VSS sg13_lv_nmos ad=0.19p pd=1.38u as=0.19p ps=1.38u w=1u l=0.13u
X155 iqmod_mixer_pex_half_0.iqmod_mixer_pex_tg_0.di_tg_ctrl iqmod_mixer_pex_half_0.iqmod_mixer_pex_se2diff_0.iqmod_mixer_pex_se2diff_half_inv$1_0.iqmod_mixer_pex_se2diff_inv_NF18$5_0.vout VSS VSS sg13_lv_nmos ad=0.19p pd=1.38u as=0.19p ps=1.38u w=1u l=0.13u
X156 voutp_RF iqmod_mixer_pex_half_1.iqmod_mixer_pex_tg_0.di_tg_ctrl vinp_IF VSS sg13_lv_nmos ad=0.57p pd=3.38u as=0.57p ps=3.38u w=3u l=0.13u
X157 VSS VSS VSS VSS sg13_lv_nmos ad=0.19p pd=1.38u as=0 ps=0 w=1u l=0.13u
X158 VSS iqmod_mixer_pex_half_1.iqmod_mixer_pex_se2diff_0.iqmod_mixer_pex_se2diff_half_tg$1_0.iqmod_mixer_pex_se2diff_inv_NF18$4_0.vout iqmod_mixer_pex_half_1.iqmod_mixer_pex_tg_0.di_tg_ctrl_n VSS sg13_lv_nmos ad=0.19p pd=1.38u as=0.19p ps=1.38u w=1u l=0.13u
X159 VSS iqmod_mixer_pex_half_1.iqmod_mixer_pex_se2diff_0.iqmod_mixer_pex_se2diff_half_inv$1_0.iqmod_mixer_pex_se2diff_inv_NF6$5_2.vin iqmod_mixer_pex_half_1.iqmod_mixer_pex_se2diff_0.iqmod_mixer_pex_se2diff_half_inv$1_0.iqmod_mixer_pex_se2diff_inv_NF6$5_2.vout VSS sg13_lv_nmos ad=0.19p pd=1.38u as=0.19p ps=1.38u w=1u l=0.13u
X160 voutn_RF iqmod_mixer_pex_half_0.iqmod_mixer_pex_tg_0.di_tg_ctrl_n voutn_RF VSS sg13_lv_nmos ad=0.57p pd=3.38u as=0 ps=0 w=3u l=0.13u
X161 iqmod_mixer_pex_half_1.iqmod_mixer_pex_tg_0.di_tg_ctrl_n iqmod_mixer_pex_half_1.iqmod_mixer_pex_se2diff_0.iqmod_mixer_pex_se2diff_half_tg$1_0.iqmod_mixer_pex_se2diff_inv_NF18$4_0.vout VSS VSS sg13_lv_nmos ad=0.19p pd=1.38u as=0.19p ps=1.38u w=1u l=0.13u
X162 iqmod_mixer_pex_half_1.iqmod_mixer_pex_se2diff_0.iqmod_mixer_pex_se2diff_half_inv$1_0.iqmod_mixer_pex_se2diff_inv_NF6$5_2.vout iqmod_mixer_pex_half_1.iqmod_mixer_pex_se2diff_0.iqmod_mixer_pex_se2diff_half_inv$1_0.iqmod_mixer_pex_se2diff_inv_NF6$5_2.vin VSS VSS sg13_lv_nmos ad=0.19p pd=1.38u as=0.19p ps=1.38u w=1u l=0.13u
X163 VSS iqmod_mixer_pex_half_1.iqmod_mixer_pex_se2diff_0.iqmod_mixer_pex_se2diff_half_inv$1_0.iqmod_mixer_pex_se2diff_inv_NF18$5_0.vout iqmod_mixer_pex_half_1.iqmod_mixer_pex_tg_0.di_tg_ctrl VSS sg13_lv_nmos ad=0.19p pd=1.38u as=0.19p ps=1.38u w=1u l=0.13u
X164 iqmod_mixer_pex_half_0.iqmod_mixer_pex_tg_0.di_tg_ctrl iqmod_mixer_pex_half_0.iqmod_mixer_pex_se2diff_0.iqmod_mixer_pex_se2diff_half_inv$1_0.iqmod_mixer_pex_se2diff_inv_NF18$5_0.vout VDD VDD sg13_lv_pmos ad=0.57p pd=3.38u as=0.57p ps=3.38u w=3u l=0.13u
X165 iqmod_mixer_pex_half_0.iqmod_mixer_pex_se2diff_0.iqmod_mixer_pex_se2diff_half_inv$1_0.iqmod_mixer_pex_se2diff_inv_NF2$5_0.vout vinn_LO VDD VDD sg13_lv_pmos ad=0.57p pd=3.38u as=0.57p ps=3.38u w=3u l=0.13u
X166 iqmod_mixer_pex_half_0.iqmod_mixer_pex_tg_0.di_tg_ctrl iqmod_mixer_pex_half_0.iqmod_mixer_pex_se2diff_0.iqmod_mixer_pex_se2diff_half_inv$1_0.iqmod_mixer_pex_se2diff_inv_NF18$5_0.vout VDD VDD sg13_lv_pmos ad=0.57p pd=3.38u as=0.57p ps=3.38u w=3u l=0.13u
X167 iqmod_mixer_pex_half_1.iqmod_mixer_pex_tg_0.di_tg_ctrl iqmod_mixer_pex_half_1.iqmod_mixer_pex_se2diff_0.iqmod_mixer_pex_se2diff_half_inv$1_0.iqmod_mixer_pex_se2diff_inv_NF18$5_0.vout VSS VSS sg13_lv_nmos ad=0.19p pd=1.38u as=0.19p ps=1.38u w=1u l=0.13u
X168 iqmod_mixer_pex_half_1.iqmod_mixer_pex_tg_0.di_tg_ctrl iqmod_mixer_pex_half_1.iqmod_mixer_pex_se2diff_0.iqmod_mixer_pex_se2diff_half_inv$1_0.iqmod_mixer_pex_se2diff_inv_NF18$5_0.vout VSS VSS sg13_lv_nmos ad=0.19p pd=1.38u as=0.19p ps=1.38u w=1u l=0.13u
X169 voutn_RF iqmod_mixer_pex_half_0.iqmod_mixer_pex_tg_0.di_tg_ctrl_n vinn_IF VDD sg13_lv_pmos ad=1.71p pd=9.38u as=1.71p ps=9.38u w=9u l=0.13u
X170 VSS iqmod_mixer_pex_half_0.iqmod_mixer_pex_se2diff_0.iqmod_mixer_pex_se2diff_half_inv$1_0.iqmod_mixer_pex_se2diff_inv_NF2$5_0.vout iqmod_mixer_pex_half_0.iqmod_mixer_pex_se2diff_0.iqmod_mixer_pex_se2diff_half_inv$1_0.iqmod_mixer_pex_se2diff_inv_NF6$5_2.vin VSS sg13_lv_nmos ad=0.19p pd=1.38u as=0.19p ps=1.38u w=1u l=0.13u
X171 vinn_IF iqmod_mixer_pex_half_0.iqmod_mixer_pex_tg_0.di_tg_ctrl voutn_RF VSS sg13_lv_nmos ad=0.57p pd=3.38u as=0.57p ps=3.38u w=3u l=0.13u
X172 VSS iqmod_mixer_pex_half_1.iqmod_mixer_pex_se2diff_0.iqmod_mixer_pex_se2diff_half_inv$1_0.iqmod_mixer_pex_se2diff_inv_NF18$5_0.vout iqmod_mixer_pex_half_1.iqmod_mixer_pex_tg_0.di_tg_ctrl VSS sg13_lv_nmos ad=0.19p pd=1.38u as=0.19p ps=1.38u w=1u l=0.13u
X173 VDD vinn_LO iqmod_mixer_pex_half_0.iqmod_mixer_pex_se2diff_0.iqmod_mixer_pex_se2diff_half_inv$1_0.iqmod_mixer_pex_se2diff_inv_NF2$5_0.vout VDD sg13_lv_pmos ad=0.57p pd=3.38u as=0.57p ps=3.38u w=3u l=0.13u
X174 VDD iqmod_mixer_pex_half_0.iqmod_mixer_pex_se2diff_0.iqmod_mixer_pex_se2diff_half_tg$1_0.iqmod_mixer_pex_se2diff_inv_NF18$4_0.vout iqmod_mixer_pex_half_0.iqmod_mixer_pex_tg_0.di_tg_ctrl_n VDD sg13_lv_pmos ad=0.57p pd=3.38u as=0.57p ps=3.38u w=3u l=0.13u
X175 VDD iqmod_mixer_pex_half_0.iqmod_mixer_pex_se2diff_0.iqmod_mixer_pex_se2diff_half_tg$1_0.iqmod_mixer_pex_se2diff_inv_NF18$4_0.vout iqmod_mixer_pex_half_0.iqmod_mixer_pex_tg_0.di_tg_ctrl_n VDD sg13_lv_pmos ad=0.57p pd=3.38u as=0.57p ps=3.38u w=3u l=0.13u
X176 iqmod_mixer_pex_half_0.iqmod_mixer_pex_tg_0.di_tg_ctrl iqmod_mixer_pex_half_0.iqmod_mixer_pex_se2diff_0.iqmod_mixer_pex_se2diff_half_inv$1_0.iqmod_mixer_pex_se2diff_inv_NF18$5_0.vout VDD VDD sg13_lv_pmos ad=0.57p pd=3.38u as=0.57p ps=3.38u w=3u l=0.13u
X177 voutn_RF iqmod_mixer_pex_half_0.iqmod_mixer_pex_tg_0.di_tg_ctrl voutn_RF VDD sg13_lv_pmos ad=1.71p pd=9.38u as=0 ps=0 w=9u l=0.13u
X178 VDD iqmod_mixer_pex_half_0.iqmod_mixer_pex_se2diff_0.iqmod_mixer_pex_se2diff_half_inv$1_0.iqmod_mixer_pex_se2diff_inv_NF6$5_1.vout iqmod_mixer_pex_half_0.iqmod_mixer_pex_se2diff_0.iqmod_mixer_pex_se2diff_half_inv$1_0.iqmod_mixer_pex_se2diff_inv_NF18$5_0.vout VDD sg13_lv_pmos ad=0.57p pd=3.38u as=0.57p ps=3.38u w=3u l=0.13u
X179 voutp_RF iqmod_mixer_pex_half_1.iqmod_mixer_pex_tg_0.di_tg_ctrl voutp_RF VDD sg13_lv_pmos ad=1.71p pd=9.38u as=0 ps=0 w=9u l=0.13u
X180 VDD VDD VDD VDD sg13_lv_pmos ad=0.57p pd=3.38u as=0 ps=0 w=3u l=0.13u
X181 iqmod_mixer_pex_half_1.iqmod_mixer_pex_se2diff_0.iqmod_mixer_pex_se2diff_half_inv$1_0.iqmod_mixer_pex_se2diff_inv_NF2$5_0.vout VDD iqmod_mixer_pex_half_1.iqmod_mixer_pex_se2diff_0.iqmod_mixer_pex_se2diff_half_tg$1_0.iqmod_mixer_pex_se2diff_tg_NF6$2_0.v_b VSS sg13_lv_nmos ad=0.34p pd=2.68u as=0.19p ps=1.38u w=1u l=0.13u
X182 VDD iqmod_mixer_pex_half_1.iqmod_mixer_pex_se2diff_0.iqmod_mixer_pex_se2diff_half_tg$1_0.iqmod_mixer_pex_se2diff_inv_NF18$4_0.vout iqmod_mixer_pex_half_1.iqmod_mixer_pex_tg_0.di_tg_ctrl_n VDD sg13_lv_pmos ad=0.57p pd=3.38u as=0.57p ps=3.38u w=3u l=0.13u
X183 VSS VSS VSS VSS sg13_lv_nmos ad=0.34p pd=2.68u as=0 ps=0 w=1u l=0.13u
X184 VDD iqmod_mixer_pex_half_0.iqmod_mixer_pex_se2diff_0.iqmod_mixer_pex_se2diff_half_tg$1_0.iqmod_mixer_pex_se2diff_inv_NF18$4_0.vout iqmod_mixer_pex_half_0.iqmod_mixer_pex_tg_0.di_tg_ctrl_n VDD sg13_lv_pmos ad=0.57p pd=3.38u as=0.57p ps=3.38u w=3u l=0.13u
X185 iqmod_mixer_pex_half_0.iqmod_mixer_pex_tg_0.di_tg_ctrl iqmod_mixer_pex_half_0.iqmod_mixer_pex_se2diff_0.iqmod_mixer_pex_se2diff_half_inv$1_0.iqmod_mixer_pex_se2diff_inv_NF18$5_0.vout VDD VDD sg13_lv_pmos ad=0.57p pd=3.38u as=0.57p ps=3.38u w=3u l=0.13u
X186 iqmod_mixer_pex_half_0.iqmod_mixer_pex_tg_0.di_tg_ctrl iqmod_mixer_pex_half_0.iqmod_mixer_pex_se2diff_0.iqmod_mixer_pex_se2diff_half_inv$1_0.iqmod_mixer_pex_se2diff_inv_NF18$5_0.vout VDD VDD sg13_lv_pmos ad=0.57p pd=3.38u as=0.57p ps=3.38u w=3u l=0.13u
X187 VDD iqmod_mixer_pex_half_0.iqmod_mixer_pex_se2diff_0.iqmod_mixer_pex_se2diff_half_inv$1_0.iqmod_mixer_pex_se2diff_inv_NF6$5_1.vout iqmod_mixer_pex_half_0.iqmod_mixer_pex_se2diff_0.iqmod_mixer_pex_se2diff_half_inv$1_0.iqmod_mixer_pex_se2diff_inv_NF18$5_0.vout VDD sg13_lv_pmos ad=0.57p pd=3.38u as=0.57p ps=3.38u w=3u l=0.13u
X188 VDD iqmod_mixer_pex_half_1.iqmod_mixer_pex_se2diff_0.iqmod_mixer_pex_se2diff_half_inv$1_0.iqmod_mixer_pex_se2diff_inv_NF6$5_1.vout iqmod_mixer_pex_half_1.iqmod_mixer_pex_se2diff_0.iqmod_mixer_pex_se2diff_half_inv$1_0.iqmod_mixer_pex_se2diff_inv_NF18$5_0.vout VDD sg13_lv_pmos ad=0.57p pd=3.38u as=0.57p ps=3.38u w=3u l=0.13u
X189 iqmod_mixer_pex_half_1.iqmod_mixer_pex_se2diff_0.iqmod_mixer_pex_se2diff_half_tg$1_0.iqmod_mixer_pex_se2diff_tg_NF6$2_0.v_b VDD iqmod_mixer_pex_half_1.iqmod_mixer_pex_se2diff_0.iqmod_mixer_pex_se2diff_half_inv$1_0.iqmod_mixer_pex_se2diff_inv_NF2$5_0.vout VSS sg13_lv_nmos ad=0.19p pd=1.38u as=0.19p ps=1.38u w=1u l=0.13u
X190 iqmod_mixer_pex_half_1.iqmod_mixer_pex_tg_0.di_tg_ctrl_n iqmod_mixer_pex_half_1.iqmod_mixer_pex_se2diff_0.iqmod_mixer_pex_se2diff_half_tg$1_0.iqmod_mixer_pex_se2diff_inv_NF18$4_0.vout VDD VDD sg13_lv_pmos ad=0.57p pd=3.38u as=0.57p ps=3.38u w=3u l=0.13u
X191 iqmod_mixer_pex_half_0.iqmod_mixer_pex_se2diff_0.iqmod_mixer_pex_se2diff_half_tg$1_0.iqmod_mixer_pex_se2diff_inv_NF18$4_0.vout iqmod_mixer_pex_half_0.iqmod_mixer_pex_se2diff_0.iqmod_mixer_pex_se2diff_half_tg$1_0.iqmod_mixer_pex_se2diff_inv_NF6$4_0.vout VDD VDD sg13_lv_pmos ad=0.57p pd=3.38u as=0.57p ps=3.38u w=3u l=0.13u
X192 VDD iqmod_mixer_pex_half_0.iqmod_mixer_pex_se2diff_0.iqmod_mixer_pex_se2diff_half_tg$1_0.iqmod_mixer_pex_se2diff_inv_NF18$4_0.vout iqmod_mixer_pex_half_0.iqmod_mixer_pex_tg_0.di_tg_ctrl_n VDD sg13_lv_pmos ad=0.57p pd=3.38u as=0.57p ps=3.38u w=3u l=0.13u
X193 VDD iqmod_mixer_pex_half_0.iqmod_mixer_pex_se2diff_0.iqmod_mixer_pex_se2diff_half_inv$1_0.iqmod_mixer_pex_se2diff_inv_NF18$5_0.vout iqmod_mixer_pex_half_0.iqmod_mixer_pex_tg_0.di_tg_ctrl VDD sg13_lv_pmos ad=0.57p pd=3.38u as=0.57p ps=3.38u w=3u l=0.13u
X194 VDD VDD VDD VDD sg13_lv_pmos ad=0.57p pd=3.38u as=0 ps=0 w=3u l=0.13u
X195 iqmod_mixer_pex_half_1.iqmod_mixer_pex_tg_0.di_tg_ctrl iqmod_mixer_pex_half_1.iqmod_mixer_pex_se2diff_0.iqmod_mixer_pex_se2diff_half_inv$1_0.iqmod_mixer_pex_se2diff_inv_NF18$5_0.vout VDD VDD sg13_lv_pmos ad=0.57p pd=3.38u as=0.57p ps=3.38u w=3u l=0.13u
X196 iqmod_mixer_pex_half_1.iqmod_mixer_pex_tg_0.di_tg_ctrl iqmod_mixer_pex_half_1.iqmod_mixer_pex_se2diff_0.iqmod_mixer_pex_se2diff_half_inv$1_0.iqmod_mixer_pex_se2diff_inv_NF18$5_0.vout VSS VSS sg13_lv_nmos ad=0.19p pd=1.38u as=0.19p ps=1.38u w=1u l=0.13u
X197 VDD iqmod_mixer_pex_half_1.iqmod_mixer_pex_se2diff_0.iqmod_mixer_pex_se2diff_half_tg$1_0.iqmod_mixer_pex_se2diff_tg_NF6$2_0.v_b iqmod_mixer_pex_half_1.iqmod_mixer_pex_se2diff_0.iqmod_mixer_pex_se2diff_half_inv$1_0.iqmod_mixer_pex_se2diff_inv_NF2$5_1.vout VDD sg13_lv_pmos ad=0.57p pd=3.38u as=0.57p ps=3.38u w=3u l=0.13u
X198 VDD iqmod_mixer_pex_half_1.iqmod_mixer_pex_se2diff_0.iqmod_mixer_pex_se2diff_half_inv$1_0.iqmod_mixer_pex_se2diff_inv_NF18$5_0.vout iqmod_mixer_pex_half_1.iqmod_mixer_pex_tg_0.di_tg_ctrl VDD sg13_lv_pmos ad=0.57p pd=3.38u as=0.57p ps=3.38u w=3u l=0.13u
X199 VDD iqmod_mixer_pex_half_1.iqmod_mixer_pex_se2diff_0.iqmod_mixer_pex_se2diff_half_tg$1_0.iqmod_mixer_pex_se2diff_inv_NF6$4_0.vout iqmod_mixer_pex_half_1.iqmod_mixer_pex_se2diff_0.iqmod_mixer_pex_se2diff_half_tg$1_0.iqmod_mixer_pex_se2diff_inv_NF18$4_0.vout VDD sg13_lv_pmos ad=0.57p pd=3.38u as=0.57p ps=3.38u w=3u l=0.13u
X200 iqmod_mixer_pex_half_0.iqmod_mixer_pex_tg_0.di_tg_ctrl iqmod_mixer_pex_half_0.iqmod_mixer_pex_se2diff_0.iqmod_mixer_pex_se2diff_half_inv$1_0.iqmod_mixer_pex_se2diff_inv_NF18$5_0.vout VDD VDD sg13_lv_pmos ad=0.57p pd=3.38u as=0.57p ps=3.38u w=3u l=0.13u
X201 iqmod_mixer_pex_half_0.iqmod_mixer_pex_se2diff_0.iqmod_mixer_pex_se2diff_half_tg$1_0.iqmod_mixer_pex_se2diff_inv_NF18$4_0.vout iqmod_mixer_pex_half_0.iqmod_mixer_pex_se2diff_0.iqmod_mixer_pex_se2diff_half_tg$1_0.iqmod_mixer_pex_se2diff_inv_NF6$4_0.vout VDD VDD sg13_lv_pmos ad=0.57p pd=3.38u as=0.57p ps=3.38u w=3u l=0.13u
X202 VDD iqmod_mixer_pex_half_0.iqmod_mixer_pex_se2diff_0.iqmod_mixer_pex_se2diff_half_tg$1_0.iqmod_mixer_pex_se2diff_inv_NF18$4_0.vout iqmod_mixer_pex_half_0.iqmod_mixer_pex_tg_0.di_tg_ctrl_n VDD sg13_lv_pmos ad=0.57p pd=3.38u as=0.57p ps=3.38u w=3u l=0.13u
X203 VDD iqmod_mixer_pex_half_0.iqmod_mixer_pex_se2diff_0.iqmod_mixer_pex_se2diff_half_tg$1_0.iqmod_mixer_pex_se2diff_inv_NF18$4_0.vout iqmod_mixer_pex_half_0.iqmod_mixer_pex_tg_0.di_tg_ctrl_n VDD sg13_lv_pmos ad=0.57p pd=3.38u as=0.57p ps=3.38u w=3u l=0.13u
X204 vinn_IF iqmod_mixer_pex_half_0.iqmod_mixer_pex_tg_0.di_tg_ctrl_n voutn_RF VDD sg13_lv_pmos ad=1.71p pd=9.38u as=1.71p ps=9.38u w=9u l=0.13u
X205 voutp_RF iqmod_mixer_pex_half_1.iqmod_mixer_pex_tg_0.di_tg_ctrl voutp_RF VDD sg13_lv_pmos ad=1.71p pd=9.38u as=0 ps=0 w=9u l=0.13u
X206 VSS iqmod_mixer_pex_half_1.iqmod_mixer_pex_se2diff_0.iqmod_mixer_pex_se2diff_half_tg$1_0.iqmod_mixer_pex_se2diff_inv_NF18$4_0.vout iqmod_mixer_pex_half_1.iqmod_mixer_pex_tg_0.di_tg_ctrl_n VSS sg13_lv_nmos ad=0.19p pd=1.38u as=0.19p ps=1.38u w=1u l=0.13u
X207 iqmod_mixer_pex_half_1.iqmod_mixer_pex_se2diff_0.iqmod_mixer_pex_se2diff_half_tg$1_0.iqmod_mixer_pex_se2diff_inv_NF18$4_0.vout iqmod_mixer_pex_half_1.iqmod_mixer_pex_se2diff_0.iqmod_mixer_pex_se2diff_half_tg$1_0.iqmod_mixer_pex_se2diff_inv_NF6$4_0.vout VDD VDD sg13_lv_pmos ad=0.57p pd=3.38u as=0.57p ps=3.38u w=3u l=0.13u
X208 iqmod_mixer_pex_half_0.iqmod_mixer_pex_tg_0.di_tg_ctrl_n iqmod_mixer_pex_half_0.iqmod_mixer_pex_se2diff_0.iqmod_mixer_pex_se2diff_half_tg$1_0.iqmod_mixer_pex_se2diff_inv_NF18$4_0.vout VDD VDD sg13_lv_pmos ad=0.57p pd=3.38u as=0.57p ps=3.38u w=3u l=0.13u
X209 voutp_RF iqmod_mixer_pex_half_1.iqmod_mixer_pex_tg_0.di_tg_ctrl_n vinp_IF VDD sg13_lv_pmos ad=1.71p pd=9.38u as=1.71p ps=9.38u w=9u l=0.13u
X210 iqmod_mixer_pex_half_1.iqmod_mixer_pex_tg_0.di_tg_ctrl_n iqmod_mixer_pex_half_1.iqmod_mixer_pex_se2diff_0.iqmod_mixer_pex_se2diff_half_tg$1_0.iqmod_mixer_pex_se2diff_inv_NF18$4_0.vout VSS VSS sg13_lv_nmos ad=0.19p pd=1.38u as=0.19p ps=1.38u w=1u l=0.13u
X211 VDD iqmod_mixer_pex_half_0.iqmod_mixer_pex_se2diff_0.iqmod_mixer_pex_se2diff_half_tg$1_0.iqmod_mixer_pex_se2diff_inv_NF18$4_0.vout iqmod_mixer_pex_half_0.iqmod_mixer_pex_tg_0.di_tg_ctrl_n VDD sg13_lv_pmos ad=0.57p pd=3.38u as=0.57p ps=3.38u w=3u l=0.13u
X212 iqmod_mixer_pex_half_0.iqmod_mixer_pex_tg_0.di_tg_ctrl iqmod_mixer_pex_half_0.iqmod_mixer_pex_se2diff_0.iqmod_mixer_pex_se2diff_half_inv$1_0.iqmod_mixer_pex_se2diff_inv_NF18$5_0.vout VDD VDD sg13_lv_pmos ad=0.57p pd=3.38u as=0.57p ps=3.38u w=3u l=0.13u
X213 VSS iqmod_mixer_pex_half_1.iqmod_mixer_pex_se2diff_0.iqmod_mixer_pex_se2diff_half_inv$1_0.iqmod_mixer_pex_se2diff_inv_NF6$5_1.vout iqmod_mixer_pex_half_1.iqmod_mixer_pex_se2diff_0.iqmod_mixer_pex_se2diff_half_inv$1_0.iqmod_mixer_pex_se2diff_inv_NF18$5_0.vout VSS sg13_lv_nmos ad=0.19p pd=1.38u as=0.19p ps=1.38u w=1u l=0.13u
X214 voutp_RF iqmod_mixer_pex_half_1.iqmod_mixer_pex_tg_0.di_tg_ctrl_n voutp_RF VSS sg13_lv_nmos ad=0.57p pd=3.38u as=0 ps=0 w=3u l=0.13u
X215 VDD iqmod_mixer_pex_half_0.iqmod_mixer_pex_se2diff_0.iqmod_mixer_pex_se2diff_half_tg$1_0.iqmod_mixer_pex_se2diff_inv_NF18$4_0.vout iqmod_mixer_pex_half_0.iqmod_mixer_pex_tg_0.di_tg_ctrl_n VDD sg13_lv_pmos ad=0.57p pd=3.38u as=0.57p ps=3.38u w=3u l=0.13u
X216 VSS iqmod_mixer_pex_half_1.iqmod_mixer_pex_se2diff_0.iqmod_mixer_pex_se2diff_half_tg$1_0.iqmod_mixer_pex_se2diff_inv_NF18$4_0.vout iqmod_mixer_pex_half_1.iqmod_mixer_pex_tg_0.di_tg_ctrl_n VSS sg13_lv_nmos ad=0.19p pd=1.38u as=0.19p ps=1.38u w=1u l=0.13u
X217 voutp_RF iqmod_mixer_pex_half_1.iqmod_mixer_pex_tg_0.di_tg_ctrl_n voutp_RF VSS sg13_lv_nmos ad=0.57p pd=3.38u as=0 ps=0 w=3u l=0.13u
X218 iqmod_mixer_pex_half_1.iqmod_mixer_pex_tg_0.di_tg_ctrl_n iqmod_mixer_pex_half_1.iqmod_mixer_pex_se2diff_0.iqmod_mixer_pex_se2diff_half_tg$1_0.iqmod_mixer_pex_se2diff_inv_NF18$4_0.vout VSS VSS sg13_lv_nmos ad=0.19p pd=1.38u as=0.19p ps=1.38u w=1u l=0.13u
X219 voutp_RF iqmod_mixer_pex_half_1.iqmod_mixer_pex_tg_0.di_tg_ctrl vinp_IF VSS sg13_lv_nmos ad=0.57p pd=3.38u as=0.57p ps=3.38u w=3u l=0.13u
X220 voutp_RF iqmod_mixer_pex_half_1.iqmod_mixer_pex_tg_0.di_tg_ctrl_n voutp_RF VSS sg13_lv_nmos ad=0.57p pd=3.38u as=0 ps=0 w=3u l=0.13u
X221 voutn_RF iqmod_mixer_pex_half_0.iqmod_mixer_pex_tg_0.di_tg_ctrl_n voutn_RF VSS sg13_lv_nmos ad=0.57p pd=3.38u as=0 ps=0 w=3u l=0.13u
X222 iqmod_mixer_pex_half_1.iqmod_mixer_pex_tg_0.di_tg_ctrl_n iqmod_mixer_pex_half_1.iqmod_mixer_pex_se2diff_0.iqmod_mixer_pex_se2diff_half_tg$1_0.iqmod_mixer_pex_se2diff_inv_NF18$4_0.vout VSS VSS sg13_lv_nmos ad=0.19p pd=1.38u as=0.19p ps=1.38u w=1u l=0.13u
X223 VDD VDD VDD VDD sg13_lv_pmos ad=0.57p pd=3.38u as=0 ps=0 w=3u l=0.13u
X224 VDD iqmod_mixer_pex_half_1.iqmod_mixer_pex_se2diff_0.iqmod_mixer_pex_se2diff_half_inv$1_0.iqmod_mixer_pex_se2diff_inv_NF6$5_2.vout iqmod_mixer_pex_half_1.iqmod_mixer_pex_se2diff_0.iqmod_mixer_pex_se2diff_half_inv$1_0.iqmod_mixer_pex_se2diff_inv_NF6$5_1.vout VDD sg13_lv_pmos ad=0.57p pd=3.38u as=0.57p ps=3.38u w=3u l=0.13u
X225 VSS VSS VSS VSS sg13_lv_nmos ad=0.34p pd=2.68u as=0 ps=0 w=1u l=0.13u
X226 vinp_IF iqmod_mixer_pex_half_1.iqmod_mixer_pex_tg_0.di_tg_ctrl voutp_RF VSS sg13_lv_nmos ad=0.57p pd=3.38u as=1.02p ps=6.68u w=3u l=0.13u
X227 VSS VSS VSS VSS sg13_lv_nmos ad=0.19p pd=1.38u as=0 ps=0 w=1u l=0.13u
X228 iqmod_mixer_pex_half_0.iqmod_mixer_pex_tg_0.di_tg_ctrl_n iqmod_mixer_pex_half_0.iqmod_mixer_pex_se2diff_0.iqmod_mixer_pex_se2diff_half_tg$1_0.iqmod_mixer_pex_se2diff_inv_NF18$4_0.vout VSS VSS sg13_lv_nmos ad=0.19p pd=1.38u as=0.19p ps=1.38u w=1u l=0.13u
X229 vinn_IF iqmod_mixer_pex_half_0.iqmod_mixer_pex_tg_0.di_tg_ctrl voutn_RF VSS sg13_lv_nmos ad=0.57p pd=3.38u as=0.57p ps=3.38u w=3u l=0.13u
X230 voutn_RF iqmod_mixer_pex_half_0.iqmod_mixer_pex_tg_0.di_tg_ctrl_n voutn_RF VSS sg13_lv_nmos ad=0.57p pd=3.38u as=0 ps=0 w=3u l=0.13u
X231 iqmod_mixer_pex_half_1.iqmod_mixer_pex_se2diff_0.iqmod_mixer_pex_se2diff_half_inv$1_0.iqmod_mixer_pex_se2diff_inv_NF6$5_1.vout iqmod_mixer_pex_half_1.iqmod_mixer_pex_se2diff_0.iqmod_mixer_pex_se2diff_half_inv$1_0.iqmod_mixer_pex_se2diff_inv_NF6$5_2.vout VDD VDD sg13_lv_pmos ad=0.57p pd=3.38u as=0.57p ps=3.38u w=3u l=0.13u
X232 VSS iqmod_mixer_pex_half_1.iqmod_mixer_pex_se2diff_0.iqmod_mixer_pex_se2diff_half_inv$1_0.iqmod_mixer_pex_se2diff_inv_NF6$5_1.vout iqmod_mixer_pex_half_1.iqmod_mixer_pex_se2diff_0.iqmod_mixer_pex_se2diff_half_inv$1_0.iqmod_mixer_pex_se2diff_inv_NF18$5_0.vout VSS sg13_lv_nmos ad=0.19p pd=1.38u as=0.19p ps=1.38u w=1u l=0.13u
X233 iqmod_mixer_pex_half_0.iqmod_mixer_pex_tg_0.di_tg_ctrl_n iqmod_mixer_pex_half_0.iqmod_mixer_pex_se2diff_0.iqmod_mixer_pex_se2diff_half_tg$1_0.iqmod_mixer_pex_se2diff_inv_NF18$4_0.vout VSS VSS sg13_lv_nmos ad=0.19p pd=1.38u as=0.19p ps=1.38u w=1u l=0.13u
X234 vinn_IF iqmod_mixer_pex_half_0.iqmod_mixer_pex_tg_0.di_tg_ctrl voutn_RF VSS sg13_lv_nmos ad=0.57p pd=3.38u as=1.02p ps=6.68u w=3u l=0.13u
X235 iqmod_mixer_pex_half_1.iqmod_mixer_pex_se2diff_0.iqmod_mixer_pex_se2diff_half_inv$1_0.iqmod_mixer_pex_se2diff_inv_NF18$5_0.vout iqmod_mixer_pex_half_1.iqmod_mixer_pex_se2diff_0.iqmod_mixer_pex_se2diff_half_inv$1_0.iqmod_mixer_pex_se2diff_inv_NF6$5_1.vout VSS VSS sg13_lv_nmos ad=0.19p pd=1.38u as=0.19p ps=1.38u w=1u l=0.13u
X236 VSS VSS VSS VSS sg13_lv_nmos ad=0.34p pd=2.68u as=0 ps=0 w=1u l=0.13u
X237 voutn_RF iqmod_mixer_pex_half_0.iqmod_mixer_pex_tg_0.di_tg_ctrl vinn_IF VSS sg13_lv_nmos ad=0.57p pd=3.38u as=0.57p ps=3.38u w=3u l=0.13u
X238 VSS iqmod_mixer_pex_half_1.iqmod_mixer_pex_se2diff_0.iqmod_mixer_pex_se2diff_half_inv$1_0.iqmod_mixer_pex_se2diff_inv_NF18$5_0.vout iqmod_mixer_pex_half_1.iqmod_mixer_pex_tg_0.di_tg_ctrl VSS sg13_lv_nmos ad=0.19p pd=1.38u as=0.19p ps=1.38u w=1u l=0.13u
X239 VDD iqmod_mixer_pex_half_1.iqmod_mixer_pex_se2diff_0.iqmod_mixer_pex_se2diff_half_inv$1_0.iqmod_mixer_pex_se2diff_inv_NF2$5_0.vout iqmod_mixer_pex_half_1.iqmod_mixer_pex_se2diff_0.iqmod_mixer_pex_se2diff_half_inv$1_0.iqmod_mixer_pex_se2diff_inv_NF6$5_2.vin VDD sg13_lv_pmos ad=0.57p pd=3.38u as=0.57p ps=3.38u w=3u l=0.13u
X240 VSS iqmod_mixer_pex_half_0.iqmod_mixer_pex_se2diff_0.iqmod_mixer_pex_se2diff_half_tg$1_0.iqmod_mixer_pex_se2diff_inv_NF6$4_0.vout iqmod_mixer_pex_half_0.iqmod_mixer_pex_se2diff_0.iqmod_mixer_pex_se2diff_half_tg$1_0.iqmod_mixer_pex_se2diff_inv_NF18$4_0.vout VSS sg13_lv_nmos ad=0.19p pd=1.38u as=0.19p ps=1.38u w=1u l=0.13u
X241 iqmod_mixer_pex_half_0.iqmod_mixer_pex_tg_0.di_tg_ctrl_n iqmod_mixer_pex_half_0.iqmod_mixer_pex_se2diff_0.iqmod_mixer_pex_se2diff_half_tg$1_0.iqmod_mixer_pex_se2diff_inv_NF18$4_0.vout VSS VSS sg13_lv_nmos ad=0.19p pd=1.38u as=0.19p ps=1.38u w=1u l=0.13u
X242 iqmod_mixer_pex_half_1.iqmod_mixer_pex_tg_0.di_tg_ctrl iqmod_mixer_pex_half_1.iqmod_mixer_pex_se2diff_0.iqmod_mixer_pex_se2diff_half_inv$1_0.iqmod_mixer_pex_se2diff_inv_NF18$5_0.vout VSS VSS sg13_lv_nmos ad=0.19p pd=1.38u as=0.19p ps=1.38u w=1u l=0.13u
X243 voutp_RF iqmod_mixer_pex_half_1.iqmod_mixer_pex_tg_0.di_tg_ctrl_n vinp_IF VDD sg13_lv_pmos ad=1.71p pd=9.38u as=1.71p ps=9.38u w=9u l=0.13u
X244 iqmod_mixer_pex_half_1.iqmod_mixer_pex_tg_0.di_tg_ctrl_n iqmod_mixer_pex_half_1.iqmod_mixer_pex_se2diff_0.iqmod_mixer_pex_se2diff_half_tg$1_0.iqmod_mixer_pex_se2diff_inv_NF18$4_0.vout VDD VDD sg13_lv_pmos ad=0.57p pd=3.38u as=0.57p ps=3.38u w=3u l=0.13u
X245 VDD iqmod_mixer_pex_half_1.iqmod_mixer_pex_se2diff_0.iqmod_mixer_pex_se2diff_half_tg$1_0.iqmod_mixer_pex_se2diff_inv_NF18$4_0.vout iqmod_mixer_pex_half_1.iqmod_mixer_pex_tg_0.di_tg_ctrl_n VDD sg13_lv_pmos ad=0.57p pd=3.38u as=0.57p ps=3.38u w=3u l=0.13u
X246 voutn_RF iqmod_mixer_pex_half_0.iqmod_mixer_pex_tg_0.di_tg_ctrl vinn_IF VSS sg13_lv_nmos ad=0.57p pd=3.38u as=0.57p ps=3.38u w=3u l=0.13u
X247 iqmod_mixer_pex_half_1.iqmod_mixer_pex_se2diff_0.iqmod_mixer_pex_se2diff_half_inv$1_0.iqmod_mixer_pex_se2diff_inv_NF6$5_2.vin iqmod_mixer_pex_half_1.iqmod_mixer_pex_se2diff_0.iqmod_mixer_pex_se2diff_half_inv$1_0.iqmod_mixer_pex_se2diff_inv_NF2$5_0.vout VDD VDD sg13_lv_pmos ad=0.57p pd=3.38u as=0.57p ps=3.38u w=3u l=0.13u
X248 VDD VDD VDD VDD sg13_lv_pmos ad=1.02p pd=6.68u as=0 ps=0 w=3u l=0.13u
X249 iqmod_mixer_pex_half_0.iqmod_mixer_pex_tg_0.di_tg_ctrl_n iqmod_mixer_pex_half_0.iqmod_mixer_pex_se2diff_0.iqmod_mixer_pex_se2diff_half_tg$1_0.iqmod_mixer_pex_se2diff_inv_NF18$4_0.vout VDD VDD sg13_lv_pmos ad=0.57p pd=3.38u as=0.57p ps=3.38u w=3u l=0.13u
X250 vinp_IF iqmod_mixer_pex_half_1.iqmod_mixer_pex_tg_0.di_tg_ctrl_n voutp_RF VDD sg13_lv_pmos ad=1.71p pd=9.38u as=1.71p ps=9.38u w=9u l=0.13u
X251 VSS VSS VSS VSS sg13_lv_nmos ad=0.34p pd=2.68u as=0 ps=0 w=1u l=0.13u
X252 iqmod_mixer_pex_half_1.iqmod_mixer_pex_se2diff_0.iqmod_mixer_pex_se2diff_half_tg$1_0.iqmod_mixer_pex_se2diff_inv_NF18$4_0.vout iqmod_mixer_pex_half_1.iqmod_mixer_pex_se2diff_0.iqmod_mixer_pex_se2diff_half_tg$1_0.iqmod_mixer_pex_se2diff_inv_NF6$4_0.vout VDD VDD sg13_lv_pmos ad=0.57p pd=3.38u as=0.57p ps=3.38u w=3u l=0.13u
X253 iqmod_mixer_pex_half_0.iqmod_mixer_pex_tg_0.di_tg_ctrl iqmod_mixer_pex_half_0.iqmod_mixer_pex_se2diff_0.iqmod_mixer_pex_se2diff_half_inv$1_0.iqmod_mixer_pex_se2diff_inv_NF18$5_0.vout VSS VSS sg13_lv_nmos ad=0.19p pd=1.38u as=0.19p ps=1.38u w=1u l=0.13u
X254 VDD iqmod_mixer_pex_half_1.iqmod_mixer_pex_se2diff_0.iqmod_mixer_pex_se2diff_half_inv$1_0.iqmod_mixer_pex_se2diff_inv_NF18$5_0.vout iqmod_mixer_pex_half_1.iqmod_mixer_pex_tg_0.di_tg_ctrl VDD sg13_lv_pmos ad=0.57p pd=3.38u as=0.57p ps=3.38u w=3u l=0.13u
X255 VDD iqmod_mixer_pex_half_1.iqmod_mixer_pex_se2diff_0.iqmod_mixer_pex_se2diff_half_inv$1_0.iqmod_mixer_pex_se2diff_inv_NF18$5_0.vout iqmod_mixer_pex_half_1.iqmod_mixer_pex_tg_0.di_tg_ctrl VDD sg13_lv_pmos ad=0.57p pd=3.38u as=0.57p ps=3.38u w=3u l=0.13u
X256 iqmod_mixer_pex_half_1.iqmod_mixer_pex_se2diff_0.iqmod_mixer_pex_se2diff_half_tg$1_0.iqmod_mixer_pex_se2diff_inv_NF18$4_0.vout iqmod_mixer_pex_half_1.iqmod_mixer_pex_se2diff_0.iqmod_mixer_pex_se2diff_half_tg$1_0.iqmod_mixer_pex_se2diff_inv_NF6$4_0.vout VSS VSS sg13_lv_nmos ad=0.19p pd=1.38u as=0.19p ps=1.38u w=1u l=0.13u
X257 VDD iqmod_mixer_pex_half_1.iqmod_mixer_pex_se2diff_0.iqmod_mixer_pex_se2diff_half_tg$1_0.iqmod_mixer_pex_se2diff_inv_NF6$4_0.vout iqmod_mixer_pex_half_1.iqmod_mixer_pex_se2diff_0.iqmod_mixer_pex_se2diff_half_tg$1_0.iqmod_mixer_pex_se2diff_inv_NF18$4_0.vout VDD sg13_lv_pmos ad=0.57p pd=3.38u as=0.57p ps=3.38u w=3u l=0.13u
X258 iqmod_mixer_pex_half_0.iqmod_mixer_pex_tg_0.di_tg_ctrl iqmod_mixer_pex_half_0.iqmod_mixer_pex_se2diff_0.iqmod_mixer_pex_se2diff_half_inv$1_0.iqmod_mixer_pex_se2diff_inv_NF18$5_0.vout VSS VSS sg13_lv_nmos ad=0.19p pd=1.38u as=0.19p ps=1.38u w=1u l=0.13u
X259 iqmod_mixer_pex_half_0.iqmod_mixer_pex_se2diff_0.iqmod_mixer_pex_se2diff_half_inv$1_0.iqmod_mixer_pex_se2diff_inv_NF2$5_0.vout vinn_LO VSS VSS sg13_lv_nmos ad=0.19p pd=1.38u as=0.19p ps=1.38u w=1u l=0.13u
X260 VDD iqmod_mixer_pex_half_0.iqmod_mixer_pex_se2diff_0.iqmod_mixer_pex_se2diff_half_tg$1_0.iqmod_mixer_pex_se2diff_inv_NF6$4_0.vout iqmod_mixer_pex_half_0.iqmod_mixer_pex_se2diff_0.iqmod_mixer_pex_se2diff_half_tg$1_0.iqmod_mixer_pex_se2diff_inv_NF18$4_0.vout VDD sg13_lv_pmos ad=0.57p pd=3.38u as=0.57p ps=3.38u w=3u l=0.13u
X261 iqmod_mixer_pex_half_0.iqmod_mixer_pex_tg_0.di_tg_ctrl_n iqmod_mixer_pex_half_0.iqmod_mixer_pex_se2diff_0.iqmod_mixer_pex_se2diff_half_tg$1_0.iqmod_mixer_pex_se2diff_inv_NF18$4_0.vout VDD VDD sg13_lv_pmos ad=0.57p pd=3.38u as=0.57p ps=3.38u w=3u l=0.13u
X262 iqmod_mixer_pex_half_1.iqmod_mixer_pex_tg_0.di_tg_ctrl iqmod_mixer_pex_half_1.iqmod_mixer_pex_se2diff_0.iqmod_mixer_pex_se2diff_half_inv$1_0.iqmod_mixer_pex_se2diff_inv_NF18$5_0.vout VDD VDD sg13_lv_pmos ad=0.57p pd=3.38u as=0.57p ps=3.38u w=3u l=0.13u
X263 VSS VSS VSS VSS sg13_lv_nmos ad=0.34p pd=2.68u as=0 ps=0 w=1u l=0.13u
X264 iqmod_mixer_pex_half_1.iqmod_mixer_pex_tg_0.di_tg_ctrl iqmod_mixer_pex_half_1.iqmod_mixer_pex_se2diff_0.iqmod_mixer_pex_se2diff_half_inv$1_0.iqmod_mixer_pex_se2diff_inv_NF18$5_0.vout VDD VDD sg13_lv_pmos ad=0.57p pd=3.38u as=0.57p ps=3.38u w=3u l=0.13u
X265 iqmod_mixer_pex_half_1.iqmod_mixer_pex_tg_0.di_tg_ctrl_n iqmod_mixer_pex_half_1.iqmod_mixer_pex_se2diff_0.iqmod_mixer_pex_se2diff_half_tg$1_0.iqmod_mixer_pex_se2diff_inv_NF18$4_0.vout VSS VSS sg13_lv_nmos ad=0.19p pd=1.38u as=0.19p ps=1.38u w=1u l=0.13u
X266 iqmod_mixer_pex_half_0.iqmod_mixer_pex_tg_0.di_tg_ctrl iqmod_mixer_pex_half_0.iqmod_mixer_pex_se2diff_0.iqmod_mixer_pex_se2diff_half_inv$1_0.iqmod_mixer_pex_se2diff_inv_NF18$5_0.vout VSS VSS sg13_lv_nmos ad=0.19p pd=1.38u as=0.19p ps=1.38u w=1u l=0.13u
X267 VSS iqmod_mixer_pex_half_0.iqmod_mixer_pex_se2diff_0.iqmod_mixer_pex_se2diff_half_inv$1_0.iqmod_mixer_pex_se2diff_inv_NF6$5_1.vout iqmod_mixer_pex_half_0.iqmod_mixer_pex_se2diff_0.iqmod_mixer_pex_se2diff_half_inv$1_0.iqmod_mixer_pex_se2diff_inv_NF18$5_0.vout VSS sg13_lv_nmos ad=0.19p pd=1.38u as=0.19p ps=1.38u w=1u l=0.13u
X268 VDD iqmod_mixer_pex_half_1.iqmod_mixer_pex_se2diff_0.iqmod_mixer_pex_se2diff_half_inv$1_0.iqmod_mixer_pex_se2diff_inv_NF18$5_0.vout iqmod_mixer_pex_half_1.iqmod_mixer_pex_tg_0.di_tg_ctrl VDD sg13_lv_pmos ad=0.57p pd=3.38u as=0.57p ps=3.38u w=3u l=0.13u
X269 VDD iqmod_mixer_pex_half_0.iqmod_mixer_pex_se2diff_0.iqmod_mixer_pex_se2diff_half_tg$1_0.iqmod_mixer_pex_se2diff_inv_NF6$4_0.vout iqmod_mixer_pex_half_0.iqmod_mixer_pex_se2diff_0.iqmod_mixer_pex_se2diff_half_tg$1_0.iqmod_mixer_pex_se2diff_inv_NF18$4_0.vout VDD sg13_lv_pmos ad=0.57p pd=3.38u as=0.57p ps=3.38u w=3u l=0.13u
X270 vinp_IF iqmod_mixer_pex_half_1.iqmod_mixer_pex_tg_0.di_tg_ctrl_n voutp_RF VDD sg13_lv_pmos ad=1.71p pd=9.38u as=1.71p ps=9.38u w=9u l=0.13u
X271 VSS iqmod_mixer_pex_half_1.iqmod_mixer_pex_se2diff_0.iqmod_mixer_pex_se2diff_half_tg$1_0.iqmod_mixer_pex_se2diff_inv_NF18$4_0.vout iqmod_mixer_pex_half_1.iqmod_mixer_pex_tg_0.di_tg_ctrl_n VSS sg13_lv_nmos ad=0.19p pd=1.38u as=0.19p ps=1.38u w=1u l=0.13u
X272 VDD iqmod_mixer_pex_half_1.iqmod_mixer_pex_se2diff_0.iqmod_mixer_pex_se2diff_half_tg$1_0.iqmod_mixer_pex_se2diff_inv_NF6$4_0.vout iqmod_mixer_pex_half_1.iqmod_mixer_pex_se2diff_0.iqmod_mixer_pex_se2diff_half_tg$1_0.iqmod_mixer_pex_se2diff_inv_NF18$4_0.vout VDD sg13_lv_pmos ad=0.57p pd=3.38u as=0.57p ps=3.38u w=3u l=0.13u
X273 VSS iqmod_mixer_pex_half_0.iqmod_mixer_pex_se2diff_0.iqmod_mixer_pex_se2diff_half_inv$1_0.iqmod_mixer_pex_se2diff_inv_NF6$5_1.vout iqmod_mixer_pex_half_0.iqmod_mixer_pex_se2diff_0.iqmod_mixer_pex_se2diff_half_inv$1_0.iqmod_mixer_pex_se2diff_inv_NF18$5_0.vout VSS sg13_lv_nmos ad=0.19p pd=1.38u as=0.19p ps=1.38u w=1u l=0.13u
X274 iqmod_mixer_pex_half_1.iqmod_mixer_pex_se2diff_0.iqmod_mixer_pex_se2diff_half_tg$1_0.iqmod_mixer_pex_se2diff_inv_NF18$4_0.vout iqmod_mixer_pex_half_1.iqmod_mixer_pex_se2diff_0.iqmod_mixer_pex_se2diff_half_tg$1_0.iqmod_mixer_pex_se2diff_inv_NF6$4_0.vout VDD VDD sg13_lv_pmos ad=0.57p pd=3.38u as=0.57p ps=3.38u w=3u l=0.13u
X275 iqmod_mixer_pex_half_0.iqmod_mixer_pex_tg_0.di_tg_ctrl_n iqmod_mixer_pex_half_0.iqmod_mixer_pex_se2diff_0.iqmod_mixer_pex_se2diff_half_tg$1_0.iqmod_mixer_pex_se2diff_inv_NF18$4_0.vout VDD VDD sg13_lv_pmos ad=0.57p pd=3.38u as=0.57p ps=3.38u w=3u l=0.13u
X276 iqmod_mixer_pex_half_0.iqmod_mixer_pex_tg_0.di_tg_ctrl iqmod_mixer_pex_half_0.iqmod_mixer_pex_se2diff_0.iqmod_mixer_pex_se2diff_half_inv$1_0.iqmod_mixer_pex_se2diff_inv_NF18$5_0.vout VSS VSS sg13_lv_nmos ad=0.19p pd=1.38u as=0.19p ps=1.38u w=1u l=0.13u
X277 iqmod_mixer_pex_half_0.iqmod_mixer_pex_tg_0.di_tg_ctrl iqmod_mixer_pex_half_0.iqmod_mixer_pex_se2diff_0.iqmod_mixer_pex_se2diff_half_inv$1_0.iqmod_mixer_pex_se2diff_inv_NF18$5_0.vout VSS VSS sg13_lv_nmos ad=0.19p pd=1.38u as=0.19p ps=1.38u w=1u l=0.13u
X278 VSS VSS VSS VSS sg13_lv_nmos ad=0.19p pd=1.38u as=0 ps=0 w=1u l=0.13u
X279 VDD vinp_LO iqmod_mixer_pex_half_1.iqmod_mixer_pex_se2diff_0.iqmod_mixer_pex_se2diff_half_inv$1_0.iqmod_mixer_pex_se2diff_inv_NF2$5_0.vout VDD sg13_lv_pmos ad=0.57p pd=3.38u as=0.57p ps=3.38u w=3u l=0.13u
X280 VSS iqmod_mixer_pex_half_1.iqmod_mixer_pex_se2diff_0.iqmod_mixer_pex_se2diff_half_tg$1_0.iqmod_mixer_pex_se2diff_inv_NF18$4_0.vout iqmod_mixer_pex_half_1.iqmod_mixer_pex_tg_0.di_tg_ctrl_n VSS sg13_lv_nmos ad=0.19p pd=1.38u as=0.19p ps=1.38u w=1u l=0.13u
X281 iqmod_mixer_pex_half_0.iqmod_mixer_pex_se2diff_0.iqmod_mixer_pex_se2diff_half_inv$1_0.iqmod_mixer_pex_se2diff_inv_NF2$5_1.vout iqmod_mixer_pex_half_0.iqmod_mixer_pex_se2diff_0.iqmod_mixer_pex_se2diff_half_tg$1_0.iqmod_mixer_pex_se2diff_tg_NF6$2_0.v_b VSS VSS sg13_lv_nmos ad=0.19p pd=1.38u as=0.19p ps=1.38u w=1u l=0.13u
X282 VSS iqmod_mixer_pex_half_0.iqmod_mixer_pex_se2diff_0.iqmod_mixer_pex_se2diff_half_inv$1_0.iqmod_mixer_pex_se2diff_inv_NF2$5_1.vout iqmod_mixer_pex_half_0.iqmod_mixer_pex_se2diff_0.iqmod_mixer_pex_se2diff_half_inv$1_0.iqmod_mixer_pex_se2diff_inv_NF6$5_2.vout VSS sg13_lv_nmos ad=0.19p pd=1.38u as=0.19p ps=1.38u w=1u l=0.13u
X283 VSS iqmod_mixer_pex_half_0.iqmod_mixer_pex_se2diff_0.iqmod_mixer_pex_se2diff_half_inv$1_0.iqmod_mixer_pex_se2diff_inv_NF18$5_0.vout iqmod_mixer_pex_half_0.iqmod_mixer_pex_tg_0.di_tg_ctrl VSS sg13_lv_nmos ad=0.19p pd=1.38u as=0.19p ps=1.38u w=1u l=0.13u
X284 VSS VSS VSS VSS sg13_lv_nmos ad=0.34p pd=2.68u as=0 ps=0 w=1u l=0.13u
X285 iqmod_mixer_pex_half_1.iqmod_mixer_pex_tg_0.di_tg_ctrl iqmod_mixer_pex_half_1.iqmod_mixer_pex_se2diff_0.iqmod_mixer_pex_se2diff_half_inv$1_0.iqmod_mixer_pex_se2diff_inv_NF18$5_0.vout VDD VDD sg13_lv_pmos ad=0.57p pd=3.38u as=0.57p ps=3.38u w=3u l=0.13u
X286 voutp_RF iqmod_mixer_pex_half_1.iqmod_mixer_pex_tg_0.di_tg_ctrl vinp_IF VSS sg13_lv_nmos ad=0.57p pd=3.38u as=0.57p ps=3.38u w=3u l=0.13u
X287 voutp_RF iqmod_mixer_pex_half_1.iqmod_mixer_pex_tg_0.di_tg_ctrl_n voutp_RF VSS sg13_lv_nmos ad=0.57p pd=3.38u as=0 ps=0 w=3u l=0.13u
X288 iqmod_mixer_pex_half_0.iqmod_mixer_pex_tg_0.di_tg_ctrl iqmod_mixer_pex_half_0.iqmod_mixer_pex_se2diff_0.iqmod_mixer_pex_se2diff_half_inv$1_0.iqmod_mixer_pex_se2diff_inv_NF18$5_0.vout VSS VSS sg13_lv_nmos ad=0.19p pd=1.38u as=0.19p ps=1.38u w=1u l=0.13u
X289 VSS iqmod_mixer_pex_half_1.iqmod_mixer_pex_se2diff_0.iqmod_mixer_pex_se2diff_half_tg$1_0.iqmod_mixer_pex_se2diff_inv_NF18$4_0.vout iqmod_mixer_pex_half_1.iqmod_mixer_pex_tg_0.di_tg_ctrl_n VSS sg13_lv_nmos ad=0.19p pd=1.38u as=0.19p ps=1.38u w=1u l=0.13u
X290 vinp_IF iqmod_mixer_pex_half_1.iqmod_mixer_pex_tg_0.di_tg_ctrl voutp_RF VSS sg13_lv_nmos ad=0.57p pd=3.38u as=0.57p ps=3.38u w=3u l=0.13u
X291 voutp_RF iqmod_mixer_pex_half_1.iqmod_mixer_pex_tg_0.di_tg_ctrl_n voutp_RF VSS sg13_lv_nmos ad=0.57p pd=3.38u as=0 ps=0 w=3u l=0.13u
X292 iqmod_mixer_pex_half_0.iqmod_mixer_pex_tg_0.di_tg_ctrl iqmod_mixer_pex_half_0.iqmod_mixer_pex_se2diff_0.iqmod_mixer_pex_se2diff_half_inv$1_0.iqmod_mixer_pex_se2diff_inv_NF18$5_0.vout VSS VSS sg13_lv_nmos ad=0.19p pd=1.38u as=0.19p ps=1.38u w=1u l=0.13u
X293 iqmod_mixer_pex_half_0.iqmod_mixer_pex_tg_0.di_tg_ctrl iqmod_mixer_pex_half_0.iqmod_mixer_pex_se2diff_0.iqmod_mixer_pex_se2diff_half_inv$1_0.iqmod_mixer_pex_se2diff_inv_NF18$5_0.vout VDD VDD sg13_lv_pmos ad=0.57p pd=3.38u as=0.57p ps=3.38u w=3u l=0.13u
X294 VDD VDD VDD VDD sg13_lv_pmos ad=0.57p pd=3.38u as=0 ps=0 w=3u l=0.13u
X295 voutn_RF iqmod_mixer_pex_half_0.iqmod_mixer_pex_tg_0.di_tg_ctrl voutn_RF VDD sg13_lv_pmos ad=1.71p pd=9.38u as=0 ps=0 w=9u l=0.13u
X296 VSS iqmod_mixer_pex_half_0.iqmod_mixer_pex_se2diff_0.iqmod_mixer_pex_se2diff_half_tg$1_0.iqmod_mixer_pex_se2diff_inv_NF18$4_0.vout iqmod_mixer_pex_half_0.iqmod_mixer_pex_tg_0.di_tg_ctrl_n VSS sg13_lv_nmos ad=0.19p pd=1.38u as=0.19p ps=1.38u w=1u l=0.13u
X297 VSS iqmod_mixer_pex_half_0.iqmod_mixer_pex_se2diff_0.iqmod_mixer_pex_se2diff_half_tg$1_0.iqmod_mixer_pex_se2diff_inv_NF18$4_0.vout iqmod_mixer_pex_half_0.iqmod_mixer_pex_tg_0.di_tg_ctrl_n VSS sg13_lv_nmos ad=0.19p pd=1.38u as=0.19p ps=1.38u w=1u l=0.13u
X298 VSS VSS VSS VSS sg13_lv_nmos ad=0.19p pd=1.38u as=0 ps=0 w=1u l=0.13u
X299 iqmod_mixer_pex_half_1.iqmod_mixer_pex_se2diff_0.iqmod_mixer_pex_se2diff_half_tg$1_0.iqmod_mixer_pex_se2diff_tg_NF6$2_0.v_b VSS iqmod_mixer_pex_half_1.iqmod_mixer_pex_se2diff_0.iqmod_mixer_pex_se2diff_half_inv$1_0.iqmod_mixer_pex_se2diff_inv_NF2$5_0.vout VDD sg13_lv_pmos ad=0.57p pd=3.38u as=1.02p ps=6.68u w=3u l=0.13u
X300 iqmod_mixer_pex_half_0.iqmod_mixer_pex_tg_0.di_tg_ctrl iqmod_mixer_pex_half_0.iqmod_mixer_pex_se2diff_0.iqmod_mixer_pex_se2diff_half_inv$1_0.iqmod_mixer_pex_se2diff_inv_NF18$5_0.vout VDD VDD sg13_lv_pmos ad=0.57p pd=3.38u as=0.57p ps=3.38u w=3u l=0.13u
X301 VDD VDD VDD VDD sg13_lv_pmos ad=0.57p pd=3.38u as=0 ps=0 w=3u l=0.13u
X302 VDD iqmod_mixer_pex_half_1.iqmod_mixer_pex_se2diff_0.iqmod_mixer_pex_se2diff_half_inv$1_0.iqmod_mixer_pex_se2diff_inv_NF6$5_1.vout iqmod_mixer_pex_half_1.iqmod_mixer_pex_se2diff_0.iqmod_mixer_pex_se2diff_half_inv$1_0.iqmod_mixer_pex_se2diff_inv_NF18$5_0.vout VDD sg13_lv_pmos ad=0.57p pd=3.38u as=0.57p ps=3.38u w=3u l=0.13u
X303 VDD iqmod_mixer_pex_half_1.iqmod_mixer_pex_se2diff_0.iqmod_mixer_pex_se2diff_half_tg$1_0.iqmod_mixer_pex_se2diff_inv_NF18$4_0.vout iqmod_mixer_pex_half_1.iqmod_mixer_pex_tg_0.di_tg_ctrl_n VDD sg13_lv_pmos ad=0.57p pd=3.38u as=0.57p ps=3.38u w=3u l=0.13u
X304 iqmod_mixer_pex_half_0.iqmod_mixer_pex_se2diff_0.iqmod_mixer_pex_se2diff_half_tg$1_0.iqmod_mixer_pex_se2diff_inv_NF18$4_0.vout iqmod_mixer_pex_half_0.iqmod_mixer_pex_se2diff_0.iqmod_mixer_pex_se2diff_half_tg$1_0.iqmod_mixer_pex_se2diff_inv_NF6$4_0.vout VSS VSS sg13_lv_nmos ad=0.19p pd=1.38u as=0.19p ps=1.38u w=1u l=0.13u
X305 VSS iqmod_mixer_pex_half_0.iqmod_mixer_pex_se2diff_0.iqmod_mixer_pex_se2diff_half_tg$1_0.iqmod_mixer_pex_se2diff_inv_NF18$4_0.vout iqmod_mixer_pex_half_0.iqmod_mixer_pex_tg_0.di_tg_ctrl_n VSS sg13_lv_nmos ad=0.19p pd=1.38u as=0.19p ps=1.38u w=1u l=0.13u
X306 VSS iqmod_mixer_pex_half_1.iqmod_mixer_pex_se2diff_0.iqmod_mixer_pex_se2diff_half_inv$1_0.iqmod_mixer_pex_se2diff_inv_NF6$5_1.vout iqmod_mixer_pex_half_1.iqmod_mixer_pex_se2diff_0.iqmod_mixer_pex_se2diff_half_inv$1_0.iqmod_mixer_pex_se2diff_inv_NF18$5_0.vout VSS sg13_lv_nmos ad=0.19p pd=1.38u as=0.19p ps=1.38u w=1u l=0.13u
X307 VDD iqmod_mixer_pex_half_1.iqmod_mixer_pex_se2diff_0.iqmod_mixer_pex_se2diff_half_inv$1_0.iqmod_mixer_pex_se2diff_inv_NF2$5_1.vout iqmod_mixer_pex_half_1.iqmod_mixer_pex_se2diff_0.iqmod_mixer_pex_se2diff_half_tg$1_0.iqmod_mixer_pex_se2diff_inv_NF6$4_0.vout VDD sg13_lv_pmos ad=0.57p pd=3.38u as=0.57p ps=3.38u w=3u l=0.13u
X308 VSS iqmod_mixer_pex_half_0.iqmod_mixer_pex_se2diff_0.iqmod_mixer_pex_se2diff_half_inv$1_0.iqmod_mixer_pex_se2diff_inv_NF2$5_1.vout iqmod_mixer_pex_half_0.iqmod_mixer_pex_se2diff_0.iqmod_mixer_pex_se2diff_half_tg$1_0.iqmod_mixer_pex_se2diff_inv_NF6$4_0.vout VSS sg13_lv_nmos ad=0.19p pd=1.38u as=0.19p ps=1.38u w=1u l=0.13u
X309 iqmod_mixer_pex_half_0.iqmod_mixer_pex_se2diff_0.iqmod_mixer_pex_se2diff_half_tg$1_0.iqmod_mixer_pex_se2diff_inv_NF18$4_0.vout iqmod_mixer_pex_half_0.iqmod_mixer_pex_se2diff_0.iqmod_mixer_pex_se2diff_half_tg$1_0.iqmod_mixer_pex_se2diff_inv_NF6$4_0.vout VSS VSS sg13_lv_nmos ad=0.19p pd=1.38u as=0.19p ps=1.38u w=1u l=0.13u
X310 vinn_IF iqmod_mixer_pex_half_0.iqmod_mixer_pex_tg_0.di_tg_ctrl_n voutn_RF VDD sg13_lv_pmos ad=1.71p pd=9.38u as=1.71p ps=9.38u w=9u l=0.13u
X311 voutn_RF iqmod_mixer_pex_half_0.iqmod_mixer_pex_tg_0.di_tg_ctrl voutn_RF VDD sg13_lv_pmos ad=1.71p pd=9.38u as=0 ps=0 w=9u l=0.13u
X312 VSS iqmod_mixer_pex_half_0.iqmod_mixer_pex_se2diff_0.iqmod_mixer_pex_se2diff_half_tg$1_0.iqmod_mixer_pex_se2diff_inv_NF18$4_0.vout iqmod_mixer_pex_half_0.iqmod_mixer_pex_tg_0.di_tg_ctrl_n VSS sg13_lv_nmos ad=0.19p pd=1.38u as=0.19p ps=1.38u w=1u l=0.13u
X313 iqmod_mixer_pex_half_1.iqmod_mixer_pex_se2diff_0.iqmod_mixer_pex_se2diff_half_tg$1_0.iqmod_mixer_pex_se2diff_inv_NF6$4_0.vout iqmod_mixer_pex_half_1.iqmod_mixer_pex_se2diff_0.iqmod_mixer_pex_se2diff_half_inv$1_0.iqmod_mixer_pex_se2diff_inv_NF2$5_1.vout VDD VDD sg13_lv_pmos ad=0.57p pd=3.38u as=0.57p ps=3.38u w=3u l=0.13u
X314 voutn_RF iqmod_mixer_pex_half_0.iqmod_mixer_pex_tg_0.di_tg_ctrl_n vinn_IF VDD sg13_lv_pmos ad=1.71p pd=9.38u as=1.71p ps=9.38u w=9u l=0.13u
X315 VSS VSS VSS VSS sg13_lv_nmos ad=0.19p pd=1.38u as=0 ps=0 w=1u l=0.13u
X316 VSS iqmod_mixer_pex_half_1.iqmod_mixer_pex_se2diff_0.iqmod_mixer_pex_se2diff_half_inv$1_0.iqmod_mixer_pex_se2diff_inv_NF18$5_0.vout iqmod_mixer_pex_half_1.iqmod_mixer_pex_tg_0.di_tg_ctrl VSS sg13_lv_nmos ad=0.19p pd=1.38u as=0.19p ps=1.38u w=1u l=0.13u
X317 iqmod_mixer_pex_half_0.iqmod_mixer_pex_tg_0.di_tg_ctrl iqmod_mixer_pex_half_0.iqmod_mixer_pex_se2diff_0.iqmod_mixer_pex_se2diff_half_inv$1_0.iqmod_mixer_pex_se2diff_inv_NF18$5_0.vout VDD VDD sg13_lv_pmos ad=0.57p pd=3.38u as=0.57p ps=3.38u w=3u l=0.13u
X318 VDD iqmod_mixer_pex_half_0.iqmod_mixer_pex_se2diff_0.iqmod_mixer_pex_se2diff_half_inv$1_0.iqmod_mixer_pex_se2diff_inv_NF6$5_1.vout iqmod_mixer_pex_half_0.iqmod_mixer_pex_se2diff_0.iqmod_mixer_pex_se2diff_half_inv$1_0.iqmod_mixer_pex_se2diff_inv_NF18$5_0.vout VDD sg13_lv_pmos ad=0.57p pd=3.38u as=0.57p ps=3.38u w=3u l=0.13u
X319 vinp_IF iqmod_mixer_pex_half_1.iqmod_mixer_pex_tg_0.di_tg_ctrl_n voutp_RF VDD sg13_lv_pmos ad=1.71p pd=9.38u as=1.71p ps=9.38u w=9u l=0.13u
X320 VSS VSS VSS VSS sg13_lv_nmos ad=0.34p pd=2.68u as=0 ps=0 w=1u l=0.13u
X321 vinn_IF iqmod_mixer_pex_half_0.iqmod_mixer_pex_tg_0.di_tg_ctrl_n voutn_RF VDD sg13_lv_pmos ad=1.71p pd=9.38u as=1.71p ps=9.38u w=9u l=0.13u
X322 VSS iqmod_mixer_pex_half_0.iqmod_mixer_pex_se2diff_0.iqmod_mixer_pex_se2diff_half_tg$1_0.iqmod_mixer_pex_se2diff_inv_NF18$4_0.vout iqmod_mixer_pex_half_0.iqmod_mixer_pex_tg_0.di_tg_ctrl_n VSS sg13_lv_nmos ad=0.19p pd=1.38u as=0.19p ps=1.38u w=1u l=0.13u
X323 iqmod_mixer_pex_half_1.iqmod_mixer_pex_se2diff_0.iqmod_mixer_pex_se2diff_half_inv$1_0.iqmod_mixer_pex_se2diff_inv_NF6$5_2.vout iqmod_mixer_pex_half_1.iqmod_mixer_pex_se2diff_0.iqmod_mixer_pex_se2diff_half_inv$1_0.iqmod_mixer_pex_se2diff_inv_NF6$5_2.vin VDD VDD sg13_lv_pmos ad=0.57p pd=3.38u as=0.57p ps=3.38u w=3u l=0.13u
X324 iqmod_mixer_pex_half_1.iqmod_mixer_pex_tg_0.di_tg_ctrl iqmod_mixer_pex_half_1.iqmod_mixer_pex_se2diff_0.iqmod_mixer_pex_se2diff_half_inv$1_0.iqmod_mixer_pex_se2diff_inv_NF18$5_0.vout VSS VSS sg13_lv_nmos ad=0.19p pd=1.38u as=0.19p ps=1.38u w=1u l=0.13u
X325 VDD iqmod_mixer_pex_half_1.iqmod_mixer_pex_se2diff_0.iqmod_mixer_pex_se2diff_half_inv$1_0.iqmod_mixer_pex_se2diff_inv_NF18$5_0.vout iqmod_mixer_pex_half_1.iqmod_mixer_pex_tg_0.di_tg_ctrl VDD sg13_lv_pmos ad=0.57p pd=3.38u as=0.57p ps=3.38u w=3u l=0.13u
X326 voutp_RF iqmod_mixer_pex_half_1.iqmod_mixer_pex_tg_0.di_tg_ctrl_n vinp_IF VDD sg13_lv_pmos ad=1.71p pd=9.38u as=1.71p ps=9.38u w=9u l=0.13u
X327 iqmod_mixer_pex_half_1.iqmod_mixer_pex_tg_0.di_tg_ctrl_n iqmod_mixer_pex_half_1.iqmod_mixer_pex_se2diff_0.iqmod_mixer_pex_se2diff_half_tg$1_0.iqmod_mixer_pex_se2diff_inv_NF18$4_0.vout VDD VDD sg13_lv_pmos ad=0.57p pd=3.38u as=0.57p ps=3.38u w=3u l=0.13u
X328 VDD iqmod_mixer_pex_half_1.iqmod_mixer_pex_se2diff_0.iqmod_mixer_pex_se2diff_half_inv$1_0.iqmod_mixer_pex_se2diff_inv_NF6$5_2.vin iqmod_mixer_pex_half_1.iqmod_mixer_pex_se2diff_0.iqmod_mixer_pex_se2diff_half_inv$1_0.iqmod_mixer_pex_se2diff_inv_NF6$5_2.vout VDD sg13_lv_pmos ad=0.57p pd=3.38u as=0.57p ps=3.38u w=3u l=0.13u
X329 vinn_IF iqmod_mixer_pex_half_0.iqmod_mixer_pex_tg_0.di_tg_ctrl_n voutn_RF VDD sg13_lv_pmos ad=1.71p pd=9.38u as=1.71p ps=9.38u w=9u l=0.13u
X330 vinn_IF iqmod_mixer_pex_half_0.iqmod_mixer_pex_tg_0.di_tg_ctrl_n voutn_RF VDD sg13_lv_pmos ad=1.71p pd=9.38u as=1.71p ps=9.38u w=9u l=0.13u
X331 VDD iqmod_mixer_pex_half_1.iqmod_mixer_pex_se2diff_0.iqmod_mixer_pex_se2diff_half_inv$1_0.iqmod_mixer_pex_se2diff_inv_NF18$5_0.vout iqmod_mixer_pex_half_1.iqmod_mixer_pex_tg_0.di_tg_ctrl VDD sg13_lv_pmos ad=0.57p pd=3.38u as=0.57p ps=3.38u w=3u l=0.13u
X332 VDD iqmod_mixer_pex_half_1.iqmod_mixer_pex_se2diff_0.iqmod_mixer_pex_se2diff_half_inv$1_0.iqmod_mixer_pex_se2diff_inv_NF18$5_0.vout iqmod_mixer_pex_half_1.iqmod_mixer_pex_tg_0.di_tg_ctrl VDD sg13_lv_pmos ad=0.57p pd=3.38u as=0.57p ps=3.38u w=3u l=0.13u
X333 iqmod_mixer_pex_half_1.iqmod_mixer_pex_se2diff_0.iqmod_mixer_pex_se2diff_half_tg$1_0.iqmod_mixer_pex_se2diff_inv_NF18$4_0.vout iqmod_mixer_pex_half_1.iqmod_mixer_pex_se2diff_0.iqmod_mixer_pex_se2diff_half_tg$1_0.iqmod_mixer_pex_se2diff_inv_NF6$4_0.vout VSS VSS sg13_lv_nmos ad=0.19p pd=1.38u as=0.19p ps=1.38u w=1u l=0.13u
X334 vinn_IF iqmod_mixer_pex_half_0.iqmod_mixer_pex_tg_0.di_tg_ctrl_n voutn_RF VDD sg13_lv_pmos ad=1.71p pd=9.38u as=1.71p ps=9.38u w=9u l=0.13u
X335 VDD VDD VDD VDD sg13_lv_pmos ad=0.57p pd=3.38u as=0 ps=0 w=3u l=0.13u
X336 VSS iqmod_mixer_pex_half_1.iqmod_mixer_pex_se2diff_0.iqmod_mixer_pex_se2diff_half_tg$1_0.iqmod_mixer_pex_se2diff_inv_NF6$4_0.vout iqmod_mixer_pex_half_1.iqmod_mixer_pex_se2diff_0.iqmod_mixer_pex_se2diff_half_tg$1_0.iqmod_mixer_pex_se2diff_inv_NF18$4_0.vout VSS sg13_lv_nmos ad=0.19p pd=1.38u as=0.19p ps=1.38u w=1u l=0.13u
X337 iqmod_mixer_pex_half_1.iqmod_mixer_pex_tg_0.di_tg_ctrl iqmod_mixer_pex_half_1.iqmod_mixer_pex_se2diff_0.iqmod_mixer_pex_se2diff_half_inv$1_0.iqmod_mixer_pex_se2diff_inv_NF18$5_0.vout VDD VDD sg13_lv_pmos ad=0.57p pd=3.38u as=0.57p ps=3.38u w=3u l=0.13u
X338 iqmod_mixer_pex_half_1.iqmod_mixer_pex_tg_0.di_tg_ctrl_n iqmod_mixer_pex_half_1.iqmod_mixer_pex_se2diff_0.iqmod_mixer_pex_se2diff_half_tg$1_0.iqmod_mixer_pex_se2diff_inv_NF18$4_0.vout VSS VSS sg13_lv_nmos ad=0.19p pd=1.38u as=0.19p ps=1.38u w=1u l=0.13u
X339 VSS iqmod_mixer_pex_half_1.iqmod_mixer_pex_se2diff_0.iqmod_mixer_pex_se2diff_half_inv$1_0.iqmod_mixer_pex_se2diff_inv_NF2$5_0.vout iqmod_mixer_pex_half_1.iqmod_mixer_pex_se2diff_0.iqmod_mixer_pex_se2diff_half_inv$1_0.iqmod_mixer_pex_se2diff_inv_NF6$5_2.vin VSS sg13_lv_nmos ad=0.19p pd=1.38u as=0.19p ps=1.38u w=1u l=0.13u
X340 iqmod_mixer_pex_half_0.iqmod_mixer_pex_se2diff_0.iqmod_mixer_pex_se2diff_half_tg$1_0.iqmod_mixer_pex_se2diff_tg_NF6$2_0.v_b VDD iqmod_mixer_pex_half_0.iqmod_mixer_pex_se2diff_0.iqmod_mixer_pex_se2diff_half_inv$1_0.iqmod_mixer_pex_se2diff_inv_NF2$5_0.vout VSS sg13_lv_nmos ad=0.19p pd=1.38u as=0.19p ps=1.38u w=1u l=0.13u
X341 VSS iqmod_mixer_pex_half_0.iqmod_mixer_pex_se2diff_0.iqmod_mixer_pex_se2diff_half_tg$1_0.iqmod_mixer_pex_se2diff_tg_NF6$2_0.v_b iqmod_mixer_pex_half_0.iqmod_mixer_pex_se2diff_0.iqmod_mixer_pex_se2diff_half_inv$1_0.iqmod_mixer_pex_se2diff_inv_NF2$5_1.vout VSS sg13_lv_nmos ad=0.19p pd=1.38u as=0.19p ps=1.38u w=1u l=0.13u
X342 VSS iqmod_mixer_pex_half_1.iqmod_mixer_pex_se2diff_0.iqmod_mixer_pex_se2diff_half_tg$1_0.iqmod_mixer_pex_se2diff_inv_NF18$4_0.vout iqmod_mixer_pex_half_1.iqmod_mixer_pex_tg_0.di_tg_ctrl_n VSS sg13_lv_nmos ad=0.19p pd=1.38u as=0.19p ps=1.38u w=1u l=0.13u
X343 iqmod_mixer_pex_half_1.iqmod_mixer_pex_se2diff_0.iqmod_mixer_pex_se2diff_half_inv$1_0.iqmod_mixer_pex_se2diff_inv_NF6$5_2.vin iqmod_mixer_pex_half_1.iqmod_mixer_pex_se2diff_0.iqmod_mixer_pex_se2diff_half_inv$1_0.iqmod_mixer_pex_se2diff_inv_NF2$5_0.vout VSS VSS sg13_lv_nmos ad=0.19p pd=1.38u as=0.19p ps=1.38u w=1u l=0.13u
X344 VDD iqmod_mixer_pex_half_0.iqmod_mixer_pex_se2diff_0.iqmod_mixer_pex_se2diff_half_inv$1_0.iqmod_mixer_pex_se2diff_inv_NF6$5_2.vout iqmod_mixer_pex_half_0.iqmod_mixer_pex_se2diff_0.iqmod_mixer_pex_se2diff_half_inv$1_0.iqmod_mixer_pex_se2diff_inv_NF2$5_1.vout VDD sg13_lv_pmos ad=0.57p pd=3.38u as=0.57p ps=3.38u w=3u l=0.13u
X345 voutn_RF iqmod_mixer_pex_half_0.iqmod_mixer_pex_tg_0.di_tg_ctrl_n voutn_RF VSS sg13_lv_nmos ad=0.57p pd=3.38u as=0 ps=0 w=3u l=0.13u
X346 VSS VSS VSS VSS sg13_lv_nmos ad=0.34p pd=2.68u as=0 ps=0 w=1u l=0.13u
X347 iqmod_mixer_pex_half_0.iqmod_mixer_pex_se2diff_0.iqmod_mixer_pex_se2diff_half_inv$1_0.iqmod_mixer_pex_se2diff_inv_NF6$5_2.vout iqmod_mixer_pex_half_0.iqmod_mixer_pex_se2diff_0.iqmod_mixer_pex_se2diff_half_inv$1_0.iqmod_mixer_pex_se2diff_inv_NF6$5_2.vin VDD VDD sg13_lv_pmos ad=0.57p pd=3.38u as=0.57p ps=3.38u w=3u l=0.13u
X348 iqmod_mixer_pex_half_0.iqmod_mixer_pex_se2diff_0.iqmod_mixer_pex_se2diff_half_tg$1_0.iqmod_mixer_pex_se2diff_tg_NF6$2_0.v_b VDD iqmod_mixer_pex_half_0.iqmod_mixer_pex_se2diff_0.iqmod_mixer_pex_se2diff_half_inv$1_0.iqmod_mixer_pex_se2diff_inv_NF2$5_0.vout VSS sg13_lv_nmos ad=0.19p pd=1.38u as=0.34p ps=2.68u w=1u l=0.13u
X349 iqmod_mixer_pex_half_1.iqmod_mixer_pex_se2diff_0.iqmod_mixer_pex_se2diff_half_inv$1_0.iqmod_mixer_pex_se2diff_inv_NF6$5_2.vout iqmod_mixer_pex_half_1.iqmod_mixer_pex_se2diff_0.iqmod_mixer_pex_se2diff_half_inv$1_0.iqmod_mixer_pex_se2diff_inv_NF2$5_1.vout VSS VSS sg13_lv_nmos ad=0.19p pd=1.38u as=0.19p ps=1.38u w=1u l=0.13u
X350 VSS iqmod_mixer_pex_half_1.iqmod_mixer_pex_se2diff_0.iqmod_mixer_pex_se2diff_half_inv$1_0.iqmod_mixer_pex_se2diff_inv_NF18$5_0.vout iqmod_mixer_pex_half_1.iqmod_mixer_pex_tg_0.di_tg_ctrl VSS sg13_lv_nmos ad=0.19p pd=1.38u as=0.19p ps=1.38u w=1u l=0.13u
X351 voutp_RF iqmod_mixer_pex_half_1.iqmod_mixer_pex_tg_0.di_tg_ctrl vinp_IF VSS sg13_lv_nmos ad=0.57p pd=3.38u as=0.57p ps=3.38u w=3u l=0.13u
X352 voutn_RF iqmod_mixer_pex_half_0.iqmod_mixer_pex_tg_0.di_tg_ctrl_n voutn_RF VSS sg13_lv_nmos ad=0.57p pd=3.38u as=0 ps=0 w=3u l=0.13u
X353 voutn_RF iqmod_mixer_pex_half_0.iqmod_mixer_pex_tg_0.di_tg_ctrl vinn_IF VSS sg13_lv_nmos ad=0.57p pd=3.38u as=0.57p ps=3.38u w=3u l=0.13u
X354 VDD VDD VDD VDD sg13_lv_pmos ad=0.57p pd=3.38u as=0 ps=0 w=3u l=0.13u
X355 iqmod_mixer_pex_half_1.iqmod_mixer_pex_tg_0.di_tg_ctrl iqmod_mixer_pex_half_1.iqmod_mixer_pex_se2diff_0.iqmod_mixer_pex_se2diff_half_inv$1_0.iqmod_mixer_pex_se2diff_inv_NF18$5_0.vout VSS VSS sg13_lv_nmos ad=0.19p pd=1.38u as=0.19p ps=1.38u w=1u l=0.13u
X356 iqmod_mixer_pex_half_1.iqmod_mixer_pex_se2diff_0.iqmod_mixer_pex_se2diff_half_inv$1_0.iqmod_mixer_pex_se2diff_inv_NF2$5_0.vout VSS iqmod_mixer_pex_half_1.iqmod_mixer_pex_se2diff_0.iqmod_mixer_pex_se2diff_half_tg$1_0.iqmod_mixer_pex_se2diff_tg_NF6$2_0.v_b VDD sg13_lv_pmos ad=0.57p pd=3.38u as=0.57p ps=3.38u w=3u l=0.13u
X357 vinp_IF iqmod_mixer_pex_half_1.iqmod_mixer_pex_tg_0.di_tg_ctrl voutp_RF VSS sg13_lv_nmos ad=0.57p pd=3.38u as=0.57p ps=3.38u w=3u l=0.13u
X358 VDD VDD VDD VDD sg13_lv_pmos ad=0.57p pd=3.38u as=0 ps=0 w=3u l=0.13u
X359 VDD iqmod_mixer_pex_half_0.iqmod_mixer_pex_se2diff_0.iqmod_mixer_pex_se2diff_half_inv$1_0.iqmod_mixer_pex_se2diff_inv_NF18$5_0.vout iqmod_mixer_pex_half_0.iqmod_mixer_pex_tg_0.di_tg_ctrl VDD sg13_lv_pmos ad=0.57p pd=3.38u as=0.57p ps=3.38u w=3u l=0.13u
X360 VDD VDD VDD VDD sg13_lv_pmos ad=0.57p pd=3.38u as=0 ps=0 w=3u l=0.13u
X361 voutn_RF iqmod_mixer_pex_half_0.iqmod_mixer_pex_tg_0.di_tg_ctrl vinn_IF VSS sg13_lv_nmos ad=0.57p pd=3.38u as=0.57p ps=3.38u w=3u l=0.13u
X362 VDD VDD VDD VDD sg13_lv_pmos ad=0.57p pd=3.38u as=0 ps=0 w=3u l=0.13u
X363 VDD iqmod_mixer_pex_half_0.iqmod_mixer_pex_se2diff_0.iqmod_mixer_pex_se2diff_half_inv$1_0.iqmod_mixer_pex_se2diff_inv_NF18$5_0.vout iqmod_mixer_pex_half_0.iqmod_mixer_pex_tg_0.di_tg_ctrl VDD sg13_lv_pmos ad=0.57p pd=3.38u as=0.57p ps=3.38u w=3u l=0.13u
X364 VDD iqmod_mixer_pex_half_1.iqmod_mixer_pex_se2diff_0.iqmod_mixer_pex_se2diff_half_inv$1_0.iqmod_mixer_pex_se2diff_inv_NF2$5_1.vout iqmod_mixer_pex_half_1.iqmod_mixer_pex_se2diff_0.iqmod_mixer_pex_se2diff_half_tg$1_0.iqmod_mixer_pex_se2diff_inv_NF6$4_0.vout VDD sg13_lv_pmos ad=0.57p pd=3.38u as=0.57p ps=3.38u w=3u l=0.13u
X365 iqmod_mixer_pex_half_1.iqmod_mixer_pex_se2diff_0.iqmod_mixer_pex_se2diff_half_inv$1_0.iqmod_mixer_pex_se2diff_inv_NF18$5_0.vout iqmod_mixer_pex_half_1.iqmod_mixer_pex_se2diff_0.iqmod_mixer_pex_se2diff_half_inv$1_0.iqmod_mixer_pex_se2diff_inv_NF6$5_1.vout VDD VDD sg13_lv_pmos ad=0.57p pd=3.38u as=0.57p ps=3.38u w=3u l=0.13u
X366 VSS iqmod_mixer_pex_half_1.iqmod_mixer_pex_se2diff_0.iqmod_mixer_pex_se2diff_half_inv$1_0.iqmod_mixer_pex_se2diff_inv_NF18$5_0.vout iqmod_mixer_pex_half_1.iqmod_mixer_pex_tg_0.di_tg_ctrl VSS sg13_lv_nmos ad=0.19p pd=1.38u as=0.19p ps=1.38u w=1u l=0.13u
X367 VDD iqmod_mixer_pex_half_0.iqmod_mixer_pex_se2diff_0.iqmod_mixer_pex_se2diff_half_inv$1_0.iqmod_mixer_pex_se2diff_inv_NF18$5_0.vout iqmod_mixer_pex_half_0.iqmod_mixer_pex_tg_0.di_tg_ctrl VDD sg13_lv_pmos ad=0.57p pd=3.38u as=0.57p ps=3.38u w=3u l=0.13u
X368 voutn_RF iqmod_mixer_pex_half_0.iqmod_mixer_pex_tg_0.di_tg_ctrl vinn_IF VSS sg13_lv_nmos ad=0.57p pd=3.38u as=0.57p ps=3.38u w=3u l=0.13u
X369 voutn_RF iqmod_mixer_pex_half_0.iqmod_mixer_pex_tg_0.di_tg_ctrl vinn_IF VSS sg13_lv_nmos ad=0.57p pd=3.38u as=0.57p ps=3.38u w=3u l=0.13u
X370 iqmod_mixer_pex_half_0.iqmod_mixer_pex_tg_0.di_tg_ctrl_n iqmod_mixer_pex_half_0.iqmod_mixer_pex_se2diff_0.iqmod_mixer_pex_se2diff_half_tg$1_0.iqmod_mixer_pex_se2diff_inv_NF18$4_0.vout VDD VDD sg13_lv_pmos ad=0.57p pd=3.38u as=0.57p ps=3.38u w=3u l=0.13u
X371 iqmod_mixer_pex_half_0.iqmod_mixer_pex_tg_0.di_tg_ctrl_n iqmod_mixer_pex_half_0.iqmod_mixer_pex_se2diff_0.iqmod_mixer_pex_se2diff_half_tg$1_0.iqmod_mixer_pex_se2diff_inv_NF18$4_0.vout VDD VDD sg13_lv_pmos ad=0.57p pd=3.38u as=0.57p ps=3.38u w=3u l=0.13u
X372 VDD iqmod_mixer_pex_half_0.iqmod_mixer_pex_se2diff_0.iqmod_mixer_pex_se2diff_half_inv$1_0.iqmod_mixer_pex_se2diff_inv_NF18$5_0.vout iqmod_mixer_pex_half_0.iqmod_mixer_pex_tg_0.di_tg_ctrl VDD sg13_lv_pmos ad=0.57p pd=3.38u as=0.57p ps=3.38u w=3u l=0.13u
X373 iqmod_mixer_pex_half_0.iqmod_mixer_pex_se2diff_0.iqmod_mixer_pex_se2diff_half_inv$1_0.iqmod_mixer_pex_se2diff_inv_NF18$5_0.vout iqmod_mixer_pex_half_0.iqmod_mixer_pex_se2diff_0.iqmod_mixer_pex_se2diff_half_inv$1_0.iqmod_mixer_pex_se2diff_inv_NF6$5_1.vout VDD VDD sg13_lv_pmos ad=0.57p pd=3.38u as=0.57p ps=3.38u w=3u l=0.13u
X374 iqmod_mixer_pex_half_0.iqmod_mixer_pex_se2diff_0.iqmod_mixer_pex_se2diff_half_inv$1_0.iqmod_mixer_pex_se2diff_inv_NF18$5_0.vout iqmod_mixer_pex_half_0.iqmod_mixer_pex_se2diff_0.iqmod_mixer_pex_se2diff_half_inv$1_0.iqmod_mixer_pex_se2diff_inv_NF6$5_1.vout VDD VDD sg13_lv_pmos ad=0.57p pd=3.38u as=0.57p ps=3.38u w=3u l=0.13u
X375 VDD iqmod_mixer_pex_half_0.iqmod_mixer_pex_se2diff_0.iqmod_mixer_pex_se2diff_half_inv$1_0.iqmod_mixer_pex_se2diff_inv_NF6$5_2.vout iqmod_mixer_pex_half_0.iqmod_mixer_pex_se2diff_0.iqmod_mixer_pex_se2diff_half_inv$1_0.iqmod_mixer_pex_se2diff_inv_NF6$5_1.vout VDD sg13_lv_pmos ad=0.57p pd=3.38u as=0.57p ps=3.38u w=3u l=0.13u
X376 VDD VDD VDD VDD sg13_lv_pmos ad=0.57p pd=3.38u as=0 ps=0 w=3u l=0.13u
X377 iqmod_mixer_pex_half_1.iqmod_mixer_pex_tg_0.di_tg_ctrl iqmod_mixer_pex_half_1.iqmod_mixer_pex_se2diff_0.iqmod_mixer_pex_se2diff_half_inv$1_0.iqmod_mixer_pex_se2diff_inv_NF18$5_0.vout VSS VSS sg13_lv_nmos ad=0.19p pd=1.38u as=0.19p ps=1.38u w=1u l=0.13u
X378 iqmod_mixer_pex_half_1.iqmod_mixer_pex_tg_0.di_tg_ctrl iqmod_mixer_pex_half_1.iqmod_mixer_pex_se2diff_0.iqmod_mixer_pex_se2diff_half_inv$1_0.iqmod_mixer_pex_se2diff_inv_NF18$5_0.vout VSS VSS sg13_lv_nmos ad=0.19p pd=1.38u as=0.19p ps=1.38u w=1u l=0.13u
X379 voutp_RF iqmod_mixer_pex_half_1.iqmod_mixer_pex_tg_0.di_tg_ctrl voutp_RF VDD sg13_lv_pmos ad=1.71p pd=9.38u as=0 ps=0 w=9u l=0.13u
X380 VDD iqmod_mixer_pex_half_1.iqmod_mixer_pex_se2diff_0.iqmod_mixer_pex_se2diff_half_tg$1_0.iqmod_mixer_pex_se2diff_inv_NF18$4_0.vout iqmod_mixer_pex_half_1.iqmod_mixer_pex_tg_0.di_tg_ctrl_n VDD sg13_lv_pmos ad=0.57p pd=3.38u as=0.57p ps=3.38u w=3u l=0.13u
X381 iqmod_mixer_pex_half_0.iqmod_mixer_pex_tg_0.di_tg_ctrl iqmod_mixer_pex_half_0.iqmod_mixer_pex_se2diff_0.iqmod_mixer_pex_se2diff_half_inv$1_0.iqmod_mixer_pex_se2diff_inv_NF18$5_0.vout VSS VSS sg13_lv_nmos ad=0.19p pd=1.38u as=0.19p ps=1.38u w=1u l=0.13u
X382 voutn_RF iqmod_mixer_pex_half_0.iqmod_mixer_pex_tg_0.di_tg_ctrl vinn_IF VSS sg13_lv_nmos ad=0.57p pd=3.38u as=0.57p ps=3.38u w=3u l=0.13u
X383 VSS VSS VSS VSS sg13_lv_nmos ad=0.34p pd=2.68u as=0 ps=0 w=1u l=0.13u
X384 iqmod_mixer_pex_half_0.iqmod_mixer_pex_tg_0.di_tg_ctrl_n iqmod_mixer_pex_half_0.iqmod_mixer_pex_se2diff_0.iqmod_mixer_pex_se2diff_half_tg$1_0.iqmod_mixer_pex_se2diff_inv_NF18$4_0.vout VDD VDD sg13_lv_pmos ad=0.57p pd=3.38u as=0.57p ps=3.38u w=3u l=0.13u
X385 VDD iqmod_mixer_pex_half_0.iqmod_mixer_pex_se2diff_0.iqmod_mixer_pex_se2diff_half_inv$1_0.iqmod_mixer_pex_se2diff_inv_NF18$5_0.vout iqmod_mixer_pex_half_0.iqmod_mixer_pex_tg_0.di_tg_ctrl VDD sg13_lv_pmos ad=0.57p pd=3.38u as=0.57p ps=3.38u w=3u l=0.13u
X386 VDD VDD VDD VDD sg13_lv_pmos ad=1.02p pd=6.68u as=0 ps=0 w=3u l=0.13u
X387 VSS VSS VSS VSS sg13_lv_nmos ad=0.19p pd=1.38u as=0 ps=0 w=1u l=0.13u
X388 voutp_RF iqmod_mixer_pex_half_1.iqmod_mixer_pex_tg_0.di_tg_ctrl voutp_RF VDD sg13_lv_pmos ad=1.71p pd=9.38u as=0 ps=0 w=9u l=0.13u
X389 iqmod_mixer_pex_half_0.iqmod_mixer_pex_se2diff_0.iqmod_mixer_pex_se2diff_half_tg$1_0.iqmod_mixer_pex_se2diff_inv_NF6$4_0.vout iqmod_mixer_pex_half_0.iqmod_mixer_pex_se2diff_0.iqmod_mixer_pex_se2diff_half_inv$1_0.iqmod_mixer_pex_se2diff_inv_NF2$5_1.vout VDD VDD sg13_lv_pmos ad=0.57p pd=3.38u as=0.57p ps=3.38u w=3u l=0.13u
X390 VDD iqmod_mixer_pex_half_0.iqmod_mixer_pex_se2diff_0.iqmod_mixer_pex_se2diff_half_tg$1_0.iqmod_mixer_pex_se2diff_inv_NF6$4_0.vout iqmod_mixer_pex_half_0.iqmod_mixer_pex_se2diff_0.iqmod_mixer_pex_se2diff_half_tg$1_0.iqmod_mixer_pex_se2diff_inv_NF18$4_0.vout VDD sg13_lv_pmos ad=0.57p pd=3.38u as=0.57p ps=3.38u w=3u l=0.13u
X391 iqmod_mixer_pex_half_0.iqmod_mixer_pex_tg_0.di_tg_ctrl_n iqmod_mixer_pex_half_0.iqmod_mixer_pex_se2diff_0.iqmod_mixer_pex_se2diff_half_tg$1_0.iqmod_mixer_pex_se2diff_inv_NF18$4_0.vout VDD VDD sg13_lv_pmos ad=0.57p pd=3.38u as=0.57p ps=3.38u w=3u l=0.13u
X392 iqmod_mixer_pex_half_0.iqmod_mixer_pex_tg_0.di_tg_ctrl_n iqmod_mixer_pex_half_0.iqmod_mixer_pex_se2diff_0.iqmod_mixer_pex_se2diff_half_tg$1_0.iqmod_mixer_pex_se2diff_inv_NF18$4_0.vout VDD VDD sg13_lv_pmos ad=0.57p pd=3.38u as=0.57p ps=3.38u w=3u l=0.13u
X393 iqmod_mixer_pex_half_1.iqmod_mixer_pex_se2diff_0.iqmod_mixer_pex_se2diff_half_tg$1_0.iqmod_mixer_pex_se2diff_inv_NF6$4_0.vout iqmod_mixer_pex_half_1.iqmod_mixer_pex_se2diff_0.iqmod_mixer_pex_se2diff_half_inv$1_0.iqmod_mixer_pex_se2diff_inv_NF2$5_1.vout VDD VDD sg13_lv_pmos ad=0.57p pd=3.38u as=0.57p ps=3.38u w=3u l=0.13u
X394 voutp_RF iqmod_mixer_pex_half_1.iqmod_mixer_pex_tg_0.di_tg_ctrl_n vinp_IF VDD sg13_lv_pmos ad=1.71p pd=9.38u as=1.71p ps=9.38u w=9u l=0.13u
X395 voutp_RF iqmod_mixer_pex_half_1.iqmod_mixer_pex_tg_0.di_tg_ctrl voutp_RF VDD sg13_lv_pmos ad=1.71p pd=9.38u as=0 ps=0 w=9u l=0.13u
X396 iqmod_mixer_pex_half_0.iqmod_mixer_pex_tg_0.di_tg_ctrl iqmod_mixer_pex_half_0.iqmod_mixer_pex_se2diff_0.iqmod_mixer_pex_se2diff_half_inv$1_0.iqmod_mixer_pex_se2diff_inv_NF18$5_0.vout VSS VSS sg13_lv_nmos ad=0.19p pd=1.38u as=0.19p ps=1.38u w=1u l=0.13u
X397 VDD VDD VDD VDD sg13_lv_pmos ad=0.57p pd=3.38u as=0 ps=0 w=3u l=0.13u
X398 VSS VSS VSS VSS sg13_lv_nmos ad=0.34p pd=2.68u as=0 ps=0 w=1u l=0.13u
X399 iqmod_mixer_pex_half_0.iqmod_mixer_pex_se2diff_0.iqmod_mixer_pex_se2diff_half_tg$1_0.iqmod_mixer_pex_se2diff_inv_NF6$4_0.vout iqmod_mixer_pex_half_0.iqmod_mixer_pex_se2diff_0.iqmod_mixer_pex_se2diff_half_inv$1_0.iqmod_mixer_pex_se2diff_inv_NF2$5_1.vout VDD VDD sg13_lv_pmos ad=0.57p pd=3.38u as=0.57p ps=3.38u w=3u l=0.13u
X400 VDD VDD VDD VDD sg13_lv_pmos ad=1.02p pd=6.68u as=0 ps=0 w=3u l=0.13u
X401 iqmod_mixer_pex_half_0.iqmod_mixer_pex_tg_0.di_tg_ctrl_n iqmod_mixer_pex_half_0.iqmod_mixer_pex_se2diff_0.iqmod_mixer_pex_se2diff_half_tg$1_0.iqmod_mixer_pex_se2diff_inv_NF18$4_0.vout VDD VDD sg13_lv_pmos ad=0.57p pd=3.38u as=0.57p ps=3.38u w=3u l=0.13u
X402 VDD iqmod_mixer_pex_half_1.iqmod_mixer_pex_se2diff_0.iqmod_mixer_pex_se2diff_half_inv$1_0.iqmod_mixer_pex_se2diff_inv_NF6$5_1.vout iqmod_mixer_pex_half_1.iqmod_mixer_pex_se2diff_0.iqmod_mixer_pex_se2diff_half_inv$1_0.iqmod_mixer_pex_se2diff_inv_NF18$5_0.vout VDD sg13_lv_pmos ad=0.57p pd=3.38u as=0.57p ps=3.38u w=3u l=0.13u
X403 vinp_IF iqmod_mixer_pex_half_1.iqmod_mixer_pex_tg_0.di_tg_ctrl_n voutp_RF VDD sg13_lv_pmos ad=1.71p pd=9.38u as=3.06p ps=18.68u w=9u l=0.13u
X404 VSS iqmod_mixer_pex_half_1.iqmod_mixer_pex_se2diff_0.iqmod_mixer_pex_se2diff_half_tg$1_0.iqmod_mixer_pex_se2diff_inv_NF6$4_0.vout iqmod_mixer_pex_half_1.iqmod_mixer_pex_se2diff_0.iqmod_mixer_pex_se2diff_half_tg$1_0.iqmod_mixer_pex_se2diff_inv_NF18$4_0.vout VSS sg13_lv_nmos ad=0.19p pd=1.38u as=0.19p ps=1.38u w=1u l=0.13u
X405 iqmod_mixer_pex_half_1.iqmod_mixer_pex_tg_0.di_tg_ctrl iqmod_mixer_pex_half_1.iqmod_mixer_pex_se2diff_0.iqmod_mixer_pex_se2diff_half_inv$1_0.iqmod_mixer_pex_se2diff_inv_NF18$5_0.vout VDD VDD sg13_lv_pmos ad=0.57p pd=3.38u as=0.57p ps=3.38u w=3u l=0.13u
X406 iqmod_mixer_pex_half_1.iqmod_mixer_pex_tg_0.di_tg_ctrl_n iqmod_mixer_pex_half_1.iqmod_mixer_pex_se2diff_0.iqmod_mixer_pex_se2diff_half_tg$1_0.iqmod_mixer_pex_se2diff_inv_NF18$4_0.vout VDD VDD sg13_lv_pmos ad=0.57p pd=3.38u as=0.57p ps=3.38u w=3u l=0.13u
X407 voutp_RF iqmod_mixer_pex_half_1.iqmod_mixer_pex_tg_0.di_tg_ctrl vinp_IF VSS sg13_lv_nmos ad=0.57p pd=3.38u as=0.57p ps=3.38u w=3u l=0.13u
X408 iqmod_mixer_pex_half_0.iqmod_mixer_pex_tg_0.di_tg_ctrl_n iqmod_mixer_pex_half_0.iqmod_mixer_pex_se2diff_0.iqmod_mixer_pex_se2diff_half_tg$1_0.iqmod_mixer_pex_se2diff_inv_NF18$4_0.vout VDD VDD sg13_lv_pmos ad=0.57p pd=3.38u as=0.57p ps=3.38u w=3u l=0.13u
X409 iqmod_mixer_pex_half_0.iqmod_mixer_pex_tg_0.di_tg_ctrl iqmod_mixer_pex_half_0.iqmod_mixer_pex_se2diff_0.iqmod_mixer_pex_se2diff_half_inv$1_0.iqmod_mixer_pex_se2diff_inv_NF18$5_0.vout VSS VSS sg13_lv_nmos ad=0.19p pd=1.38u as=0.19p ps=1.38u w=1u l=0.13u
X410 VSS iqmod_mixer_pex_half_0.iqmod_mixer_pex_se2diff_0.iqmod_mixer_pex_se2diff_half_inv$1_0.iqmod_mixer_pex_se2diff_inv_NF6$5_1.vout iqmod_mixer_pex_half_0.iqmod_mixer_pex_se2diff_0.iqmod_mixer_pex_se2diff_half_inv$1_0.iqmod_mixer_pex_se2diff_inv_NF18$5_0.vout VSS sg13_lv_nmos ad=0.19p pd=1.38u as=0.19p ps=1.38u w=1u l=0.13u
X411 iqmod_mixer_pex_half_1.iqmod_mixer_pex_se2diff_0.iqmod_mixer_pex_se2diff_half_tg$1_0.iqmod_mixer_pex_se2diff_inv_NF18$4_0.vout iqmod_mixer_pex_half_1.iqmod_mixer_pex_se2diff_0.iqmod_mixer_pex_se2diff_half_tg$1_0.iqmod_mixer_pex_se2diff_inv_NF6$4_0.vout VSS VSS sg13_lv_nmos ad=0.19p pd=1.38u as=0.19p ps=1.38u w=1u l=0.13u
X412 VSS iqmod_mixer_pex_half_1.iqmod_mixer_pex_se2diff_0.iqmod_mixer_pex_se2diff_half_tg$1_0.iqmod_mixer_pex_se2diff_inv_NF18$4_0.vout iqmod_mixer_pex_half_1.iqmod_mixer_pex_tg_0.di_tg_ctrl_n VSS sg13_lv_nmos ad=0.19p pd=1.38u as=0.19p ps=1.38u w=1u l=0.13u
X413 vinp_IF iqmod_mixer_pex_half_1.iqmod_mixer_pex_tg_0.di_tg_ctrl voutp_RF VSS sg13_lv_nmos ad=0.57p pd=3.38u as=0.57p ps=3.38u w=3u l=0.13u
X414 iqmod_mixer_pex_half_1.iqmod_mixer_pex_tg_0.di_tg_ctrl_n iqmod_mixer_pex_half_1.iqmod_mixer_pex_se2diff_0.iqmod_mixer_pex_se2diff_half_tg$1_0.iqmod_mixer_pex_se2diff_inv_NF18$4_0.vout VSS VSS sg13_lv_nmos ad=0.19p pd=1.38u as=0.19p ps=1.38u w=1u l=0.13u
X415 VDD iqmod_mixer_pex_half_0.iqmod_mixer_pex_se2diff_0.iqmod_mixer_pex_se2diff_half_inv$1_0.iqmod_mixer_pex_se2diff_inv_NF6$5_2.vin iqmod_mixer_pex_half_0.iqmod_mixer_pex_se2diff_0.iqmod_mixer_pex_se2diff_half_inv$1_0.iqmod_mixer_pex_se2diff_inv_NF6$5_2.vout VDD sg13_lv_pmos ad=0.57p pd=3.38u as=0.57p ps=3.38u w=3u l=0.13u
X416 iqmod_mixer_pex_half_0.iqmod_mixer_pex_se2diff_0.iqmod_mixer_pex_se2diff_half_inv$1_0.iqmod_mixer_pex_se2diff_inv_NF6$5_2.vin iqmod_mixer_pex_half_0.iqmod_mixer_pex_se2diff_0.iqmod_mixer_pex_se2diff_half_inv$1_0.iqmod_mixer_pex_se2diff_inv_NF2$5_0.vout VDD VDD sg13_lv_pmos ad=0.57p pd=3.38u as=0.57p ps=3.38u w=3u l=0.13u
X417 VSS iqmod_mixer_pex_half_1.iqmod_mixer_pex_se2diff_0.iqmod_mixer_pex_se2diff_half_tg$1_0.iqmod_mixer_pex_se2diff_inv_NF18$4_0.vout iqmod_mixer_pex_half_1.iqmod_mixer_pex_tg_0.di_tg_ctrl_n VSS sg13_lv_nmos ad=0.19p pd=1.38u as=0.19p ps=1.38u w=1u l=0.13u
X418 iqmod_mixer_pex_half_1.iqmod_mixer_pex_se2diff_0.iqmod_mixer_pex_se2diff_half_inv$1_0.iqmod_mixer_pex_se2diff_inv_NF18$5_0.vout iqmod_mixer_pex_half_1.iqmod_mixer_pex_se2diff_0.iqmod_mixer_pex_se2diff_half_inv$1_0.iqmod_mixer_pex_se2diff_inv_NF6$5_1.vout VSS VSS sg13_lv_nmos ad=0.19p pd=1.38u as=0.19p ps=1.38u w=1u l=0.13u
X419 voutn_RF iqmod_mixer_pex_half_0.iqmod_mixer_pex_tg_0.di_tg_ctrl_n voutn_RF VSS sg13_lv_nmos ad=0.57p pd=3.38u as=0 ps=0 w=3u l=0.13u
X420 VSS VSS VSS VSS sg13_lv_nmos ad=0.34p pd=2.68u as=0 ps=0 w=1u l=0.13u
X421 iqmod_mixer_pex_half_1.iqmod_mixer_pex_se2diff_0.iqmod_mixer_pex_se2diff_half_tg$1_0.iqmod_mixer_pex_se2diff_tg_NF6$2_0.v_b VSS iqmod_mixer_pex_half_1.iqmod_mixer_pex_se2diff_0.iqmod_mixer_pex_se2diff_half_inv$1_0.iqmod_mixer_pex_se2diff_inv_NF2$5_0.vout VDD sg13_lv_pmos ad=0.57p pd=3.38u as=0.57p ps=3.38u w=3u l=0.13u
X422 iqmod_mixer_pex_half_0.iqmod_mixer_pex_se2diff_0.iqmod_mixer_pex_se2diff_half_inv$1_0.iqmod_mixer_pex_se2diff_inv_NF2$5_1.vout iqmod_mixer_pex_half_0.iqmod_mixer_pex_se2diff_0.iqmod_mixer_pex_se2diff_half_tg$1_0.iqmod_mixer_pex_se2diff_tg_NF6$2_0.v_b VDD VDD sg13_lv_pmos ad=0.57p pd=3.38u as=0.57p ps=3.38u w=3u l=0.13u
X423 VDD VDD VDD VDD sg13_lv_pmos ad=1.02p pd=6.68u as=0 ps=0 w=3u l=0.13u
X424 iqmod_mixer_pex_half_0.iqmod_mixer_pex_se2diff_0.iqmod_mixer_pex_se2diff_half_inv$1_0.iqmod_mixer_pex_se2diff_inv_NF6$5_2.vin iqmod_mixer_pex_half_0.iqmod_mixer_pex_se2diff_0.iqmod_mixer_pex_se2diff_half_inv$1_0.iqmod_mixer_pex_se2diff_inv_NF2$5_0.vout VDD VDD sg13_lv_pmos ad=0.57p pd=3.38u as=0.57p ps=3.38u w=3u l=0.13u
X425 iqmod_mixer_pex_half_0.iqmod_mixer_pex_se2diff_0.iqmod_mixer_pex_se2diff_half_inv$1_0.iqmod_mixer_pex_se2diff_inv_NF2$5_0.vout VSS iqmod_mixer_pex_half_0.iqmod_mixer_pex_se2diff_0.iqmod_mixer_pex_se2diff_half_tg$1_0.iqmod_mixer_pex_se2diff_tg_NF6$2_0.v_b VDD sg13_lv_pmos ad=1.02p pd=6.68u as=0.57p ps=3.38u w=3u l=0.13u
X426 VSS vinn_LO iqmod_mixer_pex_half_0.iqmod_mixer_pex_se2diff_0.iqmod_mixer_pex_se2diff_half_inv$1_0.iqmod_mixer_pex_se2diff_inv_NF2$5_0.vout VSS sg13_lv_nmos ad=0.19p pd=1.38u as=0.19p ps=1.38u w=1u l=0.13u
X427 VSS iqmod_mixer_pex_half_0.iqmod_mixer_pex_se2diff_0.iqmod_mixer_pex_se2diff_half_tg$1_0.iqmod_mixer_pex_se2diff_inv_NF18$4_0.vout iqmod_mixer_pex_half_0.iqmod_mixer_pex_tg_0.di_tg_ctrl_n VSS sg13_lv_nmos ad=0.19p pd=1.38u as=0.19p ps=1.38u w=1u l=0.13u
X428 VSS iqmod_mixer_pex_half_0.iqmod_mixer_pex_se2diff_0.iqmod_mixer_pex_se2diff_half_tg$1_0.iqmod_mixer_pex_se2diff_inv_NF18$4_0.vout iqmod_mixer_pex_half_0.iqmod_mixer_pex_tg_0.di_tg_ctrl_n VSS sg13_lv_nmos ad=0.19p pd=1.38u as=0.19p ps=1.38u w=1u l=0.13u
X429 iqmod_mixer_pex_half_1.iqmod_mixer_pex_tg_0.di_tg_ctrl iqmod_mixer_pex_half_1.iqmod_mixer_pex_se2diff_0.iqmod_mixer_pex_se2diff_half_inv$1_0.iqmod_mixer_pex_se2diff_inv_NF18$5_0.vout VSS VSS sg13_lv_nmos ad=0.19p pd=1.38u as=0.19p ps=1.38u w=1u l=0.13u
X430 vinp_IF iqmod_mixer_pex_half_1.iqmod_mixer_pex_tg_0.di_tg_ctrl voutp_RF VSS sg13_lv_nmos ad=0.57p pd=3.38u as=0.57p ps=3.38u w=3u l=0.13u
X431 VSS iqmod_mixer_pex_half_1.iqmod_mixer_pex_se2diff_0.iqmod_mixer_pex_se2diff_half_inv$1_0.iqmod_mixer_pex_se2diff_inv_NF18$5_0.vout iqmod_mixer_pex_half_1.iqmod_mixer_pex_tg_0.di_tg_ctrl VSS sg13_lv_nmos ad=0.19p pd=1.38u as=0.19p ps=1.38u w=1u l=0.13u
X432 iqmod_mixer_pex_half_0.iqmod_mixer_pex_se2diff_0.iqmod_mixer_pex_se2diff_half_inv$1_0.iqmod_mixer_pex_se2diff_inv_NF2$5_1.vout iqmod_mixer_pex_half_0.iqmod_mixer_pex_se2diff_0.iqmod_mixer_pex_se2diff_half_tg$1_0.iqmod_mixer_pex_se2diff_tg_NF6$2_0.v_b VDD VDD sg13_lv_pmos ad=0.57p pd=3.38u as=0.57p ps=3.38u w=3u l=0.13u
X433 VDD VDD VDD VDD sg13_lv_pmos ad=1.02p pd=6.68u as=0 ps=0 w=3u l=0.13u
X434 VDD iqmod_mixer_pex_half_1.iqmod_mixer_pex_se2diff_0.iqmod_mixer_pex_se2diff_half_tg$1_0.iqmod_mixer_pex_se2diff_inv_NF18$4_0.vout iqmod_mixer_pex_half_1.iqmod_mixer_pex_tg_0.di_tg_ctrl_n VDD sg13_lv_pmos ad=0.57p pd=3.38u as=0.57p ps=3.38u w=3u l=0.13u
X435 iqmod_mixer_pex_half_0.iqmod_mixer_pex_se2diff_0.iqmod_mixer_pex_se2diff_half_inv$1_0.iqmod_mixer_pex_se2diff_inv_NF2$5_0.vout VSS iqmod_mixer_pex_half_0.iqmod_mixer_pex_se2diff_0.iqmod_mixer_pex_se2diff_half_tg$1_0.iqmod_mixer_pex_se2diff_tg_NF6$2_0.v_b VDD sg13_lv_pmos ad=0.57p pd=3.38u as=0.57p ps=3.38u w=3u l=0.13u
X436 VSS iqmod_mixer_pex_half_0.iqmod_mixer_pex_se2diff_0.iqmod_mixer_pex_se2diff_half_tg$1_0.iqmod_mixer_pex_se2diff_inv_NF18$4_0.vout iqmod_mixer_pex_half_0.iqmod_mixer_pex_tg_0.di_tg_ctrl_n VSS sg13_lv_nmos ad=0.19p pd=1.38u as=0.19p ps=1.38u w=1u l=0.13u
X437 iqmod_mixer_pex_half_0.iqmod_mixer_pex_se2diff_0.iqmod_mixer_pex_se2diff_half_tg$1_0.iqmod_mixer_pex_se2diff_inv_NF18$4_0.vout iqmod_mixer_pex_half_0.iqmod_mixer_pex_se2diff_0.iqmod_mixer_pex_se2diff_half_tg$1_0.iqmod_mixer_pex_se2diff_inv_NF6$4_0.vout VSS VSS sg13_lv_nmos ad=0.19p pd=1.38u as=0.19p ps=1.38u w=1u l=0.13u
X438 voutn_RF iqmod_mixer_pex_half_0.iqmod_mixer_pex_tg_0.di_tg_ctrl voutn_RF VDD sg13_lv_pmos ad=1.71p pd=9.38u as=0 ps=0 w=9u l=0.13u
X439 VSS iqmod_mixer_pex_half_0.iqmod_mixer_pex_se2diff_0.iqmod_mixer_pex_se2diff_half_tg$1_0.iqmod_mixer_pex_se2diff_inv_NF18$4_0.vout iqmod_mixer_pex_half_0.iqmod_mixer_pex_tg_0.di_tg_ctrl_n VSS sg13_lv_nmos ad=0.19p pd=1.38u as=0.19p ps=1.38u w=1u l=0.13u
X440 vinn_IF iqmod_mixer_pex_half_0.iqmod_mixer_pex_tg_0.di_tg_ctrl voutn_RF VSS sg13_lv_nmos ad=0.57p pd=3.38u as=0.57p ps=3.38u w=3u l=0.13u
X441 VSS iqmod_mixer_pex_half_1.iqmod_mixer_pex_se2diff_0.iqmod_mixer_pex_se2diff_half_inv$1_0.iqmod_mixer_pex_se2diff_inv_NF18$5_0.vout iqmod_mixer_pex_half_1.iqmod_mixer_pex_tg_0.di_tg_ctrl VSS sg13_lv_nmos ad=0.19p pd=1.38u as=0.19p ps=1.38u w=1u l=0.13u
X442 VSS iqmod_mixer_pex_half_0.iqmod_mixer_pex_se2diff_0.iqmod_mixer_pex_se2diff_half_inv$1_0.iqmod_mixer_pex_se2diff_inv_NF6$5_2.vout iqmod_mixer_pex_half_0.iqmod_mixer_pex_se2diff_0.iqmod_mixer_pex_se2diff_half_inv$1_0.iqmod_mixer_pex_se2diff_inv_NF2$5_1.vout VSS sg13_lv_nmos ad=0.19p pd=1.38u as=0.19p ps=1.38u w=1u l=0.13u
X443 iqmod_mixer_pex_half_0.iqmod_mixer_pex_se2diff_0.iqmod_mixer_pex_se2diff_half_inv$1_0.iqmod_mixer_pex_se2diff_inv_NF6$5_2.vout iqmod_mixer_pex_half_0.iqmod_mixer_pex_se2diff_0.iqmod_mixer_pex_se2diff_half_inv$1_0.iqmod_mixer_pex_se2diff_inv_NF6$5_2.vin VSS VSS sg13_lv_nmos ad=0.19p pd=1.38u as=0.19p ps=1.38u w=1u l=0.13u
X444 VSS VSS VSS VSS sg13_lv_nmos ad=0.34p pd=2.68u as=0 ps=0 w=1u l=0.13u
X445 iqmod_mixer_pex_half_1.iqmod_mixer_pex_se2diff_0.iqmod_mixer_pex_se2diff_half_inv$1_0.iqmod_mixer_pex_se2diff_inv_NF2$5_0.vout VSS iqmod_mixer_pex_half_1.iqmod_mixer_pex_se2diff_0.iqmod_mixer_pex_se2diff_half_tg$1_0.iqmod_mixer_pex_se2diff_tg_NF6$2_0.v_b VDD sg13_lv_pmos ad=0.57p pd=3.38u as=0.57p ps=3.38u w=3u l=0.13u
X446 iqmod_mixer_pex_half_1.iqmod_mixer_pex_se2diff_0.iqmod_mixer_pex_se2diff_half_tg$1_0.iqmod_mixer_pex_se2diff_inv_NF6$4_0.vout iqmod_mixer_pex_half_1.iqmod_mixer_pex_se2diff_0.iqmod_mixer_pex_se2diff_half_inv$1_0.iqmod_mixer_pex_se2diff_inv_NF2$5_1.vout VSS VSS sg13_lv_nmos ad=0.19p pd=1.38u as=0.19p ps=1.38u w=1u l=0.13u
X447 iqmod_mixer_pex_half_0.iqmod_mixer_pex_se2diff_0.iqmod_mixer_pex_se2diff_half_tg$1_0.iqmod_mixer_pex_se2diff_inv_NF18$4_0.vout iqmod_mixer_pex_half_0.iqmod_mixer_pex_se2diff_0.iqmod_mixer_pex_se2diff_half_tg$1_0.iqmod_mixer_pex_se2diff_inv_NF6$4_0.vout VSS VSS sg13_lv_nmos ad=0.19p pd=1.38u as=0.19p ps=1.38u w=1u l=0.13u
X448 VSS iqmod_mixer_pex_half_0.iqmod_mixer_pex_se2diff_0.iqmod_mixer_pex_se2diff_half_tg$1_0.iqmod_mixer_pex_se2diff_inv_NF18$4_0.vout iqmod_mixer_pex_half_0.iqmod_mixer_pex_tg_0.di_tg_ctrl_n VSS sg13_lv_nmos ad=0.19p pd=1.38u as=0.19p ps=1.38u w=1u l=0.13u
X449 VSS iqmod_mixer_pex_half_0.iqmod_mixer_pex_se2diff_0.iqmod_mixer_pex_se2diff_half_tg$1_0.iqmod_mixer_pex_se2diff_inv_NF18$4_0.vout iqmod_mixer_pex_half_0.iqmod_mixer_pex_tg_0.di_tg_ctrl_n VSS sg13_lv_nmos ad=0.19p pd=1.38u as=0.19p ps=1.38u w=1u l=0.13u
X450 iqmod_mixer_pex_half_0.iqmod_mixer_pex_tg_0.di_tg_ctrl_n iqmod_mixer_pex_half_0.iqmod_mixer_pex_se2diff_0.iqmod_mixer_pex_se2diff_half_tg$1_0.iqmod_mixer_pex_se2diff_inv_NF18$4_0.vout VSS VSS sg13_lv_nmos ad=0.19p pd=1.38u as=0.19p ps=1.38u w=1u l=0.13u
X451 iqmod_mixer_pex_half_1.iqmod_mixer_pex_se2diff_0.iqmod_mixer_pex_se2diff_half_inv$1_0.iqmod_mixer_pex_se2diff_inv_NF18$5_0.vout iqmod_mixer_pex_half_1.iqmod_mixer_pex_se2diff_0.iqmod_mixer_pex_se2diff_half_inv$1_0.iqmod_mixer_pex_se2diff_inv_NF6$5_1.vout VDD VDD sg13_lv_pmos ad=0.57p pd=3.38u as=0.57p ps=3.38u w=3u l=0.13u
X452 VSS VSS VSS VSS sg13_lv_nmos ad=0.34p pd=2.68u as=0 ps=0 w=1u l=0.13u
X453 VDD iqmod_mixer_pex_half_1.iqmod_mixer_pex_se2diff_0.iqmod_mixer_pex_se2diff_half_inv$1_0.iqmod_mixer_pex_se2diff_inv_NF18$5_0.vout iqmod_mixer_pex_half_1.iqmod_mixer_pex_tg_0.di_tg_ctrl VDD sg13_lv_pmos ad=0.57p pd=3.38u as=0.57p ps=3.38u w=3u l=0.13u
X454 VSS iqmod_mixer_pex_half_1.iqmod_mixer_pex_se2diff_0.iqmod_mixer_pex_se2diff_half_inv$1_0.iqmod_mixer_pex_se2diff_inv_NF18$5_0.vout iqmod_mixer_pex_half_1.iqmod_mixer_pex_tg_0.di_tg_ctrl VSS sg13_lv_nmos ad=0.19p pd=1.38u as=0.19p ps=1.38u w=1u l=0.13u
X455 VDD iqmod_mixer_pex_half_1.iqmod_mixer_pex_se2diff_0.iqmod_mixer_pex_se2diff_half_inv$1_0.iqmod_mixer_pex_se2diff_inv_NF2$5_1.vout iqmod_mixer_pex_half_1.iqmod_mixer_pex_se2diff_0.iqmod_mixer_pex_se2diff_half_tg$1_0.iqmod_mixer_pex_se2diff_inv_NF6$4_0.vout VDD sg13_lv_pmos ad=0.57p pd=3.38u as=0.57p ps=3.38u w=3u l=0.13u
X456 vinn_IF iqmod_mixer_pex_half_0.iqmod_mixer_pex_tg_0.di_tg_ctrl_n voutn_RF VDD sg13_lv_pmos ad=1.71p pd=9.38u as=1.71p ps=9.38u w=9u l=0.13u
X457 VSS iqmod_mixer_pex_half_0.iqmod_mixer_pex_se2diff_0.iqmod_mixer_pex_se2diff_half_tg$1_0.iqmod_mixer_pex_se2diff_inv_NF18$4_0.vout iqmod_mixer_pex_half_0.iqmod_mixer_pex_tg_0.di_tg_ctrl_n VSS sg13_lv_nmos ad=0.19p pd=1.38u as=0.19p ps=1.38u w=1u l=0.13u
X458 iqmod_mixer_pex_half_1.iqmod_mixer_pex_tg_0.di_tg_ctrl iqmod_mixer_pex_half_1.iqmod_mixer_pex_se2diff_0.iqmod_mixer_pex_se2diff_half_inv$1_0.iqmod_mixer_pex_se2diff_inv_NF18$5_0.vout VDD VDD sg13_lv_pmos ad=0.57p pd=3.38u as=0.57p ps=3.38u w=3u l=0.13u
X459 voutp_RF iqmod_mixer_pex_half_1.iqmod_mixer_pex_tg_0.di_tg_ctrl_n vinp_IF VDD sg13_lv_pmos ad=1.71p pd=9.38u as=1.71p ps=9.38u w=9u l=0.13u
X460 VSS iqmod_mixer_pex_half_0.iqmod_mixer_pex_se2diff_0.iqmod_mixer_pex_se2diff_half_inv$1_0.iqmod_mixer_pex_se2diff_inv_NF18$5_0.vout iqmod_mixer_pex_half_0.iqmod_mixer_pex_tg_0.di_tg_ctrl VSS sg13_lv_nmos ad=0.19p pd=1.38u as=0.19p ps=1.38u w=1u l=0.13u
X461 vinn_IF iqmod_mixer_pex_half_0.iqmod_mixer_pex_tg_0.di_tg_ctrl voutn_RF VSS sg13_lv_nmos ad=0.57p pd=3.38u as=0.57p ps=3.38u w=3u l=0.13u
X462 voutp_RF iqmod_mixer_pex_half_1.iqmod_mixer_pex_tg_0.di_tg_ctrl voutp_RF VDD sg13_lv_pmos ad=1.71p pd=9.38u as=0 ps=0 w=9u l=0.13u
X463 VSS iqmod_mixer_pex_half_0.iqmod_mixer_pex_se2diff_0.iqmod_mixer_pex_se2diff_half_inv$1_0.iqmod_mixer_pex_se2diff_inv_NF18$5_0.vout iqmod_mixer_pex_half_0.iqmod_mixer_pex_tg_0.di_tg_ctrl VSS sg13_lv_nmos ad=0.19p pd=1.38u as=0.19p ps=1.38u w=1u l=0.13u
X464 VSS VSS VSS VSS sg13_lv_nmos ad=0.19p pd=1.38u as=0 ps=0 w=1u l=0.13u
X465 vinp_IF iqmod_mixer_pex_half_1.iqmod_mixer_pex_tg_0.di_tg_ctrl_n voutp_RF VDD sg13_lv_pmos ad=1.71p pd=9.38u as=1.71p ps=9.38u w=9u l=0.13u
X466 VDD VDD VDD VDD sg13_lv_pmos ad=1.02p pd=6.68u as=0 ps=0 w=3u l=0.13u
X467 voutp_RF iqmod_mixer_pex_half_1.iqmod_mixer_pex_tg_0.di_tg_ctrl voutp_RF VDD sg13_lv_pmos ad=1.71p pd=9.38u as=0 ps=0 w=9u l=0.13u
X468 VSS iqmod_mixer_pex_half_0.iqmod_mixer_pex_se2diff_0.iqmod_mixer_pex_se2diff_half_tg$1_0.iqmod_mixer_pex_se2diff_inv_NF18$4_0.vout iqmod_mixer_pex_half_0.iqmod_mixer_pex_tg_0.di_tg_ctrl_n VSS sg13_lv_nmos ad=0.19p pd=1.38u as=0.19p ps=1.38u w=1u l=0.13u
X469 VDD iqmod_mixer_pex_half_1.iqmod_mixer_pex_se2diff_0.iqmod_mixer_pex_se2diff_half_tg$1_0.iqmod_mixer_pex_se2diff_inv_NF18$4_0.vout iqmod_mixer_pex_half_1.iqmod_mixer_pex_tg_0.di_tg_ctrl_n VDD sg13_lv_pmos ad=0.57p pd=3.38u as=0.57p ps=3.38u w=3u l=0.13u
X470 VSS iqmod_mixer_pex_half_0.iqmod_mixer_pex_se2diff_0.iqmod_mixer_pex_se2diff_half_inv$1_0.iqmod_mixer_pex_se2diff_inv_NF18$5_0.vout iqmod_mixer_pex_half_0.iqmod_mixer_pex_tg_0.di_tg_ctrl VSS sg13_lv_nmos ad=0.19p pd=1.38u as=0.19p ps=1.38u w=1u l=0.13u
X471 VSS iqmod_mixer_pex_half_0.iqmod_mixer_pex_se2diff_0.iqmod_mixer_pex_se2diff_half_inv$1_0.iqmod_mixer_pex_se2diff_inv_NF18$5_0.vout iqmod_mixer_pex_half_0.iqmod_mixer_pex_tg_0.di_tg_ctrl VSS sg13_lv_nmos ad=0.19p pd=1.38u as=0.19p ps=1.38u w=1u l=0.13u
X472 iqmod_mixer_pex_half_0.iqmod_mixer_pex_se2diff_0.iqmod_mixer_pex_se2diff_half_inv$1_0.iqmod_mixer_pex_se2diff_inv_NF18$5_0.vout iqmod_mixer_pex_half_0.iqmod_mixer_pex_se2diff_0.iqmod_mixer_pex_se2diff_half_inv$1_0.iqmod_mixer_pex_se2diff_inv_NF6$5_1.vout VSS VSS sg13_lv_nmos ad=0.19p pd=1.38u as=0.19p ps=1.38u w=1u l=0.13u
X473 iqmod_mixer_pex_half_0.iqmod_mixer_pex_se2diff_0.iqmod_mixer_pex_se2diff_half_inv$1_0.iqmod_mixer_pex_se2diff_inv_NF18$5_0.vout iqmod_mixer_pex_half_0.iqmod_mixer_pex_se2diff_0.iqmod_mixer_pex_se2diff_half_inv$1_0.iqmod_mixer_pex_se2diff_inv_NF6$5_1.vout VSS VSS sg13_lv_nmos ad=0.19p pd=1.38u as=0.19p ps=1.38u w=1u l=0.13u
X474 VSS iqmod_mixer_pex_half_0.iqmod_mixer_pex_se2diff_0.iqmod_mixer_pex_se2diff_half_inv$1_0.iqmod_mixer_pex_se2diff_inv_NF6$5_2.vout iqmod_mixer_pex_half_0.iqmod_mixer_pex_se2diff_0.iqmod_mixer_pex_se2diff_half_inv$1_0.iqmod_mixer_pex_se2diff_inv_NF6$5_1.vout VSS sg13_lv_nmos ad=0.19p pd=1.38u as=0.19p ps=1.38u w=1u l=0.13u
X475 voutp_RF iqmod_mixer_pex_half_1.iqmod_mixer_pex_tg_0.di_tg_ctrl_n voutp_RF VSS sg13_lv_nmos ad=0.57p pd=3.38u as=0 ps=0 w=3u l=0.13u
X476 iqmod_mixer_pex_half_1.iqmod_mixer_pex_tg_0.di_tg_ctrl iqmod_mixer_pex_half_1.iqmod_mixer_pex_se2diff_0.iqmod_mixer_pex_se2diff_half_inv$1_0.iqmod_mixer_pex_se2diff_inv_NF18$5_0.vout VDD VDD sg13_lv_pmos ad=0.57p pd=3.38u as=0.57p ps=3.38u w=3u l=0.13u
X477 iqmod_mixer_pex_half_1.iqmod_mixer_pex_tg_0.di_tg_ctrl_n iqmod_mixer_pex_half_1.iqmod_mixer_pex_se2diff_0.iqmod_mixer_pex_se2diff_half_tg$1_0.iqmod_mixer_pex_se2diff_inv_NF18$4_0.vout VSS VSS sg13_lv_nmos ad=0.19p pd=1.38u as=0.19p ps=1.38u w=1u l=0.13u
X478 voutp_RF iqmod_mixer_pex_half_1.iqmod_mixer_pex_tg_0.di_tg_ctrl_n voutp_RF VSS sg13_lv_nmos ad=0.57p pd=3.38u as=0 ps=0 w=3u l=0.13u
X479 VSS iqmod_mixer_pex_half_0.iqmod_mixer_pex_se2diff_0.iqmod_mixer_pex_se2diff_half_inv$1_0.iqmod_mixer_pex_se2diff_inv_NF18$5_0.vout iqmod_mixer_pex_half_0.iqmod_mixer_pex_tg_0.di_tg_ctrl VSS sg13_lv_nmos ad=0.19p pd=1.38u as=0.19p ps=1.38u w=1u l=0.13u
X480 VSS VSS VSS VSS sg13_lv_nmos ad=0.34p pd=2.68u as=0 ps=0 w=1u l=0.13u
X481 vinp_IF iqmod_mixer_pex_half_1.iqmod_mixer_pex_tg_0.di_tg_ctrl voutp_RF VSS sg13_lv_nmos ad=0.57p pd=3.38u as=0.57p ps=3.38u w=3u l=0.13u
X482 VSS iqmod_mixer_pex_half_1.iqmod_mixer_pex_se2diff_0.iqmod_mixer_pex_se2diff_half_tg$1_0.iqmod_mixer_pex_se2diff_inv_NF18$4_0.vout iqmod_mixer_pex_half_1.iqmod_mixer_pex_tg_0.di_tg_ctrl_n VSS sg13_lv_nmos ad=0.19p pd=1.38u as=0.19p ps=1.38u w=1u l=0.13u
X483 VSS iqmod_mixer_pex_half_1.iqmod_mixer_pex_se2diff_0.iqmod_mixer_pex_se2diff_half_tg$1_0.iqmod_mixer_pex_se2diff_inv_NF18$4_0.vout iqmod_mixer_pex_half_1.iqmod_mixer_pex_tg_0.di_tg_ctrl_n VSS sg13_lv_nmos ad=0.19p pd=1.38u as=0.19p ps=1.38u w=1u l=0.13u
X484 iqmod_mixer_pex_half_1.iqmod_mixer_pex_se2diff_0.iqmod_mixer_pex_se2diff_half_inv$1_0.iqmod_mixer_pex_se2diff_inv_NF6$5_1.vout iqmod_mixer_pex_half_1.iqmod_mixer_pex_se2diff_0.iqmod_mixer_pex_se2diff_half_inv$1_0.iqmod_mixer_pex_se2diff_inv_NF6$5_2.vout VDD VDD sg13_lv_pmos ad=0.57p pd=3.38u as=0.57p ps=3.38u w=3u l=0.13u
X485 voutp_RF iqmod_mixer_pex_half_1.iqmod_mixer_pex_tg_0.di_tg_ctrl vinp_IF VSS sg13_lv_nmos ad=0.57p pd=3.38u as=0.57p ps=3.38u w=3u l=0.13u
X486 iqmod_mixer_pex_half_1.iqmod_mixer_pex_tg_0.di_tg_ctrl_n iqmod_mixer_pex_half_1.iqmod_mixer_pex_se2diff_0.iqmod_mixer_pex_se2diff_half_tg$1_0.iqmod_mixer_pex_se2diff_inv_NF18$4_0.vout VSS VSS sg13_lv_nmos ad=0.19p pd=1.38u as=0.19p ps=1.38u w=1u l=0.13u
X487 VDD iqmod_mixer_pex_half_1.iqmod_mixer_pex_se2diff_0.iqmod_mixer_pex_se2diff_half_inv$1_0.iqmod_mixer_pex_se2diff_inv_NF6$5_2.vout iqmod_mixer_pex_half_1.iqmod_mixer_pex_se2diff_0.iqmod_mixer_pex_se2diff_half_inv$1_0.iqmod_mixer_pex_se2diff_inv_NF6$5_1.vout VDD sg13_lv_pmos ad=0.57p pd=3.38u as=0.57p ps=3.38u w=3u l=0.13u
X488 iqmod_mixer_pex_half_1.iqmod_mixer_pex_se2diff_0.iqmod_mixer_pex_se2diff_half_inv$1_0.iqmod_mixer_pex_se2diff_inv_NF18$5_0.vout iqmod_mixer_pex_half_1.iqmod_mixer_pex_se2diff_0.iqmod_mixer_pex_se2diff_half_inv$1_0.iqmod_mixer_pex_se2diff_inv_NF6$5_1.vout VSS VSS sg13_lv_nmos ad=0.19p pd=1.38u as=0.19p ps=1.38u w=1u l=0.13u
X489 iqmod_mixer_pex_half_1.iqmod_mixer_pex_se2diff_0.iqmod_mixer_pex_se2diff_half_inv$1_0.iqmod_mixer_pex_se2diff_inv_NF2$5_0.vout vinp_LO VSS VSS sg13_lv_nmos ad=0.19p pd=1.38u as=0.19p ps=1.38u w=1u l=0.13u
X490 iqmod_mixer_pex_half_1.iqmod_mixer_pex_tg_0.di_tg_ctrl_n iqmod_mixer_pex_half_1.iqmod_mixer_pex_se2diff_0.iqmod_mixer_pex_se2diff_half_tg$1_0.iqmod_mixer_pex_se2diff_inv_NF18$4_0.vout VDD VDD sg13_lv_pmos ad=0.57p pd=3.38u as=0.57p ps=3.38u w=3u l=0.13u
X491 VDD iqmod_mixer_pex_half_0.iqmod_mixer_pex_se2diff_0.iqmod_mixer_pex_se2diff_half_inv$1_0.iqmod_mixer_pex_se2diff_inv_NF18$5_0.vout iqmod_mixer_pex_half_0.iqmod_mixer_pex_tg_0.di_tg_ctrl VDD sg13_lv_pmos ad=0.57p pd=3.38u as=0.57p ps=3.38u w=3u l=0.13u
X492 VDD vinn_LO iqmod_mixer_pex_half_0.iqmod_mixer_pex_se2diff_0.iqmod_mixer_pex_se2diff_half_inv$1_0.iqmod_mixer_pex_se2diff_inv_NF2$5_0.vout VDD sg13_lv_pmos ad=0.57p pd=3.38u as=0.57p ps=3.38u w=3u l=0.13u
X493 VSS iqmod_mixer_pex_half_1.iqmod_mixer_pex_se2diff_0.iqmod_mixer_pex_se2diff_half_inv$1_0.iqmod_mixer_pex_se2diff_inv_NF6$5_1.vout iqmod_mixer_pex_half_1.iqmod_mixer_pex_se2diff_0.iqmod_mixer_pex_se2diff_half_inv$1_0.iqmod_mixer_pex_se2diff_inv_NF18$5_0.vout VSS sg13_lv_nmos ad=0.19p pd=1.38u as=0.19p ps=1.38u w=1u l=0.13u
X494 VDD iqmod_mixer_pex_half_0.iqmod_mixer_pex_se2diff_0.iqmod_mixer_pex_se2diff_half_inv$1_0.iqmod_mixer_pex_se2diff_inv_NF18$5_0.vout iqmod_mixer_pex_half_0.iqmod_mixer_pex_tg_0.di_tg_ctrl VDD sg13_lv_pmos ad=0.57p pd=3.38u as=0.57p ps=3.38u w=3u l=0.13u
X495 voutn_RF iqmod_mixer_pex_half_0.iqmod_mixer_pex_tg_0.di_tg_ctrl voutn_RF VDD sg13_lv_pmos ad=1.71p pd=9.38u as=0 ps=0 w=9u l=0.13u
X496 iqmod_mixer_pex_half_0.iqmod_mixer_pex_tg_0.di_tg_ctrl_n iqmod_mixer_pex_half_0.iqmod_mixer_pex_se2diff_0.iqmod_mixer_pex_se2diff_half_tg$1_0.iqmod_mixer_pex_se2diff_inv_NF18$4_0.vout VSS VSS sg13_lv_nmos ad=0.19p pd=1.38u as=0.19p ps=1.38u w=1u l=0.13u
X497 iqmod_mixer_pex_half_1.iqmod_mixer_pex_tg_0.di_tg_ctrl iqmod_mixer_pex_half_1.iqmod_mixer_pex_se2diff_0.iqmod_mixer_pex_se2diff_half_inv$1_0.iqmod_mixer_pex_se2diff_inv_NF18$5_0.vout VSS VSS sg13_lv_nmos ad=0.19p pd=1.38u as=0.19p ps=1.38u w=1u l=0.13u
X498 iqmod_mixer_pex_half_1.iqmod_mixer_pex_se2diff_0.iqmod_mixer_pex_se2diff_half_inv$1_0.iqmod_mixer_pex_se2diff_inv_NF6$5_2.vin iqmod_mixer_pex_half_1.iqmod_mixer_pex_se2diff_0.iqmod_mixer_pex_se2diff_half_inv$1_0.iqmod_mixer_pex_se2diff_inv_NF2$5_0.vout VDD VDD sg13_lv_pmos ad=0.57p pd=3.38u as=0.57p ps=3.38u w=3u l=0.13u
X499 iqmod_mixer_pex_half_1.iqmod_mixer_pex_se2diff_0.iqmod_mixer_pex_se2diff_half_tg$1_0.iqmod_mixer_pex_se2diff_tg_NF6$2_0.v_b VSS iqmod_mixer_pex_half_1.iqmod_mixer_pex_se2diff_0.iqmod_mixer_pex_se2diff_half_inv$1_0.iqmod_mixer_pex_se2diff_inv_NF2$5_0.vout VDD sg13_lv_pmos ad=0.57p pd=3.38u as=0.57p ps=3.38u w=3u l=0.13u
X500 vinn_IF iqmod_mixer_pex_half_0.iqmod_mixer_pex_tg_0.di_tg_ctrl_n voutn_RF VDD sg13_lv_pmos ad=1.71p pd=9.38u as=1.71p ps=9.38u w=9u l=0.13u
X501 VDD iqmod_mixer_pex_half_0.iqmod_mixer_pex_se2diff_0.iqmod_mixer_pex_se2diff_half_inv$1_0.iqmod_mixer_pex_se2diff_inv_NF18$5_0.vout iqmod_mixer_pex_half_0.iqmod_mixer_pex_tg_0.di_tg_ctrl VDD sg13_lv_pmos ad=0.57p pd=3.38u as=0.57p ps=3.38u w=3u l=0.13u
X502 VSS iqmod_mixer_pex_half_0.iqmod_mixer_pex_se2diff_0.iqmod_mixer_pex_se2diff_half_inv$1_0.iqmod_mixer_pex_se2diff_inv_NF6$5_2.vin iqmod_mixer_pex_half_0.iqmod_mixer_pex_se2diff_0.iqmod_mixer_pex_se2diff_half_inv$1_0.iqmod_mixer_pex_se2diff_inv_NF6$5_2.vout VSS sg13_lv_nmos ad=0.19p pd=1.38u as=0.19p ps=1.38u w=1u l=0.13u
X503 iqmod_mixer_pex_half_0.iqmod_mixer_pex_se2diff_0.iqmod_mixer_pex_se2diff_half_inv$1_0.iqmod_mixer_pex_se2diff_inv_NF6$5_2.vin iqmod_mixer_pex_half_0.iqmod_mixer_pex_se2diff_0.iqmod_mixer_pex_se2diff_half_inv$1_0.iqmod_mixer_pex_se2diff_inv_NF2$5_0.vout VSS VSS sg13_lv_nmos ad=0.19p pd=1.38u as=0.19p ps=1.38u w=1u l=0.13u
X504 VSS iqmod_mixer_pex_half_1.iqmod_mixer_pex_se2diff_0.iqmod_mixer_pex_se2diff_half_inv$1_0.iqmod_mixer_pex_se2diff_inv_NF18$5_0.vout iqmod_mixer_pex_half_1.iqmod_mixer_pex_tg_0.di_tg_ctrl VSS sg13_lv_nmos ad=0.19p pd=1.38u as=0.19p ps=1.38u w=1u l=0.13u
X505 VDD VDD VDD VDD sg13_lv_pmos ad=0.57p pd=3.38u as=0 ps=0 w=3u l=0.13u
X506 iqmod_mixer_pex_half_0.iqmod_mixer_pex_tg_0.di_tg_ctrl_n iqmod_mixer_pex_half_0.iqmod_mixer_pex_se2diff_0.iqmod_mixer_pex_se2diff_half_tg$1_0.iqmod_mixer_pex_se2diff_inv_NF18$4_0.vout VDD VDD sg13_lv_pmos ad=0.57p pd=3.38u as=0.57p ps=3.38u w=3u l=0.13u
X507 VSS iqmod_mixer_pex_half_0.iqmod_mixer_pex_se2diff_0.iqmod_mixer_pex_se2diff_half_tg$1_0.iqmod_mixer_pex_se2diff_inv_NF6$4_0.vout iqmod_mixer_pex_half_0.iqmod_mixer_pex_se2diff_0.iqmod_mixer_pex_se2diff_half_tg$1_0.iqmod_mixer_pex_se2diff_inv_NF18$4_0.vout VSS sg13_lv_nmos ad=0.19p pd=1.38u as=0.19p ps=1.38u w=1u l=0.13u
X508 VDD iqmod_mixer_pex_half_0.iqmod_mixer_pex_se2diff_0.iqmod_mixer_pex_se2diff_half_inv$1_0.iqmod_mixer_pex_se2diff_inv_NF18$5_0.vout iqmod_mixer_pex_half_0.iqmod_mixer_pex_tg_0.di_tg_ctrl VDD sg13_lv_pmos ad=0.57p pd=3.38u as=0.57p ps=3.38u w=3u l=0.13u
X509 iqmod_mixer_pex_half_0.iqmod_mixer_pex_se2diff_0.iqmod_mixer_pex_se2diff_half_inv$1_0.iqmod_mixer_pex_se2diff_inv_NF18$5_0.vout iqmod_mixer_pex_half_0.iqmod_mixer_pex_se2diff_0.iqmod_mixer_pex_se2diff_half_inv$1_0.iqmod_mixer_pex_se2diff_inv_NF6$5_1.vout VDD VDD sg13_lv_pmos ad=0.57p pd=3.38u as=0.57p ps=3.38u w=3u l=0.13u
X510 VDD iqmod_mixer_pex_half_1.iqmod_mixer_pex_se2diff_0.iqmod_mixer_pex_se2diff_half_inv$1_0.iqmod_mixer_pex_se2diff_inv_NF2$5_0.vout iqmod_mixer_pex_half_1.iqmod_mixer_pex_se2diff_0.iqmod_mixer_pex_se2diff_half_inv$1_0.iqmod_mixer_pex_se2diff_inv_NF6$5_2.vin VDD sg13_lv_pmos ad=0.57p pd=3.38u as=0.57p ps=3.38u w=3u l=0.13u
X511 voutn_RF iqmod_mixer_pex_half_0.iqmod_mixer_pex_tg_0.di_tg_ctrl voutn_RF VDD sg13_lv_pmos ad=1.71p pd=9.38u as=0 ps=0 w=9u l=0.13u
X512 iqmod_mixer_pex_half_0.iqmod_mixer_pex_tg_0.di_tg_ctrl_n iqmod_mixer_pex_half_0.iqmod_mixer_pex_se2diff_0.iqmod_mixer_pex_se2diff_half_tg$1_0.iqmod_mixer_pex_se2diff_inv_NF18$4_0.vout VSS VSS sg13_lv_nmos ad=0.19p pd=1.38u as=0.19p ps=1.38u w=1u l=0.13u
X513 iqmod_mixer_pex_half_1.iqmod_mixer_pex_se2diff_0.iqmod_mixer_pex_se2diff_half_tg$1_0.iqmod_mixer_pex_se2diff_inv_NF6$4_0.vout iqmod_mixer_pex_half_1.iqmod_mixer_pex_se2diff_0.iqmod_mixer_pex_se2diff_half_inv$1_0.iqmod_mixer_pex_se2diff_inv_NF2$5_1.vout VDD VDD sg13_lv_pmos ad=0.57p pd=3.38u as=0.57p ps=3.38u w=3u l=0.13u
X514 vinn_IF iqmod_mixer_pex_half_0.iqmod_mixer_pex_tg_0.di_tg_ctrl_n voutn_RF VDD sg13_lv_pmos ad=1.71p pd=9.38u as=3.06p ps=18.68u w=9u l=0.13u
X515 VSS VSS VSS VSS sg13_lv_nmos ad=0.34p pd=2.68u as=0 ps=0 w=1u l=0.13u
X516 iqmod_mixer_pex_half_0.iqmod_mixer_pex_se2diff_0.iqmod_mixer_pex_se2diff_half_inv$1_0.iqmod_mixer_pex_se2diff_inv_NF6$5_2.vin iqmod_mixer_pex_half_0.iqmod_mixer_pex_se2diff_0.iqmod_mixer_pex_se2diff_half_inv$1_0.iqmod_mixer_pex_se2diff_inv_NF2$5_0.vout VSS VSS sg13_lv_nmos ad=0.19p pd=1.38u as=0.19p ps=1.38u w=1u l=0.13u
X517 VDD iqmod_mixer_pex_half_0.iqmod_mixer_pex_se2diff_0.iqmod_mixer_pex_se2diff_half_inv$1_0.iqmod_mixer_pex_se2diff_inv_NF18$5_0.vout iqmod_mixer_pex_half_0.iqmod_mixer_pex_tg_0.di_tg_ctrl VDD sg13_lv_pmos ad=0.57p pd=3.38u as=0.57p ps=3.38u w=3u l=0.13u
X518 VDD iqmod_mixer_pex_half_0.iqmod_mixer_pex_se2diff_0.iqmod_mixer_pex_se2diff_half_inv$1_0.iqmod_mixer_pex_se2diff_inv_NF18$5_0.vout iqmod_mixer_pex_half_0.iqmod_mixer_pex_tg_0.di_tg_ctrl VDD sg13_lv_pmos ad=0.57p pd=3.38u as=0.57p ps=3.38u w=3u l=0.13u
X519 iqmod_mixer_pex_half_0.iqmod_mixer_pex_se2diff_0.iqmod_mixer_pex_se2diff_half_inv$1_0.iqmod_mixer_pex_se2diff_inv_NF18$5_0.vout iqmod_mixer_pex_half_0.iqmod_mixer_pex_se2diff_0.iqmod_mixer_pex_se2diff_half_inv$1_0.iqmod_mixer_pex_se2diff_inv_NF6$5_1.vout VDD VDD sg13_lv_pmos ad=0.57p pd=3.38u as=0.57p ps=3.38u w=3u l=0.13u
X520 iqmod_mixer_pex_half_1.iqmod_mixer_pex_tg_0.di_tg_ctrl iqmod_mixer_pex_half_1.iqmod_mixer_pex_se2diff_0.iqmod_mixer_pex_se2diff_half_inv$1_0.iqmod_mixer_pex_se2diff_inv_NF18$5_0.vout VDD VDD sg13_lv_pmos ad=0.57p pd=3.38u as=0.57p ps=3.38u w=3u l=0.13u
X521 iqmod_mixer_pex_half_1.iqmod_mixer_pex_se2diff_0.iqmod_mixer_pex_se2diff_half_inv$1_0.iqmod_mixer_pex_se2diff_inv_NF2$5_1.vout iqmod_mixer_pex_half_1.iqmod_mixer_pex_se2diff_0.iqmod_mixer_pex_se2diff_half_inv$1_0.iqmod_mixer_pex_se2diff_inv_NF6$5_2.vout VSS VSS sg13_lv_nmos ad=0.19p pd=1.38u as=0.19p ps=1.38u w=1u l=0.13u
X522 VDD iqmod_mixer_pex_half_0.iqmod_mixer_pex_se2diff_0.iqmod_mixer_pex_se2diff_half_tg$1_0.iqmod_mixer_pex_se2diff_inv_NF6$4_0.vout iqmod_mixer_pex_half_0.iqmod_mixer_pex_se2diff_0.iqmod_mixer_pex_se2diff_half_tg$1_0.iqmod_mixer_pex_se2diff_inv_NF18$4_0.vout VDD sg13_lv_pmos ad=0.57p pd=3.38u as=0.57p ps=3.38u w=3u l=0.13u
X523 iqmod_mixer_pex_half_0.iqmod_mixer_pex_tg_0.di_tg_ctrl_n iqmod_mixer_pex_half_0.iqmod_mixer_pex_se2diff_0.iqmod_mixer_pex_se2diff_half_tg$1_0.iqmod_mixer_pex_se2diff_inv_NF18$4_0.vout VDD VDD sg13_lv_pmos ad=0.57p pd=3.38u as=0.57p ps=3.38u w=3u l=0.13u
X524 VSS iqmod_mixer_pex_half_0.iqmod_mixer_pex_se2diff_0.iqmod_mixer_pex_se2diff_half_tg$1_0.iqmod_mixer_pex_se2diff_inv_NF6$4_0.vout iqmod_mixer_pex_half_0.iqmod_mixer_pex_se2diff_0.iqmod_mixer_pex_se2diff_half_tg$1_0.iqmod_mixer_pex_se2diff_inv_NF18$4_0.vout VSS sg13_lv_nmos ad=0.19p pd=1.38u as=0.19p ps=1.38u w=1u l=0.13u
X525 iqmod_mixer_pex_half_0.iqmod_mixer_pex_tg_0.di_tg_ctrl iqmod_mixer_pex_half_0.iqmod_mixer_pex_se2diff_0.iqmod_mixer_pex_se2diff_half_inv$1_0.iqmod_mixer_pex_se2diff_inv_NF18$5_0.vout VDD VDD sg13_lv_pmos ad=0.57p pd=3.38u as=0.57p ps=3.38u w=3u l=0.13u
X526 voutn_RF iqmod_mixer_pex_half_0.iqmod_mixer_pex_tg_0.di_tg_ctrl_n vinn_IF VDD sg13_lv_pmos ad=1.71p pd=9.38u as=1.71p ps=9.38u w=9u l=0.13u
X527 iqmod_mixer_pex_half_1.iqmod_mixer_pex_tg_0.di_tg_ctrl iqmod_mixer_pex_half_1.iqmod_mixer_pex_se2diff_0.iqmod_mixer_pex_se2diff_half_inv$1_0.iqmod_mixer_pex_se2diff_inv_NF18$5_0.vout VDD VDD sg13_lv_pmos ad=0.57p pd=3.38u as=0.57p ps=3.38u w=3u l=0.13u
X528 iqmod_mixer_pex_half_1.iqmod_mixer_pex_se2diff_0.iqmod_mixer_pex_se2diff_half_inv$1_0.iqmod_mixer_pex_se2diff_inv_NF2$5_0.vout vinp_LO VDD VDD sg13_lv_pmos ad=0.57p pd=3.38u as=0.57p ps=3.38u w=3u l=0.13u
X529 VDD iqmod_mixer_pex_half_1.iqmod_mixer_pex_se2diff_0.iqmod_mixer_pex_se2diff_half_inv$1_0.iqmod_mixer_pex_se2diff_inv_NF18$5_0.vout iqmod_mixer_pex_half_1.iqmod_mixer_pex_tg_0.di_tg_ctrl VDD sg13_lv_pmos ad=0.57p pd=3.38u as=0.57p ps=3.38u w=3u l=0.13u
X530 VSS iqmod_mixer_pex_half_1.iqmod_mixer_pex_se2diff_0.iqmod_mixer_pex_se2diff_half_inv$1_0.iqmod_mixer_pex_se2diff_inv_NF2$5_1.vout iqmod_mixer_pex_half_1.iqmod_mixer_pex_se2diff_0.iqmod_mixer_pex_se2diff_half_tg$1_0.iqmod_mixer_pex_se2diff_inv_NF6$4_0.vout VSS sg13_lv_nmos ad=0.19p pd=1.38u as=0.19p ps=1.38u w=1u l=0.13u
X531 iqmod_mixer_pex_half_1.iqmod_mixer_pex_se2diff_0.iqmod_mixer_pex_se2diff_half_tg$1_0.iqmod_mixer_pex_se2diff_inv_NF18$4_0.vout iqmod_mixer_pex_half_1.iqmod_mixer_pex_se2diff_0.iqmod_mixer_pex_se2diff_half_tg$1_0.iqmod_mixer_pex_se2diff_inv_NF6$4_0.vout VSS VSS sg13_lv_nmos ad=0.19p pd=1.38u as=0.19p ps=1.38u w=1u l=0.13u
X532 iqmod_mixer_pex_half_1.iqmod_mixer_pex_tg_0.di_tg_ctrl_n iqmod_mixer_pex_half_1.iqmod_mixer_pex_se2diff_0.iqmod_mixer_pex_se2diff_half_tg$1_0.iqmod_mixer_pex_se2diff_inv_NF18$4_0.vout VDD VDD sg13_lv_pmos ad=0.57p pd=3.38u as=0.57p ps=3.38u w=3u l=0.13u
X533 VDD iqmod_mixer_pex_half_0.iqmod_mixer_pex_se2diff_0.iqmod_mixer_pex_se2diff_half_inv$1_0.iqmod_mixer_pex_se2diff_inv_NF18$5_0.vout iqmod_mixer_pex_half_0.iqmod_mixer_pex_tg_0.di_tg_ctrl VDD sg13_lv_pmos ad=0.57p pd=3.38u as=0.57p ps=3.38u w=3u l=0.13u
X534 voutn_RF iqmod_mixer_pex_half_0.iqmod_mixer_pex_tg_0.di_tg_ctrl_n vinn_IF VDD sg13_lv_pmos ad=1.71p pd=9.38u as=1.71p ps=9.38u w=9u l=0.13u
X535 iqmod_mixer_pex_half_0.iqmod_mixer_pex_tg_0.di_tg_ctrl_n iqmod_mixer_pex_half_0.iqmod_mixer_pex_se2diff_0.iqmod_mixer_pex_se2diff_half_tg$1_0.iqmod_mixer_pex_se2diff_inv_NF18$4_0.vout VSS VSS sg13_lv_nmos ad=0.19p pd=1.38u as=0.19p ps=1.38u w=1u l=0.13u
X536 VSS iqmod_mixer_pex_half_1.iqmod_mixer_pex_se2diff_0.iqmod_mixer_pex_se2diff_half_tg$1_0.iqmod_mixer_pex_se2diff_inv_NF18$4_0.vout iqmod_mixer_pex_half_1.iqmod_mixer_pex_tg_0.di_tg_ctrl_n VSS sg13_lv_nmos ad=0.19p pd=1.38u as=0.19p ps=1.38u w=1u l=0.13u
X537 VDD iqmod_mixer_pex_half_0.iqmod_mixer_pex_se2diff_0.iqmod_mixer_pex_se2diff_half_tg$1_0.iqmod_mixer_pex_se2diff_inv_NF18$4_0.vout iqmod_mixer_pex_half_0.iqmod_mixer_pex_tg_0.di_tg_ctrl_n VDD sg13_lv_pmos ad=0.57p pd=3.38u as=0.57p ps=3.38u w=3u l=0.13u
X538 voutp_RF iqmod_mixer_pex_half_1.iqmod_mixer_pex_tg_0.di_tg_ctrl_n vinp_IF VDD sg13_lv_pmos ad=1.71p pd=9.38u as=1.71p ps=9.38u w=9u l=0.13u
X539 iqmod_mixer_pex_half_1.iqmod_mixer_pex_tg_0.di_tg_ctrl_n iqmod_mixer_pex_half_1.iqmod_mixer_pex_se2diff_0.iqmod_mixer_pex_se2diff_half_tg$1_0.iqmod_mixer_pex_se2diff_inv_NF18$4_0.vout VSS VSS sg13_lv_nmos ad=0.19p pd=1.38u as=0.19p ps=1.38u w=1u l=0.13u
X540 iqmod_mixer_pex_half_0.iqmod_mixer_pex_tg_0.di_tg_ctrl_n iqmod_mixer_pex_half_0.iqmod_mixer_pex_se2diff_0.iqmod_mixer_pex_se2diff_half_tg$1_0.iqmod_mixer_pex_se2diff_inv_NF18$4_0.vout VDD VDD sg13_lv_pmos ad=0.57p pd=3.38u as=0.57p ps=3.38u w=3u l=0.13u
X541 VDD iqmod_mixer_pex_half_0.iqmod_mixer_pex_se2diff_0.iqmod_mixer_pex_se2diff_half_inv$1_0.iqmod_mixer_pex_se2diff_inv_NF18$5_0.vout iqmod_mixer_pex_half_0.iqmod_mixer_pex_tg_0.di_tg_ctrl VDD sg13_lv_pmos ad=0.57p pd=3.38u as=0.57p ps=3.38u w=3u l=0.13u
X542 vinp_IF iqmod_mixer_pex_half_1.iqmod_mixer_pex_tg_0.di_tg_ctrl_n voutp_RF VDD sg13_lv_pmos ad=1.71p pd=9.38u as=1.71p ps=9.38u w=9u l=0.13u
X543 VDD VDD VDD VDD sg13_lv_pmos ad=0.57p pd=3.38u as=0 ps=0 w=3u l=0.13u
X544 VSS iqmod_mixer_pex_half_1.iqmod_mixer_pex_se2diff_0.iqmod_mixer_pex_se2diff_half_tg$1_0.iqmod_mixer_pex_se2diff_tg_NF6$2_0.v_b iqmod_mixer_pex_half_1.iqmod_mixer_pex_se2diff_0.iqmod_mixer_pex_se2diff_half_inv$1_0.iqmod_mixer_pex_se2diff_inv_NF2$5_1.vout VSS sg13_lv_nmos ad=0.19p pd=1.38u as=0.19p ps=1.38u w=1u l=0.13u
X545 iqmod_mixer_pex_half_1.iqmod_mixer_pex_tg_0.di_tg_ctrl_n iqmod_mixer_pex_half_1.iqmod_mixer_pex_se2diff_0.iqmod_mixer_pex_se2diff_half_tg$1_0.iqmod_mixer_pex_se2diff_inv_NF18$4_0.vout VSS VSS sg13_lv_nmos ad=0.19p pd=1.38u as=0.19p ps=1.38u w=1u l=0.13u
X546 VDD iqmod_mixer_pex_half_1.iqmod_mixer_pex_se2diff_0.iqmod_mixer_pex_se2diff_half_inv$1_0.iqmod_mixer_pex_se2diff_inv_NF18$5_0.vout iqmod_mixer_pex_half_1.iqmod_mixer_pex_tg_0.di_tg_ctrl VDD sg13_lv_pmos ad=0.57p pd=3.38u as=0.57p ps=3.38u w=3u l=0.13u
X547 iqmod_mixer_pex_half_1.iqmod_mixer_pex_se2diff_0.iqmod_mixer_pex_se2diff_half_inv$1_0.iqmod_mixer_pex_se2diff_inv_NF2$5_1.vout iqmod_mixer_pex_half_1.iqmod_mixer_pex_se2diff_0.iqmod_mixer_pex_se2diff_half_tg$1_0.iqmod_mixer_pex_se2diff_tg_NF6$2_0.v_b VSS VSS sg13_lv_nmos ad=0.19p pd=1.38u as=0.19p ps=1.38u w=1u l=0.13u
X548 voutp_RF iqmod_mixer_pex_half_1.iqmod_mixer_pex_tg_0.di_tg_ctrl_n voutp_RF VSS sg13_lv_nmos ad=0.57p pd=3.38u as=0 ps=0 w=3u l=0.13u
X549 vinp_IF iqmod_mixer_pex_half_1.iqmod_mixer_pex_tg_0.di_tg_ctrl voutp_RF VSS sg13_lv_nmos ad=0.57p pd=3.38u as=0.57p ps=3.38u w=3u l=0.13u
X550 voutp_RF iqmod_mixer_pex_half_1.iqmod_mixer_pex_tg_0.di_tg_ctrl_n voutp_RF VSS sg13_lv_nmos ad=0.57p pd=3.38u as=0 ps=0 w=3u l=0.13u
X551 voutp_RF iqmod_mixer_pex_half_1.iqmod_mixer_pex_tg_0.di_tg_ctrl vinp_IF VSS sg13_lv_nmos ad=0.57p pd=3.38u as=0.57p ps=3.38u w=3u l=0.13u
X552 iqmod_mixer_pex_half_1.iqmod_mixer_pex_tg_0.di_tg_ctrl_n iqmod_mixer_pex_half_1.iqmod_mixer_pex_se2diff_0.iqmod_mixer_pex_se2diff_half_tg$1_0.iqmod_mixer_pex_se2diff_inv_NF18$4_0.vout VSS VSS sg13_lv_nmos ad=0.19p pd=1.38u as=0.19p ps=1.38u w=1u l=0.13u
X553 voutp_RF iqmod_mixer_pex_half_1.iqmod_mixer_pex_tg_0.di_tg_ctrl_n voutp_RF VSS sg13_lv_nmos ad=0.57p pd=3.38u as=0 ps=0 w=3u l=0.13u
X554 voutn_RF iqmod_mixer_pex_half_0.iqmod_mixer_pex_tg_0.di_tg_ctrl_n voutn_RF VSS sg13_lv_nmos ad=0.57p pd=3.38u as=0 ps=0 w=3u l=0.13u
X555 iqmod_mixer_pex_half_1.iqmod_mixer_pex_tg_0.di_tg_ctrl_n iqmod_mixer_pex_half_1.iqmod_mixer_pex_se2diff_0.iqmod_mixer_pex_se2diff_half_tg$1_0.iqmod_mixer_pex_se2diff_inv_NF18$4_0.vout VSS VSS sg13_lv_nmos ad=0.19p pd=1.38u as=0.19p ps=1.38u w=1u l=0.13u
X556 VDD VDD VDD VDD sg13_lv_pmos ad=1.02p pd=6.68u as=0 ps=0 w=3u l=0.13u
X557 VSS iqmod_mixer_pex_half_1.iqmod_mixer_pex_se2diff_0.iqmod_mixer_pex_se2diff_half_tg$1_0.iqmod_mixer_pex_se2diff_inv_NF18$4_0.vout iqmod_mixer_pex_half_1.iqmod_mixer_pex_tg_0.di_tg_ctrl_n VSS sg13_lv_nmos ad=0.19p pd=1.38u as=0.19p ps=1.38u w=1u l=0.13u
X558 VDD iqmod_mixer_pex_half_1.iqmod_mixer_pex_se2diff_0.iqmod_mixer_pex_se2diff_half_tg$1_0.iqmod_mixer_pex_se2diff_inv_NF18$4_0.vout iqmod_mixer_pex_half_1.iqmod_mixer_pex_tg_0.di_tg_ctrl_n VDD sg13_lv_pmos ad=0.57p pd=3.38u as=0.57p ps=3.38u w=3u l=0.13u
X559 voutn_RF iqmod_mixer_pex_half_0.iqmod_mixer_pex_tg_0.di_tg_ctrl vinn_IF VSS sg13_lv_nmos ad=0.57p pd=3.38u as=0.57p ps=3.38u w=3u l=0.13u
X560 voutn_RF iqmod_mixer_pex_half_0.iqmod_mixer_pex_tg_0.di_tg_ctrl_n voutn_RF VSS sg13_lv_nmos ad=0.57p pd=3.38u as=0 ps=0 w=3u l=0.13u
X561 voutp_RF iqmod_mixer_pex_half_1.iqmod_mixer_pex_tg_0.di_tg_ctrl vinp_IF VSS sg13_lv_nmos ad=0.57p pd=3.38u as=0.57p ps=3.38u w=3u l=0.13u
X562 VSS iqmod_mixer_pex_half_1.iqmod_mixer_pex_se2diff_0.iqmod_mixer_pex_se2diff_half_inv$1_0.iqmod_mixer_pex_se2diff_inv_NF6$5_1.vout iqmod_mixer_pex_half_1.iqmod_mixer_pex_se2diff_0.iqmod_mixer_pex_se2diff_half_inv$1_0.iqmod_mixer_pex_se2diff_inv_NF18$5_0.vout VSS sg13_lv_nmos ad=0.19p pd=1.38u as=0.19p ps=1.38u w=1u l=0.13u
X563 iqmod_mixer_pex_half_1.iqmod_mixer_pex_se2diff_0.iqmod_mixer_pex_se2diff_half_inv$1_0.iqmod_mixer_pex_se2diff_inv_NF2$5_0.vout VSS iqmod_mixer_pex_half_1.iqmod_mixer_pex_se2diff_0.iqmod_mixer_pex_se2diff_half_tg$1_0.iqmod_mixer_pex_se2diff_tg_NF6$2_0.v_b VDD sg13_lv_pmos ad=1.02p pd=6.68u as=0.57p ps=3.38u w=3u l=0.13u
X564 voutn_RF iqmod_mixer_pex_half_0.iqmod_mixer_pex_tg_0.di_tg_ctrl vinn_IF VSS sg13_lv_nmos ad=0.57p pd=3.38u as=0.57p ps=3.38u w=3u l=0.13u
X565 iqmod_mixer_pex_half_1.iqmod_mixer_pex_se2diff_0.iqmod_mixer_pex_se2diff_half_inv$1_0.iqmod_mixer_pex_se2diff_inv_NF18$5_0.vout iqmod_mixer_pex_half_1.iqmod_mixer_pex_se2diff_0.iqmod_mixer_pex_se2diff_half_inv$1_0.iqmod_mixer_pex_se2diff_inv_NF6$5_1.vout VSS VSS sg13_lv_nmos ad=0.19p pd=1.38u as=0.19p ps=1.38u w=1u l=0.13u
X566 voutn_RF iqmod_mixer_pex_half_0.iqmod_mixer_pex_tg_0.di_tg_ctrl_n voutn_RF VSS sg13_lv_nmos ad=0.57p pd=3.38u as=0 ps=0 w=3u l=0.13u
X567 vinn_IF iqmod_mixer_pex_half_0.iqmod_mixer_pex_tg_0.di_tg_ctrl voutn_RF VSS sg13_lv_nmos ad=0.57p pd=3.38u as=0.57p ps=3.38u w=3u l=0.13u
X568 VSS iqmod_mixer_pex_half_1.iqmod_mixer_pex_se2diff_0.iqmod_mixer_pex_se2diff_half_inv$1_0.iqmod_mixer_pex_se2diff_inv_NF18$5_0.vout iqmod_mixer_pex_half_1.iqmod_mixer_pex_tg_0.di_tg_ctrl VSS sg13_lv_nmos ad=0.19p pd=1.38u as=0.19p ps=1.38u w=1u l=0.13u
X569 iqmod_mixer_pex_half_0.iqmod_mixer_pex_tg_0.di_tg_ctrl iqmod_mixer_pex_half_0.iqmod_mixer_pex_se2diff_0.iqmod_mixer_pex_se2diff_half_inv$1_0.iqmod_mixer_pex_se2diff_inv_NF18$5_0.vout VDD VDD sg13_lv_pmos ad=0.57p pd=3.38u as=0.57p ps=3.38u w=3u l=0.13u
X570 iqmod_mixer_pex_half_1.iqmod_mixer_pex_tg_0.di_tg_ctrl iqmod_mixer_pex_half_1.iqmod_mixer_pex_se2diff_0.iqmod_mixer_pex_se2diff_half_inv$1_0.iqmod_mixer_pex_se2diff_inv_NF18$5_0.vout VSS VSS sg13_lv_nmos ad=0.19p pd=1.38u as=0.19p ps=1.38u w=1u l=0.13u
X571 voutp_RF iqmod_mixer_pex_half_1.iqmod_mixer_pex_tg_0.di_tg_ctrl_n vinp_IF VDD sg13_lv_pmos ad=1.71p pd=9.38u as=1.71p ps=9.38u w=9u l=0.13u
X572 vinn_IF iqmod_mixer_pex_half_0.iqmod_mixer_pex_tg_0.di_tg_ctrl voutn_RF VSS sg13_lv_nmos ad=0.57p pd=3.38u as=0.57p ps=3.38u w=3u l=0.13u
X573 VDD iqmod_mixer_pex_half_1.iqmod_mixer_pex_se2diff_0.iqmod_mixer_pex_se2diff_half_inv$1_0.iqmod_mixer_pex_se2diff_inv_NF6$5_2.vin iqmod_mixer_pex_half_1.iqmod_mixer_pex_se2diff_0.iqmod_mixer_pex_se2diff_half_inv$1_0.iqmod_mixer_pex_se2diff_inv_NF6$5_2.vout VDD sg13_lv_pmos ad=0.57p pd=3.38u as=0.57p ps=3.38u w=3u l=0.13u
X574 VSS iqmod_mixer_pex_half_1.iqmod_mixer_pex_se2diff_0.iqmod_mixer_pex_se2diff_half_inv$1_0.iqmod_mixer_pex_se2diff_inv_NF18$5_0.vout iqmod_mixer_pex_half_1.iqmod_mixer_pex_tg_0.di_tg_ctrl VSS sg13_lv_nmos ad=0.19p pd=1.38u as=0.19p ps=1.38u w=1u l=0.13u
X575 VDD VDD VDD VDD sg13_lv_pmos ad=1.02p pd=6.68u as=0 ps=0 w=3u l=0.13u
X576 iqmod_mixer_pex_half_0.iqmod_mixer_pex_se2diff_0.iqmod_mixer_pex_se2diff_half_tg$1_0.iqmod_mixer_pex_se2diff_inv_NF18$4_0.vout iqmod_mixer_pex_half_0.iqmod_mixer_pex_se2diff_0.iqmod_mixer_pex_se2diff_half_tg$1_0.iqmod_mixer_pex_se2diff_inv_NF6$4_0.vout VDD VDD sg13_lv_pmos ad=0.57p pd=3.38u as=0.57p ps=3.38u w=3u l=0.13u
X577 VDD iqmod_mixer_pex_half_0.iqmod_mixer_pex_se2diff_0.iqmod_mixer_pex_se2diff_half_tg$1_0.iqmod_mixer_pex_se2diff_inv_NF18$4_0.vout iqmod_mixer_pex_half_0.iqmod_mixer_pex_tg_0.di_tg_ctrl_n VDD sg13_lv_pmos ad=0.57p pd=3.38u as=0.57p ps=3.38u w=3u l=0.13u
X578 VDD iqmod_mixer_pex_half_0.iqmod_mixer_pex_se2diff_0.iqmod_mixer_pex_se2diff_half_tg$1_0.iqmod_mixer_pex_se2diff_inv_NF18$4_0.vout iqmod_mixer_pex_half_0.iqmod_mixer_pex_tg_0.di_tg_ctrl_n VDD sg13_lv_pmos ad=0.57p pd=3.38u as=0.57p ps=3.38u w=3u l=0.13u
X579 iqmod_mixer_pex_half_0.iqmod_mixer_pex_tg_0.di_tg_ctrl iqmod_mixer_pex_half_0.iqmod_mixer_pex_se2diff_0.iqmod_mixer_pex_se2diff_half_inv$1_0.iqmod_mixer_pex_se2diff_inv_NF18$5_0.vout VDD VDD sg13_lv_pmos ad=0.57p pd=3.38u as=0.57p ps=3.38u w=3u l=0.13u
X580 VDD iqmod_mixer_pex_half_0.iqmod_mixer_pex_se2diff_0.iqmod_mixer_pex_se2diff_half_inv$1_0.iqmod_mixer_pex_se2diff_inv_NF6$5_1.vout iqmod_mixer_pex_half_0.iqmod_mixer_pex_se2diff_0.iqmod_mixer_pex_se2diff_half_inv$1_0.iqmod_mixer_pex_se2diff_inv_NF18$5_0.vout VDD sg13_lv_pmos ad=0.57p pd=3.38u as=0.57p ps=3.38u w=3u l=0.13u
X581 vinp_IF iqmod_mixer_pex_half_1.iqmod_mixer_pex_tg_0.di_tg_ctrl_n voutp_RF VDD sg13_lv_pmos ad=1.71p pd=9.38u as=1.71p ps=9.38u w=9u l=0.13u
X582 iqmod_mixer_pex_half_1.iqmod_mixer_pex_se2diff_0.iqmod_mixer_pex_se2diff_half_inv$1_0.iqmod_mixer_pex_se2diff_inv_NF6$5_2.vout iqmod_mixer_pex_half_1.iqmod_mixer_pex_se2diff_0.iqmod_mixer_pex_se2diff_half_inv$1_0.iqmod_mixer_pex_se2diff_inv_NF6$5_2.vin VDD VDD sg13_lv_pmos ad=0.57p pd=3.38u as=0.57p ps=3.38u w=3u l=0.13u
X583 VDD vinp_LO iqmod_mixer_pex_half_1.iqmod_mixer_pex_se2diff_0.iqmod_mixer_pex_se2diff_half_inv$1_0.iqmod_mixer_pex_se2diff_inv_NF2$5_0.vout VDD sg13_lv_pmos ad=0.57p pd=3.38u as=0.57p ps=3.38u w=3u l=0.13u
X584 iqmod_mixer_pex_half_1.iqmod_mixer_pex_tg_0.di_tg_ctrl_n iqmod_mixer_pex_half_1.iqmod_mixer_pex_se2diff_0.iqmod_mixer_pex_se2diff_half_tg$1_0.iqmod_mixer_pex_se2diff_inv_NF18$4_0.vout VDD VDD sg13_lv_pmos ad=0.57p pd=3.38u as=0.57p ps=3.38u w=3u l=0.13u
X585 VDD iqmod_mixer_pex_half_1.iqmod_mixer_pex_se2diff_0.iqmod_mixer_pex_se2diff_half_tg$1_0.iqmod_mixer_pex_se2diff_inv_NF18$4_0.vout iqmod_mixer_pex_half_1.iqmod_mixer_pex_tg_0.di_tg_ctrl_n VDD sg13_lv_pmos ad=0.57p pd=3.38u as=0.57p ps=3.38u w=3u l=0.13u
X586 VSS iqmod_mixer_pex_half_0.iqmod_mixer_pex_se2diff_0.iqmod_mixer_pex_se2diff_half_inv$1_0.iqmod_mixer_pex_se2diff_inv_NF18$5_0.vout iqmod_mixer_pex_half_0.iqmod_mixer_pex_tg_0.di_tg_ctrl VSS sg13_lv_nmos ad=0.19p pd=1.38u as=0.19p ps=1.38u w=1u l=0.13u
X587 vinn_IF iqmod_mixer_pex_half_0.iqmod_mixer_pex_tg_0.di_tg_ctrl voutn_RF VSS sg13_lv_nmos ad=0.57p pd=3.38u as=0.57p ps=3.38u w=3u l=0.13u
X588 VDD iqmod_mixer_pex_half_1.iqmod_mixer_pex_se2diff_0.iqmod_mixer_pex_se2diff_half_inv$1_0.iqmod_mixer_pex_se2diff_inv_NF18$5_0.vout iqmod_mixer_pex_half_1.iqmod_mixer_pex_tg_0.di_tg_ctrl VDD sg13_lv_pmos ad=0.57p pd=3.38u as=0.57p ps=3.38u w=3u l=0.13u
X589 iqmod_mixer_pex_half_1.iqmod_mixer_pex_se2diff_0.iqmod_mixer_pex_se2diff_half_tg$1_0.iqmod_mixer_pex_se2diff_inv_NF18$4_0.vout iqmod_mixer_pex_half_1.iqmod_mixer_pex_se2diff_0.iqmod_mixer_pex_se2diff_half_tg$1_0.iqmod_mixer_pex_se2diff_inv_NF6$4_0.vout VSS VSS sg13_lv_nmos ad=0.19p pd=1.38u as=0.19p ps=1.38u w=1u l=0.13u
X590 VDD iqmod_mixer_pex_half_0.iqmod_mixer_pex_se2diff_0.iqmod_mixer_pex_se2diff_half_inv$1_0.iqmod_mixer_pex_se2diff_inv_NF6$5_1.vout iqmod_mixer_pex_half_0.iqmod_mixer_pex_se2diff_0.iqmod_mixer_pex_se2diff_half_inv$1_0.iqmod_mixer_pex_se2diff_inv_NF18$5_0.vout VDD sg13_lv_pmos ad=0.57p pd=3.38u as=0.57p ps=3.38u w=3u l=0.13u
X591 VSS iqmod_mixer_pex_half_0.iqmod_mixer_pex_se2diff_0.iqmod_mixer_pex_se2diff_half_inv$1_0.iqmod_mixer_pex_se2diff_inv_NF18$5_0.vout iqmod_mixer_pex_half_0.iqmod_mixer_pex_tg_0.di_tg_ctrl VSS sg13_lv_nmos ad=0.19p pd=1.38u as=0.19p ps=1.38u w=1u l=0.13u
X592 VSS vinn_LO iqmod_mixer_pex_half_0.iqmod_mixer_pex_se2diff_0.iqmod_mixer_pex_se2diff_half_inv$1_0.iqmod_mixer_pex_se2diff_inv_NF2$5_0.vout VSS sg13_lv_nmos ad=0.19p pd=1.38u as=0.19p ps=1.38u w=1u l=0.13u
X593 iqmod_mixer_pex_half_0.iqmod_mixer_pex_se2diff_0.iqmod_mixer_pex_se2diff_half_tg$1_0.iqmod_mixer_pex_se2diff_inv_NF18$4_0.vout iqmod_mixer_pex_half_0.iqmod_mixer_pex_se2diff_0.iqmod_mixer_pex_se2diff_half_tg$1_0.iqmod_mixer_pex_se2diff_inv_NF6$4_0.vout VDD VDD sg13_lv_pmos ad=0.57p pd=3.38u as=0.57p ps=3.38u w=3u l=0.13u
X594 VDD iqmod_mixer_pex_half_0.iqmod_mixer_pex_se2diff_0.iqmod_mixer_pex_se2diff_half_tg$1_0.iqmod_mixer_pex_se2diff_inv_NF18$4_0.vout iqmod_mixer_pex_half_0.iqmod_mixer_pex_tg_0.di_tg_ctrl_n VDD sg13_lv_pmos ad=0.57p pd=3.38u as=0.57p ps=3.38u w=3u l=0.13u
X595 iqmod_mixer_pex_half_1.iqmod_mixer_pex_tg_0.di_tg_ctrl iqmod_mixer_pex_half_1.iqmod_mixer_pex_se2diff_0.iqmod_mixer_pex_se2diff_half_inv$1_0.iqmod_mixer_pex_se2diff_inv_NF18$5_0.vout VDD VDD sg13_lv_pmos ad=0.57p pd=3.38u as=0.57p ps=3.38u w=3u l=0.13u
X596 VSS iqmod_mixer_pex_half_1.iqmod_mixer_pex_se2diff_0.iqmod_mixer_pex_se2diff_half_tg$1_0.iqmod_mixer_pex_se2diff_inv_NF6$4_0.vout iqmod_mixer_pex_half_1.iqmod_mixer_pex_se2diff_0.iqmod_mixer_pex_se2diff_half_tg$1_0.iqmod_mixer_pex_se2diff_inv_NF18$4_0.vout VSS sg13_lv_nmos ad=0.19p pd=1.38u as=0.19p ps=1.38u w=1u l=0.13u
X597 iqmod_mixer_pex_half_1.iqmod_mixer_pex_tg_0.di_tg_ctrl iqmod_mixer_pex_half_1.iqmod_mixer_pex_se2diff_0.iqmod_mixer_pex_se2diff_half_inv$1_0.iqmod_mixer_pex_se2diff_inv_NF18$5_0.vout VDD VDD sg13_lv_pmos ad=0.57p pd=3.38u as=0.57p ps=3.38u w=3u l=0.13u
X598 iqmod_mixer_pex_half_0.iqmod_mixer_pex_tg_0.di_tg_ctrl iqmod_mixer_pex_half_0.iqmod_mixer_pex_se2diff_0.iqmod_mixer_pex_se2diff_half_inv$1_0.iqmod_mixer_pex_se2diff_inv_NF18$5_0.vout VDD VDD sg13_lv_pmos ad=0.57p pd=3.38u as=0.57p ps=3.38u w=3u l=0.13u
X599 VSS iqmod_mixer_pex_half_0.iqmod_mixer_pex_se2diff_0.iqmod_mixer_pex_se2diff_half_inv$1_0.iqmod_mixer_pex_se2diff_inv_NF18$5_0.vout iqmod_mixer_pex_half_0.iqmod_mixer_pex_tg_0.di_tg_ctrl VSS sg13_lv_nmos ad=0.19p pd=1.38u as=0.19p ps=1.38u w=1u l=0.13u
X600 VSS iqmod_mixer_pex_half_0.iqmod_mixer_pex_se2diff_0.iqmod_mixer_pex_se2diff_half_inv$1_0.iqmod_mixer_pex_se2diff_inv_NF18$5_0.vout iqmod_mixer_pex_half_0.iqmod_mixer_pex_tg_0.di_tg_ctrl VSS sg13_lv_nmos ad=0.19p pd=1.38u as=0.19p ps=1.38u w=1u l=0.13u
X601 iqmod_mixer_pex_half_0.iqmod_mixer_pex_se2diff_0.iqmod_mixer_pex_se2diff_half_inv$1_0.iqmod_mixer_pex_se2diff_inv_NF18$5_0.vout iqmod_mixer_pex_half_0.iqmod_mixer_pex_se2diff_0.iqmod_mixer_pex_se2diff_half_inv$1_0.iqmod_mixer_pex_se2diff_inv_NF6$5_1.vout VSS VSS sg13_lv_nmos ad=0.19p pd=1.38u as=0.19p ps=1.38u w=1u l=0.13u
X602 VDD iqmod_mixer_pex_half_1.iqmod_mixer_pex_se2diff_0.iqmod_mixer_pex_se2diff_half_inv$1_0.iqmod_mixer_pex_se2diff_inv_NF18$5_0.vout iqmod_mixer_pex_half_1.iqmod_mixer_pex_tg_0.di_tg_ctrl VDD sg13_lv_pmos ad=0.57p pd=3.38u as=0.57p ps=3.38u w=3u l=0.13u
X603 iqmod_mixer_pex_half_1.iqmod_mixer_pex_se2diff_0.iqmod_mixer_pex_se2diff_half_tg$1_0.iqmod_mixer_pex_se2diff_inv_NF18$4_0.vout iqmod_mixer_pex_half_1.iqmod_mixer_pex_se2diff_0.iqmod_mixer_pex_se2diff_half_tg$1_0.iqmod_mixer_pex_se2diff_inv_NF6$4_0.vout VSS VSS sg13_lv_nmos ad=0.19p pd=1.38u as=0.19p ps=1.38u w=1u l=0.13u
X604 VDD iqmod_mixer_pex_half_0.iqmod_mixer_pex_se2diff_0.iqmod_mixer_pex_se2diff_half_inv$1_0.iqmod_mixer_pex_se2diff_inv_NF2$5_1.vout iqmod_mixer_pex_half_0.iqmod_mixer_pex_se2diff_0.iqmod_mixer_pex_se2diff_half_tg$1_0.iqmod_mixer_pex_se2diff_inv_NF6$4_0.vout VDD sg13_lv_pmos ad=0.57p pd=3.38u as=0.57p ps=3.38u w=3u l=0.13u
X605 iqmod_mixer_pex_half_0.iqmod_mixer_pex_se2diff_0.iqmod_mixer_pex_se2diff_half_tg$1_0.iqmod_mixer_pex_se2diff_inv_NF18$4_0.vout iqmod_mixer_pex_half_0.iqmod_mixer_pex_se2diff_0.iqmod_mixer_pex_se2diff_half_tg$1_0.iqmod_mixer_pex_se2diff_inv_NF6$4_0.vout VDD VDD sg13_lv_pmos ad=0.57p pd=3.38u as=0.57p ps=3.38u w=3u l=0.13u
X606 VDD iqmod_mixer_pex_half_0.iqmod_mixer_pex_se2diff_0.iqmod_mixer_pex_se2diff_half_tg$1_0.iqmod_mixer_pex_se2diff_inv_NF18$4_0.vout iqmod_mixer_pex_half_0.iqmod_mixer_pex_tg_0.di_tg_ctrl_n VDD sg13_lv_pmos ad=0.57p pd=3.38u as=0.57p ps=3.38u w=3u l=0.13u
X607 vinp_IF iqmod_mixer_pex_half_1.iqmod_mixer_pex_tg_0.di_tg_ctrl_n voutp_RF VDD sg13_lv_pmos ad=1.71p pd=9.38u as=1.71p ps=9.38u w=9u l=0.13u
X608 VSS iqmod_mixer_pex_half_1.iqmod_mixer_pex_se2diff_0.iqmod_mixer_pex_se2diff_half_tg$1_0.iqmod_mixer_pex_se2diff_inv_NF18$4_0.vout iqmod_mixer_pex_half_1.iqmod_mixer_pex_tg_0.di_tg_ctrl_n VSS sg13_lv_nmos ad=0.19p pd=1.38u as=0.19p ps=1.38u w=1u l=0.13u
X609 VSS VSS VSS VSS sg13_lv_nmos ad=0.19p pd=1.38u as=0 ps=0 w=1u l=0.13u
X610 iqmod_mixer_pex_half_1.iqmod_mixer_pex_se2diff_0.iqmod_mixer_pex_se2diff_half_inv$1_0.iqmod_mixer_pex_se2diff_inv_NF6$5_1.vout iqmod_mixer_pex_half_1.iqmod_mixer_pex_se2diff_0.iqmod_mixer_pex_se2diff_half_inv$1_0.iqmod_mixer_pex_se2diff_inv_NF6$5_2.vout VSS VSS sg13_lv_nmos ad=0.19p pd=1.38u as=0.19p ps=1.38u w=1u l=0.13u
X611 iqmod_mixer_pex_half_0.iqmod_mixer_pex_se2diff_0.iqmod_mixer_pex_se2diff_half_inv$1_0.iqmod_mixer_pex_se2diff_inv_NF18$5_0.vout iqmod_mixer_pex_half_0.iqmod_mixer_pex_se2diff_0.iqmod_mixer_pex_se2diff_half_inv$1_0.iqmod_mixer_pex_se2diff_inv_NF6$5_1.vout VSS VSS sg13_lv_nmos ad=0.19p pd=1.38u as=0.19p ps=1.38u w=1u l=0.13u
X612 VDD iqmod_mixer_pex_half_0.iqmod_mixer_pex_se2diff_0.iqmod_mixer_pex_se2diff_half_tg$1_0.iqmod_mixer_pex_se2diff_inv_NF18$4_0.vout iqmod_mixer_pex_half_0.iqmod_mixer_pex_tg_0.di_tg_ctrl_n VDD sg13_lv_pmos ad=0.57p pd=3.38u as=0.57p ps=3.38u w=3u l=0.13u
X613 VSS iqmod_mixer_pex_half_0.iqmod_mixer_pex_se2diff_0.iqmod_mixer_pex_se2diff_half_inv$1_0.iqmod_mixer_pex_se2diff_inv_NF18$5_0.vout iqmod_mixer_pex_half_0.iqmod_mixer_pex_tg_0.di_tg_ctrl VSS sg13_lv_nmos ad=0.19p pd=1.38u as=0.19p ps=1.38u w=1u l=0.13u
X614 VSS iqmod_mixer_pex_half_0.iqmod_mixer_pex_se2diff_0.iqmod_mixer_pex_se2diff_half_inv$1_0.iqmod_mixer_pex_se2diff_inv_NF18$5_0.vout iqmod_mixer_pex_half_0.iqmod_mixer_pex_tg_0.di_tg_ctrl VSS sg13_lv_nmos ad=0.19p pd=1.38u as=0.19p ps=1.38u w=1u l=0.13u
X615 VSS VSS VSS VSS sg13_lv_nmos ad=0.19p pd=1.38u as=0 ps=0 w=1u l=0.13u
X616 iqmod_mixer_pex_half_0.iqmod_mixer_pex_tg_0.di_tg_ctrl iqmod_mixer_pex_half_0.iqmod_mixer_pex_se2diff_0.iqmod_mixer_pex_se2diff_half_inv$1_0.iqmod_mixer_pex_se2diff_inv_NF18$5_0.vout VSS VSS sg13_lv_nmos ad=0.19p pd=1.38u as=0.19p ps=1.38u w=1u l=0.13u
X617 VSS VSS VSS VSS sg13_lv_nmos ad=0.34p pd=2.68u as=0 ps=0 w=1u l=0.13u
X618 iqmod_mixer_pex_half_1.iqmod_mixer_pex_tg_0.di_tg_ctrl iqmod_mixer_pex_half_1.iqmod_mixer_pex_se2diff_0.iqmod_mixer_pex_se2diff_half_inv$1_0.iqmod_mixer_pex_se2diff_inv_NF18$5_0.vout VDD VDD sg13_lv_pmos ad=0.57p pd=3.38u as=0.57p ps=3.38u w=3u l=0.13u
X619 iqmod_mixer_pex_half_1.iqmod_mixer_pex_se2diff_0.iqmod_mixer_pex_se2diff_half_inv$1_0.iqmod_mixer_pex_se2diff_inv_NF6$5_2.vout iqmod_mixer_pex_half_1.iqmod_mixer_pex_se2diff_0.iqmod_mixer_pex_se2diff_half_inv$1_0.iqmod_mixer_pex_se2diff_inv_NF2$5_1.vout VDD VDD sg13_lv_pmos ad=0.57p pd=3.38u as=0.57p ps=3.38u w=3u l=0.13u
X620 voutp_RF iqmod_mixer_pex_half_1.iqmod_mixer_pex_tg_0.di_tg_ctrl vinp_IF VSS sg13_lv_nmos ad=0.57p pd=3.38u as=0.57p ps=3.38u w=3u l=0.13u
X621 VSS iqmod_mixer_pex_half_0.iqmod_mixer_pex_se2diff_0.iqmod_mixer_pex_se2diff_half_inv$1_0.iqmod_mixer_pex_se2diff_inv_NF18$5_0.vout iqmod_mixer_pex_half_0.iqmod_mixer_pex_tg_0.di_tg_ctrl VSS sg13_lv_nmos ad=0.19p pd=1.38u as=0.19p ps=1.38u w=1u l=0.13u
X622 VSS VSS VSS VSS sg13_lv_nmos ad=0.19p pd=1.38u as=0 ps=0 w=1u l=0.13u
X623 VSS iqmod_mixer_pex_half_1.iqmod_mixer_pex_se2diff_0.iqmod_mixer_pex_se2diff_half_inv$1_0.iqmod_mixer_pex_se2diff_inv_NF2$5_1.vout iqmod_mixer_pex_half_1.iqmod_mixer_pex_se2diff_0.iqmod_mixer_pex_se2diff_half_inv$1_0.iqmod_mixer_pex_se2diff_inv_NF6$5_2.vout VSS sg13_lv_nmos ad=0.19p pd=1.38u as=0.19p ps=1.38u w=1u l=0.13u
X624 vinp_IF iqmod_mixer_pex_half_1.iqmod_mixer_pex_tg_0.di_tg_ctrl voutp_RF VSS sg13_lv_nmos ad=0.57p pd=3.38u as=0.57p ps=3.38u w=3u l=0.13u
X625 voutp_RF iqmod_mixer_pex_half_1.iqmod_mixer_pex_tg_0.di_tg_ctrl vinp_IF VSS sg13_lv_nmos ad=0.57p pd=3.38u as=0.57p ps=3.38u w=3u l=0.13u
X626 VSS iqmod_mixer_pex_half_0.iqmod_mixer_pex_se2diff_0.iqmod_mixer_pex_se2diff_half_inv$1_0.iqmod_mixer_pex_se2diff_inv_NF18$5_0.vout iqmod_mixer_pex_half_0.iqmod_mixer_pex_tg_0.di_tg_ctrl VSS sg13_lv_nmos ad=0.19p pd=1.38u as=0.19p ps=1.38u w=1u l=0.13u
X627 voutn_RF iqmod_mixer_pex_half_0.iqmod_mixer_pex_tg_0.di_tg_ctrl voutn_RF VDD sg13_lv_pmos ad=1.71p pd=9.38u as=0 ps=0 w=9u l=0.13u
X628 iqmod_mixer_pex_half_0.iqmod_mixer_pex_tg_0.di_tg_ctrl_n iqmod_mixer_pex_half_0.iqmod_mixer_pex_se2diff_0.iqmod_mixer_pex_se2diff_half_tg$1_0.iqmod_mixer_pex_se2diff_inv_NF18$4_0.vout VSS VSS sg13_lv_nmos ad=0.19p pd=1.38u as=0.19p ps=1.38u w=1u l=0.13u
X629 iqmod_mixer_pex_half_0.iqmod_mixer_pex_tg_0.di_tg_ctrl_n iqmod_mixer_pex_half_0.iqmod_mixer_pex_se2diff_0.iqmod_mixer_pex_se2diff_half_tg$1_0.iqmod_mixer_pex_se2diff_inv_NF18$4_0.vout VSS VSS sg13_lv_nmos ad=0.19p pd=1.38u as=0.19p ps=1.38u w=1u l=0.13u
X630 VSS VSS VSS VSS sg13_lv_nmos ad=0.34p pd=2.68u as=0 ps=0 w=1u l=0.13u
X631 VDD iqmod_mixer_pex_half_1.iqmod_mixer_pex_se2diff_0.iqmod_mixer_pex_se2diff_half_inv$1_0.iqmod_mixer_pex_se2diff_inv_NF6$5_1.vout iqmod_mixer_pex_half_1.iqmod_mixer_pex_se2diff_0.iqmod_mixer_pex_se2diff_half_inv$1_0.iqmod_mixer_pex_se2diff_inv_NF18$5_0.vout VDD sg13_lv_pmos ad=0.57p pd=3.38u as=0.57p ps=3.38u w=3u l=0.13u
X632 iqmod_mixer_pex_half_0.iqmod_mixer_pex_tg_0.di_tg_ctrl_n iqmod_mixer_pex_half_0.iqmod_mixer_pex_se2diff_0.iqmod_mixer_pex_se2diff_half_tg$1_0.iqmod_mixer_pex_se2diff_inv_NF18$4_0.vout VSS VSS sg13_lv_nmos ad=0.19p pd=1.38u as=0.19p ps=1.38u w=1u l=0.13u
X633 iqmod_mixer_pex_half_1.iqmod_mixer_pex_tg_0.di_tg_ctrl iqmod_mixer_pex_half_1.iqmod_mixer_pex_se2diff_0.iqmod_mixer_pex_se2diff_half_inv$1_0.iqmod_mixer_pex_se2diff_inv_NF18$5_0.vout VSS VSS sg13_lv_nmos ad=0.19p pd=1.38u as=0.19p ps=1.38u w=1u l=0.13u
X634 iqmod_mixer_pex_half_0.iqmod_mixer_pex_se2diff_0.iqmod_mixer_pex_se2diff_half_tg$1_0.iqmod_mixer_pex_se2diff_inv_NF6$4_0.vout iqmod_mixer_pex_half_0.iqmod_mixer_pex_se2diff_0.iqmod_mixer_pex_se2diff_half_inv$1_0.iqmod_mixer_pex_se2diff_inv_NF2$5_1.vout VSS VSS sg13_lv_nmos ad=0.19p pd=1.38u as=0.19p ps=1.38u w=1u l=0.13u
X635 voutn_RF iqmod_mixer_pex_half_0.iqmod_mixer_pex_tg_0.di_tg_ctrl_n vinn_IF VDD sg13_lv_pmos ad=1.71p pd=9.38u as=1.71p ps=9.38u w=9u l=0.13u
X636 voutn_RF iqmod_mixer_pex_half_0.iqmod_mixer_pex_tg_0.di_tg_ctrl voutn_RF VDD sg13_lv_pmos ad=1.71p pd=9.38u as=0 ps=0 w=9u l=0.13u
X637 iqmod_mixer_pex_half_0.iqmod_mixer_pex_tg_0.di_tg_ctrl_n iqmod_mixer_pex_half_0.iqmod_mixer_pex_se2diff_0.iqmod_mixer_pex_se2diff_half_tg$1_0.iqmod_mixer_pex_se2diff_inv_NF18$4_0.vout VSS VSS sg13_lv_nmos ad=0.19p pd=1.38u as=0.19p ps=1.38u w=1u l=0.13u
X638 iqmod_mixer_pex_half_0.iqmod_mixer_pex_tg_0.di_tg_ctrl_n iqmod_mixer_pex_half_0.iqmod_mixer_pex_se2diff_0.iqmod_mixer_pex_se2diff_half_tg$1_0.iqmod_mixer_pex_se2diff_inv_NF18$4_0.vout VSS VSS sg13_lv_nmos ad=0.19p pd=1.38u as=0.19p ps=1.38u w=1u l=0.13u
X639 VSS iqmod_mixer_pex_half_0.iqmod_mixer_pex_se2diff_0.iqmod_mixer_pex_se2diff_half_tg$1_0.iqmod_mixer_pex_se2diff_inv_NF6$4_0.vout iqmod_mixer_pex_half_0.iqmod_mixer_pex_se2diff_0.iqmod_mixer_pex_se2diff_half_tg$1_0.iqmod_mixer_pex_se2diff_inv_NF18$4_0.vout VSS sg13_lv_nmos ad=0.19p pd=1.38u as=0.19p ps=1.38u w=1u l=0.13u
X640 VSS iqmod_mixer_pex_half_1.iqmod_mixer_pex_se2diff_0.iqmod_mixer_pex_se2diff_half_inv$1_0.iqmod_mixer_pex_se2diff_inv_NF18$5_0.vout iqmod_mixer_pex_half_1.iqmod_mixer_pex_tg_0.di_tg_ctrl VSS sg13_lv_nmos ad=0.19p pd=1.38u as=0.19p ps=1.38u w=1u l=0.13u
X641 VSS iqmod_mixer_pex_half_1.iqmod_mixer_pex_se2diff_0.iqmod_mixer_pex_se2diff_half_inv$1_0.iqmod_mixer_pex_se2diff_inv_NF18$5_0.vout iqmod_mixer_pex_half_1.iqmod_mixer_pex_tg_0.di_tg_ctrl VSS sg13_lv_nmos ad=0.19p pd=1.38u as=0.19p ps=1.38u w=1u l=0.13u
X642 VDD VDD VDD VDD sg13_lv_pmos ad=0.57p pd=3.38u as=0 ps=0 w=3u l=0.13u
X643 voutp_RF iqmod_mixer_pex_half_1.iqmod_mixer_pex_tg_0.di_tg_ctrl voutp_RF VDD sg13_lv_pmos ad=1.71p pd=9.38u as=0 ps=0 w=9u l=0.13u
X644 VDD iqmod_mixer_pex_half_1.iqmod_mixer_pex_se2diff_0.iqmod_mixer_pex_se2diff_half_tg$1_0.iqmod_mixer_pex_se2diff_inv_NF18$4_0.vout iqmod_mixer_pex_half_1.iqmod_mixer_pex_tg_0.di_tg_ctrl_n VDD sg13_lv_pmos ad=0.57p pd=3.38u as=0.57p ps=3.38u w=3u l=0.13u
X645 iqmod_mixer_pex_half_0.iqmod_mixer_pex_se2diff_0.iqmod_mixer_pex_se2diff_half_tg$1_0.iqmod_mixer_pex_se2diff_inv_NF6$4_0.vout iqmod_mixer_pex_half_0.iqmod_mixer_pex_se2diff_0.iqmod_mixer_pex_se2diff_half_inv$1_0.iqmod_mixer_pex_se2diff_inv_NF2$5_1.vout VSS VSS sg13_lv_nmos ad=0.19p pd=1.38u as=0.19p ps=1.38u w=1u l=0.13u
X646 VSS VSS VSS VSS sg13_lv_nmos ad=0.34p pd=2.68u as=0 ps=0 w=1u l=0.13u
X647 voutn_RF iqmod_mixer_pex_half_0.iqmod_mixer_pex_tg_0.di_tg_ctrl_n vinn_IF VDD sg13_lv_pmos ad=1.71p pd=9.38u as=1.71p ps=9.38u w=9u l=0.13u
X648 iqmod_mixer_pex_half_0.iqmod_mixer_pex_tg_0.di_tg_ctrl_n iqmod_mixer_pex_half_0.iqmod_mixer_pex_se2diff_0.iqmod_mixer_pex_se2diff_half_tg$1_0.iqmod_mixer_pex_se2diff_inv_NF18$4_0.vout VSS VSS sg13_lv_nmos ad=0.19p pd=1.38u as=0.19p ps=1.38u w=1u l=0.13u
X649 iqmod_mixer_pex_half_1.iqmod_mixer_pex_tg_0.di_tg_ctrl iqmod_mixer_pex_half_1.iqmod_mixer_pex_se2diff_0.iqmod_mixer_pex_se2diff_half_inv$1_0.iqmod_mixer_pex_se2diff_inv_NF18$5_0.vout VSS VSS sg13_lv_nmos ad=0.19p pd=1.38u as=0.19p ps=1.38u w=1u l=0.13u
X650 iqmod_mixer_pex_half_1.iqmod_mixer_pex_tg_0.di_tg_ctrl_n iqmod_mixer_pex_half_1.iqmod_mixer_pex_se2diff_0.iqmod_mixer_pex_se2diff_half_tg$1_0.iqmod_mixer_pex_se2diff_inv_NF18$4_0.vout VDD VDD sg13_lv_pmos ad=0.57p pd=3.38u as=0.57p ps=3.38u w=3u l=0.13u
X651 voutp_RF iqmod_mixer_pex_half_1.iqmod_mixer_pex_tg_0.di_tg_ctrl voutp_RF VDD sg13_lv_pmos ad=1.71p pd=9.38u as=0 ps=0 w=9u l=0.13u
X652 VDD iqmod_mixer_pex_half_1.iqmod_mixer_pex_se2diff_0.iqmod_mixer_pex_se2diff_half_inv$1_0.iqmod_mixer_pex_se2diff_inv_NF6$5_1.vout iqmod_mixer_pex_half_1.iqmod_mixer_pex_se2diff_0.iqmod_mixer_pex_se2diff_half_inv$1_0.iqmod_mixer_pex_se2diff_inv_NF18$5_0.vout VDD sg13_lv_pmos ad=0.57p pd=3.38u as=0.57p ps=3.38u w=3u l=0.13u
X653 vinp_IF iqmod_mixer_pex_half_1.iqmod_mixer_pex_tg_0.di_tg_ctrl_n voutp_RF VDD sg13_lv_pmos ad=1.71p pd=9.38u as=1.71p ps=9.38u w=9u l=0.13u
X654 voutn_RF iqmod_mixer_pex_half_0.iqmod_mixer_pex_tg_0.di_tg_ctrl_n vinn_IF VDD sg13_lv_pmos ad=1.71p pd=9.38u as=1.71p ps=9.38u w=9u l=0.13u
X655 voutn_RF iqmod_mixer_pex_half_0.iqmod_mixer_pex_tg_0.di_tg_ctrl_n vinn_IF VDD sg13_lv_pmos ad=1.71p pd=9.38u as=1.71p ps=9.38u w=9u l=0.13u
X656 iqmod_mixer_pex_half_0.iqmod_mixer_pex_tg_0.di_tg_ctrl_n iqmod_mixer_pex_half_0.iqmod_mixer_pex_se2diff_0.iqmod_mixer_pex_se2diff_half_tg$1_0.iqmod_mixer_pex_se2diff_inv_NF18$4_0.vout VSS VSS sg13_lv_nmos ad=0.19p pd=1.38u as=0.19p ps=1.38u w=1u l=0.13u
X657 iqmod_mixer_pex_half_1.iqmod_mixer_pex_se2diff_0.iqmod_mixer_pex_se2diff_half_inv$1_0.iqmod_mixer_pex_se2diff_inv_NF2$5_0.vout vinp_LO VSS VSS sg13_lv_nmos ad=0.19p pd=1.38u as=0.19p ps=1.38u w=1u l=0.13u
X658 voutp_RF iqmod_mixer_pex_half_1.iqmod_mixer_pex_tg_0.di_tg_ctrl_n vinp_IF VDD sg13_lv_pmos ad=1.71p pd=9.38u as=1.71p ps=9.38u w=9u l=0.13u
X659 iqmod_mixer_pex_half_0.iqmod_mixer_pex_tg_0.di_tg_ctrl iqmod_mixer_pex_half_0.iqmod_mixer_pex_se2diff_0.iqmod_mixer_pex_se2diff_half_inv$1_0.iqmod_mixer_pex_se2diff_inv_NF18$5_0.vout VSS VSS sg13_lv_nmos ad=0.19p pd=1.38u as=0.19p ps=1.38u w=1u l=0.13u
X660 iqmod_mixer_pex_half_1.iqmod_mixer_pex_se2diff_0.iqmod_mixer_pex_se2diff_half_inv$1_0.iqmod_mixer_pex_se2diff_inv_NF18$5_0.vout iqmod_mixer_pex_half_1.iqmod_mixer_pex_se2diff_0.iqmod_mixer_pex_se2diff_half_inv$1_0.iqmod_mixer_pex_se2diff_inv_NF6$5_1.vout VDD VDD sg13_lv_pmos ad=0.57p pd=3.38u as=0.57p ps=3.38u w=3u l=0.13u
X661 VDD iqmod_mixer_pex_half_1.iqmod_mixer_pex_se2diff_0.iqmod_mixer_pex_se2diff_half_inv$1_0.iqmod_mixer_pex_se2diff_inv_NF18$5_0.vout iqmod_mixer_pex_half_1.iqmod_mixer_pex_tg_0.di_tg_ctrl VDD sg13_lv_pmos ad=0.57p pd=3.38u as=0.57p ps=3.38u w=3u l=0.13u
X662 VSS VSS VSS VSS sg13_lv_nmos ad=0.19p pd=1.38u as=0 ps=0 w=1u l=0.13u
X663 iqmod_mixer_pex_half_1.iqmod_mixer_pex_tg_0.di_tg_ctrl_n iqmod_mixer_pex_half_1.iqmod_mixer_pex_se2diff_0.iqmod_mixer_pex_se2diff_half_tg$1_0.iqmod_mixer_pex_se2diff_inv_NF18$4_0.vout VDD VDD sg13_lv_pmos ad=0.57p pd=3.38u as=0.57p ps=3.38u w=3u l=0.13u
X664 voutn_RF iqmod_mixer_pex_half_0.iqmod_mixer_pex_tg_0.di_tg_ctrl_n vinn_IF VDD sg13_lv_pmos ad=1.71p pd=9.38u as=1.71p ps=9.38u w=9u l=0.13u
X665 VSS iqmod_mixer_pex_half_1.iqmod_mixer_pex_se2diff_0.iqmod_mixer_pex_se2diff_half_tg$1_0.iqmod_mixer_pex_se2diff_inv_NF6$4_0.vout iqmod_mixer_pex_half_1.iqmod_mixer_pex_se2diff_0.iqmod_mixer_pex_se2diff_half_tg$1_0.iqmod_mixer_pex_se2diff_inv_NF18$4_0.vout VSS sg13_lv_nmos ad=0.19p pd=1.38u as=0.19p ps=1.38u w=1u l=0.13u
X666 VDD iqmod_mixer_pex_half_1.iqmod_mixer_pex_se2diff_0.iqmod_mixer_pex_se2diff_half_tg$1_0.iqmod_mixer_pex_se2diff_inv_NF18$4_0.vout iqmod_mixer_pex_half_1.iqmod_mixer_pex_tg_0.di_tg_ctrl_n VDD sg13_lv_pmos ad=0.57p pd=3.38u as=0.57p ps=3.38u w=3u l=0.13u
X667 iqmod_mixer_pex_half_1.iqmod_mixer_pex_tg_0.di_tg_ctrl iqmod_mixer_pex_half_1.iqmod_mixer_pex_se2diff_0.iqmod_mixer_pex_se2diff_half_inv$1_0.iqmod_mixer_pex_se2diff_inv_NF18$5_0.vout VDD VDD sg13_lv_pmos ad=0.57p pd=3.38u as=0.57p ps=3.38u w=3u l=0.13u
X668 iqmod_mixer_pex_half_1.iqmod_mixer_pex_tg_0.di_tg_ctrl_n iqmod_mixer_pex_half_1.iqmod_mixer_pex_se2diff_0.iqmod_mixer_pex_se2diff_half_tg$1_0.iqmod_mixer_pex_se2diff_inv_NF18$4_0.vout VSS VSS sg13_lv_nmos ad=0.19p pd=1.38u as=0.19p ps=1.38u w=1u l=0.13u
X669 iqmod_mixer_pex_half_0.iqmod_mixer_pex_tg_0.di_tg_ctrl iqmod_mixer_pex_half_0.iqmod_mixer_pex_se2diff_0.iqmod_mixer_pex_se2diff_half_inv$1_0.iqmod_mixer_pex_se2diff_inv_NF18$5_0.vout VSS VSS sg13_lv_nmos ad=0.19p pd=1.38u as=0.19p ps=1.38u w=1u l=0.13u
X670 VSS iqmod_mixer_pex_half_0.iqmod_mixer_pex_se2diff_0.iqmod_mixer_pex_se2diff_half_inv$1_0.iqmod_mixer_pex_se2diff_inv_NF6$5_1.vout iqmod_mixer_pex_half_0.iqmod_mixer_pex_se2diff_0.iqmod_mixer_pex_se2diff_half_inv$1_0.iqmod_mixer_pex_se2diff_inv_NF18$5_0.vout VSS sg13_lv_nmos ad=0.19p pd=1.38u as=0.19p ps=1.38u w=1u l=0.13u
X671 VSS iqmod_mixer_pex_half_1.iqmod_mixer_pex_se2diff_0.iqmod_mixer_pex_se2diff_half_tg$1_0.iqmod_mixer_pex_se2diff_inv_NF18$4_0.vout iqmod_mixer_pex_half_1.iqmod_mixer_pex_tg_0.di_tg_ctrl_n VSS sg13_lv_nmos ad=0.19p pd=1.38u as=0.19p ps=1.38u w=1u l=0.13u
X672 iqmod_mixer_pex_half_0.iqmod_mixer_pex_se2diff_0.iqmod_mixer_pex_se2diff_half_inv$1_0.iqmod_mixer_pex_se2diff_inv_NF2$5_1.vout iqmod_mixer_pex_half_0.iqmod_mixer_pex_se2diff_0.iqmod_mixer_pex_se2diff_half_tg$1_0.iqmod_mixer_pex_se2diff_tg_NF6$2_0.v_b VSS VSS sg13_lv_nmos ad=0.19p pd=1.38u as=0.19p ps=1.38u w=1u l=0.13u
X673 VDD iqmod_mixer_pex_half_1.iqmod_mixer_pex_se2diff_0.iqmod_mixer_pex_se2diff_half_inv$1_0.iqmod_mixer_pex_se2diff_inv_NF2$5_1.vout iqmod_mixer_pex_half_1.iqmod_mixer_pex_se2diff_0.iqmod_mixer_pex_se2diff_half_inv$1_0.iqmod_mixer_pex_se2diff_inv_NF6$5_2.vout VDD sg13_lv_pmos ad=0.57p pd=3.38u as=0.57p ps=3.38u w=3u l=0.13u
X674 iqmod_mixer_pex_half_0.iqmod_mixer_pex_se2diff_0.iqmod_mixer_pex_se2diff_half_inv$1_0.iqmod_mixer_pex_se2diff_inv_NF2$5_0.vout VDD iqmod_mixer_pex_half_0.iqmod_mixer_pex_se2diff_0.iqmod_mixer_pex_se2diff_half_tg$1_0.iqmod_mixer_pex_se2diff_tg_NF6$2_0.v_b VSS sg13_lv_nmos ad=0.34p pd=2.68u as=0.19p ps=1.38u w=1u l=0.13u
X675 VSS iqmod_mixer_pex_half_0.iqmod_mixer_pex_se2diff_0.iqmod_mixer_pex_se2diff_half_inv$1_0.iqmod_mixer_pex_se2diff_inv_NF6$5_1.vout iqmod_mixer_pex_half_0.iqmod_mixer_pex_se2diff_0.iqmod_mixer_pex_se2diff_half_inv$1_0.iqmod_mixer_pex_se2diff_inv_NF18$5_0.vout VSS sg13_lv_nmos ad=0.19p pd=1.38u as=0.19p ps=1.38u w=1u l=0.13u
X676 VDD VDD VDD VDD sg13_lv_pmos ad=1.02p pd=6.68u as=0 ps=0 w=3u l=0.13u
X677 VDD VDD VDD VDD sg13_lv_pmos ad=1.02p pd=6.68u as=0 ps=0 w=3u l=0.13u
X678 VDD VDD VDD VDD sg13_lv_pmos ad=0.57p pd=3.38u as=0 ps=0 w=3u l=0.13u
X679 voutn_RF iqmod_mixer_pex_half_0.iqmod_mixer_pex_tg_0.di_tg_ctrl_n voutn_RF VSS sg13_lv_nmos ad=0.57p pd=3.38u as=0 ps=0 w=3u l=0.13u
X680 iqmod_mixer_pex_half_0.iqmod_mixer_pex_se2diff_0.iqmod_mixer_pex_se2diff_half_inv$1_0.iqmod_mixer_pex_se2diff_inv_NF2$5_1.vout iqmod_mixer_pex_half_0.iqmod_mixer_pex_se2diff_0.iqmod_mixer_pex_se2diff_half_tg$1_0.iqmod_mixer_pex_se2diff_tg_NF6$2_0.v_b VSS VSS sg13_lv_nmos ad=0.19p pd=1.38u as=0.19p ps=1.38u w=1u l=0.13u
X681 VSS VSS VSS VSS sg13_lv_nmos ad=0.34p pd=2.68u as=0 ps=0 w=1u l=0.13u
X682 iqmod_mixer_pex_half_0.iqmod_mixer_pex_se2diff_0.iqmod_mixer_pex_se2diff_half_inv$1_0.iqmod_mixer_pex_se2diff_inv_NF2$5_0.vout VDD iqmod_mixer_pex_half_0.iqmod_mixer_pex_se2diff_0.iqmod_mixer_pex_se2diff_half_tg$1_0.iqmod_mixer_pex_se2diff_tg_NF6$2_0.v_b VSS sg13_lv_nmos ad=0.19p pd=1.38u as=0.19p ps=1.38u w=1u l=0.13u
X683 VSS iqmod_mixer_pex_half_1.iqmod_mixer_pex_se2diff_0.iqmod_mixer_pex_se2diff_half_inv$1_0.iqmod_mixer_pex_se2diff_inv_NF6$5_2.vout iqmod_mixer_pex_half_1.iqmod_mixer_pex_se2diff_0.iqmod_mixer_pex_se2diff_half_inv$1_0.iqmod_mixer_pex_se2diff_inv_NF6$5_1.vout VSS sg13_lv_nmos ad=0.19p pd=1.38u as=0.19p ps=1.38u w=1u l=0.13u
X684 iqmod_mixer_pex_half_1.iqmod_mixer_pex_se2diff_0.iqmod_mixer_pex_se2diff_half_inv$1_0.iqmod_mixer_pex_se2diff_inv_NF18$5_0.vout iqmod_mixer_pex_half_1.iqmod_mixer_pex_se2diff_0.iqmod_mixer_pex_se2diff_half_inv$1_0.iqmod_mixer_pex_se2diff_inv_NF6$5_1.vout VSS VSS sg13_lv_nmos ad=0.19p pd=1.38u as=0.19p ps=1.38u w=1u l=0.13u
X685 VSS iqmod_mixer_pex_half_1.iqmod_mixer_pex_se2diff_0.iqmod_mixer_pex_se2diff_half_inv$1_0.iqmod_mixer_pex_se2diff_inv_NF18$5_0.vout iqmod_mixer_pex_half_1.iqmod_mixer_pex_tg_0.di_tg_ctrl VSS sg13_lv_nmos ad=0.19p pd=1.38u as=0.19p ps=1.38u w=1u l=0.13u
X686 voutp_RF iqmod_mixer_pex_half_1.iqmod_mixer_pex_tg_0.di_tg_ctrl vinp_IF VSS sg13_lv_nmos ad=0.57p pd=3.38u as=0.57p ps=3.38u w=3u l=0.13u
X687 iqmod_mixer_pex_half_0.iqmod_mixer_pex_tg_0.di_tg_ctrl iqmod_mixer_pex_half_0.iqmod_mixer_pex_se2diff_0.iqmod_mixer_pex_se2diff_half_inv$1_0.iqmod_mixer_pex_se2diff_inv_NF18$5_0.vout VSS VSS sg13_lv_nmos ad=0.19p pd=1.38u as=0.19p ps=1.38u w=1u l=0.13u
X688 iqmod_mixer_pex_half_1.iqmod_mixer_pex_tg_0.di_tg_ctrl iqmod_mixer_pex_half_1.iqmod_mixer_pex_se2diff_0.iqmod_mixer_pex_se2diff_half_inv$1_0.iqmod_mixer_pex_se2diff_inv_NF18$5_0.vout VSS VSS sg13_lv_nmos ad=0.19p pd=1.38u as=0.19p ps=1.38u w=1u l=0.13u
X689 vinp_IF iqmod_mixer_pex_half_1.iqmod_mixer_pex_tg_0.di_tg_ctrl voutp_RF VSS sg13_lv_nmos ad=0.57p pd=3.38u as=0.57p ps=3.38u w=3u l=0.13u
X690 VSS iqmod_mixer_pex_half_1.iqmod_mixer_pex_se2diff_0.iqmod_mixer_pex_se2diff_half_inv$1_0.iqmod_mixer_pex_se2diff_inv_NF6$5_2.vin iqmod_mixer_pex_half_1.iqmod_mixer_pex_se2diff_0.iqmod_mixer_pex_se2diff_half_inv$1_0.iqmod_mixer_pex_se2diff_inv_NF6$5_2.vout VSS sg13_lv_nmos ad=0.19p pd=1.38u as=0.19p ps=1.38u w=1u l=0.13u
X691 iqmod_mixer_pex_half_1.iqmod_mixer_pex_tg_0.di_tg_ctrl_n iqmod_mixer_pex_half_1.iqmod_mixer_pex_se2diff_0.iqmod_mixer_pex_se2diff_half_tg$1_0.iqmod_mixer_pex_se2diff_inv_NF18$4_0.vout VDD VDD sg13_lv_pmos ad=0.57p pd=3.38u as=0.57p ps=3.38u w=3u l=0.13u
X692 iqmod_mixer_pex_half_0.iqmod_mixer_pex_tg_0.di_tg_ctrl iqmod_mixer_pex_half_0.iqmod_mixer_pex_se2diff_0.iqmod_mixer_pex_se2diff_half_inv$1_0.iqmod_mixer_pex_se2diff_inv_NF18$5_0.vout VDD VDD sg13_lv_pmos ad=0.57p pd=3.38u as=0.57p ps=3.38u w=3u l=0.13u
X693 vinn_IF iqmod_mixer_pex_half_0.iqmod_mixer_pex_tg_0.di_tg_ctrl voutn_RF VSS sg13_lv_nmos ad=0.57p pd=3.38u as=0.57p ps=3.38u w=3u l=0.13u
X694 iqmod_mixer_pex_half_1.iqmod_mixer_pex_tg_0.di_tg_ctrl iqmod_mixer_pex_half_1.iqmod_mixer_pex_se2diff_0.iqmod_mixer_pex_se2diff_half_inv$1_0.iqmod_mixer_pex_se2diff_inv_NF18$5_0.vout VSS VSS sg13_lv_nmos ad=0.19p pd=1.38u as=0.19p ps=1.38u w=1u l=0.13u
X695 iqmod_mixer_pex_half_0.iqmod_mixer_pex_tg_0.di_tg_ctrl iqmod_mixer_pex_half_0.iqmod_mixer_pex_se2diff_0.iqmod_mixer_pex_se2diff_half_inv$1_0.iqmod_mixer_pex_se2diff_inv_NF18$5_0.vout VDD VDD sg13_lv_pmos ad=0.57p pd=3.38u as=0.57p ps=3.38u w=3u l=0.13u
X696 voutn_RF iqmod_mixer_pex_half_0.iqmod_mixer_pex_tg_0.di_tg_ctrl voutn_RF VDD sg13_lv_pmos ad=1.71p pd=9.38u as=0 ps=0 w=9u l=0.13u
X697 iqmod_mixer_pex_half_1.iqmod_mixer_pex_se2diff_0.iqmod_mixer_pex_se2diff_half_inv$1_0.iqmod_mixer_pex_se2diff_inv_NF6$5_2.vout iqmod_mixer_pex_half_1.iqmod_mixer_pex_se2diff_0.iqmod_mixer_pex_se2diff_half_inv$1_0.iqmod_mixer_pex_se2diff_inv_NF6$5_2.vin VSS VSS sg13_lv_nmos ad=0.19p pd=1.38u as=0.19p ps=1.38u w=1u l=0.13u
X698 VSS iqmod_mixer_pex_half_1.iqmod_mixer_pex_se2diff_0.iqmod_mixer_pex_se2diff_half_inv$1_0.iqmod_mixer_pex_se2diff_inv_NF2$5_1.vout iqmod_mixer_pex_half_1.iqmod_mixer_pex_se2diff_0.iqmod_mixer_pex_se2diff_half_tg$1_0.iqmod_mixer_pex_se2diff_inv_NF6$4_0.vout VSS sg13_lv_nmos ad=0.19p pd=1.38u as=0.19p ps=1.38u w=1u l=0.13u
X699 iqmod_mixer_pex_half_0.iqmod_mixer_pex_tg_0.di_tg_ctrl iqmod_mixer_pex_half_0.iqmod_mixer_pex_se2diff_0.iqmod_mixer_pex_se2diff_half_inv$1_0.iqmod_mixer_pex_se2diff_inv_NF18$5_0.vout VDD VDD sg13_lv_pmos ad=0.57p pd=3.38u as=0.57p ps=3.38u w=3u l=0.13u
X700 VDD iqmod_mixer_pex_half_0.iqmod_mixer_pex_se2diff_0.iqmod_mixer_pex_se2diff_half_tg$1_0.iqmod_mixer_pex_se2diff_inv_NF18$4_0.vout iqmod_mixer_pex_half_0.iqmod_mixer_pex_tg_0.di_tg_ctrl_n VDD sg13_lv_pmos ad=0.57p pd=3.38u as=0.57p ps=3.38u w=3u l=0.13u
X701 VDD iqmod_mixer_pex_half_0.iqmod_mixer_pex_se2diff_0.iqmod_mixer_pex_se2diff_half_tg$1_0.iqmod_mixer_pex_se2diff_inv_NF18$4_0.vout iqmod_mixer_pex_half_0.iqmod_mixer_pex_tg_0.di_tg_ctrl_n VDD sg13_lv_pmos ad=0.57p pd=3.38u as=0.57p ps=3.38u w=3u l=0.13u
X702 iqmod_mixer_pex_half_0.iqmod_mixer_pex_tg_0.di_tg_ctrl iqmod_mixer_pex_half_0.iqmod_mixer_pex_se2diff_0.iqmod_mixer_pex_se2diff_half_inv$1_0.iqmod_mixer_pex_se2diff_inv_NF18$5_0.vout VDD VDD sg13_lv_pmos ad=0.57p pd=3.38u as=0.57p ps=3.38u w=3u l=0.13u
X703 iqmod_mixer_pex_half_0.iqmod_mixer_pex_tg_0.di_tg_ctrl iqmod_mixer_pex_half_0.iqmod_mixer_pex_se2diff_0.iqmod_mixer_pex_se2diff_half_inv$1_0.iqmod_mixer_pex_se2diff_inv_NF18$5_0.vout VDD VDD sg13_lv_pmos ad=0.57p pd=3.38u as=0.57p ps=3.38u w=3u l=0.13u
X704 VDD iqmod_mixer_pex_half_0.iqmod_mixer_pex_se2diff_0.iqmod_mixer_pex_se2diff_half_inv$1_0.iqmod_mixer_pex_se2diff_inv_NF6$5_1.vout iqmod_mixer_pex_half_0.iqmod_mixer_pex_se2diff_0.iqmod_mixer_pex_se2diff_half_inv$1_0.iqmod_mixer_pex_se2diff_inv_NF18$5_0.vout VDD sg13_lv_pmos ad=0.57p pd=3.38u as=0.57p ps=3.38u w=3u l=0.13u
X705 iqmod_mixer_pex_half_0.iqmod_mixer_pex_se2diff_0.iqmod_mixer_pex_se2diff_half_inv$1_0.iqmod_mixer_pex_se2diff_inv_NF6$5_1.vout iqmod_mixer_pex_half_0.iqmod_mixer_pex_se2diff_0.iqmod_mixer_pex_se2diff_half_inv$1_0.iqmod_mixer_pex_se2diff_inv_NF6$5_2.vout VDD VDD sg13_lv_pmos ad=0.57p pd=3.38u as=0.57p ps=3.38u w=3u l=0.13u
X706 iqmod_mixer_pex_half_1.iqmod_mixer_pex_se2diff_0.iqmod_mixer_pex_se2diff_half_tg$1_0.iqmod_mixer_pex_se2diff_inv_NF6$4_0.vout iqmod_mixer_pex_half_1.iqmod_mixer_pex_se2diff_0.iqmod_mixer_pex_se2diff_half_inv$1_0.iqmod_mixer_pex_se2diff_inv_NF2$5_1.vout VSS VSS sg13_lv_nmos ad=0.19p pd=1.38u as=0.19p ps=1.38u w=1u l=0.13u
X707 iqmod_mixer_pex_half_1.iqmod_mixer_pex_tg_0.di_tg_ctrl iqmod_mixer_pex_half_1.iqmod_mixer_pex_se2diff_0.iqmod_mixer_pex_se2diff_half_inv$1_0.iqmod_mixer_pex_se2diff_inv_NF18$5_0.vout VSS VSS sg13_lv_nmos ad=0.19p pd=1.38u as=0.19p ps=1.38u w=1u l=0.13u
X708 iqmod_mixer_pex_half_1.iqmod_mixer_pex_tg_0.di_tg_ctrl iqmod_mixer_pex_half_1.iqmod_mixer_pex_se2diff_0.iqmod_mixer_pex_se2diff_half_inv$1_0.iqmod_mixer_pex_se2diff_inv_NF18$5_0.vout VSS VSS sg13_lv_nmos ad=0.19p pd=1.38u as=0.19p ps=1.38u w=1u l=0.13u
X709 voutp_RF iqmod_mixer_pex_half_1.iqmod_mixer_pex_tg_0.di_tg_ctrl voutp_RF VDD sg13_lv_pmos ad=1.71p pd=9.38u as=0 ps=0 w=9u l=0.13u
X710 vinn_IF iqmod_mixer_pex_half_0.iqmod_mixer_pex_tg_0.di_tg_ctrl voutn_RF VSS sg13_lv_nmos ad=0.57p pd=3.38u as=0.57p ps=3.38u w=3u l=0.13u
X711 VSS iqmod_mixer_pex_half_1.iqmod_mixer_pex_se2diff_0.iqmod_mixer_pex_se2diff_half_inv$1_0.iqmod_mixer_pex_se2diff_inv_NF18$5_0.vout iqmod_mixer_pex_half_1.iqmod_mixer_pex_tg_0.di_tg_ctrl VSS sg13_lv_nmos ad=0.19p pd=1.38u as=0.19p ps=1.38u w=1u l=0.13u
X712 vinp_IF iqmod_mixer_pex_half_1.iqmod_mixer_pex_tg_0.di_tg_ctrl_n voutp_RF VDD sg13_lv_pmos ad=1.71p pd=9.38u as=1.71p ps=9.38u w=9u l=0.13u
X713 VDD iqmod_mixer_pex_half_0.iqmod_mixer_pex_se2diff_0.iqmod_mixer_pex_se2diff_half_tg$1_0.iqmod_mixer_pex_se2diff_inv_NF18$4_0.vout iqmod_mixer_pex_half_0.iqmod_mixer_pex_tg_0.di_tg_ctrl_n VDD sg13_lv_pmos ad=0.57p pd=3.38u as=0.57p ps=3.38u w=3u l=0.13u
X714 iqmod_mixer_pex_half_0.iqmod_mixer_pex_tg_0.di_tg_ctrl iqmod_mixer_pex_half_0.iqmod_mixer_pex_se2diff_0.iqmod_mixer_pex_se2diff_half_inv$1_0.iqmod_mixer_pex_se2diff_inv_NF18$5_0.vout VDD VDD sg13_lv_pmos ad=0.57p pd=3.38u as=0.57p ps=3.38u w=3u l=0.13u
X715 VDD VDD VDD VDD sg13_lv_pmos ad=1.02p pd=6.68u as=0 ps=0 w=3u l=0.13u
X716 voutp_RF iqmod_mixer_pex_half_1.iqmod_mixer_pex_tg_0.di_tg_ctrl voutp_RF VDD sg13_lv_pmos ad=1.71p pd=9.38u as=0 ps=0 w=9u l=0.13u
X717 iqmod_mixer_pex_half_0.iqmod_mixer_pex_se2diff_0.iqmod_mixer_pex_se2diff_half_tg$1_0.iqmod_mixer_pex_se2diff_inv_NF18$4_0.vout iqmod_mixer_pex_half_0.iqmod_mixer_pex_se2diff_0.iqmod_mixer_pex_se2diff_half_tg$1_0.iqmod_mixer_pex_se2diff_inv_NF6$4_0.vout VDD VDD sg13_lv_pmos ad=0.57p pd=3.38u as=0.57p ps=3.38u w=3u l=0.13u
X718 VDD iqmod_mixer_pex_half_0.iqmod_mixer_pex_se2diff_0.iqmod_mixer_pex_se2diff_half_tg$1_0.iqmod_mixer_pex_se2diff_inv_NF18$4_0.vout iqmod_mixer_pex_half_0.iqmod_mixer_pex_tg_0.di_tg_ctrl_n VDD sg13_lv_pmos ad=0.57p pd=3.38u as=0.57p ps=3.38u w=3u l=0.13u
X719 VDD iqmod_mixer_pex_half_0.iqmod_mixer_pex_se2diff_0.iqmod_mixer_pex_se2diff_half_tg$1_0.iqmod_mixer_pex_se2diff_inv_NF18$4_0.vout iqmod_mixer_pex_half_0.iqmod_mixer_pex_tg_0.di_tg_ctrl_n VDD sg13_lv_pmos ad=0.57p pd=3.38u as=0.57p ps=3.38u w=3u l=0.13u
X720 vinn_IF iqmod_mixer_pex_half_0.iqmod_mixer_pex_tg_0.di_tg_ctrl_n voutn_RF VDD sg13_lv_pmos ad=1.71p pd=9.38u as=1.71p ps=9.38u w=9u l=0.13u
X721 iqmod_mixer_pex_half_0.iqmod_mixer_pex_se2diff_0.iqmod_mixer_pex_se2diff_half_inv$1_0.iqmod_mixer_pex_se2diff_inv_NF6$5_1.vout iqmod_mixer_pex_half_0.iqmod_mixer_pex_se2diff_0.iqmod_mixer_pex_se2diff_half_inv$1_0.iqmod_mixer_pex_se2diff_inv_NF6$5_2.vout VDD VDD sg13_lv_pmos ad=0.57p pd=3.38u as=0.57p ps=3.38u w=3u l=0.13u
X722 voutp_RF iqmod_mixer_pex_half_1.iqmod_mixer_pex_tg_0.di_tg_ctrl_n vinp_IF VDD sg13_lv_pmos ad=1.71p pd=9.38u as=1.71p ps=9.38u w=9u l=0.13u
X723 iqmod_mixer_pex_half_1.iqmod_mixer_pex_se2diff_0.iqmod_mixer_pex_se2diff_half_inv$1_0.iqmod_mixer_pex_se2diff_inv_NF2$5_0.vout VDD iqmod_mixer_pex_half_1.iqmod_mixer_pex_se2diff_0.iqmod_mixer_pex_se2diff_half_tg$1_0.iqmod_mixer_pex_se2diff_tg_NF6$2_0.v_b VSS sg13_lv_nmos ad=0.19p pd=1.38u as=0.19p ps=1.38u w=1u l=0.13u
X724 voutp_RF iqmod_mixer_pex_half_1.iqmod_mixer_pex_tg_0.di_tg_ctrl voutp_RF VDD sg13_lv_pmos ad=1.71p pd=9.38u as=0 ps=0 w=9u l=0.13u
X725 VDD iqmod_mixer_pex_half_1.iqmod_mixer_pex_se2diff_0.iqmod_mixer_pex_se2diff_half_tg$1_0.iqmod_mixer_pex_se2diff_inv_NF18$4_0.vout iqmod_mixer_pex_half_1.iqmod_mixer_pex_tg_0.di_tg_ctrl_n VDD sg13_lv_pmos ad=0.57p pd=3.38u as=0.57p ps=3.38u w=3u l=0.13u
X726 VDD VDD VDD VDD sg13_lv_pmos ad=1.02p pd=6.68u as=0 ps=0 w=3u l=0.13u
X727 iqmod_mixer_pex_half_0.iqmod_mixer_pex_tg_0.di_tg_ctrl iqmod_mixer_pex_half_0.iqmod_mixer_pex_se2diff_0.iqmod_mixer_pex_se2diff_half_inv$1_0.iqmod_mixer_pex_se2diff_inv_NF18$5_0.vout VDD VDD sg13_lv_pmos ad=0.57p pd=3.38u as=0.57p ps=3.38u w=3u l=0.13u
X728 VDD iqmod_mixer_pex_half_0.iqmod_mixer_pex_se2diff_0.iqmod_mixer_pex_se2diff_half_inv$1_0.iqmod_mixer_pex_se2diff_inv_NF2$5_1.vout iqmod_mixer_pex_half_0.iqmod_mixer_pex_se2diff_0.iqmod_mixer_pex_se2diff_half_tg$1_0.iqmod_mixer_pex_se2diff_inv_NF6$4_0.vout VDD sg13_lv_pmos ad=0.57p pd=3.38u as=0.57p ps=3.38u w=3u l=0.13u
X729 iqmod_mixer_pex_half_0.iqmod_mixer_pex_se2diff_0.iqmod_mixer_pex_se2diff_half_tg$1_0.iqmod_mixer_pex_se2diff_inv_NF18$4_0.vout iqmod_mixer_pex_half_0.iqmod_mixer_pex_se2diff_0.iqmod_mixer_pex_se2diff_half_tg$1_0.iqmod_mixer_pex_se2diff_inv_NF6$4_0.vout VDD VDD sg13_lv_pmos ad=0.57p pd=3.38u as=0.57p ps=3.38u w=3u l=0.13u
X730 VDD iqmod_mixer_pex_half_0.iqmod_mixer_pex_se2diff_0.iqmod_mixer_pex_se2diff_half_tg$1_0.iqmod_mixer_pex_se2diff_inv_NF18$4_0.vout iqmod_mixer_pex_half_0.iqmod_mixer_pex_tg_0.di_tg_ctrl_n VDD sg13_lv_pmos ad=0.57p pd=3.38u as=0.57p ps=3.38u w=3u l=0.13u
X731 VDD iqmod_mixer_pex_half_1.iqmod_mixer_pex_se2diff_0.iqmod_mixer_pex_se2diff_half_inv$1_0.iqmod_mixer_pex_se2diff_inv_NF6$5_1.vout iqmod_mixer_pex_half_1.iqmod_mixer_pex_se2diff_0.iqmod_mixer_pex_se2diff_half_inv$1_0.iqmod_mixer_pex_se2diff_inv_NF18$5_0.vout VDD sg13_lv_pmos ad=0.57p pd=3.38u as=0.57p ps=3.38u w=3u l=0.13u
X732 iqmod_mixer_pex_half_1.iqmod_mixer_pex_se2diff_0.iqmod_mixer_pex_se2diff_half_tg$1_0.iqmod_mixer_pex_se2diff_tg_NF6$2_0.v_b VDD iqmod_mixer_pex_half_1.iqmod_mixer_pex_se2diff_0.iqmod_mixer_pex_se2diff_half_inv$1_0.iqmod_mixer_pex_se2diff_inv_NF2$5_0.vout VSS sg13_lv_nmos ad=0.19p pd=1.38u as=0.34p ps=2.68u w=1u l=0.13u
X733 iqmod_mixer_pex_half_1.iqmod_mixer_pex_tg_0.di_tg_ctrl_n iqmod_mixer_pex_half_1.iqmod_mixer_pex_se2diff_0.iqmod_mixer_pex_se2diff_half_tg$1_0.iqmod_mixer_pex_se2diff_inv_NF18$4_0.vout VDD VDD sg13_lv_pmos ad=0.57p pd=3.38u as=0.57p ps=3.38u w=3u l=0.13u
X734 voutp_RF iqmod_mixer_pex_half_1.iqmod_mixer_pex_tg_0.di_tg_ctrl_n vinp_IF VDD sg13_lv_pmos ad=1.71p pd=9.38u as=1.71p ps=9.38u w=9u l=0.13u
X735 voutp_RF iqmod_mixer_pex_half_1.iqmod_mixer_pex_tg_0.di_tg_ctrl_n voutp_RF VSS sg13_lv_nmos ad=0.57p pd=3.38u as=0 ps=0 w=3u l=0.13u
X736 VDD iqmod_mixer_pex_half_1.iqmod_mixer_pex_se2diff_0.iqmod_mixer_pex_se2diff_half_inv$1_0.iqmod_mixer_pex_se2diff_inv_NF18$5_0.vout iqmod_mixer_pex_half_1.iqmod_mixer_pex_tg_0.di_tg_ctrl VDD sg13_lv_pmos ad=0.57p pd=3.38u as=0.57p ps=3.38u w=3u l=0.13u
X737 VDD VDD VDD VDD sg13_lv_pmos ad=0.57p pd=3.38u as=0 ps=0 w=3u l=0.13u
X738 VDD iqmod_mixer_pex_half_0.iqmod_mixer_pex_se2diff_0.iqmod_mixer_pex_se2diff_half_tg$1_0.iqmod_mixer_pex_se2diff_inv_NF18$4_0.vout iqmod_mixer_pex_half_0.iqmod_mixer_pex_tg_0.di_tg_ctrl_n VDD sg13_lv_pmos ad=0.57p pd=3.38u as=0.57p ps=3.38u w=3u l=0.13u
X739 vinn_IF iqmod_mixer_pex_half_0.iqmod_mixer_pex_tg_0.di_tg_ctrl_n voutn_RF VDD sg13_lv_pmos ad=1.71p pd=9.38u as=1.71p ps=9.38u w=9u l=0.13u
X740 VSS iqmod_mixer_pex_half_1.iqmod_mixer_pex_se2diff_0.iqmod_mixer_pex_se2diff_half_tg$1_0.iqmod_mixer_pex_se2diff_inv_NF18$4_0.vout iqmod_mixer_pex_half_1.iqmod_mixer_pex_tg_0.di_tg_ctrl_n VSS sg13_lv_nmos ad=0.19p pd=1.38u as=0.19p ps=1.38u w=1u l=0.13u
X741 VSS iqmod_mixer_pex_half_1.iqmod_mixer_pex_se2diff_0.iqmod_mixer_pex_se2diff_half_tg$1_0.iqmod_mixer_pex_se2diff_inv_NF18$4_0.vout iqmod_mixer_pex_half_1.iqmod_mixer_pex_tg_0.di_tg_ctrl_n VSS sg13_lv_nmos ad=0.19p pd=1.38u as=0.19p ps=1.38u w=1u l=0.13u
X742 voutp_RF iqmod_mixer_pex_half_1.iqmod_mixer_pex_tg_0.di_tg_ctrl_n voutp_RF VSS sg13_lv_nmos ad=0.57p pd=3.38u as=0 ps=0 w=3u l=0.13u
X743 iqmod_mixer_pex_half_1.iqmod_mixer_pex_tg_0.di_tg_ctrl iqmod_mixer_pex_half_1.iqmod_mixer_pex_se2diff_0.iqmod_mixer_pex_se2diff_half_inv$1_0.iqmod_mixer_pex_se2diff_inv_NF18$5_0.vout VDD VDD sg13_lv_pmos ad=0.57p pd=3.38u as=0.57p ps=3.38u w=3u l=0.13u
X744 iqmod_mixer_pex_half_1.iqmod_mixer_pex_tg_0.di_tg_ctrl_n iqmod_mixer_pex_half_1.iqmod_mixer_pex_se2diff_0.iqmod_mixer_pex_se2diff_half_tg$1_0.iqmod_mixer_pex_se2diff_inv_NF18$4_0.vout VSS VSS sg13_lv_nmos ad=0.19p pd=1.38u as=0.19p ps=1.38u w=1u l=0.13u
X745 voutp_RF iqmod_mixer_pex_half_1.iqmod_mixer_pex_tg_0.di_tg_ctrl vinp_IF VSS sg13_lv_nmos ad=0.57p pd=3.38u as=0.57p ps=3.38u w=3u l=0.13u
X746 voutn_RF iqmod_mixer_pex_half_0.iqmod_mixer_pex_tg_0.di_tg_ctrl_n voutn_RF VSS sg13_lv_nmos ad=0.57p pd=3.38u as=0 ps=0 w=3u l=0.13u
X747 iqmod_mixer_pex_half_1.iqmod_mixer_pex_tg_0.di_tg_ctrl_n iqmod_mixer_pex_half_1.iqmod_mixer_pex_se2diff_0.iqmod_mixer_pex_se2diff_half_tg$1_0.iqmod_mixer_pex_se2diff_inv_NF18$4_0.vout VSS VSS sg13_lv_nmos ad=0.19p pd=1.38u as=0.19p ps=1.38u w=1u l=0.13u
X748 iqmod_mixer_pex_half_0.iqmod_mixer_pex_se2diff_0.iqmod_mixer_pex_se2diff_half_inv$1_0.iqmod_mixer_pex_se2diff_inv_NF6$5_2.vout iqmod_mixer_pex_half_0.iqmod_mixer_pex_se2diff_0.iqmod_mixer_pex_se2diff_half_inv$1_0.iqmod_mixer_pex_se2diff_inv_NF6$5_2.vin VDD VDD sg13_lv_pmos ad=0.57p pd=3.38u as=0.57p ps=3.38u w=3u l=0.13u
X749 vinp_IF iqmod_mixer_pex_half_1.iqmod_mixer_pex_tg_0.di_tg_ctrl voutp_RF VSS sg13_lv_nmos ad=0.57p pd=3.38u as=0.57p ps=3.38u w=3u l=0.13u
X750 VDD iqmod_mixer_pex_half_0.iqmod_mixer_pex_se2diff_0.iqmod_mixer_pex_se2diff_half_inv$1_0.iqmod_mixer_pex_se2diff_inv_NF2$5_0.vout iqmod_mixer_pex_half_0.iqmod_mixer_pex_se2diff_0.iqmod_mixer_pex_se2diff_half_inv$1_0.iqmod_mixer_pex_se2diff_inv_NF6$5_2.vin VDD sg13_lv_pmos ad=0.57p pd=3.38u as=0.57p ps=3.38u w=3u l=0.13u
X751 VSS iqmod_mixer_pex_half_1.iqmod_mixer_pex_se2diff_0.iqmod_mixer_pex_se2diff_half_tg$1_0.iqmod_mixer_pex_se2diff_inv_NF18$4_0.vout iqmod_mixer_pex_half_1.iqmod_mixer_pex_tg_0.di_tg_ctrl_n VSS sg13_lv_nmos ad=0.19p pd=1.38u as=0.19p ps=1.38u w=1u l=0.13u
X752 iqmod_mixer_pex_half_1.iqmod_mixer_pex_se2diff_0.iqmod_mixer_pex_se2diff_half_inv$1_0.iqmod_mixer_pex_se2diff_inv_NF18$5_0.vout iqmod_mixer_pex_half_1.iqmod_mixer_pex_se2diff_0.iqmod_mixer_pex_se2diff_half_inv$1_0.iqmod_mixer_pex_se2diff_inv_NF6$5_1.vout VSS VSS sg13_lv_nmos ad=0.19p pd=1.38u as=0.19p ps=1.38u w=1u l=0.13u
X753 VDD VDD VDD VDD sg13_lv_pmos ad=1.02p pd=6.68u as=0 ps=0 w=3u l=0.13u
X754 voutn_RF iqmod_mixer_pex_half_0.iqmod_mixer_pex_tg_0.di_tg_ctrl_n voutn_RF VSS sg13_lv_nmos ad=0.57p pd=3.38u as=0 ps=0 w=3u l=0.13u
X755 VSS iqmod_mixer_pex_half_1.iqmod_mixer_pex_se2diff_0.iqmod_mixer_pex_se2diff_half_inv$1_0.iqmod_mixer_pex_se2diff_inv_NF6$5_1.vout iqmod_mixer_pex_half_1.iqmod_mixer_pex_se2diff_0.iqmod_mixer_pex_se2diff_half_inv$1_0.iqmod_mixer_pex_se2diff_inv_NF18$5_0.vout VSS sg13_lv_nmos ad=0.19p pd=1.38u as=0.19p ps=1.38u w=1u l=0.13u
X756 VDD iqmod_mixer_pex_half_0.iqmod_mixer_pex_se2diff_0.iqmod_mixer_pex_se2diff_half_tg$1_0.iqmod_mixer_pex_se2diff_tg_NF6$2_0.v_b iqmod_mixer_pex_half_0.iqmod_mixer_pex_se2diff_0.iqmod_mixer_pex_se2diff_half_inv$1_0.iqmod_mixer_pex_se2diff_inv_NF2$5_1.vout VDD sg13_lv_pmos ad=0.57p pd=3.38u as=0.57p ps=3.38u w=3u l=0.13u
X757 iqmod_mixer_pex_half_0.iqmod_mixer_pex_se2diff_0.iqmod_mixer_pex_se2diff_half_inv$1_0.iqmod_mixer_pex_se2diff_inv_NF6$5_2.vout iqmod_mixer_pex_half_0.iqmod_mixer_pex_se2diff_0.iqmod_mixer_pex_se2diff_half_inv$1_0.iqmod_mixer_pex_se2diff_inv_NF6$5_2.vin VDD VDD sg13_lv_pmos ad=0.57p pd=3.38u as=0.57p ps=3.38u w=3u l=0.13u
X758 VDD iqmod_mixer_pex_half_0.iqmod_mixer_pex_se2diff_0.iqmod_mixer_pex_se2diff_half_inv$1_0.iqmod_mixer_pex_se2diff_inv_NF2$5_0.vout iqmod_mixer_pex_half_0.iqmod_mixer_pex_se2diff_0.iqmod_mixer_pex_se2diff_half_inv$1_0.iqmod_mixer_pex_se2diff_inv_NF6$5_2.vin VDD sg13_lv_pmos ad=0.57p pd=3.38u as=0.57p ps=3.38u w=3u l=0.13u
X759 VSS VSS VSS VSS sg13_lv_nmos ad=0.19p pd=1.38u as=0 ps=0 w=1u l=0.13u
X760 iqmod_mixer_pex_half_0.iqmod_mixer_pex_tg_0.di_tg_ctrl_n iqmod_mixer_pex_half_0.iqmod_mixer_pex_se2diff_0.iqmod_mixer_pex_se2diff_half_tg$1_0.iqmod_mixer_pex_se2diff_inv_NF18$4_0.vout VSS VSS sg13_lv_nmos ad=0.19p pd=1.38u as=0.19p ps=1.38u w=1u l=0.13u
X761 VSS vinp_LO iqmod_mixer_pex_half_1.iqmod_mixer_pex_se2diff_0.iqmod_mixer_pex_se2diff_half_inv$1_0.iqmod_mixer_pex_se2diff_inv_NF2$5_0.vout VSS sg13_lv_nmos ad=0.19p pd=1.38u as=0.19p ps=1.38u w=1u l=0.13u
X762 voutp_RF iqmod_mixer_pex_half_1.iqmod_mixer_pex_tg_0.di_tg_ctrl_n voutp_RF VSS sg13_lv_nmos ad=0.57p pd=3.38u as=0 ps=0 w=3u l=0.13u
X763 iqmod_mixer_pex_half_1.iqmod_mixer_pex_se2diff_0.iqmod_mixer_pex_se2diff_half_inv$1_0.iqmod_mixer_pex_se2diff_inv_NF18$5_0.vout iqmod_mixer_pex_half_1.iqmod_mixer_pex_se2diff_0.iqmod_mixer_pex_se2diff_half_inv$1_0.iqmod_mixer_pex_se2diff_inv_NF6$5_1.vout VSS VSS sg13_lv_nmos ad=0.19p pd=1.38u as=0.19p ps=1.38u w=1u l=0.13u
X764 VDD iqmod_mixer_pex_half_1.iqmod_mixer_pex_se2diff_0.iqmod_mixer_pex_se2diff_half_tg$1_0.iqmod_mixer_pex_se2diff_inv_NF18$4_0.vout iqmod_mixer_pex_half_1.iqmod_mixer_pex_tg_0.di_tg_ctrl_n VDD sg13_lv_pmos ad=0.57p pd=3.38u as=0.57p ps=3.38u w=3u l=0.13u
X765 voutn_RF iqmod_mixer_pex_half_0.iqmod_mixer_pex_tg_0.di_tg_ctrl vinn_IF VSS sg13_lv_nmos ad=0.57p pd=3.38u as=0.57p ps=3.38u w=3u l=0.13u
X766 VSS iqmod_mixer_pex_half_1.iqmod_mixer_pex_se2diff_0.iqmod_mixer_pex_se2diff_half_inv$1_0.iqmod_mixer_pex_se2diff_inv_NF18$5_0.vout iqmod_mixer_pex_half_1.iqmod_mixer_pex_tg_0.di_tg_ctrl VSS sg13_lv_nmos ad=0.19p pd=1.38u as=0.19p ps=1.38u w=1u l=0.13u
X767 iqmod_mixer_pex_half_1.iqmod_mixer_pex_tg_0.di_tg_ctrl_n iqmod_mixer_pex_half_1.iqmod_mixer_pex_se2diff_0.iqmod_mixer_pex_se2diff_half_tg$1_0.iqmod_mixer_pex_se2diff_inv_NF18$4_0.vout VSS VSS sg13_lv_nmos ad=0.19p pd=1.38u as=0.19p ps=1.38u w=1u l=0.13u
X768 VDD iqmod_mixer_pex_half_0.iqmod_mixer_pex_se2diff_0.iqmod_mixer_pex_se2diff_half_tg$1_0.iqmod_mixer_pex_se2diff_tg_NF6$2_0.v_b iqmod_mixer_pex_half_0.iqmod_mixer_pex_se2diff_0.iqmod_mixer_pex_se2diff_half_inv$1_0.iqmod_mixer_pex_se2diff_inv_NF2$5_1.vout VDD sg13_lv_pmos ad=0.57p pd=3.38u as=0.57p ps=3.38u w=3u l=0.13u
X769 iqmod_mixer_pex_half_0.iqmod_mixer_pex_se2diff_0.iqmod_mixer_pex_se2diff_half_inv$1_0.iqmod_mixer_pex_se2diff_inv_NF6$5_2.vout iqmod_mixer_pex_half_0.iqmod_mixer_pex_se2diff_0.iqmod_mixer_pex_se2diff_half_inv$1_0.iqmod_mixer_pex_se2diff_inv_NF2$5_1.vout VDD VDD sg13_lv_pmos ad=0.57p pd=3.38u as=0.57p ps=3.38u w=3u l=0.13u
X770 iqmod_mixer_pex_half_0.iqmod_mixer_pex_se2diff_0.iqmod_mixer_pex_se2diff_half_tg$1_0.iqmod_mixer_pex_se2diff_tg_NF6$2_0.v_b VSS iqmod_mixer_pex_half_0.iqmod_mixer_pex_se2diff_0.iqmod_mixer_pex_se2diff_half_inv$1_0.iqmod_mixer_pex_se2diff_inv_NF2$5_0.vout VDD sg13_lv_pmos ad=0.57p pd=3.38u as=0.57p ps=3.38u w=3u l=0.13u
X771 VDD iqmod_mixer_pex_half_1.iqmod_mixer_pex_se2diff_0.iqmod_mixer_pex_se2diff_half_inv$1_0.iqmod_mixer_pex_se2diff_inv_NF2$5_0.vout iqmod_mixer_pex_half_1.iqmod_mixer_pex_se2diff_0.iqmod_mixer_pex_se2diff_half_inv$1_0.iqmod_mixer_pex_se2diff_inv_NF6$5_2.vin VDD sg13_lv_pmos ad=0.57p pd=3.38u as=0.57p ps=3.38u w=3u l=0.13u
X772 VSS iqmod_mixer_pex_half_0.iqmod_mixer_pex_se2diff_0.iqmod_mixer_pex_se2diff_half_tg$1_0.iqmod_mixer_pex_se2diff_inv_NF6$4_0.vout iqmod_mixer_pex_half_0.iqmod_mixer_pex_se2diff_0.iqmod_mixer_pex_se2diff_half_tg$1_0.iqmod_mixer_pex_se2diff_inv_NF18$4_0.vout VSS sg13_lv_nmos ad=0.19p pd=1.38u as=0.19p ps=1.38u w=1u l=0.13u
X773 iqmod_mixer_pex_half_0.iqmod_mixer_pex_tg_0.di_tg_ctrl_n iqmod_mixer_pex_half_0.iqmod_mixer_pex_se2diff_0.iqmod_mixer_pex_se2diff_half_tg$1_0.iqmod_mixer_pex_se2diff_inv_NF18$4_0.vout VSS VSS sg13_lv_nmos ad=0.19p pd=1.38u as=0.19p ps=1.38u w=1u l=0.13u
X774 voutn_RF iqmod_mixer_pex_half_0.iqmod_mixer_pex_tg_0.di_tg_ctrl vinn_IF VSS sg13_lv_nmos ad=0.57p pd=3.38u as=0.57p ps=3.38u w=3u l=0.13u
X775 iqmod_mixer_pex_half_1.iqmod_mixer_pex_se2diff_0.iqmod_mixer_pex_se2diff_half_inv$1_0.iqmod_mixer_pex_se2diff_inv_NF6$5_2.vin iqmod_mixer_pex_half_1.iqmod_mixer_pex_se2diff_0.iqmod_mixer_pex_se2diff_half_inv$1_0.iqmod_mixer_pex_se2diff_inv_NF2$5_0.vout VDD VDD sg13_lv_pmos ad=0.57p pd=3.38u as=0.57p ps=3.38u w=3u l=0.13u
X776 VSS VSS VSS VSS sg13_lv_nmos ad=0.19p pd=1.38u as=0 ps=0 w=1u l=0.13u
X777 VSS VSS VSS VSS sg13_lv_nmos ad=0.19p pd=1.38u as=0 ps=0 w=1u l=0.13u
X778 VSS iqmod_mixer_pex_half_1.iqmod_mixer_pex_se2diff_0.iqmod_mixer_pex_se2diff_half_inv$1_0.iqmod_mixer_pex_se2diff_inv_NF6$5_2.vout iqmod_mixer_pex_half_1.iqmod_mixer_pex_se2diff_0.iqmod_mixer_pex_se2diff_half_inv$1_0.iqmod_mixer_pex_se2diff_inv_NF2$5_1.vout VSS sg13_lv_nmos ad=0.19p pd=1.38u as=0.19p ps=1.38u w=1u l=0.13u
X779 VSS iqmod_mixer_pex_half_0.iqmod_mixer_pex_se2diff_0.iqmod_mixer_pex_se2diff_half_tg$1_0.iqmod_mixer_pex_se2diff_inv_NF18$4_0.vout iqmod_mixer_pex_half_0.iqmod_mixer_pex_tg_0.di_tg_ctrl_n VSS sg13_lv_nmos ad=0.19p pd=1.38u as=0.19p ps=1.38u w=1u l=0.13u
X780 voutn_RF iqmod_mixer_pex_half_0.iqmod_mixer_pex_tg_0.di_tg_ctrl vinn_IF VSS sg13_lv_nmos ad=0.57p pd=3.38u as=0.57p ps=3.38u w=3u l=0.13u
X781 VDD iqmod_mixer_pex_half_1.iqmod_mixer_pex_se2diff_0.iqmod_mixer_pex_se2diff_half_inv$1_0.iqmod_mixer_pex_se2diff_inv_NF18$5_0.vout iqmod_mixer_pex_half_1.iqmod_mixer_pex_tg_0.di_tg_ctrl VDD sg13_lv_pmos ad=0.57p pd=3.38u as=0.57p ps=3.38u w=3u l=0.13u
X782 VDD iqmod_mixer_pex_half_0.iqmod_mixer_pex_se2diff_0.iqmod_mixer_pex_se2diff_half_tg$1_0.iqmod_mixer_pex_se2diff_inv_NF6$4_0.vout iqmod_mixer_pex_half_0.iqmod_mixer_pex_se2diff_0.iqmod_mixer_pex_se2diff_half_tg$1_0.iqmod_mixer_pex_se2diff_inv_NF18$4_0.vout VDD sg13_lv_pmos ad=0.57p pd=3.38u as=0.57p ps=3.38u w=3u l=0.13u
X783 iqmod_mixer_pex_half_0.iqmod_mixer_pex_tg_0.di_tg_ctrl_n iqmod_mixer_pex_half_0.iqmod_mixer_pex_se2diff_0.iqmod_mixer_pex_se2diff_half_tg$1_0.iqmod_mixer_pex_se2diff_inv_NF18$4_0.vout VDD VDD sg13_lv_pmos ad=0.57p pd=3.38u as=0.57p ps=3.38u w=3u l=0.13u
X784 iqmod_mixer_pex_half_0.iqmod_mixer_pex_tg_0.di_tg_ctrl_n iqmod_mixer_pex_half_0.iqmod_mixer_pex_se2diff_0.iqmod_mixer_pex_se2diff_half_tg$1_0.iqmod_mixer_pex_se2diff_inv_NF18$4_0.vout VSS VSS sg13_lv_nmos ad=0.19p pd=1.38u as=0.19p ps=1.38u w=1u l=0.13u
X785 iqmod_mixer_pex_half_1.iqmod_mixer_pex_tg_0.di_tg_ctrl iqmod_mixer_pex_half_1.iqmod_mixer_pex_se2diff_0.iqmod_mixer_pex_se2diff_half_inv$1_0.iqmod_mixer_pex_se2diff_inv_NF18$5_0.vout VDD VDD sg13_lv_pmos ad=0.57p pd=3.38u as=0.57p ps=3.38u w=3u l=0.13u
X786 VSS VSS VSS VSS sg13_lv_nmos ad=0.19p pd=1.38u as=0 ps=0 w=1u l=0.13u
X787 VSS iqmod_mixer_pex_half_1.iqmod_mixer_pex_se2diff_0.iqmod_mixer_pex_se2diff_half_tg$1_0.iqmod_mixer_pex_se2diff_inv_NF6$4_0.vout iqmod_mixer_pex_half_1.iqmod_mixer_pex_se2diff_0.iqmod_mixer_pex_se2diff_half_tg$1_0.iqmod_mixer_pex_se2diff_inv_NF18$4_0.vout VSS sg13_lv_nmos ad=0.19p pd=1.38u as=0.19p ps=1.38u w=1u l=0.13u
X788 voutp_RF iqmod_mixer_pex_half_1.iqmod_mixer_pex_tg_0.di_tg_ctrl_n vinp_IF VDD sg13_lv_pmos ad=1.71p pd=9.38u as=1.71p ps=9.38u w=9u l=0.13u
X789 iqmod_mixer_pex_half_1.iqmod_mixer_pex_tg_0.di_tg_ctrl_n iqmod_mixer_pex_half_1.iqmod_mixer_pex_se2diff_0.iqmod_mixer_pex_se2diff_half_tg$1_0.iqmod_mixer_pex_se2diff_inv_NF18$4_0.vout VDD VDD sg13_lv_pmos ad=0.57p pd=3.38u as=0.57p ps=3.38u w=3u l=0.13u
X790 iqmod_mixer_pex_half_0.iqmod_mixer_pex_tg_0.di_tg_ctrl iqmod_mixer_pex_half_0.iqmod_mixer_pex_se2diff_0.iqmod_mixer_pex_se2diff_half_inv$1_0.iqmod_mixer_pex_se2diff_inv_NF18$5_0.vout VSS VSS sg13_lv_nmos ad=0.19p pd=1.38u as=0.19p ps=1.38u w=1u l=0.13u
X791 voutn_RF iqmod_mixer_pex_half_0.iqmod_mixer_pex_tg_0.di_tg_ctrl vinn_IF VSS sg13_lv_nmos ad=0.57p pd=3.38u as=0.57p ps=3.38u w=3u l=0.13u
X792 VDD iqmod_mixer_pex_half_1.iqmod_mixer_pex_se2diff_0.iqmod_mixer_pex_se2diff_half_tg$1_0.iqmod_mixer_pex_se2diff_inv_NF18$4_0.vout iqmod_mixer_pex_half_1.iqmod_mixer_pex_tg_0.di_tg_ctrl_n VDD sg13_lv_pmos ad=0.57p pd=3.38u as=0.57p ps=3.38u w=3u l=0.13u
X793 iqmod_mixer_pex_half_0.iqmod_mixer_pex_tg_0.di_tg_ctrl_n iqmod_mixer_pex_half_0.iqmod_mixer_pex_se2diff_0.iqmod_mixer_pex_se2diff_half_tg$1_0.iqmod_mixer_pex_se2diff_inv_NF18$4_0.vout VDD VDD sg13_lv_pmos ad=0.57p pd=3.38u as=0.57p ps=3.38u w=3u l=0.13u
X794 iqmod_mixer_pex_half_0.iqmod_mixer_pex_tg_0.di_tg_ctrl iqmod_mixer_pex_half_0.iqmod_mixer_pex_se2diff_0.iqmod_mixer_pex_se2diff_half_inv$1_0.iqmod_mixer_pex_se2diff_inv_NF18$5_0.vout VSS VSS sg13_lv_nmos ad=0.19p pd=1.38u as=0.19p ps=1.38u w=1u l=0.13u
X795 vinp_IF iqmod_mixer_pex_half_1.iqmod_mixer_pex_tg_0.di_tg_ctrl_n voutp_RF VDD sg13_lv_pmos ad=1.71p pd=9.38u as=1.71p ps=9.38u w=9u l=0.13u
X796 iqmod_mixer_pex_half_0.iqmod_mixer_pex_se2diff_0.iqmod_mixer_pex_se2diff_half_tg$1_0.iqmod_mixer_pex_se2diff_inv_NF6$4_0.vout iqmod_mixer_pex_half_0.iqmod_mixer_pex_se2diff_0.iqmod_mixer_pex_se2diff_half_inv$1_0.iqmod_mixer_pex_se2diff_inv_NF2$5_1.vout VDD VDD sg13_lv_pmos ad=0.57p pd=3.38u as=0.57p ps=3.38u w=3u l=0.13u
X797 VDD iqmod_mixer_pex_half_0.iqmod_mixer_pex_se2diff_0.iqmod_mixer_pex_se2diff_half_tg$1_0.iqmod_mixer_pex_se2diff_inv_NF6$4_0.vout iqmod_mixer_pex_half_0.iqmod_mixer_pex_se2diff_0.iqmod_mixer_pex_se2diff_half_tg$1_0.iqmod_mixer_pex_se2diff_inv_NF18$4_0.vout VDD sg13_lv_pmos ad=0.57p pd=3.38u as=0.57p ps=3.38u w=3u l=0.13u
X798 voutp_RF iqmod_mixer_pex_half_1.iqmod_mixer_pex_tg_0.di_tg_ctrl_n vinp_IF VDD sg13_lv_pmos ad=1.71p pd=9.38u as=1.71p ps=9.38u w=9u l=0.13u
X799 iqmod_mixer_pex_half_1.iqmod_mixer_pex_se2diff_0.iqmod_mixer_pex_se2diff_half_inv$1_0.iqmod_mixer_pex_se2diff_inv_NF2$5_1.vout iqmod_mixer_pex_half_1.iqmod_mixer_pex_se2diff_0.iqmod_mixer_pex_se2diff_half_tg$1_0.iqmod_mixer_pex_se2diff_tg_NF6$2_0.v_b VSS VSS sg13_lv_nmos ad=0.19p pd=1.38u as=0.19p ps=1.38u w=1u l=0.13u
X800 iqmod_mixer_pex_half_0.iqmod_mixer_pex_tg_0.di_tg_ctrl iqmod_mixer_pex_half_0.iqmod_mixer_pex_se2diff_0.iqmod_mixer_pex_se2diff_half_inv$1_0.iqmod_mixer_pex_se2diff_inv_NF18$5_0.vout VSS VSS sg13_lv_nmos ad=0.19p pd=1.38u as=0.19p ps=1.38u w=1u l=0.13u
X801 iqmod_mixer_pex_half_0.iqmod_mixer_pex_tg_0.di_tg_ctrl iqmod_mixer_pex_half_0.iqmod_mixer_pex_se2diff_0.iqmod_mixer_pex_se2diff_half_inv$1_0.iqmod_mixer_pex_se2diff_inv_NF18$5_0.vout VSS VSS sg13_lv_nmos ad=0.19p pd=1.38u as=0.19p ps=1.38u w=1u l=0.13u
X802 iqmod_mixer_pex_half_0.iqmod_mixer_pex_tg_0.di_tg_ctrl iqmod_mixer_pex_half_0.iqmod_mixer_pex_se2diff_0.iqmod_mixer_pex_se2diff_half_inv$1_0.iqmod_mixer_pex_se2diff_inv_NF18$5_0.vout VSS VSS sg13_lv_nmos ad=0.19p pd=1.38u as=0.19p ps=1.38u w=1u l=0.13u
X803 VSS iqmod_mixer_pex_half_0.iqmod_mixer_pex_se2diff_0.iqmod_mixer_pex_se2diff_half_inv$1_0.iqmod_mixer_pex_se2diff_inv_NF6$5_1.vout iqmod_mixer_pex_half_0.iqmod_mixer_pex_se2diff_0.iqmod_mixer_pex_se2diff_half_inv$1_0.iqmod_mixer_pex_se2diff_inv_NF18$5_0.vout VSS sg13_lv_nmos ad=0.19p pd=1.38u as=0.19p ps=1.38u w=1u l=0.13u
X804 VDD iqmod_mixer_pex_half_1.iqmod_mixer_pex_se2diff_0.iqmod_mixer_pex_se2diff_half_inv$1_0.iqmod_mixer_pex_se2diff_inv_NF18$5_0.vout iqmod_mixer_pex_half_1.iqmod_mixer_pex_tg_0.di_tg_ctrl VDD sg13_lv_pmos ad=0.57p pd=3.38u as=0.57p ps=3.38u w=3u l=0.13u
X805 VSS iqmod_mixer_pex_half_1.iqmod_mixer_pex_se2diff_0.iqmod_mixer_pex_se2diff_half_tg$1_0.iqmod_mixer_pex_se2diff_inv_NF18$4_0.vout iqmod_mixer_pex_half_1.iqmod_mixer_pex_tg_0.di_tg_ctrl_n VSS sg13_lv_nmos ad=0.19p pd=1.38u as=0.19p ps=1.38u w=1u l=0.13u
X806 iqmod_mixer_pex_half_0.iqmod_mixer_pex_tg_0.di_tg_ctrl_n iqmod_mixer_pex_half_0.iqmod_mixer_pex_se2diff_0.iqmod_mixer_pex_se2diff_half_tg$1_0.iqmod_mixer_pex_se2diff_inv_NF18$4_0.vout VDD VDD sg13_lv_pmos ad=0.57p pd=3.38u as=0.57p ps=3.38u w=3u l=0.13u
X807 iqmod_mixer_pex_half_0.iqmod_mixer_pex_se2diff_0.iqmod_mixer_pex_se2diff_half_inv$1_0.iqmod_mixer_pex_se2diff_inv_NF6$5_1.vout iqmod_mixer_pex_half_0.iqmod_mixer_pex_se2diff_0.iqmod_mixer_pex_se2diff_half_inv$1_0.iqmod_mixer_pex_se2diff_inv_NF6$5_2.vout VSS VSS sg13_lv_nmos ad=0.19p pd=1.38u as=0.19p ps=1.38u w=1u l=0.13u
X808 iqmod_mixer_pex_half_1.iqmod_mixer_pex_tg_0.di_tg_ctrl iqmod_mixer_pex_half_1.iqmod_mixer_pex_se2diff_0.iqmod_mixer_pex_se2diff_half_inv$1_0.iqmod_mixer_pex_se2diff_inv_NF18$5_0.vout VDD VDD sg13_lv_pmos ad=0.57p pd=3.38u as=0.57p ps=3.38u w=3u l=0.13u
X809 VSS iqmod_mixer_pex_half_1.iqmod_mixer_pex_se2diff_0.iqmod_mixer_pex_se2diff_half_tg$1_0.iqmod_mixer_pex_se2diff_tg_NF6$2_0.v_b iqmod_mixer_pex_half_1.iqmod_mixer_pex_se2diff_0.iqmod_mixer_pex_se2diff_half_inv$1_0.iqmod_mixer_pex_se2diff_inv_NF2$5_1.vout VSS sg13_lv_nmos ad=0.19p pd=1.38u as=0.19p ps=1.38u w=1u l=0.13u
X810 iqmod_mixer_pex_half_1.iqmod_mixer_pex_tg_0.di_tg_ctrl iqmod_mixer_pex_half_1.iqmod_mixer_pex_se2diff_0.iqmod_mixer_pex_se2diff_half_inv$1_0.iqmod_mixer_pex_se2diff_inv_NF18$5_0.vout VDD VDD sg13_lv_pmos ad=0.57p pd=3.38u as=0.57p ps=3.38u w=3u l=0.13u
X811 voutp_RF iqmod_mixer_pex_half_1.iqmod_mixer_pex_tg_0.di_tg_ctrl vinp_IF VSS sg13_lv_nmos ad=0.57p pd=3.38u as=0.57p ps=3.38u w=3u l=0.13u
X812 VSS VSS VSS VSS sg13_lv_nmos ad=0.34p pd=2.68u as=0 ps=0 w=1u l=0.13u
X813 VDD VDD VDD VDD sg13_lv_pmos ad=1.02p pd=6.68u as=0 ps=0 w=3u l=0.13u
X814 voutp_RF iqmod_mixer_pex_half_1.iqmod_mixer_pex_tg_0.di_tg_ctrl_n voutp_RF VSS sg13_lv_nmos ad=0.57p pd=3.38u as=0 ps=0 w=3u l=0.13u
X815 iqmod_mixer_pex_half_0.iqmod_mixer_pex_tg_0.di_tg_ctrl iqmod_mixer_pex_half_0.iqmod_mixer_pex_se2diff_0.iqmod_mixer_pex_se2diff_half_inv$1_0.iqmod_mixer_pex_se2diff_inv_NF18$5_0.vout VSS VSS sg13_lv_nmos ad=0.19p pd=1.38u as=0.19p ps=1.38u w=1u l=0.13u
X816 iqmod_mixer_pex_half_0.iqmod_mixer_pex_se2diff_0.iqmod_mixer_pex_se2diff_half_inv$1_0.iqmod_mixer_pex_se2diff_inv_NF6$5_1.vout iqmod_mixer_pex_half_0.iqmod_mixer_pex_se2diff_0.iqmod_mixer_pex_se2diff_half_inv$1_0.iqmod_mixer_pex_se2diff_inv_NF6$5_2.vout VSS VSS sg13_lv_nmos ad=0.19p pd=1.38u as=0.19p ps=1.38u w=1u l=0.13u
X817 vinp_IF iqmod_mixer_pex_half_1.iqmod_mixer_pex_tg_0.di_tg_ctrl voutp_RF VSS sg13_lv_nmos ad=0.57p pd=3.38u as=0.57p ps=3.38u w=3u l=0.13u
X818 VSS iqmod_mixer_pex_half_1.iqmod_mixer_pex_se2diff_0.iqmod_mixer_pex_se2diff_half_tg$1_0.iqmod_mixer_pex_se2diff_inv_NF18$4_0.vout iqmod_mixer_pex_half_1.iqmod_mixer_pex_tg_0.di_tg_ctrl_n VSS sg13_lv_nmos ad=0.19p pd=1.38u as=0.19p ps=1.38u w=1u l=0.13u
X819 VSS iqmod_mixer_pex_half_1.iqmod_mixer_pex_se2diff_0.iqmod_mixer_pex_se2diff_half_tg$1_0.iqmod_mixer_pex_se2diff_inv_NF18$4_0.vout iqmod_mixer_pex_half_1.iqmod_mixer_pex_tg_0.di_tg_ctrl_n VSS sg13_lv_nmos ad=0.19p pd=1.38u as=0.19p ps=1.38u w=1u l=0.13u
X820 iqmod_mixer_pex_half_0.iqmod_mixer_pex_tg_0.di_tg_ctrl iqmod_mixer_pex_half_0.iqmod_mixer_pex_se2diff_0.iqmod_mixer_pex_se2diff_half_inv$1_0.iqmod_mixer_pex_se2diff_inv_NF18$5_0.vout VSS VSS sg13_lv_nmos ad=0.19p pd=1.38u as=0.19p ps=1.38u w=1u l=0.13u
X821 iqmod_mixer_pex_half_1.iqmod_mixer_pex_tg_0.di_tg_ctrl_n iqmod_mixer_pex_half_1.iqmod_mixer_pex_se2diff_0.iqmod_mixer_pex_se2diff_half_tg$1_0.iqmod_mixer_pex_se2diff_inv_NF18$4_0.vout VSS VSS sg13_lv_nmos ad=0.19p pd=1.38u as=0.19p ps=1.38u w=1u l=0.13u
X822 VDD VDD VDD VDD sg13_lv_pmos ad=1.02p pd=6.68u as=0 ps=0 w=3u l=0.13u
X823 iqmod_mixer_pex_half_1.iqmod_mixer_pex_tg_0.di_tg_ctrl_n iqmod_mixer_pex_half_1.iqmod_mixer_pex_se2diff_0.iqmod_mixer_pex_se2diff_half_tg$1_0.iqmod_mixer_pex_se2diff_inv_NF18$4_0.vout VDD VDD sg13_lv_pmos ad=0.57p pd=3.38u as=0.57p ps=3.38u w=3u l=0.13u
X824 VSS VSS VSS VSS sg13_lv_nmos ad=0.19p pd=1.38u as=0 ps=0 w=1u l=0.13u
X825 iqmod_mixer_pex_half_0.iqmod_mixer_pex_tg_0.di_tg_ctrl iqmod_mixer_pex_half_0.iqmod_mixer_pex_se2diff_0.iqmod_mixer_pex_se2diff_half_inv$1_0.iqmod_mixer_pex_se2diff_inv_NF18$5_0.vout VDD VDD sg13_lv_pmos ad=0.57p pd=3.38u as=0.57p ps=3.38u w=3u l=0.13u
X826 VDD VDD VDD VDD sg13_lv_pmos ad=0.57p pd=3.38u as=0 ps=0 w=3u l=0.13u
X827 VSS iqmod_mixer_pex_half_1.iqmod_mixer_pex_se2diff_0.iqmod_mixer_pex_se2diff_half_inv$1_0.iqmod_mixer_pex_se2diff_inv_NF6$5_1.vout iqmod_mixer_pex_half_1.iqmod_mixer_pex_se2diff_0.iqmod_mixer_pex_se2diff_half_inv$1_0.iqmod_mixer_pex_se2diff_inv_NF18$5_0.vout VSS sg13_lv_nmos ad=0.19p pd=1.38u as=0.19p ps=1.38u w=1u l=0.13u
X828 iqmod_mixer_pex_half_0.iqmod_mixer_pex_se2diff_0.iqmod_mixer_pex_se2diff_half_inv$1_0.iqmod_mixer_pex_se2diff_inv_NF2$5_0.vout VSS iqmod_mixer_pex_half_0.iqmod_mixer_pex_se2diff_0.iqmod_mixer_pex_se2diff_half_tg$1_0.iqmod_mixer_pex_se2diff_tg_NF6$2_0.v_b VDD sg13_lv_pmos ad=0.57p pd=3.38u as=0.57p ps=3.38u w=3u l=0.13u
X829 VSS VSS VSS VSS sg13_lv_nmos ad=0.34p pd=2.68u as=0 ps=0 w=1u l=0.13u
X830 iqmod_mixer_pex_half_0.iqmod_mixer_pex_se2diff_0.iqmod_mixer_pex_se2diff_half_tg$1_0.iqmod_mixer_pex_se2diff_inv_NF18$4_0.vout iqmod_mixer_pex_half_0.iqmod_mixer_pex_se2diff_0.iqmod_mixer_pex_se2diff_half_tg$1_0.iqmod_mixer_pex_se2diff_inv_NF6$4_0.vout VSS VSS sg13_lv_nmos ad=0.19p pd=1.38u as=0.19p ps=1.38u w=1u l=0.13u
X831 voutn_RF iqmod_mixer_pex_half_0.iqmod_mixer_pex_tg_0.di_tg_ctrl voutn_RF VDD sg13_lv_pmos ad=1.71p pd=9.38u as=0 ps=0 w=9u l=0.13u
X832 VSS iqmod_mixer_pex_half_0.iqmod_mixer_pex_se2diff_0.iqmod_mixer_pex_se2diff_half_tg$1_0.iqmod_mixer_pex_se2diff_inv_NF18$4_0.vout iqmod_mixer_pex_half_0.iqmod_mixer_pex_tg_0.di_tg_ctrl_n VSS sg13_lv_nmos ad=0.19p pd=1.38u as=0.19p ps=1.38u w=1u l=0.13u
X833 VSS iqmod_mixer_pex_half_0.iqmod_mixer_pex_se2diff_0.iqmod_mixer_pex_se2diff_half_tg$1_0.iqmod_mixer_pex_se2diff_inv_NF18$4_0.vout iqmod_mixer_pex_half_0.iqmod_mixer_pex_tg_0.di_tg_ctrl_n VSS sg13_lv_nmos ad=0.19p pd=1.38u as=0.19p ps=1.38u w=1u l=0.13u
X834 iqmod_mixer_pex_half_1.iqmod_mixer_pex_tg_0.di_tg_ctrl iqmod_mixer_pex_half_1.iqmod_mixer_pex_se2diff_0.iqmod_mixer_pex_se2diff_half_inv$1_0.iqmod_mixer_pex_se2diff_inv_NF18$5_0.vout VSS VSS sg13_lv_nmos ad=0.19p pd=1.38u as=0.19p ps=1.38u w=1u l=0.13u
X835 vinp_IF iqmod_mixer_pex_half_1.iqmod_mixer_pex_tg_0.di_tg_ctrl voutp_RF VSS sg13_lv_nmos ad=0.57p pd=3.38u as=0.57p ps=3.38u w=3u l=0.13u
X836 VSS iqmod_mixer_pex_half_1.iqmod_mixer_pex_se2diff_0.iqmod_mixer_pex_se2diff_half_inv$1_0.iqmod_mixer_pex_se2diff_inv_NF18$5_0.vout iqmod_mixer_pex_half_1.iqmod_mixer_pex_tg_0.di_tg_ctrl VSS sg13_lv_nmos ad=0.19p pd=1.38u as=0.19p ps=1.38u w=1u l=0.13u
X837 voutn_RF iqmod_mixer_pex_half_0.iqmod_mixer_pex_tg_0.di_tg_ctrl_n vinn_IF VDD sg13_lv_pmos ad=1.71p pd=9.38u as=1.71p ps=9.38u w=9u l=0.13u
X838 iqmod_mixer_pex_half_0.iqmod_mixer_pex_se2diff_0.iqmod_mixer_pex_se2diff_half_inv$1_0.iqmod_mixer_pex_se2diff_inv_NF6$5_2.vout iqmod_mixer_pex_half_0.iqmod_mixer_pex_se2diff_0.iqmod_mixer_pex_se2diff_half_inv$1_0.iqmod_mixer_pex_se2diff_inv_NF6$5_2.vin VSS VSS sg13_lv_nmos ad=0.19p pd=1.38u as=0.19p ps=1.38u w=1u l=0.13u
X839 VSS iqmod_mixer_pex_half_0.iqmod_mixer_pex_se2diff_0.iqmod_mixer_pex_se2diff_half_inv$1_0.iqmod_mixer_pex_se2diff_inv_NF2$5_0.vout iqmod_mixer_pex_half_0.iqmod_mixer_pex_se2diff_0.iqmod_mixer_pex_se2diff_half_inv$1_0.iqmod_mixer_pex_se2diff_inv_NF6$5_2.vin VSS sg13_lv_nmos ad=0.19p pd=1.38u as=0.19p ps=1.38u w=1u l=0.13u
X840 iqmod_mixer_pex_half_0.iqmod_mixer_pex_se2diff_0.iqmod_mixer_pex_se2diff_half_tg$1_0.iqmod_mixer_pex_se2diff_inv_NF18$4_0.vout iqmod_mixer_pex_half_0.iqmod_mixer_pex_se2diff_0.iqmod_mixer_pex_se2diff_half_tg$1_0.iqmod_mixer_pex_se2diff_inv_NF6$4_0.vout VSS VSS sg13_lv_nmos ad=0.19p pd=1.38u as=0.19p ps=1.38u w=1u l=0.13u
X841 iqmod_mixer_pex_half_0.iqmod_mixer_pex_tg_0.di_tg_ctrl iqmod_mixer_pex_half_0.iqmod_mixer_pex_se2diff_0.iqmod_mixer_pex_se2diff_half_inv$1_0.iqmod_mixer_pex_se2diff_inv_NF18$5_0.vout VDD VDD sg13_lv_pmos ad=0.57p pd=3.38u as=0.57p ps=3.38u w=3u l=0.13u
X842 VDD iqmod_mixer_pex_half_0.iqmod_mixer_pex_se2diff_0.iqmod_mixer_pex_se2diff_half_inv$1_0.iqmod_mixer_pex_se2diff_inv_NF6$5_1.vout iqmod_mixer_pex_half_0.iqmod_mixer_pex_se2diff_0.iqmod_mixer_pex_se2diff_half_inv$1_0.iqmod_mixer_pex_se2diff_inv_NF18$5_0.vout VDD sg13_lv_pmos ad=0.57p pd=3.38u as=0.57p ps=3.38u w=3u l=0.13u
X843 voutn_RF iqmod_mixer_pex_half_0.iqmod_mixer_pex_tg_0.di_tg_ctrl voutn_RF VDD sg13_lv_pmos ad=1.71p pd=9.38u as=0 ps=0 w=9u l=0.13u
X844 VSS iqmod_mixer_pex_half_0.iqmod_mixer_pex_se2diff_0.iqmod_mixer_pex_se2diff_half_tg$1_0.iqmod_mixer_pex_se2diff_inv_NF18$4_0.vout iqmod_mixer_pex_half_0.iqmod_mixer_pex_tg_0.di_tg_ctrl_n VSS sg13_lv_nmos ad=0.19p pd=1.38u as=0.19p ps=1.38u w=1u l=0.13u
X845 iqmod_mixer_pex_half_1.iqmod_mixer_pex_se2diff_0.iqmod_mixer_pex_se2diff_half_inv$1_0.iqmod_mixer_pex_se2diff_inv_NF18$5_0.vout iqmod_mixer_pex_half_1.iqmod_mixer_pex_se2diff_0.iqmod_mixer_pex_se2diff_half_inv$1_0.iqmod_mixer_pex_se2diff_inv_NF6$5_1.vout VDD VDD sg13_lv_pmos ad=0.57p pd=3.38u as=0.57p ps=3.38u w=3u l=0.13u
X846 VSS VSS VSS VSS sg13_lv_nmos ad=0.34p pd=2.68u as=0 ps=0 w=1u l=0.13u
X847 voutn_RF iqmod_mixer_pex_half_0.iqmod_mixer_pex_tg_0.di_tg_ctrl_n vinn_IF VDD sg13_lv_pmos ad=1.71p pd=9.38u as=1.71p ps=9.38u w=9u l=0.13u
X848 iqmod_mixer_pex_half_0.iqmod_mixer_pex_se2diff_0.iqmod_mixer_pex_se2diff_half_inv$1_0.iqmod_mixer_pex_se2diff_inv_NF6$5_2.vout iqmod_mixer_pex_half_0.iqmod_mixer_pex_se2diff_0.iqmod_mixer_pex_se2diff_half_inv$1_0.iqmod_mixer_pex_se2diff_inv_NF6$5_2.vin VSS VSS sg13_lv_nmos ad=0.19p pd=1.38u as=0.19p ps=1.38u w=1u l=0.13u
X849 VSS iqmod_mixer_pex_half_0.iqmod_mixer_pex_se2diff_0.iqmod_mixer_pex_se2diff_half_inv$1_0.iqmod_mixer_pex_se2diff_inv_NF2$5_0.vout iqmod_mixer_pex_half_0.iqmod_mixer_pex_se2diff_0.iqmod_mixer_pex_se2diff_half_inv$1_0.iqmod_mixer_pex_se2diff_inv_NF6$5_2.vin VSS sg13_lv_nmos ad=0.19p pd=1.38u as=0.19p ps=1.38u w=1u l=0.13u
X850 VDD VDD VDD VDD sg13_lv_pmos ad=1.02p pd=6.68u as=0 ps=0 w=3u l=0.13u
X851 iqmod_mixer_pex_half_1.iqmod_mixer_pex_tg_0.di_tg_ctrl_n iqmod_mixer_pex_half_1.iqmod_mixer_pex_se2diff_0.iqmod_mixer_pex_se2diff_half_tg$1_0.iqmod_mixer_pex_se2diff_inv_NF18$4_0.vout VDD VDD sg13_lv_pmos ad=0.57p pd=3.38u as=0.57p ps=3.38u w=3u l=0.13u
X852 VDD iqmod_mixer_pex_half_1.iqmod_mixer_pex_se2diff_0.iqmod_mixer_pex_se2diff_half_tg$1_0.iqmod_mixer_pex_se2diff_inv_NF18$4_0.vout iqmod_mixer_pex_half_1.iqmod_mixer_pex_tg_0.di_tg_ctrl_n VDD sg13_lv_pmos ad=0.57p pd=3.38u as=0.57p ps=3.38u w=3u l=0.13u
X853 VSS iqmod_mixer_pex_half_0.iqmod_mixer_pex_se2diff_0.iqmod_mixer_pex_se2diff_half_inv$1_0.iqmod_mixer_pex_se2diff_inv_NF2$5_1.vout iqmod_mixer_pex_half_0.iqmod_mixer_pex_se2diff_0.iqmod_mixer_pex_se2diff_half_tg$1_0.iqmod_mixer_pex_se2diff_inv_NF6$4_0.vout VSS sg13_lv_nmos ad=0.19p pd=1.38u as=0.19p ps=1.38u w=1u l=0.13u
X854 iqmod_mixer_pex_half_0.iqmod_mixer_pex_se2diff_0.iqmod_mixer_pex_se2diff_half_tg$1_0.iqmod_mixer_pex_se2diff_inv_NF18$4_0.vout iqmod_mixer_pex_half_0.iqmod_mixer_pex_se2diff_0.iqmod_mixer_pex_se2diff_half_tg$1_0.iqmod_mixer_pex_se2diff_inv_NF6$4_0.vout VSS VSS sg13_lv_nmos ad=0.19p pd=1.38u as=0.19p ps=1.38u w=1u l=0.13u
X855 VDD iqmod_mixer_pex_half_0.iqmod_mixer_pex_se2diff_0.iqmod_mixer_pex_se2diff_half_inv$1_0.iqmod_mixer_pex_se2diff_inv_NF18$5_0.vout iqmod_mixer_pex_half_0.iqmod_mixer_pex_tg_0.di_tg_ctrl VDD sg13_lv_pmos ad=0.57p pd=3.38u as=0.57p ps=3.38u w=3u l=0.13u
X856 vinn_IF iqmod_mixer_pex_half_0.iqmod_mixer_pex_tg_0.di_tg_ctrl_n voutn_RF VDD sg13_lv_pmos ad=1.71p pd=9.38u as=1.71p ps=9.38u w=9u l=0.13u
X857 voutn_RF iqmod_mixer_pex_half_0.iqmod_mixer_pex_tg_0.di_tg_ctrl voutn_RF VDD sg13_lv_pmos ad=1.71p pd=9.38u as=0 ps=0 w=9u l=0.13u
X858 VSS iqmod_mixer_pex_half_0.iqmod_mixer_pex_se2diff_0.iqmod_mixer_pex_se2diff_half_tg$1_0.iqmod_mixer_pex_se2diff_inv_NF18$4_0.vout iqmod_mixer_pex_half_0.iqmod_mixer_pex_tg_0.di_tg_ctrl_n VSS sg13_lv_nmos ad=0.19p pd=1.38u as=0.19p ps=1.38u w=1u l=0.13u
X859 iqmod_mixer_pex_half_1.iqmod_mixer_pex_tg_0.di_tg_ctrl iqmod_mixer_pex_half_1.iqmod_mixer_pex_se2diff_0.iqmod_mixer_pex_se2diff_half_inv$1_0.iqmod_mixer_pex_se2diff_inv_NF18$5_0.vout VDD VDD sg13_lv_pmos ad=0.57p pd=3.38u as=0.57p ps=3.38u w=3u l=0.13u
X860 VDD iqmod_mixer_pex_half_1.iqmod_mixer_pex_se2diff_0.iqmod_mixer_pex_se2diff_half_inv$1_0.iqmod_mixer_pex_se2diff_inv_NF18$5_0.vout iqmod_mixer_pex_half_1.iqmod_mixer_pex_tg_0.di_tg_ctrl VDD sg13_lv_pmos ad=0.57p pd=3.38u as=0.57p ps=3.38u w=3u l=0.13u
X861 iqmod_mixer_pex_half_1.iqmod_mixer_pex_se2diff_0.iqmod_mixer_pex_se2diff_half_tg$1_0.iqmod_mixer_pex_se2diff_inv_NF18$4_0.vout iqmod_mixer_pex_half_1.iqmod_mixer_pex_se2diff_0.iqmod_mixer_pex_se2diff_half_tg$1_0.iqmod_mixer_pex_se2diff_inv_NF6$4_0.vout VSS VSS sg13_lv_nmos ad=0.19p pd=1.38u as=0.19p ps=1.38u w=1u l=0.13u
X862 iqmod_mixer_pex_half_0.iqmod_mixer_pex_tg_0.di_tg_ctrl iqmod_mixer_pex_half_0.iqmod_mixer_pex_se2diff_0.iqmod_mixer_pex_se2diff_half_inv$1_0.iqmod_mixer_pex_se2diff_inv_NF18$5_0.vout VDD VDD sg13_lv_pmos ad=0.57p pd=3.38u as=0.57p ps=3.38u w=3u l=0.13u
X863 vinn_IF iqmod_mixer_pex_half_0.iqmod_mixer_pex_tg_0.di_tg_ctrl_n voutn_RF VDD sg13_lv_pmos ad=1.71p pd=9.38u as=1.71p ps=9.38u w=9u l=0.13u
X864 VSS iqmod_mixer_pex_half_0.iqmod_mixer_pex_se2diff_0.iqmod_mixer_pex_se2diff_half_tg$1_0.iqmod_mixer_pex_se2diff_inv_NF18$4_0.vout iqmod_mixer_pex_half_0.iqmod_mixer_pex_tg_0.di_tg_ctrl_n VSS sg13_lv_nmos ad=0.19p pd=1.38u as=0.19p ps=1.38u w=1u l=0.13u
X865 VDD iqmod_mixer_pex_half_1.iqmod_mixer_pex_se2diff_0.iqmod_mixer_pex_se2diff_half_inv$1_0.iqmod_mixer_pex_se2diff_inv_NF18$5_0.vout iqmod_mixer_pex_half_1.iqmod_mixer_pex_tg_0.di_tg_ctrl VDD sg13_lv_pmos ad=0.57p pd=3.38u as=0.57p ps=3.38u w=3u l=0.13u
X866 voutp_RF iqmod_mixer_pex_half_1.iqmod_mixer_pex_tg_0.di_tg_ctrl_n vinp_IF VDD sg13_lv_pmos ad=1.71p pd=9.38u as=1.71p ps=9.38u w=9u l=0.13u
X867 VSS VSS VSS VSS sg13_lv_nmos ad=0.19p pd=1.38u as=0 ps=0 w=1u l=0.13u
X868 VDD VDD VDD VDD sg13_lv_pmos ad=1.02p pd=6.68u as=0 ps=0 w=3u l=0.13u
X869 VSS iqmod_mixer_pex_half_1.iqmod_mixer_pex_se2diff_0.iqmod_mixer_pex_se2diff_half_inv$1_0.iqmod_mixer_pex_se2diff_inv_NF6$5_2.vout iqmod_mixer_pex_half_1.iqmod_mixer_pex_se2diff_0.iqmod_mixer_pex_se2diff_half_inv$1_0.iqmod_mixer_pex_se2diff_inv_NF6$5_1.vout VSS sg13_lv_nmos ad=0.19p pd=1.38u as=0.19p ps=1.38u w=1u l=0.13u
X870 vinp_IF iqmod_mixer_pex_half_1.iqmod_mixer_pex_tg_0.di_tg_ctrl_n voutp_RF VDD sg13_lv_pmos ad=1.71p pd=9.38u as=1.71p ps=9.38u w=9u l=0.13u
X871 vinn_IF iqmod_mixer_pex_half_0.iqmod_mixer_pex_tg_0.di_tg_ctrl_n voutn_RF VDD sg13_lv_pmos ad=1.71p pd=9.38u as=1.71p ps=9.38u w=9u l=0.13u
X872 iqmod_mixer_pex_half_1.iqmod_mixer_pex_se2diff_0.iqmod_mixer_pex_se2diff_half_inv$1_0.iqmod_mixer_pex_se2diff_inv_NF6$5_1.vout iqmod_mixer_pex_half_1.iqmod_mixer_pex_se2diff_0.iqmod_mixer_pex_se2diff_half_inv$1_0.iqmod_mixer_pex_se2diff_inv_NF6$5_2.vout VSS VSS sg13_lv_nmos ad=0.19p pd=1.38u as=0.19p ps=1.38u w=1u l=0.13u
X873 VDD iqmod_mixer_pex_half_1.iqmod_mixer_pex_se2diff_0.iqmod_mixer_pex_se2diff_half_inv$1_0.iqmod_mixer_pex_se2diff_inv_NF18$5_0.vout iqmod_mixer_pex_half_1.iqmod_mixer_pex_tg_0.di_tg_ctrl VDD sg13_lv_pmos ad=0.57p pd=3.38u as=0.57p ps=3.38u w=3u l=0.13u
X874 VDD iqmod_mixer_pex_half_1.iqmod_mixer_pex_se2diff_0.iqmod_mixer_pex_se2diff_half_tg$1_0.iqmod_mixer_pex_se2diff_inv_NF6$4_0.vout iqmod_mixer_pex_half_1.iqmod_mixer_pex_se2diff_0.iqmod_mixer_pex_se2diff_half_tg$1_0.iqmod_mixer_pex_se2diff_inv_NF18$4_0.vout VDD sg13_lv_pmos ad=0.57p pd=3.38u as=0.57p ps=3.38u w=3u l=0.13u
X875 vinp_IF iqmod_mixer_pex_half_1.iqmod_mixer_pex_tg_0.di_tg_ctrl voutp_RF VSS sg13_lv_nmos ad=0.57p pd=3.38u as=0.57p ps=3.38u w=3u l=0.13u
X876 VSS VSS VSS VSS sg13_lv_nmos ad=0.19p pd=1.38u as=0 ps=0 w=1u l=0.13u
X877 VSS iqmod_mixer_pex_half_1.iqmod_mixer_pex_se2diff_0.iqmod_mixer_pex_se2diff_half_tg$1_0.iqmod_mixer_pex_se2diff_inv_NF6$4_0.vout iqmod_mixer_pex_half_1.iqmod_mixer_pex_se2diff_0.iqmod_mixer_pex_se2diff_half_tg$1_0.iqmod_mixer_pex_se2diff_inv_NF18$4_0.vout VSS sg13_lv_nmos ad=0.19p pd=1.38u as=0.19p ps=1.38u w=1u l=0.13u
X878 voutp_RF iqmod_mixer_pex_half_1.iqmod_mixer_pex_tg_0.di_tg_ctrl vinp_IF VSS sg13_lv_nmos ad=0.57p pd=3.38u as=0.57p ps=3.38u w=3u l=0.13u
X879 VDD iqmod_mixer_pex_half_1.iqmod_mixer_pex_se2diff_0.iqmod_mixer_pex_se2diff_half_tg$1_0.iqmod_mixer_pex_se2diff_inv_NF18$4_0.vout iqmod_mixer_pex_half_1.iqmod_mixer_pex_tg_0.di_tg_ctrl_n VDD sg13_lv_pmos ad=0.57p pd=3.38u as=0.57p ps=3.38u w=3u l=0.13u
X880 voutn_RF iqmod_mixer_pex_half_0.iqmod_mixer_pex_tg_0.di_tg_ctrl_n voutn_RF VSS sg13_lv_nmos ad=0.57p pd=3.38u as=0 ps=0 w=3u l=0.13u
X881 iqmod_mixer_pex_half_1.iqmod_mixer_pex_tg_0.di_tg_ctrl_n iqmod_mixer_pex_half_1.iqmod_mixer_pex_se2diff_0.iqmod_mixer_pex_se2diff_half_tg$1_0.iqmod_mixer_pex_se2diff_inv_NF18$4_0.vout VSS VSS sg13_lv_nmos ad=0.19p pd=1.38u as=0.19p ps=1.38u w=1u l=0.13u
X882 VSS iqmod_mixer_pex_half_1.iqmod_mixer_pex_se2diff_0.iqmod_mixer_pex_se2diff_half_inv$1_0.iqmod_mixer_pex_se2diff_inv_NF2$5_0.vout iqmod_mixer_pex_half_1.iqmod_mixer_pex_se2diff_0.iqmod_mixer_pex_se2diff_half_inv$1_0.iqmod_mixer_pex_se2diff_inv_NF6$5_2.vin VSS sg13_lv_nmos ad=0.19p pd=1.38u as=0.19p ps=1.38u w=1u l=0.13u
X883 vinn_IF iqmod_mixer_pex_half_0.iqmod_mixer_pex_tg_0.di_tg_ctrl voutn_RF VSS sg13_lv_nmos ad=0.57p pd=3.38u as=0.57p ps=3.38u w=3u l=0.13u
X884 iqmod_mixer_pex_half_1.iqmod_mixer_pex_se2diff_0.iqmod_mixer_pex_se2diff_half_inv$1_0.iqmod_mixer_pex_se2diff_inv_NF6$5_2.vin iqmod_mixer_pex_half_1.iqmod_mixer_pex_se2diff_0.iqmod_mixer_pex_se2diff_half_inv$1_0.iqmod_mixer_pex_se2diff_inv_NF2$5_0.vout VSS VSS sg13_lv_nmos ad=0.19p pd=1.38u as=0.19p ps=1.38u w=1u l=0.13u
X885 voutn_RF iqmod_mixer_pex_half_0.iqmod_mixer_pex_tg_0.di_tg_ctrl_n voutn_RF VSS sg13_lv_nmos ad=0.57p pd=3.38u as=0 ps=0 w=3u l=0.13u
X886 vinn_IF iqmod_mixer_pex_half_0.iqmod_mixer_pex_tg_0.di_tg_ctrl voutn_RF VSS sg13_lv_nmos ad=0.57p pd=3.38u as=0.57p ps=3.38u w=3u l=0.13u
X887 VSS iqmod_mixer_pex_half_1.iqmod_mixer_pex_se2diff_0.iqmod_mixer_pex_se2diff_half_inv$1_0.iqmod_mixer_pex_se2diff_inv_NF18$5_0.vout iqmod_mixer_pex_half_1.iqmod_mixer_pex_tg_0.di_tg_ctrl VSS sg13_lv_nmos ad=0.19p pd=1.38u as=0.19p ps=1.38u w=1u l=0.13u
X888 voutn_RF iqmod_mixer_pex_half_0.iqmod_mixer_pex_tg_0.di_tg_ctrl vinn_IF VSS sg13_lv_nmos ad=0.57p pd=3.38u as=0.57p ps=3.38u w=3u l=0.13u
X889 VSS iqmod_mixer_pex_half_1.iqmod_mixer_pex_se2diff_0.iqmod_mixer_pex_se2diff_half_inv$1_0.iqmod_mixer_pex_se2diff_inv_NF18$5_0.vout iqmod_mixer_pex_half_1.iqmod_mixer_pex_tg_0.di_tg_ctrl VSS sg13_lv_nmos ad=0.19p pd=1.38u as=0.19p ps=1.38u w=1u l=0.13u
X890 VDD iqmod_mixer_pex_half_0.iqmod_mixer_pex_se2diff_0.iqmod_mixer_pex_se2diff_half_inv$1_0.iqmod_mixer_pex_se2diff_inv_NF18$5_0.vout iqmod_mixer_pex_half_0.iqmod_mixer_pex_tg_0.di_tg_ctrl VDD sg13_lv_pmos ad=0.57p pd=3.38u as=0.57p ps=3.38u w=3u l=0.13u
X891 iqmod_mixer_pex_half_0.iqmod_mixer_pex_se2diff_0.iqmod_mixer_pex_se2diff_half_inv$1_0.iqmod_mixer_pex_se2diff_inv_NF18$5_0.vout iqmod_mixer_pex_half_0.iqmod_mixer_pex_se2diff_0.iqmod_mixer_pex_se2diff_half_inv$1_0.iqmod_mixer_pex_se2diff_inv_NF6$5_1.vout VDD VDD sg13_lv_pmos ad=0.57p pd=3.38u as=0.57p ps=3.38u w=3u l=0.13u
X892 VDD VDD VDD VDD sg13_lv_pmos ad=1.02p pd=6.68u as=0 ps=0 w=3u l=0.13u
X893 voutn_RF iqmod_mixer_pex_half_0.iqmod_mixer_pex_tg_0.di_tg_ctrl_n voutn_RF VSS sg13_lv_nmos ad=0.57p pd=3.38u as=0 ps=0 w=3u l=0.13u
X894 VDD iqmod_mixer_pex_half_0.iqmod_mixer_pex_se2diff_0.iqmod_mixer_pex_se2diff_half_inv$1_0.iqmod_mixer_pex_se2diff_inv_NF18$5_0.vout iqmod_mixer_pex_half_0.iqmod_mixer_pex_tg_0.di_tg_ctrl VDD sg13_lv_pmos ad=0.57p pd=3.38u as=0.57p ps=3.38u w=3u l=0.13u
X895 iqmod_mixer_pex_half_1.iqmod_mixer_pex_tg_0.di_tg_ctrl iqmod_mixer_pex_half_1.iqmod_mixer_pex_se2diff_0.iqmod_mixer_pex_se2diff_half_inv$1_0.iqmod_mixer_pex_se2diff_inv_NF18$5_0.vout VSS VSS sg13_lv_nmos ad=0.19p pd=1.38u as=0.19p ps=1.38u w=1u l=0.13u
X896 iqmod_mixer_pex_half_1.iqmod_mixer_pex_tg_0.di_tg_ctrl iqmod_mixer_pex_half_1.iqmod_mixer_pex_se2diff_0.iqmod_mixer_pex_se2diff_half_inv$1_0.iqmod_mixer_pex_se2diff_inv_NF18$5_0.vout VSS VSS sg13_lv_nmos ad=0.19p pd=1.38u as=0.19p ps=1.38u w=1u l=0.13u
X897 voutp_RF iqmod_mixer_pex_half_1.iqmod_mixer_pex_tg_0.di_tg_ctrl voutp_RF VDD sg13_lv_pmos ad=1.71p pd=9.38u as=0 ps=0 w=9u l=0.13u
X898 VDD iqmod_mixer_pex_half_1.iqmod_mixer_pex_se2diff_0.iqmod_mixer_pex_se2diff_half_tg$1_0.iqmod_mixer_pex_se2diff_inv_NF18$4_0.vout iqmod_mixer_pex_half_1.iqmod_mixer_pex_tg_0.di_tg_ctrl_n VDD sg13_lv_pmos ad=0.57p pd=3.38u as=0.57p ps=3.38u w=3u l=0.13u
X899 voutn_RF iqmod_mixer_pex_half_0.iqmod_mixer_pex_tg_0.di_tg_ctrl vinn_IF VSS sg13_lv_nmos ad=0.57p pd=3.38u as=0.57p ps=3.38u w=3u l=0.13u
X900 VSS iqmod_mixer_pex_half_1.iqmod_mixer_pex_se2diff_0.iqmod_mixer_pex_se2diff_half_inv$1_0.iqmod_mixer_pex_se2diff_inv_NF18$5_0.vout iqmod_mixer_pex_half_1.iqmod_mixer_pex_tg_0.di_tg_ctrl VSS sg13_lv_nmos ad=0.19p pd=1.38u as=0.19p ps=1.38u w=1u l=0.13u
X901 iqmod_mixer_pex_half_1.iqmod_mixer_pex_tg_0.di_tg_ctrl_n iqmod_mixer_pex_half_1.iqmod_mixer_pex_se2diff_0.iqmod_mixer_pex_se2diff_half_tg$1_0.iqmod_mixer_pex_se2diff_inv_NF18$4_0.vout VDD VDD sg13_lv_pmos ad=0.57p pd=3.38u as=0.57p ps=3.38u w=3u l=0.13u
X902 iqmod_mixer_pex_half_0.iqmod_mixer_pex_se2diff_0.iqmod_mixer_pex_se2diff_half_inv$1_0.iqmod_mixer_pex_se2diff_inv_NF2$5_0.vout vinn_LO VDD VDD sg13_lv_pmos ad=0.57p pd=3.38u as=0.57p ps=3.38u w=3u l=0.13u
X903 iqmod_mixer_pex_half_0.iqmod_mixer_pex_tg_0.di_tg_ctrl_n iqmod_mixer_pex_half_0.iqmod_mixer_pex_se2diff_0.iqmod_mixer_pex_se2diff_half_tg$1_0.iqmod_mixer_pex_se2diff_inv_NF18$4_0.vout VDD VDD sg13_lv_pmos ad=0.57p pd=3.38u as=0.57p ps=3.38u w=3u l=0.13u
X904 iqmod_mixer_pex_half_0.iqmod_mixer_pex_tg_0.di_tg_ctrl_n iqmod_mixer_pex_half_0.iqmod_mixer_pex_se2diff_0.iqmod_mixer_pex_se2diff_half_tg$1_0.iqmod_mixer_pex_se2diff_inv_NF18$4_0.vout VDD VDD sg13_lv_pmos ad=0.57p pd=3.38u as=0.57p ps=3.38u w=3u l=0.13u
X905 VDD iqmod_mixer_pex_half_0.iqmod_mixer_pex_se2diff_0.iqmod_mixer_pex_se2diff_half_inv$1_0.iqmod_mixer_pex_se2diff_inv_NF18$5_0.vout iqmod_mixer_pex_half_0.iqmod_mixer_pex_tg_0.di_tg_ctrl VDD sg13_lv_pmos ad=0.57p pd=3.38u as=0.57p ps=3.38u w=3u l=0.13u
X906 iqmod_mixer_pex_half_0.iqmod_mixer_pex_se2diff_0.iqmod_mixer_pex_se2diff_half_inv$1_0.iqmod_mixer_pex_se2diff_inv_NF18$5_0.vout iqmod_mixer_pex_half_0.iqmod_mixer_pex_se2diff_0.iqmod_mixer_pex_se2diff_half_inv$1_0.iqmod_mixer_pex_se2diff_inv_NF6$5_1.vout VDD VDD sg13_lv_pmos ad=0.57p pd=3.38u as=0.57p ps=3.38u w=3u l=0.13u
X907 voutp_RF iqmod_mixer_pex_half_1.iqmod_mixer_pex_tg_0.di_tg_ctrl voutp_RF VDD sg13_lv_pmos ad=1.71p pd=9.38u as=0 ps=0 w=9u l=0.13u
X908 voutp_RF iqmod_mixer_pex_half_1.iqmod_mixer_pex_tg_0.di_tg_ctrl_n vinp_IF VDD sg13_lv_pmos ad=1.71p pd=9.38u as=1.71p ps=9.38u w=9u l=0.13u
X909 iqmod_mixer_pex_half_1.iqmod_mixer_pex_se2diff_0.iqmod_mixer_pex_se2diff_half_inv$1_0.iqmod_mixer_pex_se2diff_inv_NF18$5_0.vout iqmod_mixer_pex_half_1.iqmod_mixer_pex_se2diff_0.iqmod_mixer_pex_se2diff_half_inv$1_0.iqmod_mixer_pex_se2diff_inv_NF6$5_1.vout VDD VDD sg13_lv_pmos ad=0.57p pd=3.38u as=0.57p ps=3.38u w=3u l=0.13u
X910 iqmod_mixer_pex_half_0.iqmod_mixer_pex_tg_0.di_tg_ctrl iqmod_mixer_pex_half_0.iqmod_mixer_pex_se2diff_0.iqmod_mixer_pex_se2diff_half_inv$1_0.iqmod_mixer_pex_se2diff_inv_NF18$5_0.vout VSS VSS sg13_lv_nmos ad=0.19p pd=1.38u as=0.19p ps=1.38u w=1u l=0.13u
X911 voutn_RF iqmod_mixer_pex_half_0.iqmod_mixer_pex_tg_0.di_tg_ctrl vinn_IF VSS sg13_lv_nmos ad=0.57p pd=3.38u as=0.57p ps=3.38u w=3u l=0.13u
X912 VSS vinp_LO iqmod_mixer_pex_half_1.iqmod_mixer_pex_se2diff_0.iqmod_mixer_pex_se2diff_half_inv$1_0.iqmod_mixer_pex_se2diff_inv_NF2$5_0.vout VSS sg13_lv_nmos ad=0.19p pd=1.38u as=0.19p ps=1.38u w=1u l=0.13u
X913 VDD iqmod_mixer_pex_half_0.iqmod_mixer_pex_se2diff_0.iqmod_mixer_pex_se2diff_half_inv$1_0.iqmod_mixer_pex_se2diff_inv_NF18$5_0.vout iqmod_mixer_pex_half_0.iqmod_mixer_pex_tg_0.di_tg_ctrl VDD sg13_lv_pmos ad=0.57p pd=3.38u as=0.57p ps=3.38u w=3u l=0.13u
X914 iqmod_mixer_pex_half_0.iqmod_mixer_pex_se2diff_0.iqmod_mixer_pex_se2diff_half_inv$1_0.iqmod_mixer_pex_se2diff_inv_NF18$5_0.vout iqmod_mixer_pex_half_0.iqmod_mixer_pex_se2diff_0.iqmod_mixer_pex_se2diff_half_inv$1_0.iqmod_mixer_pex_se2diff_inv_NF6$5_1.vout VDD VDD sg13_lv_pmos ad=0.57p pd=3.38u as=0.57p ps=3.38u w=3u l=0.13u
X915 VDD iqmod_mixer_pex_half_0.iqmod_mixer_pex_se2diff_0.iqmod_mixer_pex_se2diff_half_inv$1_0.iqmod_mixer_pex_se2diff_inv_NF6$5_2.vout iqmod_mixer_pex_half_0.iqmod_mixer_pex_se2diff_0.iqmod_mixer_pex_se2diff_half_inv$1_0.iqmod_mixer_pex_se2diff_inv_NF6$5_1.vout VDD sg13_lv_pmos ad=0.57p pd=3.38u as=0.57p ps=3.38u w=3u l=0.13u
X916 VSS VSS VSS VSS sg13_lv_nmos ad=0.19p pd=1.38u as=0 ps=0 w=1u l=0.13u
X917 VDD iqmod_mixer_pex_half_1.iqmod_mixer_pex_se2diff_0.iqmod_mixer_pex_se2diff_half_inv$1_0.iqmod_mixer_pex_se2diff_inv_NF6$5_1.vout iqmod_mixer_pex_half_1.iqmod_mixer_pex_se2diff_0.iqmod_mixer_pex_se2diff_half_inv$1_0.iqmod_mixer_pex_se2diff_inv_NF18$5_0.vout VDD sg13_lv_pmos ad=0.57p pd=3.38u as=0.57p ps=3.38u w=3u l=0.13u
X918 vinp_IF iqmod_mixer_pex_half_1.iqmod_mixer_pex_tg_0.di_tg_ctrl_n voutp_RF VDD sg13_lv_pmos ad=1.71p pd=9.38u as=1.71p ps=9.38u w=9u l=0.13u
X919 VDD iqmod_mixer_pex_half_0.iqmod_mixer_pex_se2diff_0.iqmod_mixer_pex_se2diff_half_tg$1_0.iqmod_mixer_pex_se2diff_inv_NF6$4_0.vout iqmod_mixer_pex_half_0.iqmod_mixer_pex_se2diff_0.iqmod_mixer_pex_se2diff_half_tg$1_0.iqmod_mixer_pex_se2diff_inv_NF18$4_0.vout VDD sg13_lv_pmos ad=0.57p pd=3.38u as=0.57p ps=3.38u w=3u l=0.13u
X920 iqmod_mixer_pex_half_0.iqmod_mixer_pex_tg_0.di_tg_ctrl_n iqmod_mixer_pex_half_0.iqmod_mixer_pex_se2diff_0.iqmod_mixer_pex_se2diff_half_tg$1_0.iqmod_mixer_pex_se2diff_inv_NF18$4_0.vout VDD VDD sg13_lv_pmos ad=0.57p pd=3.38u as=0.57p ps=3.38u w=3u l=0.13u
X921 iqmod_mixer_pex_half_1.iqmod_mixer_pex_tg_0.di_tg_ctrl iqmod_mixer_pex_half_1.iqmod_mixer_pex_se2diff_0.iqmod_mixer_pex_se2diff_half_inv$1_0.iqmod_mixer_pex_se2diff_inv_NF18$5_0.vout VSS VSS sg13_lv_nmos ad=0.19p pd=1.38u as=0.19p ps=1.38u w=1u l=0.13u
X922 iqmod_mixer_pex_half_1.iqmod_mixer_pex_tg_0.di_tg_ctrl iqmod_mixer_pex_half_1.iqmod_mixer_pex_se2diff_0.iqmod_mixer_pex_se2diff_half_inv$1_0.iqmod_mixer_pex_se2diff_inv_NF18$5_0.vout VDD VDD sg13_lv_pmos ad=0.57p pd=3.38u as=0.57p ps=3.38u w=3u l=0.13u
X923 iqmod_mixer_pex_half_1.iqmod_mixer_pex_tg_0.di_tg_ctrl_n iqmod_mixer_pex_half_1.iqmod_mixer_pex_se2diff_0.iqmod_mixer_pex_se2diff_half_tg$1_0.iqmod_mixer_pex_se2diff_inv_NF18$4_0.vout VDD VDD sg13_lv_pmos ad=0.57p pd=3.38u as=0.57p ps=3.38u w=3u l=0.13u
X924 VDD iqmod_mixer_pex_half_0.iqmod_mixer_pex_se2diff_0.iqmod_mixer_pex_se2diff_half_inv$1_0.iqmod_mixer_pex_se2diff_inv_NF18$5_0.vout iqmod_mixer_pex_half_0.iqmod_mixer_pex_tg_0.di_tg_ctrl VDD sg13_lv_pmos ad=0.57p pd=3.38u as=0.57p ps=3.38u w=3u l=0.13u
X925 iqmod_mixer_pex_half_0.iqmod_mixer_pex_tg_0.di_tg_ctrl iqmod_mixer_pex_half_0.iqmod_mixer_pex_se2diff_0.iqmod_mixer_pex_se2diff_half_inv$1_0.iqmod_mixer_pex_se2diff_inv_NF18$5_0.vout VSS VSS sg13_lv_nmos ad=0.19p pd=1.38u as=0.19p ps=1.38u w=1u l=0.13u
X926 VSS iqmod_mixer_pex_half_0.iqmod_mixer_pex_se2diff_0.iqmod_mixer_pex_se2diff_half_inv$1_0.iqmod_mixer_pex_se2diff_inv_NF6$5_1.vout iqmod_mixer_pex_half_0.iqmod_mixer_pex_se2diff_0.iqmod_mixer_pex_se2diff_half_inv$1_0.iqmod_mixer_pex_se2diff_inv_NF18$5_0.vout VSS sg13_lv_nmos ad=0.19p pd=1.38u as=0.19p ps=1.38u w=1u l=0.13u
X927 VDD iqmod_mixer_pex_half_1.iqmod_mixer_pex_se2diff_0.iqmod_mixer_pex_se2diff_half_inv$1_0.iqmod_mixer_pex_se2diff_inv_NF18$5_0.vout iqmod_mixer_pex_half_1.iqmod_mixer_pex_tg_0.di_tg_ctrl VDD sg13_lv_pmos ad=0.57p pd=3.38u as=0.57p ps=3.38u w=3u l=0.13u
X928 iqmod_mixer_pex_half_1.iqmod_mixer_pex_se2diff_0.iqmod_mixer_pex_se2diff_half_tg$1_0.iqmod_mixer_pex_se2diff_inv_NF18$4_0.vout iqmod_mixer_pex_half_1.iqmod_mixer_pex_se2diff_0.iqmod_mixer_pex_se2diff_half_tg$1_0.iqmod_mixer_pex_se2diff_inv_NF6$4_0.vout VSS VSS sg13_lv_nmos ad=0.19p pd=1.38u as=0.19p ps=1.38u w=1u l=0.13u
X929 VDD VDD VDD VDD sg13_lv_pmos ad=1.02p pd=6.68u as=0 ps=0 w=3u l=0.13u
X930 VDD iqmod_mixer_pex_half_1.iqmod_mixer_pex_se2diff_0.iqmod_mixer_pex_se2diff_half_tg$1_0.iqmod_mixer_pex_se2diff_inv_NF18$4_0.vout iqmod_mixer_pex_half_1.iqmod_mixer_pex_tg_0.di_tg_ctrl_n VDD sg13_lv_pmos ad=0.57p pd=3.38u as=0.57p ps=3.38u w=3u l=0.13u
X931 VDD VDD VDD VDD sg13_lv_pmos ad=0.57p pd=3.38u as=0 ps=0 w=3u l=0.13u
X932 VDD iqmod_mixer_pex_half_0.iqmod_mixer_pex_se2diff_0.iqmod_mixer_pex_se2diff_half_tg$1_0.iqmod_mixer_pex_se2diff_inv_NF6$4_0.vout iqmod_mixer_pex_half_0.iqmod_mixer_pex_se2diff_0.iqmod_mixer_pex_se2diff_half_tg$1_0.iqmod_mixer_pex_se2diff_inv_NF18$4_0.vout VDD sg13_lv_pmos ad=0.57p pd=3.38u as=0.57p ps=3.38u w=3u l=0.13u
X933 iqmod_mixer_pex_half_0.iqmod_mixer_pex_tg_0.di_tg_ctrl_n iqmod_mixer_pex_half_0.iqmod_mixer_pex_se2diff_0.iqmod_mixer_pex_se2diff_half_tg$1_0.iqmod_mixer_pex_se2diff_inv_NF18$4_0.vout VDD VDD sg13_lv_pmos ad=0.57p pd=3.38u as=0.57p ps=3.38u w=3u l=0.13u
X934 iqmod_mixer_pex_half_0.iqmod_mixer_pex_tg_0.di_tg_ctrl_n iqmod_mixer_pex_half_0.iqmod_mixer_pex_se2diff_0.iqmod_mixer_pex_se2diff_half_tg$1_0.iqmod_mixer_pex_se2diff_inv_NF18$4_0.vout VDD VDD sg13_lv_pmos ad=0.57p pd=3.38u as=0.57p ps=3.38u w=3u l=0.13u
X935 voutp_RF iqmod_mixer_pex_half_1.iqmod_mixer_pex_tg_0.di_tg_ctrl voutp_RF VDD sg13_lv_pmos ad=1.71p pd=9.38u as=0 ps=0 w=9u l=0.13u
X936 VSS iqmod_mixer_pex_half_1.iqmod_mixer_pex_se2diff_0.iqmod_mixer_pex_se2diff_half_tg$1_0.iqmod_mixer_pex_se2diff_inv_NF18$4_0.vout iqmod_mixer_pex_half_1.iqmod_mixer_pex_tg_0.di_tg_ctrl_n VSS sg13_lv_nmos ad=0.19p pd=1.38u as=0.19p ps=1.38u w=1u l=0.13u
X937 VDD iqmod_mixer_pex_half_0.iqmod_mixer_pex_se2diff_0.iqmod_mixer_pex_se2diff_half_tg$1_0.iqmod_mixer_pex_se2diff_inv_NF18$4_0.vout iqmod_mixer_pex_half_0.iqmod_mixer_pex_tg_0.di_tg_ctrl_n VDD sg13_lv_pmos ad=0.57p pd=3.38u as=0.57p ps=3.38u w=3u l=0.13u
X938 iqmod_mixer_pex_half_1.iqmod_mixer_pex_tg_0.di_tg_ctrl_n iqmod_mixer_pex_half_1.iqmod_mixer_pex_se2diff_0.iqmod_mixer_pex_se2diff_half_tg$1_0.iqmod_mixer_pex_se2diff_inv_NF18$4_0.vout VSS VSS sg13_lv_nmos ad=0.19p pd=1.38u as=0.19p ps=1.38u w=1u l=0.13u
X939 iqmod_mixer_pex_half_1.iqmod_mixer_pex_se2diff_0.iqmod_mixer_pex_se2diff_half_tg$1_0.iqmod_mixer_pex_se2diff_inv_NF18$4_0.vout iqmod_mixer_pex_half_1.iqmod_mixer_pex_se2diff_0.iqmod_mixer_pex_se2diff_half_tg$1_0.iqmod_mixer_pex_se2diff_inv_NF6$4_0.vout VDD VDD sg13_lv_pmos ad=0.57p pd=3.38u as=0.57p ps=3.38u w=3u l=0.13u
X940 iqmod_mixer_pex_half_0.iqmod_mixer_pex_tg_0.di_tg_ctrl_n iqmod_mixer_pex_half_0.iqmod_mixer_pex_se2diff_0.iqmod_mixer_pex_se2diff_half_tg$1_0.iqmod_mixer_pex_se2diff_inv_NF18$4_0.vout VDD VDD sg13_lv_pmos ad=0.57p pd=3.38u as=0.57p ps=3.38u w=3u l=0.13u
X941 iqmod_mixer_pex_half_1.iqmod_mixer_pex_se2diff_0.iqmod_mixer_pex_se2diff_half_inv$1_0.iqmod_mixer_pex_se2diff_inv_NF2$5_1.vout iqmod_mixer_pex_half_1.iqmod_mixer_pex_se2diff_0.iqmod_mixer_pex_se2diff_half_inv$1_0.iqmod_mixer_pex_se2diff_inv_NF6$5_2.vout VDD VDD sg13_lv_pmos ad=0.57p pd=3.38u as=0.57p ps=3.38u w=3u l=0.13u
X942 VDD VDD VDD VDD sg13_lv_pmos ad=1.02p pd=6.68u as=0 ps=0 w=3u l=0.13u
X943 VSS iqmod_mixer_pex_half_0.iqmod_mixer_pex_se2diff_0.iqmod_mixer_pex_se2diff_half_inv$1_0.iqmod_mixer_pex_se2diff_inv_NF18$5_0.vout iqmod_mixer_pex_half_0.iqmod_mixer_pex_tg_0.di_tg_ctrl VSS sg13_lv_nmos ad=0.19p pd=1.38u as=0.19p ps=1.38u w=1u l=0.13u
X944 VDD iqmod_mixer_pex_half_1.iqmod_mixer_pex_se2diff_0.iqmod_mixer_pex_se2diff_half_tg$1_0.iqmod_mixer_pex_se2diff_inv_NF18$4_0.vout iqmod_mixer_pex_half_1.iqmod_mixer_pex_tg_0.di_tg_ctrl_n VDD sg13_lv_pmos ad=0.57p pd=3.38u as=0.57p ps=3.38u w=3u l=0.13u
X945 iqmod_mixer_pex_half_1.iqmod_mixer_pex_tg_0.di_tg_ctrl_n iqmod_mixer_pex_half_1.iqmod_mixer_pex_se2diff_0.iqmod_mixer_pex_se2diff_half_tg$1_0.iqmod_mixer_pex_se2diff_inv_NF18$4_0.vout VDD VDD sg13_lv_pmos ad=0.57p pd=3.38u as=0.57p ps=3.38u w=3u l=0.13u
X946 voutp_RF iqmod_mixer_pex_half_1.iqmod_mixer_pex_tg_0.di_tg_ctrl vinp_IF VSS sg13_lv_nmos ad=0.57p pd=3.38u as=0.57p ps=3.38u w=3u l=0.13u
X947 VSS VSS VSS VSS sg13_lv_nmos ad=0.19p pd=1.38u as=0 ps=0 w=1u l=0.13u
X948 VSS iqmod_mixer_pex_half_1.iqmod_mixer_pex_se2diff_0.iqmod_mixer_pex_se2diff_half_inv$1_0.iqmod_mixer_pex_se2diff_inv_NF6$5_1.vout iqmod_mixer_pex_half_1.iqmod_mixer_pex_se2diff_0.iqmod_mixer_pex_se2diff_half_inv$1_0.iqmod_mixer_pex_se2diff_inv_NF18$5_0.vout VSS sg13_lv_nmos ad=0.19p pd=1.38u as=0.19p ps=1.38u w=1u l=0.13u
X949 iqmod_mixer_pex_half_0.iqmod_mixer_pex_tg_0.di_tg_ctrl iqmod_mixer_pex_half_0.iqmod_mixer_pex_se2diff_0.iqmod_mixer_pex_se2diff_half_inv$1_0.iqmod_mixer_pex_se2diff_inv_NF18$5_0.vout VSS VSS sg13_lv_nmos ad=0.19p pd=1.38u as=0.19p ps=1.38u w=1u l=0.13u
X950 iqmod_mixer_pex_half_0.iqmod_mixer_pex_tg_0.di_tg_ctrl_n iqmod_mixer_pex_half_0.iqmod_mixer_pex_se2diff_0.iqmod_mixer_pex_se2diff_half_tg$1_0.iqmod_mixer_pex_se2diff_inv_NF18$4_0.vout VDD VDD sg13_lv_pmos ad=0.57p pd=3.38u as=0.57p ps=3.38u w=3u l=0.13u
X951 vinp_IF iqmod_mixer_pex_half_1.iqmod_mixer_pex_tg_0.di_tg_ctrl voutp_RF VSS sg13_lv_nmos ad=0.57p pd=3.38u as=0.57p ps=3.38u w=3u l=0.13u
X952 voutp_RF iqmod_mixer_pex_half_1.iqmod_mixer_pex_tg_0.di_tg_ctrl vinp_IF VSS sg13_lv_nmos ad=0.57p pd=3.38u as=0.57p ps=3.38u w=3u l=0.13u
X953 iqmod_mixer_pex_half_1.iqmod_mixer_pex_tg_0.di_tg_ctrl_n iqmod_mixer_pex_half_1.iqmod_mixer_pex_se2diff_0.iqmod_mixer_pex_se2diff_half_tg$1_0.iqmod_mixer_pex_se2diff_inv_NF18$4_0.vout VSS VSS sg13_lv_nmos ad=0.19p pd=1.38u as=0.19p ps=1.38u w=1u l=0.13u
X954 voutn_RF iqmod_mixer_pex_half_0.iqmod_mixer_pex_tg_0.di_tg_ctrl voutn_RF VDD sg13_lv_pmos ad=1.71p pd=9.38u as=0 ps=0 w=9u l=0.13u
X955 voutn_RF iqmod_mixer_pex_half_0.iqmod_mixer_pex_tg_0.di_tg_ctrl vinn_IF VSS sg13_lv_nmos ad=0.57p pd=3.38u as=0.57p ps=3.38u w=3u l=0.13u
X956 VSS iqmod_mixer_pex_half_0.iqmod_mixer_pex_se2diff_0.iqmod_mixer_pex_se2diff_half_tg$1_0.iqmod_mixer_pex_se2diff_inv_NF18$4_0.vout iqmod_mixer_pex_half_0.iqmod_mixer_pex_tg_0.di_tg_ctrl_n VSS sg13_lv_nmos ad=0.19p pd=1.38u as=0.19p ps=1.38u w=1u l=0.13u
X957 VSS iqmod_mixer_pex_half_0.iqmod_mixer_pex_se2diff_0.iqmod_mixer_pex_se2diff_half_tg$1_0.iqmod_mixer_pex_se2diff_inv_NF18$4_0.vout iqmod_mixer_pex_half_0.iqmod_mixer_pex_tg_0.di_tg_ctrl_n VSS sg13_lv_nmos ad=0.19p pd=1.38u as=0.19p ps=1.38u w=1u l=0.13u
X958 iqmod_mixer_pex_half_1.iqmod_mixer_pex_se2diff_0.iqmod_mixer_pex_se2diff_half_inv$1_0.iqmod_mixer_pex_se2diff_inv_NF6$5_2.vout iqmod_mixer_pex_half_1.iqmod_mixer_pex_se2diff_0.iqmod_mixer_pex_se2diff_half_inv$1_0.iqmod_mixer_pex_se2diff_inv_NF6$5_2.vin VSS VSS sg13_lv_nmos ad=0.19p pd=1.38u as=0.19p ps=1.38u w=1u l=0.13u
X959 iqmod_mixer_pex_half_1.iqmod_mixer_pex_tg_0.di_tg_ctrl_n iqmod_mixer_pex_half_1.iqmod_mixer_pex_se2diff_0.iqmod_mixer_pex_se2diff_half_tg$1_0.iqmod_mixer_pex_se2diff_inv_NF18$4_0.vout VDD VDD sg13_lv_pmos ad=0.57p pd=3.38u as=0.57p ps=3.38u w=3u l=0.13u
X960 VSS iqmod_mixer_pex_half_1.iqmod_mixer_pex_se2diff_0.iqmod_mixer_pex_se2diff_half_inv$1_0.iqmod_mixer_pex_se2diff_inv_NF18$5_0.vout iqmod_mixer_pex_half_1.iqmod_mixer_pex_tg_0.di_tg_ctrl VSS sg13_lv_nmos ad=0.19p pd=1.38u as=0.19p ps=1.38u w=1u l=0.13u
X961 VDD iqmod_mixer_pex_half_1.iqmod_mixer_pex_se2diff_0.iqmod_mixer_pex_se2diff_half_tg$1_0.iqmod_mixer_pex_se2diff_inv_NF18$4_0.vout iqmod_mixer_pex_half_1.iqmod_mixer_pex_tg_0.di_tg_ctrl_n VDD sg13_lv_pmos ad=0.57p pd=3.38u as=0.57p ps=3.38u w=3u l=0.13u
X962 voutn_RF iqmod_mixer_pex_half_0.iqmod_mixer_pex_tg_0.di_tg_ctrl_n voutn_RF VSS sg13_lv_nmos ad=0.57p pd=3.38u as=0 ps=0 w=3u l=0.13u
X963 VSS iqmod_mixer_pex_half_1.iqmod_mixer_pex_se2diff_0.iqmod_mixer_pex_se2diff_half_inv$1_0.iqmod_mixer_pex_se2diff_inv_NF6$5_2.vin iqmod_mixer_pex_half_1.iqmod_mixer_pex_se2diff_0.iqmod_mixer_pex_se2diff_half_inv$1_0.iqmod_mixer_pex_se2diff_inv_NF6$5_2.vout VSS sg13_lv_nmos ad=0.19p pd=1.38u as=0.19p ps=1.38u w=1u l=0.13u
X964 VDD VDD VDD VDD sg13_lv_pmos ad=0.57p pd=3.38u as=0 ps=0 w=3u l=0.13u
X965 iqmod_mixer_pex_half_1.iqmod_mixer_pex_se2diff_0.iqmod_mixer_pex_se2diff_half_tg$1_0.iqmod_mixer_pex_se2diff_inv_NF6$4_0.vout iqmod_mixer_pex_half_1.iqmod_mixer_pex_se2diff_0.iqmod_mixer_pex_se2diff_half_inv$1_0.iqmod_mixer_pex_se2diff_inv_NF2$5_1.vout VSS VSS sg13_lv_nmos ad=0.19p pd=1.38u as=0.19p ps=1.38u w=1u l=0.13u
X966 VSS iqmod_mixer_pex_half_0.iqmod_mixer_pex_se2diff_0.iqmod_mixer_pex_se2diff_half_tg$1_0.iqmod_mixer_pex_se2diff_inv_NF18$4_0.vout iqmod_mixer_pex_half_0.iqmod_mixer_pex_tg_0.di_tg_ctrl_n VSS sg13_lv_nmos ad=0.19p pd=1.38u as=0.19p ps=1.38u w=1u l=0.13u
X967 VSS iqmod_mixer_pex_half_0.iqmod_mixer_pex_se2diff_0.iqmod_mixer_pex_se2diff_half_tg$1_0.iqmod_mixer_pex_se2diff_inv_NF18$4_0.vout iqmod_mixer_pex_half_0.iqmod_mixer_pex_tg_0.di_tg_ctrl_n VSS sg13_lv_nmos ad=0.19p pd=1.38u as=0.19p ps=1.38u w=1u l=0.13u
X968 VSS iqmod_mixer_pex_half_0.iqmod_mixer_pex_se2diff_0.iqmod_mixer_pex_se2diff_half_tg$1_0.iqmod_mixer_pex_se2diff_inv_NF18$4_0.vout iqmod_mixer_pex_half_0.iqmod_mixer_pex_tg_0.di_tg_ctrl_n VSS sg13_lv_nmos ad=0.19p pd=1.38u as=0.19p ps=1.38u w=1u l=0.13u
X969 iqmod_mixer_pex_half_0.iqmod_mixer_pex_se2diff_0.iqmod_mixer_pex_se2diff_half_tg$1_0.iqmod_mixer_pex_se2diff_inv_NF18$4_0.vout iqmod_mixer_pex_half_0.iqmod_mixer_pex_se2diff_0.iqmod_mixer_pex_se2diff_half_tg$1_0.iqmod_mixer_pex_se2diff_inv_NF6$4_0.vout VSS VSS sg13_lv_nmos ad=0.19p pd=1.38u as=0.19p ps=1.38u w=1u l=0.13u
X970 VSS iqmod_mixer_pex_half_1.iqmod_mixer_pex_se2diff_0.iqmod_mixer_pex_se2diff_half_inv$1_0.iqmod_mixer_pex_se2diff_inv_NF2$5_1.vout iqmod_mixer_pex_half_1.iqmod_mixer_pex_se2diff_0.iqmod_mixer_pex_se2diff_half_tg$1_0.iqmod_mixer_pex_se2diff_inv_NF6$4_0.vout VSS sg13_lv_nmos ad=0.19p pd=1.38u as=0.19p ps=1.38u w=1u l=0.13u
X971 VSS iqmod_mixer_pex_half_1.iqmod_mixer_pex_se2diff_0.iqmod_mixer_pex_se2diff_half_inv$1_0.iqmod_mixer_pex_se2diff_inv_NF18$5_0.vout iqmod_mixer_pex_half_1.iqmod_mixer_pex_tg_0.di_tg_ctrl VSS sg13_lv_nmos ad=0.19p pd=1.38u as=0.19p ps=1.38u w=1u l=0.13u
X972 VSS iqmod_mixer_pex_half_1.iqmod_mixer_pex_se2diff_0.iqmod_mixer_pex_se2diff_half_inv$1_0.iqmod_mixer_pex_se2diff_inv_NF18$5_0.vout iqmod_mixer_pex_half_1.iqmod_mixer_pex_tg_0.di_tg_ctrl VSS sg13_lv_nmos ad=0.19p pd=1.38u as=0.19p ps=1.38u w=1u l=0.13u
X973 VSS VSS VSS VSS sg13_lv_nmos ad=0.34p pd=2.68u as=0 ps=0 w=1u l=0.13u
X974 VSS iqmod_mixer_pex_half_0.iqmod_mixer_pex_se2diff_0.iqmod_mixer_pex_se2diff_half_inv$1_0.iqmod_mixer_pex_se2diff_inv_NF2$5_1.vout iqmod_mixer_pex_half_0.iqmod_mixer_pex_se2diff_0.iqmod_mixer_pex_se2diff_half_tg$1_0.iqmod_mixer_pex_se2diff_inv_NF6$4_0.vout VSS sg13_lv_nmos ad=0.19p pd=1.38u as=0.19p ps=1.38u w=1u l=0.13u
X975 iqmod_mixer_pex_half_0.iqmod_mixer_pex_se2diff_0.iqmod_mixer_pex_se2diff_half_tg$1_0.iqmod_mixer_pex_se2diff_inv_NF18$4_0.vout iqmod_mixer_pex_half_0.iqmod_mixer_pex_se2diff_0.iqmod_mixer_pex_se2diff_half_tg$1_0.iqmod_mixer_pex_se2diff_inv_NF6$4_0.vout VSS VSS sg13_lv_nmos ad=0.19p pd=1.38u as=0.19p ps=1.38u w=1u l=0.13u
X976 vinn_IF iqmod_mixer_pex_half_0.iqmod_mixer_pex_tg_0.di_tg_ctrl_n voutn_RF VDD sg13_lv_pmos ad=1.71p pd=9.38u as=1.71p ps=9.38u w=9u l=0.13u
X977 VSS iqmod_mixer_pex_half_0.iqmod_mixer_pex_se2diff_0.iqmod_mixer_pex_se2diff_half_tg$1_0.iqmod_mixer_pex_se2diff_inv_NF18$4_0.vout iqmod_mixer_pex_half_0.iqmod_mixer_pex_tg_0.di_tg_ctrl_n VSS sg13_lv_nmos ad=0.19p pd=1.38u as=0.19p ps=1.38u w=1u l=0.13u
X978 iqmod_mixer_pex_half_1.iqmod_mixer_pex_tg_0.di_tg_ctrl iqmod_mixer_pex_half_1.iqmod_mixer_pex_se2diff_0.iqmod_mixer_pex_se2diff_half_inv$1_0.iqmod_mixer_pex_se2diff_inv_NF18$5_0.vout VSS VSS sg13_lv_nmos ad=0.19p pd=1.38u as=0.19p ps=1.38u w=1u l=0.13u
X979 voutp_RF iqmod_mixer_pex_half_1.iqmod_mixer_pex_tg_0.di_tg_ctrl_n vinp_IF VDD sg13_lv_pmos ad=1.71p pd=9.38u as=1.71p ps=9.38u w=9u l=0.13u
X980 voutp_RF iqmod_mixer_pex_half_1.iqmod_mixer_pex_tg_0.di_tg_ctrl voutp_RF VDD sg13_lv_pmos ad=1.71p pd=9.38u as=0 ps=0 w=9u l=0.13u
X981 vinn_IF iqmod_mixer_pex_half_0.iqmod_mixer_pex_tg_0.di_tg_ctrl voutn_RF VSS sg13_lv_nmos ad=0.57p pd=3.38u as=0.57p ps=3.38u w=3u l=0.13u
X982 vinp_IF iqmod_mixer_pex_half_1.iqmod_mixer_pex_tg_0.di_tg_ctrl_n voutp_RF VDD sg13_lv_pmos ad=1.71p pd=9.38u as=1.71p ps=9.38u w=9u l=0.13u
X983 VDD iqmod_mixer_pex_half_1.iqmod_mixer_pex_se2diff_0.iqmod_mixer_pex_se2diff_half_inv$1_0.iqmod_mixer_pex_se2diff_inv_NF6$5_1.vout iqmod_mixer_pex_half_1.iqmod_mixer_pex_se2diff_0.iqmod_mixer_pex_se2diff_half_inv$1_0.iqmod_mixer_pex_se2diff_inv_NF18$5_0.vout VDD sg13_lv_pmos ad=0.57p pd=3.38u as=0.57p ps=3.38u w=3u l=0.13u
X984 iqmod_mixer_pex_half_1.iqmod_mixer_pex_se2diff_0.iqmod_mixer_pex_se2diff_half_tg$1_0.iqmod_mixer_pex_se2diff_tg_NF6$2_0.v_b VDD iqmod_mixer_pex_half_1.iqmod_mixer_pex_se2diff_0.iqmod_mixer_pex_se2diff_half_inv$1_0.iqmod_mixer_pex_se2diff_inv_NF2$5_0.vout VSS sg13_lv_nmos ad=0.19p pd=1.38u as=0.19p ps=1.38u w=1u l=0.13u
X985 VSS iqmod_mixer_pex_half_0.iqmod_mixer_pex_se2diff_0.iqmod_mixer_pex_se2diff_half_tg$1_0.iqmod_mixer_pex_se2diff_inv_NF18$4_0.vout iqmod_mixer_pex_half_0.iqmod_mixer_pex_tg_0.di_tg_ctrl_n VSS sg13_lv_nmos ad=0.19p pd=1.38u as=0.19p ps=1.38u w=1u l=0.13u
X986 VDD iqmod_mixer_pex_half_1.iqmod_mixer_pex_se2diff_0.iqmod_mixer_pex_se2diff_half_tg$1_0.iqmod_mixer_pex_se2diff_inv_NF18$4_0.vout iqmod_mixer_pex_half_1.iqmod_mixer_pex_tg_0.di_tg_ctrl_n VDD sg13_lv_pmos ad=0.57p pd=3.38u as=0.57p ps=3.38u w=3u l=0.13u
X987 iqmod_mixer_pex_half_1.iqmod_mixer_pex_se2diff_0.iqmod_mixer_pex_se2diff_half_inv$1_0.iqmod_mixer_pex_se2diff_inv_NF2$5_0.vout VDD iqmod_mixer_pex_half_1.iqmod_mixer_pex_se2diff_0.iqmod_mixer_pex_se2diff_half_tg$1_0.iqmod_mixer_pex_se2diff_tg_NF6$2_0.v_b VSS sg13_lv_nmos ad=0.19p pd=1.38u as=0.19p ps=1.38u w=1u l=0.13u
X988 iqmod_mixer_pex_half_1.iqmod_mixer_pex_se2diff_0.iqmod_mixer_pex_se2diff_half_inv$1_0.iqmod_mixer_pex_se2diff_inv_NF2$5_1.vout iqmod_mixer_pex_half_1.iqmod_mixer_pex_se2diff_0.iqmod_mixer_pex_se2diff_half_tg$1_0.iqmod_mixer_pex_se2diff_tg_NF6$2_0.v_b VDD VDD sg13_lv_pmos ad=0.57p pd=3.38u as=0.57p ps=3.38u w=3u l=0.13u
X989 iqmod_mixer_pex_half_1.iqmod_mixer_pex_tg_0.di_tg_ctrl_n iqmod_mixer_pex_half_1.iqmod_mixer_pex_se2diff_0.iqmod_mixer_pex_se2diff_half_tg$1_0.iqmod_mixer_pex_se2diff_inv_NF18$4_0.vout VDD VDD sg13_lv_pmos ad=0.57p pd=3.38u as=0.57p ps=3.38u w=3u l=0.13u
X990 VSS iqmod_mixer_pex_half_0.iqmod_mixer_pex_se2diff_0.iqmod_mixer_pex_se2diff_half_inv$1_0.iqmod_mixer_pex_se2diff_inv_NF18$5_0.vout iqmod_mixer_pex_half_0.iqmod_mixer_pex_tg_0.di_tg_ctrl VSS sg13_lv_nmos ad=0.19p pd=1.38u as=0.19p ps=1.38u w=1u l=0.13u
X991 VSS VSS VSS VSS sg13_lv_nmos ad=0.34p pd=2.68u as=0 ps=0 w=1u l=0.13u
X992 iqmod_mixer_pex_half_1.iqmod_mixer_pex_se2diff_0.iqmod_mixer_pex_se2diff_half_inv$1_0.iqmod_mixer_pex_se2diff_inv_NF18$5_0.vout iqmod_mixer_pex_half_1.iqmod_mixer_pex_se2diff_0.iqmod_mixer_pex_se2diff_half_inv$1_0.iqmod_mixer_pex_se2diff_inv_NF6$5_1.vout VDD VDD sg13_lv_pmos ad=0.57p pd=3.38u as=0.57p ps=3.38u w=3u l=0.13u
X993 VDD iqmod_mixer_pex_half_1.iqmod_mixer_pex_se2diff_0.iqmod_mixer_pex_se2diff_half_inv$1_0.iqmod_mixer_pex_se2diff_inv_NF18$5_0.vout iqmod_mixer_pex_half_1.iqmod_mixer_pex_tg_0.di_tg_ctrl VDD sg13_lv_pmos ad=0.57p pd=3.38u as=0.57p ps=3.38u w=3u l=0.13u
X994 VSS iqmod_mixer_pex_half_0.iqmod_mixer_pex_se2diff_0.iqmod_mixer_pex_se2diff_half_inv$1_0.iqmod_mixer_pex_se2diff_inv_NF18$5_0.vout iqmod_mixer_pex_half_0.iqmod_mixer_pex_tg_0.di_tg_ctrl VSS sg13_lv_nmos ad=0.19p pd=1.38u as=0.19p ps=1.38u w=1u l=0.13u
X995 iqmod_mixer_pex_half_0.iqmod_mixer_pex_se2diff_0.iqmod_mixer_pex_se2diff_half_inv$1_0.iqmod_mixer_pex_se2diff_inv_NF18$5_0.vout iqmod_mixer_pex_half_0.iqmod_mixer_pex_se2diff_0.iqmod_mixer_pex_se2diff_half_inv$1_0.iqmod_mixer_pex_se2diff_inv_NF6$5_1.vout VSS VSS sg13_lv_nmos ad=0.19p pd=1.38u as=0.19p ps=1.38u w=1u l=0.13u
X996 vinn_IF iqmod_mixer_pex_half_0.iqmod_mixer_pex_tg_0.di_tg_ctrl_n voutn_RF VDD sg13_lv_pmos ad=1.71p pd=9.38u as=1.71p ps=9.38u w=9u l=0.13u
X997 iqmod_mixer_pex_half_1.iqmod_mixer_pex_tg_0.di_tg_ctrl iqmod_mixer_pex_half_1.iqmod_mixer_pex_se2diff_0.iqmod_mixer_pex_se2diff_half_inv$1_0.iqmod_mixer_pex_se2diff_inv_NF18$5_0.vout VDD VDD sg13_lv_pmos ad=0.57p pd=3.38u as=0.57p ps=3.38u w=3u l=0.13u
X998 iqmod_mixer_pex_half_1.iqmod_mixer_pex_tg_0.di_tg_ctrl_n iqmod_mixer_pex_half_1.iqmod_mixer_pex_se2diff_0.iqmod_mixer_pex_se2diff_half_tg$1_0.iqmod_mixer_pex_se2diff_inv_NF18$4_0.vout VSS VSS sg13_lv_nmos ad=0.19p pd=1.38u as=0.19p ps=1.38u w=1u l=0.13u
X999 VDD iqmod_mixer_pex_half_1.iqmod_mixer_pex_se2diff_0.iqmod_mixer_pex_se2diff_half_tg$1_0.iqmod_mixer_pex_se2diff_inv_NF6$4_0.vout iqmod_mixer_pex_half_1.iqmod_mixer_pex_se2diff_0.iqmod_mixer_pex_se2diff_half_tg$1_0.iqmod_mixer_pex_se2diff_inv_NF18$4_0.vout VDD sg13_lv_pmos ad=0.57p pd=3.38u as=0.57p ps=3.38u w=3u l=0.13u
X1000 iqmod_mixer_pex_half_1.iqmod_mixer_pex_tg_0.di_tg_ctrl_n iqmod_mixer_pex_half_1.iqmod_mixer_pex_se2diff_0.iqmod_mixer_pex_se2diff_half_tg$1_0.iqmod_mixer_pex_se2diff_inv_NF18$4_0.vout VSS VSS sg13_lv_nmos ad=0.19p pd=1.38u as=0.19p ps=1.38u w=1u l=0.13u
X1001 iqmod_mixer_pex_half_1.iqmod_mixer_pex_se2diff_0.iqmod_mixer_pex_se2diff_half_tg$1_0.iqmod_mixer_pex_se2diff_inv_NF18$4_0.vout iqmod_mixer_pex_half_1.iqmod_mixer_pex_se2diff_0.iqmod_mixer_pex_se2diff_half_tg$1_0.iqmod_mixer_pex_se2diff_inv_NF6$4_0.vout VDD VDD sg13_lv_pmos ad=0.57p pd=3.38u as=0.57p ps=3.38u w=3u l=0.13u
X1002 VSS iqmod_mixer_pex_half_0.iqmod_mixer_pex_se2diff_0.iqmod_mixer_pex_se2diff_half_inv$1_0.iqmod_mixer_pex_se2diff_inv_NF18$5_0.vout iqmod_mixer_pex_half_0.iqmod_mixer_pex_tg_0.di_tg_ctrl VSS sg13_lv_nmos ad=0.19p pd=1.38u as=0.19p ps=1.38u w=1u l=0.13u
X1003 iqmod_mixer_pex_half_0.iqmod_mixer_pex_se2diff_0.iqmod_mixer_pex_se2diff_half_inv$1_0.iqmod_mixer_pex_se2diff_inv_NF18$5_0.vout iqmod_mixer_pex_half_0.iqmod_mixer_pex_se2diff_0.iqmod_mixer_pex_se2diff_half_inv$1_0.iqmod_mixer_pex_se2diff_inv_NF6$5_1.vout VSS VSS sg13_lv_nmos ad=0.19p pd=1.38u as=0.19p ps=1.38u w=1u l=0.13u
X1004 VDD iqmod_mixer_pex_half_1.iqmod_mixer_pex_se2diff_0.iqmod_mixer_pex_se2diff_half_inv$1_0.iqmod_mixer_pex_se2diff_inv_NF18$5_0.vout iqmod_mixer_pex_half_1.iqmod_mixer_pex_tg_0.di_tg_ctrl VDD sg13_lv_pmos ad=0.57p pd=3.38u as=0.57p ps=3.38u w=3u l=0.13u
X1005 vinp_IF iqmod_mixer_pex_half_1.iqmod_mixer_pex_tg_0.di_tg_ctrl_n voutp_RF VDD sg13_lv_pmos ad=1.71p pd=9.38u as=1.71p ps=9.38u w=9u l=0.13u
X1006 VSS iqmod_mixer_pex_half_1.iqmod_mixer_pex_se2diff_0.iqmod_mixer_pex_se2diff_half_tg$1_0.iqmod_mixer_pex_se2diff_inv_NF18$4_0.vout iqmod_mixer_pex_half_1.iqmod_mixer_pex_tg_0.di_tg_ctrl_n VSS sg13_lv_nmos ad=0.19p pd=1.38u as=0.19p ps=1.38u w=1u l=0.13u
X1007 vinp_IF iqmod_mixer_pex_half_1.iqmod_mixer_pex_tg_0.di_tg_ctrl voutp_RF VSS sg13_lv_nmos ad=0.57p pd=3.38u as=0.57p ps=3.38u w=3u l=0.13u
X1008 VSS iqmod_mixer_pex_half_0.iqmod_mixer_pex_se2diff_0.iqmod_mixer_pex_se2diff_half_tg$1_0.iqmod_mixer_pex_se2diff_tg_NF6$2_0.v_b iqmod_mixer_pex_half_0.iqmod_mixer_pex_se2diff_0.iqmod_mixer_pex_se2diff_half_inv$1_0.iqmod_mixer_pex_se2diff_inv_NF2$5_1.vout VSS sg13_lv_nmos ad=0.19p pd=1.38u as=0.19p ps=1.38u w=1u l=0.13u
X1009 iqmod_mixer_pex_half_0.iqmod_mixer_pex_se2diff_0.iqmod_mixer_pex_se2diff_half_inv$1_0.iqmod_mixer_pex_se2diff_inv_NF18$5_0.vout iqmod_mixer_pex_half_0.iqmod_mixer_pex_se2diff_0.iqmod_mixer_pex_se2diff_half_inv$1_0.iqmod_mixer_pex_se2diff_inv_NF6$5_1.vout VSS VSS sg13_lv_nmos ad=0.19p pd=1.38u as=0.19p ps=1.38u w=1u l=0.13u
X1010 VSS iqmod_mixer_pex_half_0.iqmod_mixer_pex_se2diff_0.iqmod_mixer_pex_se2diff_half_inv$1_0.iqmod_mixer_pex_se2diff_inv_NF18$5_0.vout iqmod_mixer_pex_half_0.iqmod_mixer_pex_tg_0.di_tg_ctrl VSS sg13_lv_nmos ad=0.19p pd=1.38u as=0.19p ps=1.38u w=1u l=0.13u
X1011 VSS iqmod_mixer_pex_half_0.iqmod_mixer_pex_se2diff_0.iqmod_mixer_pex_se2diff_half_inv$1_0.iqmod_mixer_pex_se2diff_inv_NF6$5_2.vout iqmod_mixer_pex_half_0.iqmod_mixer_pex_se2diff_0.iqmod_mixer_pex_se2diff_half_inv$1_0.iqmod_mixer_pex_se2diff_inv_NF6$5_1.vout VSS sg13_lv_nmos ad=0.19p pd=1.38u as=0.19p ps=1.38u w=1u l=0.13u
X1012 VSS iqmod_mixer_pex_half_0.iqmod_mixer_pex_se2diff_0.iqmod_mixer_pex_se2diff_half_tg$1_0.iqmod_mixer_pex_se2diff_tg_NF6$2_0.v_b iqmod_mixer_pex_half_0.iqmod_mixer_pex_se2diff_0.iqmod_mixer_pex_se2diff_half_inv$1_0.iqmod_mixer_pex_se2diff_inv_NF2$5_1.vout VSS sg13_lv_nmos ad=0.19p pd=1.38u as=0.19p ps=1.38u w=1u l=0.13u
X1013 iqmod_mixer_pex_half_0.iqmod_mixer_pex_se2diff_0.iqmod_mixer_pex_se2diff_half_inv$1_0.iqmod_mixer_pex_se2diff_inv_NF6$5_2.vout iqmod_mixer_pex_half_0.iqmod_mixer_pex_se2diff_0.iqmod_mixer_pex_se2diff_half_inv$1_0.iqmod_mixer_pex_se2diff_inv_NF2$5_1.vout VSS VSS sg13_lv_nmos ad=0.19p pd=1.38u as=0.19p ps=1.38u w=1u l=0.13u
X1014 iqmod_mixer_pex_half_0.iqmod_mixer_pex_se2diff_0.iqmod_mixer_pex_se2diff_half_tg$1_0.iqmod_mixer_pex_se2diff_tg_NF6$2_0.v_b VDD iqmod_mixer_pex_half_0.iqmod_mixer_pex_se2diff_0.iqmod_mixer_pex_se2diff_half_inv$1_0.iqmod_mixer_pex_se2diff_inv_NF2$5_0.vout VSS sg13_lv_nmos ad=0.19p pd=1.38u as=0.19p ps=1.38u w=1u l=0.13u
X1015 iqmod_mixer_pex_half_1.iqmod_mixer_pex_se2diff_0.iqmod_mixer_pex_se2diff_half_inv$1_0.iqmod_mixer_pex_se2diff_inv_NF18$5_0.vout iqmod_mixer_pex_half_1.iqmod_mixer_pex_se2diff_0.iqmod_mixer_pex_se2diff_half_inv$1_0.iqmod_mixer_pex_se2diff_inv_NF6$5_1.vout VSS VSS sg13_lv_nmos ad=0.19p pd=1.38u as=0.19p ps=1.38u w=1u l=0.13u
X1016 VSS VSS VSS VSS sg13_lv_nmos ad=0.19p pd=1.38u as=0 ps=0 w=1u l=0.13u
X1017 voutp_RF iqmod_mixer_pex_half_1.iqmod_mixer_pex_tg_0.di_tg_ctrl_n voutp_RF VSS sg13_lv_nmos ad=0.57p pd=3.38u as=0 ps=0 w=3u l=0.13u
X1018 VSS iqmod_mixer_pex_half_0.iqmod_mixer_pex_se2diff_0.iqmod_mixer_pex_se2diff_half_inv$1_0.iqmod_mixer_pex_se2diff_inv_NF18$5_0.vout iqmod_mixer_pex_half_0.iqmod_mixer_pex_tg_0.di_tg_ctrl VSS sg13_lv_nmos ad=0.19p pd=1.38u as=0.19p ps=1.38u w=1u l=0.13u
X1019 VDD iqmod_mixer_pex_half_1.iqmod_mixer_pex_se2diff_0.iqmod_mixer_pex_se2diff_half_tg$1_0.iqmod_mixer_pex_se2diff_inv_NF18$4_0.vout iqmod_mixer_pex_half_1.iqmod_mixer_pex_tg_0.di_tg_ctrl_n VDD sg13_lv_pmos ad=0.57p pd=3.38u as=0.57p ps=3.38u w=3u l=0.13u
X1020 VSS iqmod_mixer_pex_half_1.iqmod_mixer_pex_se2diff_0.iqmod_mixer_pex_se2diff_half_tg$1_0.iqmod_mixer_pex_se2diff_inv_NF18$4_0.vout iqmod_mixer_pex_half_1.iqmod_mixer_pex_tg_0.di_tg_ctrl_n VSS sg13_lv_nmos ad=0.19p pd=1.38u as=0.19p ps=1.38u w=1u l=0.13u
X1021 voutn_RF iqmod_mixer_pex_half_0.iqmod_mixer_pex_tg_0.di_tg_ctrl voutn_RF VDD sg13_lv_pmos ad=1.71p pd=9.38u as=0 ps=0 w=9u l=0.13u
X1022 VSS VSS VSS VSS sg13_lv_nmos ad=0.19p pd=1.38u as=0 ps=0 w=1u l=0.13u
X1023 iqmod_mixer_pex_half_1.iqmod_mixer_pex_tg_0.di_tg_ctrl_n iqmod_mixer_pex_half_1.iqmod_mixer_pex_se2diff_0.iqmod_mixer_pex_se2diff_half_tg$1_0.iqmod_mixer_pex_se2diff_inv_NF18$4_0.vout VDD VDD sg13_lv_pmos ad=0.57p pd=3.38u as=0.57p ps=3.38u w=3u l=0.13u
X1024 voutp_RF iqmod_mixer_pex_half_1.iqmod_mixer_pex_tg_0.di_tg_ctrl_n voutp_RF VSS sg13_lv_nmos ad=0.57p pd=3.38u as=0 ps=0 w=3u l=0.13u
X1025 VDD VDD VDD VDD sg13_lv_pmos ad=0.57p pd=3.38u as=0 ps=0 w=3u l=0.13u
X1026 iqmod_mixer_pex_half_1.iqmod_mixer_pex_se2diff_0.iqmod_mixer_pex_se2diff_half_inv$1_0.iqmod_mixer_pex_se2diff_inv_NF6$5_1.vout iqmod_mixer_pex_half_1.iqmod_mixer_pex_se2diff_0.iqmod_mixer_pex_se2diff_half_inv$1_0.iqmod_mixer_pex_se2diff_inv_NF6$5_2.vout VDD VDD sg13_lv_pmos ad=0.57p pd=3.38u as=0.57p ps=3.38u w=3u l=0.13u
X1027 VDD iqmod_mixer_pex_half_0.iqmod_mixer_pex_se2diff_0.iqmod_mixer_pex_se2diff_half_inv$1_0.iqmod_mixer_pex_se2diff_inv_NF18$5_0.vout iqmod_mixer_pex_half_0.iqmod_mixer_pex_tg_0.di_tg_ctrl VDD sg13_lv_pmos ad=0.57p pd=3.38u as=0.57p ps=3.38u w=3u l=0.13u
X1028 VDD iqmod_mixer_pex_half_0.iqmod_mixer_pex_se2diff_0.iqmod_mixer_pex_se2diff_half_inv$1_0.iqmod_mixer_pex_se2diff_inv_NF18$5_0.vout iqmod_mixer_pex_half_0.iqmod_mixer_pex_tg_0.di_tg_ctrl VDD sg13_lv_pmos ad=0.57p pd=3.38u as=0.57p ps=3.38u w=3u l=0.13u
X1029 voutn_RF iqmod_mixer_pex_half_0.iqmod_mixer_pex_tg_0.di_tg_ctrl voutn_RF VDD sg13_lv_pmos ad=1.71p pd=9.38u as=0 ps=0 w=9u l=0.13u
X1030 iqmod_mixer_pex_half_0.iqmod_mixer_pex_tg_0.di_tg_ctrl_n iqmod_mixer_pex_half_0.iqmod_mixer_pex_se2diff_0.iqmod_mixer_pex_se2diff_half_tg$1_0.iqmod_mixer_pex_se2diff_inv_NF18$4_0.vout VSS VSS sg13_lv_nmos ad=0.19p pd=1.38u as=0.19p ps=1.38u w=1u l=0.13u
X1031 VSS iqmod_mixer_pex_half_0.iqmod_mixer_pex_se2diff_0.iqmod_mixer_pex_se2diff_half_tg$1_0.iqmod_mixer_pex_se2diff_inv_NF6$4_0.vout iqmod_mixer_pex_half_0.iqmod_mixer_pex_se2diff_0.iqmod_mixer_pex_se2diff_half_tg$1_0.iqmod_mixer_pex_se2diff_inv_NF18$4_0.vout VSS sg13_lv_nmos ad=0.19p pd=1.38u as=0.19p ps=1.38u w=1u l=0.13u
X1032 VDD VDD VDD VDD sg13_lv_pmos ad=1.02p pd=6.68u as=0 ps=0 w=3u l=0.13u
X1033 VDD iqmod_mixer_pex_half_0.iqmod_mixer_pex_se2diff_0.iqmod_mixer_pex_se2diff_half_inv$1_0.iqmod_mixer_pex_se2diff_inv_NF18$5_0.vout iqmod_mixer_pex_half_0.iqmod_mixer_pex_tg_0.di_tg_ctrl VDD sg13_lv_pmos ad=0.57p pd=3.38u as=0.57p ps=3.38u w=3u l=0.13u
X1034 VSS VSS VSS VSS sg13_lv_nmos ad=0.19p pd=1.38u as=0 ps=0 w=1u l=0.13u
X1035 iqmod_mixer_pex_half_0.iqmod_mixer_pex_tg_0.di_tg_ctrl_n iqmod_mixer_pex_half_0.iqmod_mixer_pex_se2diff_0.iqmod_mixer_pex_se2diff_half_tg$1_0.iqmod_mixer_pex_se2diff_inv_NF18$4_0.vout VDD VDD sg13_lv_pmos ad=0.57p pd=3.38u as=0.57p ps=3.38u w=3u l=0.13u
X1036 VSS iqmod_mixer_pex_half_0.iqmod_mixer_pex_se2diff_0.iqmod_mixer_pex_se2diff_half_tg$1_0.iqmod_mixer_pex_se2diff_inv_NF6$4_0.vout iqmod_mixer_pex_half_0.iqmod_mixer_pex_se2diff_0.iqmod_mixer_pex_se2diff_half_tg$1_0.iqmod_mixer_pex_se2diff_inv_NF18$4_0.vout VSS sg13_lv_nmos ad=0.19p pd=1.38u as=0.19p ps=1.38u w=1u l=0.13u
X1037 VDD iqmod_mixer_pex_half_0.iqmod_mixer_pex_se2diff_0.iqmod_mixer_pex_se2diff_half_inv$1_0.iqmod_mixer_pex_se2diff_inv_NF18$5_0.vout iqmod_mixer_pex_half_0.iqmod_mixer_pex_tg_0.di_tg_ctrl VDD sg13_lv_pmos ad=0.57p pd=3.38u as=0.57p ps=3.38u w=3u l=0.13u
X1038 VDD iqmod_mixer_pex_half_0.iqmod_mixer_pex_se2diff_0.iqmod_mixer_pex_se2diff_half_inv$1_0.iqmod_mixer_pex_se2diff_inv_NF18$5_0.vout iqmod_mixer_pex_half_0.iqmod_mixer_pex_tg_0.di_tg_ctrl VDD sg13_lv_pmos ad=0.57p pd=3.38u as=0.57p ps=3.38u w=3u l=0.13u
X1039 iqmod_mixer_pex_half_0.iqmod_mixer_pex_se2diff_0.iqmod_mixer_pex_se2diff_half_inv$1_0.iqmod_mixer_pex_se2diff_inv_NF18$5_0.vout iqmod_mixer_pex_half_0.iqmod_mixer_pex_se2diff_0.iqmod_mixer_pex_se2diff_half_inv$1_0.iqmod_mixer_pex_se2diff_inv_NF6$5_1.vout VDD VDD sg13_lv_pmos ad=0.57p pd=3.38u as=0.57p ps=3.38u w=3u l=0.13u
X1040 iqmod_mixer_pex_half_0.iqmod_mixer_pex_tg_0.di_tg_ctrl_n iqmod_mixer_pex_half_0.iqmod_mixer_pex_se2diff_0.iqmod_mixer_pex_se2diff_half_tg$1_0.iqmod_mixer_pex_se2diff_inv_NF18$4_0.vout VSS VSS sg13_lv_nmos ad=0.19p pd=1.38u as=0.19p ps=1.38u w=1u l=0.13u
X1041 VSS iqmod_mixer_pex_half_1.iqmod_mixer_pex_se2diff_0.iqmod_mixer_pex_se2diff_half_inv$1_0.iqmod_mixer_pex_se2diff_inv_NF6$5_1.vout iqmod_mixer_pex_half_1.iqmod_mixer_pex_se2diff_0.iqmod_mixer_pex_se2diff_half_inv$1_0.iqmod_mixer_pex_se2diff_inv_NF18$5_0.vout VSS sg13_lv_nmos ad=0.19p pd=1.38u as=0.19p ps=1.38u w=1u l=0.13u
X1042 VDD VDD VDD VDD sg13_lv_pmos ad=0.57p pd=3.38u as=0 ps=0 w=3u l=0.13u
X1043 iqmod_mixer_pex_half_0.iqmod_mixer_pex_se2diff_0.iqmod_mixer_pex_se2diff_half_tg$1_0.iqmod_mixer_pex_se2diff_inv_NF6$4_0.vout iqmod_mixer_pex_half_0.iqmod_mixer_pex_se2diff_0.iqmod_mixer_pex_se2diff_half_inv$1_0.iqmod_mixer_pex_se2diff_inv_NF2$5_1.vout VSS VSS sg13_lv_nmos ad=0.19p pd=1.38u as=0.19p ps=1.38u w=1u l=0.13u
X1044 voutn_RF iqmod_mixer_pex_half_0.iqmod_mixer_pex_tg_0.di_tg_ctrl_n vinn_IF VDD sg13_lv_pmos ad=1.71p pd=9.38u as=1.71p ps=9.38u w=9u l=0.13u
X1045 iqmod_mixer_pex_half_1.iqmod_mixer_pex_tg_0.di_tg_ctrl iqmod_mixer_pex_half_1.iqmod_mixer_pex_se2diff_0.iqmod_mixer_pex_se2diff_half_inv$1_0.iqmod_mixer_pex_se2diff_inv_NF18$5_0.vout VSS VSS sg13_lv_nmos ad=0.19p pd=1.38u as=0.19p ps=1.38u w=1u l=0.13u
X1046 vinp_IF iqmod_mixer_pex_half_1.iqmod_mixer_pex_tg_0.di_tg_ctrl_n voutp_RF VDD sg13_lv_pmos ad=1.71p pd=9.38u as=1.71p ps=9.38u w=9u l=0.13u
X1047 VDD VDD VDD VDD sg13_lv_pmos ad=0.57p pd=3.38u as=0 ps=0 w=3u l=0.13u
X1048 iqmod_mixer_pex_half_1.iqmod_mixer_pex_tg_0.di_tg_ctrl_n iqmod_mixer_pex_half_1.iqmod_mixer_pex_se2diff_0.iqmod_mixer_pex_se2diff_half_tg$1_0.iqmod_mixer_pex_se2diff_inv_NF18$4_0.vout VDD VDD sg13_lv_pmos ad=0.57p pd=3.38u as=0.57p ps=3.38u w=3u l=0.13u
X1049 iqmod_mixer_pex_half_0.iqmod_mixer_pex_tg_0.di_tg_ctrl_n iqmod_mixer_pex_half_0.iqmod_mixer_pex_se2diff_0.iqmod_mixer_pex_se2diff_half_tg$1_0.iqmod_mixer_pex_se2diff_inv_NF18$4_0.vout VDD VDD sg13_lv_pmos ad=0.57p pd=3.38u as=0.57p ps=3.38u w=3u l=0.13u
X1050 VDD iqmod_mixer_pex_half_0.iqmod_mixer_pex_se2diff_0.iqmod_mixer_pex_se2diff_half_inv$1_0.iqmod_mixer_pex_se2diff_inv_NF18$5_0.vout iqmod_mixer_pex_half_0.iqmod_mixer_pex_tg_0.di_tg_ctrl VDD sg13_lv_pmos ad=0.57p pd=3.38u as=0.57p ps=3.38u w=3u l=0.13u
X1051 VDD VDD VDD VDD sg13_lv_pmos ad=1.02p pd=6.68u as=0 ps=0 w=3u l=0.13u
X1052 iqmod_mixer_pex_half_0.iqmod_mixer_pex_se2diff_0.iqmod_mixer_pex_se2diff_half_inv$1_0.iqmod_mixer_pex_se2diff_inv_NF18$5_0.vout iqmod_mixer_pex_half_0.iqmod_mixer_pex_se2diff_0.iqmod_mixer_pex_se2diff_half_inv$1_0.iqmod_mixer_pex_se2diff_inv_NF6$5_1.vout VDD VDD sg13_lv_pmos ad=0.57p pd=3.38u as=0.57p ps=3.38u w=3u l=0.13u
X1053 voutn_RF iqmod_mixer_pex_half_0.iqmod_mixer_pex_tg_0.di_tg_ctrl_n vinn_IF VDD sg13_lv_pmos ad=1.71p pd=9.38u as=1.71p ps=9.38u w=9u l=0.13u
X1054 VDD iqmod_mixer_pex_half_0.iqmod_mixer_pex_se2diff_0.iqmod_mixer_pex_se2diff_half_inv$1_0.iqmod_mixer_pex_se2diff_inv_NF6$5_2.vout iqmod_mixer_pex_half_0.iqmod_mixer_pex_se2diff_0.iqmod_mixer_pex_se2diff_half_inv$1_0.iqmod_mixer_pex_se2diff_inv_NF6$5_1.vout VDD sg13_lv_pmos ad=0.57p pd=3.38u as=0.57p ps=3.38u w=3u l=0.13u
X1055 iqmod_mixer_pex_half_0.iqmod_mixer_pex_tg_0.di_tg_ctrl_n iqmod_mixer_pex_half_0.iqmod_mixer_pex_se2diff_0.iqmod_mixer_pex_se2diff_half_tg$1_0.iqmod_mixer_pex_se2diff_inv_NF18$4_0.vout VSS VSS sg13_lv_nmos ad=0.19p pd=1.38u as=0.19p ps=1.38u w=1u l=0.13u
X1056 VDD VDD VDD VDD sg13_lv_pmos ad=1.02p pd=6.68u as=0 ps=0 w=3u l=0.13u
X1057 VDD iqmod_mixer_pex_half_1.iqmod_mixer_pex_se2diff_0.iqmod_mixer_pex_se2diff_half_tg$1_0.iqmod_mixer_pex_se2diff_tg_NF6$2_0.v_b iqmod_mixer_pex_half_1.iqmod_mixer_pex_se2diff_0.iqmod_mixer_pex_se2diff_half_inv$1_0.iqmod_mixer_pex_se2diff_inv_NF2$5_1.vout VDD sg13_lv_pmos ad=0.57p pd=3.38u as=0.57p ps=3.38u w=3u l=0.13u
X1058 VDD iqmod_mixer_pex_half_1.iqmod_mixer_pex_se2diff_0.iqmod_mixer_pex_se2diff_half_tg$1_0.iqmod_mixer_pex_se2diff_inv_NF18$4_0.vout iqmod_mixer_pex_half_1.iqmod_mixer_pex_tg_0.di_tg_ctrl_n VDD sg13_lv_pmos ad=0.57p pd=3.38u as=0.57p ps=3.38u w=3u l=0.13u
X1059 voutp_RF iqmod_mixer_pex_half_1.iqmod_mixer_pex_tg_0.di_tg_ctrl_n vinp_IF VDD sg13_lv_pmos ad=1.71p pd=9.38u as=1.71p ps=9.38u w=9u l=0.13u
X1060 iqmod_mixer_pex_half_1.iqmod_mixer_pex_se2diff_0.iqmod_mixer_pex_se2diff_half_tg$1_0.iqmod_mixer_pex_se2diff_inv_NF18$4_0.vout iqmod_mixer_pex_half_1.iqmod_mixer_pex_se2diff_0.iqmod_mixer_pex_se2diff_half_tg$1_0.iqmod_mixer_pex_se2diff_inv_NF6$4_0.vout VDD VDD sg13_lv_pmos ad=0.57p pd=3.38u as=0.57p ps=3.38u w=3u l=0.13u
X1061 VDD iqmod_mixer_pex_half_0.iqmod_mixer_pex_se2diff_0.iqmod_mixer_pex_se2diff_half_tg$1_0.iqmod_mixer_pex_se2diff_inv_NF6$4_0.vout iqmod_mixer_pex_half_0.iqmod_mixer_pex_se2diff_0.iqmod_mixer_pex_se2diff_half_tg$1_0.iqmod_mixer_pex_se2diff_inv_NF18$4_0.vout VDD sg13_lv_pmos ad=0.57p pd=3.38u as=0.57p ps=3.38u w=3u l=0.13u
X1062 iqmod_mixer_pex_half_0.iqmod_mixer_pex_tg_0.di_tg_ctrl_n iqmod_mixer_pex_half_0.iqmod_mixer_pex_se2diff_0.iqmod_mixer_pex_se2diff_half_tg$1_0.iqmod_mixer_pex_se2diff_inv_NF18$4_0.vout VDD VDD sg13_lv_pmos ad=0.57p pd=3.38u as=0.57p ps=3.38u w=3u l=0.13u
X1063 VDD iqmod_mixer_pex_half_0.iqmod_mixer_pex_se2diff_0.iqmod_mixer_pex_se2diff_half_inv$1_0.iqmod_mixer_pex_se2diff_inv_NF18$5_0.vout iqmod_mixer_pex_half_0.iqmod_mixer_pex_tg_0.di_tg_ctrl VDD sg13_lv_pmos ad=0.57p pd=3.38u as=0.57p ps=3.38u w=3u l=0.13u
X1064 voutn_RF iqmod_mixer_pex_half_0.iqmod_mixer_pex_tg_0.di_tg_ctrl_n vinn_IF VDD sg13_lv_pmos ad=1.71p pd=9.38u as=1.71p ps=9.38u w=9u l=0.13u
X1065 iqmod_mixer_pex_half_1.iqmod_mixer_pex_tg_0.di_tg_ctrl iqmod_mixer_pex_half_1.iqmod_mixer_pex_se2diff_0.iqmod_mixer_pex_se2diff_half_inv$1_0.iqmod_mixer_pex_se2diff_inv_NF18$5_0.vout VDD VDD sg13_lv_pmos ad=0.57p pd=3.38u as=0.57p ps=3.38u w=3u l=0.13u
X1066 VSS iqmod_mixer_pex_half_1.iqmod_mixer_pex_se2diff_0.iqmod_mixer_pex_se2diff_half_tg$1_0.iqmod_mixer_pex_se2diff_tg_NF6$2_0.v_b iqmod_mixer_pex_half_1.iqmod_mixer_pex_se2diff_0.iqmod_mixer_pex_se2diff_half_inv$1_0.iqmod_mixer_pex_se2diff_inv_NF2$5_1.vout VSS sg13_lv_nmos ad=0.19p pd=1.38u as=0.19p ps=1.38u w=1u l=0.13u
X1067 VDD iqmod_mixer_pex_half_1.iqmod_mixer_pex_se2diff_0.iqmod_mixer_pex_se2diff_half_tg$1_0.iqmod_mixer_pex_se2diff_inv_NF6$4_0.vout iqmod_mixer_pex_half_1.iqmod_mixer_pex_se2diff_0.iqmod_mixer_pex_se2diff_half_tg$1_0.iqmod_mixer_pex_se2diff_inv_NF18$4_0.vout VDD sg13_lv_pmos ad=0.57p pd=3.38u as=0.57p ps=3.38u w=3u l=0.13u
X1068 iqmod_mixer_pex_half_1.iqmod_mixer_pex_se2diff_0.iqmod_mixer_pex_se2diff_half_inv$1_0.iqmod_mixer_pex_se2diff_inv_NF2$5_1.vout iqmod_mixer_pex_half_1.iqmod_mixer_pex_se2diff_0.iqmod_mixer_pex_se2diff_half_tg$1_0.iqmod_mixer_pex_se2diff_tg_NF6$2_0.v_b VSS VSS sg13_lv_nmos ad=0.19p pd=1.38u as=0.19p ps=1.38u w=1u l=0.13u
X1069 VDD iqmod_mixer_pex_half_1.iqmod_mixer_pex_se2diff_0.iqmod_mixer_pex_se2diff_half_inv$1_0.iqmod_mixer_pex_se2diff_inv_NF18$5_0.vout iqmod_mixer_pex_half_1.iqmod_mixer_pex_tg_0.di_tg_ctrl VDD sg13_lv_pmos ad=0.57p pd=3.38u as=0.57p ps=3.38u w=3u l=0.13u
X1070 VDD iqmod_mixer_pex_half_1.iqmod_mixer_pex_se2diff_0.iqmod_mixer_pex_se2diff_half_inv$1_0.iqmod_mixer_pex_se2diff_inv_NF18$5_0.vout iqmod_mixer_pex_half_1.iqmod_mixer_pex_tg_0.di_tg_ctrl VDD sg13_lv_pmos ad=0.57p pd=3.38u as=0.57p ps=3.38u w=3u l=0.13u
X1071 voutn_RF iqmod_mixer_pex_half_0.iqmod_mixer_pex_tg_0.di_tg_ctrl_n vinn_IF VDD sg13_lv_pmos ad=1.71p pd=9.38u as=1.71p ps=9.38u w=9u l=0.13u
C0 vinn_IF VSS 60.0267f
C1 voutn_RF VSS 87.43629f
C2 vinn_LO VSS 3.04832f
C3 vinp_IF VSS 60.0267f
C4 voutp_RF VSS 87.43629f
C5 vinp_LO VSS 3.04832f
C6 VDD VSS 0.34794p
C7 iqmod_mixer_pex_half_0.iqmod_mixer_pex_se2diff_0.iqmod_mixer_pex_se2diff_half_inv$1_0.iqmod_mixer_pex_se2diff_inv_NF18$5_0.vout VSS 36.8004f
C8 iqmod_mixer_pex_half_0.iqmod_mixer_pex_se2diff_0.iqmod_mixer_pex_se2diff_half_inv$1_0.iqmod_mixer_pex_se2diff_inv_NF6$5_1.vout VSS 12.426f
C9 iqmod_mixer_pex_half_0.iqmod_mixer_pex_se2diff_0.iqmod_mixer_pex_se2diff_half_inv$1_0.iqmod_mixer_pex_se2diff_inv_NF6$5_2.vin VSS 6.8681f
C10 iqmod_mixer_pex_half_0.iqmod_mixer_pex_tg_0.di_tg_ctrl VSS 50.7336f
C11 iqmod_mixer_pex_half_0.iqmod_mixer_pex_tg_0.di_tg_ctrl_n VSS 52.1289f
C12 iqmod_mixer_pex_half_0.iqmod_mixer_pex_se2diff_0.iqmod_mixer_pex_se2diff_half_tg$1_0.iqmod_mixer_pex_se2diff_inv_NF18$4_0.vout VSS 36.8004f
C13 iqmod_mixer_pex_half_0.iqmod_mixer_pex_se2diff_0.iqmod_mixer_pex_se2diff_half_tg$1_0.iqmod_mixer_pex_se2diff_inv_NF6$4_0.vout VSS 12.426f
C14 iqmod_mixer_pex_half_0.iqmod_mixer_pex_se2diff_0.iqmod_mixer_pex_se2diff_half_inv$1_0.iqmod_mixer_pex_se2diff_inv_NF6$5_2.vout VSS 10.4104f
C15 iqmod_mixer_pex_half_0.iqmod_mixer_pex_se2diff_0.iqmod_mixer_pex_se2diff_half_inv$1_0.iqmod_mixer_pex_se2diff_inv_NF2$5_1.vout VSS 10.247f
C16 iqmod_mixer_pex_half_0.iqmod_mixer_pex_se2diff_0.iqmod_mixer_pex_se2diff_half_tg$1_0.iqmod_mixer_pex_se2diff_tg_NF6$2_0.v_b VSS 6.8681f
C17 iqmod_mixer_pex_half_0.iqmod_mixer_pex_se2diff_0.iqmod_mixer_pex_se2diff_half_inv$1_0.iqmod_mixer_pex_se2diff_inv_NF2$5_0.vout VSS 10.384f
C18 iqmod_mixer_pex_half_1.iqmod_mixer_pex_se2diff_0.iqmod_mixer_pex_se2diff_half_tg$1_0.iqmod_mixer_pex_se2diff_inv_NF18$4_0.vout VSS 36.8004f
C19 iqmod_mixer_pex_half_1.iqmod_mixer_pex_se2diff_0.iqmod_mixer_pex_se2diff_half_tg$1_0.iqmod_mixer_pex_se2diff_inv_NF6$4_0.vout VSS 12.426f
C20 iqmod_mixer_pex_half_1.iqmod_mixer_pex_se2diff_0.iqmod_mixer_pex_se2diff_half_tg$1_0.iqmod_mixer_pex_se2diff_tg_NF6$2_0.v_b VSS 6.8681f
C21 iqmod_mixer_pex_half_1.iqmod_mixer_pex_tg_0.di_tg_ctrl_n VSS 52.1289f
C22 iqmod_mixer_pex_half_1.iqmod_mixer_pex_tg_0.di_tg_ctrl VSS 50.7336f
C23 iqmod_mixer_pex_half_1.iqmod_mixer_pex_se2diff_0.iqmod_mixer_pex_se2diff_half_inv$1_0.iqmod_mixer_pex_se2diff_inv_NF18$5_0.vout VSS 36.8004f
C24 iqmod_mixer_pex_half_1.iqmod_mixer_pex_se2diff_0.iqmod_mixer_pex_se2diff_half_inv$1_0.iqmod_mixer_pex_se2diff_inv_NF6$5_1.vout VSS 12.426f
C25 iqmod_mixer_pex_half_1.iqmod_mixer_pex_se2diff_0.iqmod_mixer_pex_se2diff_half_inv$1_0.iqmod_mixer_pex_se2diff_inv_NF2$5_1.vout VSS 10.247f
C26 iqmod_mixer_pex_half_1.iqmod_mixer_pex_se2diff_0.iqmod_mixer_pex_se2diff_half_inv$1_0.iqmod_mixer_pex_se2diff_inv_NF6$5_2.vout VSS 10.4104f
C27 iqmod_mixer_pex_half_1.iqmod_mixer_pex_se2diff_0.iqmod_mixer_pex_se2diff_half_inv$1_0.iqmod_mixer_pex_se2diff_inv_NF6$5_2.vin VSS 6.8681f
C28 iqmod_mixer_pex_half_1.iqmod_mixer_pex_se2diff_0.iqmod_mixer_pex_se2diff_half_inv$1_0.iqmod_mixer_pex_se2diff_inv_NF2$5_0.vout VSS 10.384f
.ends
